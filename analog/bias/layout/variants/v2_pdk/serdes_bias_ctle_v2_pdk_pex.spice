* NGSPICE file created from serdes_bias_ctle_v2_pdk.ext - technology: sky130A

.subckt serdes_bias_ctle_v2_pdk iin vss
X0 vss iin iin vss sky130_fd_pr__nfet_01v8_lvt ad=0.29 pd=2.29 as=0.29 ps=2.29 w=2 l=0.5
X1 iin iin vss vss sky130_fd_pr__nfet_01v8_lvt ad=0.29 pd=2.29 as=0.29 ps=2.29 w=2 l=0.5
X2 vss iin iin vss sky130_fd_pr__nfet_01v8_lvt ad=0.29 pd=2.29 as=0.29 ps=2.29 w=2 l=0.5
X3 vss vss vss vss sky130_fd_pr__nfet_01v8_lvt ad=0.58 pd=4.58 as=2.9 ps=22.9 w=2 l=0.5
X4 iin iin vss vss sky130_fd_pr__nfet_01v8_lvt ad=0.29 pd=2.29 as=0.29 ps=2.29 w=2 l=0.5
X5 vss vss vss vss sky130_fd_pr__nfet_01v8_lvt ad=0.29 pd=2.29 as=0 ps=0 w=2 l=0.5
C0 iin vss 2.04326f
.ends
