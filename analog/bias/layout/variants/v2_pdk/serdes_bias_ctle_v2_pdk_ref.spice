* BIAS v2 serdes_bias_ctle_v2_pdk (4 active + 2 outer shorted dummy fingers)
.subckt serdes_bias_ctle_v2_pdk iin vss
Xd iin iin vss vss sky130_fd_pr__nfet_01v8_lvt w=8 l=0.5
Xdum_l vss vss vss vss sky130_fd_pr__nfet_01v8_lvt w=2 l=0.5
Xdum_r vss vss vss vss sky130_fd_pr__nfet_01v8_lvt w=2 l=0.5
.ends serdes_bias_ctle_v2_pdk
