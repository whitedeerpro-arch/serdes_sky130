* NGSPICE file created from serdes_bias_ref_v2_pdk.ext - technology: sky130A

.subckt serdes_bias_ref_v2_pdk vbg i0 i1 i2 i3 vgi g0 g1 g2 g3 g4 vdd vss
X0 vdd vgi i3 vdd sky130_fd_pr__pfet_01v8_lvt ad=1.16 pd=8.29 as=1.16 ps=8.29 w=8 l=4
X1 a_28488_13114# a_28784_10985# vss sky130_fd_pr__res_high_po w=1 l=8.65
X2 a_7215_2409# a_7653_4996# vss vss sky130_fd_pr__nfet_01v8 ad=0.58 pd=4.29 as=0.58 ps=4.29 w=4 l=8
X3 vdd a_8813_7656# a_7095_4996# vdd sky130_fd_pr__pfet_01v8_lvt ad=1.74 pd=12.29 as=1.74 ps=12.29 w=12 l=8
X4 a_810_9710# a_20632_4864# vss sky130_fd_pr__res_high_po w=1 l=39.79
X5 a_25232_13115# a_25232_5085# vss sky130_fd_pr__res_high_po w=1 l=38.15
X6 a_26416_13114# a_26712_5934# vss sky130_fd_pr__res_high_po w=1 l=33.9
X7 vdd vdd vss vdd sky130_fd_pr__pfet_01v8_lvt ad=1.16 pd=8.29 as=2.32 ps=16.58 w=8 l=4
X8 vdd vdd vdd vdd sky130_fd_pr__pfet_01v8_lvt ad=1.74 pd=12.29 as=150.63181 ps=1.0661k w=12 l=8
X9 a_10273_1327# a_7653_4996# vss vss sky130_fd_pr__nfet_01v8 ad=0.58 pd=4.29 as=0.58 ps=4.29 w=4 l=8
X10 a_18619_429# a_5519_16918# vss vss sky130_fd_pr__nfet_01v8 ad=0.29 pd=2.58 as=0.29 ps=2.58 w=1 l=6
X11 a_29080_13115# a_28784_10985# vss sky130_fd_pr__res_high_po w=1 l=3.73
X12 vdd a_3119_13856# a_7877_3393# vdd sky130_fd_pr__pfet_01v8_lvt ad=2.03 pd=14.29 as=2.03 ps=14.29 w=14 l=12
X13 a_7653_4996# a_7273_2383# a_7215_2409# vss sky130_fd_pr__nfet_01v8 ad=0.58 pd=4.29 as=1.16 ps=8.58 w=4 l=4
X14 a_9593_3393# a_3119_13856# vdd vdd sky130_fd_pr__pfet_01v8_lvt ad=2.03 pd=14.29 as=2.03 ps=14.29 w=14 l=12
X15 vdd vgi a_2233_3855# vdd sky130_fd_pr__pfet_01v8_lvt ad=1.16 pd=8.29 as=1.16 ps=8.29 w=8 l=4
X16 a_25824_13114# a_25528_5934# vss sky130_fd_pr__res_high_po w=1 l=33.9
X17 vss vdd vdd vdd sky130_fd_pr__pfet_01v8_lvt ad=2.32 pd=16.58 as=1.16 ps=8.29 w=8 l=4
X18 a_8677_3419# a_8813_7656# vdd vdd sky130_fd_pr__pfet_01v8_lvt ad=1.74 pd=12.29 as=1.74 ps=12.29 w=12 l=8
X19 vbg vss sky130_fd_pr__cap_mim_m3_1 l=22.2 w=22.2
X20 vss vss a_7819_3419# vss sky130_fd_pr__nfet_01v8 ad=1.74 pd=12.58 as=0.87 ps=6.29 w=6 l=4
X21 a_7819_3419# a_7877_3393# a_8677_3419# vss sky130_fd_pr__nfet_01v8 ad=0.87 pd=6.29 as=0.87 ps=6.29 w=6 l=4
X22 a_25232_5085# g4 a_25232_13115# vss sky130_fd_pr__nfet_01v8 ad=0.75 pd=5.3 as=0.75 ps=5.3 w=5 l=0.18
X23 a_10273_1327# a_7273_2383# a_3119_13856# vss sky130_fd_pr__nfet_01v8 ad=1.16 pd=8.58 as=0.58 ps=4.29 w=4 l=4
X24 a_25232_13115# g4 a_25232_5085# vss sky130_fd_pr__nfet_01v8 ad=0.75 pd=5.3 as=0.75 ps=5.3 w=5 l=0.18
X25 vdd vgi i1 vdd sky130_fd_pr__pfet_01v8_lvt ad=1.16 pd=8.29 as=1.16 ps=8.29 w=8 l=4
X26 vss a_7653_4996# a_10273_1327# vss sky130_fd_pr__nfet_01v8 ad=0.58 pd=4.29 as=0.58 ps=4.29 w=4 l=8
X27 a_8813_7656# a_8813_7656# vdd vdd sky130_fd_pr__pfet_01v8_lvt ad=1.74 pd=12.29 as=3.48 ps=24.58 w=12 l=8
X28 vdd a_8813_7656# a_8813_7656# vdd sky130_fd_pr__pfet_01v8_lvt ad=3.48 pd=24.58 as=1.74 ps=12.29 w=12 l=8
X29 vdd vdd vbg vdd sky130_fd_pr__pfet_01v8_lvt ad=2.03 pd=14.29 as=4.06 ps=28.58 w=14 l=12
X30 a_7877_3393# a_3119_13856# vdd vdd sky130_fd_pr__pfet_01v8_lvt ad=2.03 pd=14.29 as=2.03 ps=14.29 w=14 l=12
X31 vbg a_3119_13856# vdd vdd sky130_fd_pr__pfet_01v8_lvt ad=2.03 pd=14.29 as=2.03 ps=14.29 w=14 l=12
X32 vbg vdd vdd vdd sky130_fd_pr__pfet_01v8_lvt ad=4.06 pd=28.58 as=2.03 ps=14.29 w=14 l=12
X33 vdd a_3119_13856# a_5519_16918# vdd sky130_fd_pr__pfet_01v8_lvt ad=2.03 pd=14.29 as=2.03 ps=14.29 w=14 l=12
X34 a_7653_4996# a_7153_4899# a_7095_4996# vdd sky130_fd_pr__pfet_01v8_lvt ad=1.74 pd=12.29 as=1.74 ps=12.29 w=12 l=2.5
X35 vss a_5519_16918# a_5519_16918# vss sky130_fd_pr__nfet_01v8 ad=0.87 pd=6.58 as=0.435 ps=3.29 w=3 l=4
X36 vdd a_3119_13856# vbg vdd sky130_fd_pr__pfet_01v8_lvt ad=2.03 pd=14.29 as=2.03 ps=14.29 w=14 l=12
X37 i3 vgi vdd vdd sky130_fd_pr__pfet_01v8_lvt ad=1.16 pd=8.29 as=1.16 ps=8.29 w=8 l=4
X38 a_28488_13114# g2 a_28784_10985# vss sky130_fd_pr__nfet_01v8 ad=0.75 pd=5.3 as=0.75 ps=5.3 w=5 l=0.18
X39 a_28784_10985# g2 a_28488_13114# vss sky130_fd_pr__nfet_01v8 ad=0.75 pd=5.3 as=0.75 ps=5.3 w=5 l=0.18
X40 vdd vdd vdd vdd sky130_fd_pr__pfet_01v8_lvt ad=1.74 pd=12.29 as=0 ps=0 w=12 l=8
X41 a_19477_429# a_2233_3855# a_18619_429# vss sky130_fd_pr__nfet_01v8 ad=0.87 pd=6.29 as=0.87 ps=6.29 w=6 l=4
X42 vdd a_3119_13856# a_5519_13953# vdd sky130_fd_pr__pfet_01v8_lvt ad=2.03 pd=14.29 as=2.03 ps=14.29 w=14 l=12
X43 vss vss a_810_9710# sky130_fd_pr__pnp_05v5_W3p40L3p40
**devattr s=462400,2720
X44 a_5519_16918# a_3119_13856# vdd vdd sky130_fd_pr__pfet_01v8_lvt ad=2.03 pd=14.29 as=2.03 ps=14.29 w=14 l=12
X45 a_3119_13856# a_11300_13364# vss vss sky130_fd_pr__nfet_01v8 ad=0.29 pd=2.58 as=0.29 ps=2.58 w=1 l=1
X46 vss vdd vdd vdd sky130_fd_pr__pfet_01v8_lvt ad=2.32 pd=16.58 as=1.16 ps=8.29 w=8 l=4
X47 a_7095_4996# a_9593_3393# a_7819_3419# vss sky130_fd_pr__nfet_01v8 ad=0.87 pd=6.29 as=0.87 ps=6.29 w=6 l=4
X48 a_8677_3419# a_7153_4899# a_3119_13856# vdd sky130_fd_pr__pfet_01v8_lvt ad=3.48 pd=24.58 as=1.74 ps=12.29 w=12 l=2.5
X49 vss a_5519_13953# a_7819_3419# vss sky130_fd_pr__nfet_01v8 ad=0.87 pd=6.58 as=0.435 ps=3.29 w=3 l=4
X50 a_7819_3419# a_7877_3393# a_8677_3419# vss sky130_fd_pr__nfet_01v8 ad=0.87 pd=6.29 as=0.87 ps=6.29 w=6 l=4
X51 a_25232_5085# g3 a_28488_13114# vss sky130_fd_pr__nfet_01v8 ad=0.75 pd=5.3 as=0.75 ps=5.3 w=5 l=0.18
X52 a_28488_13114# g3 a_25232_5085# vss sky130_fd_pr__nfet_01v8 ad=0.75 pd=5.3 as=0.75 ps=5.3 w=5 l=0.18
X53 vdd vdd vss vdd sky130_fd_pr__pfet_01v8_lvt ad=1.16 pd=8.29 as=2.32 ps=16.58 w=8 l=4
X54 a_19477_429# a_19477_429# vdd vdd sky130_fd_pr__pfet_01v8_lvt ad=1.74 pd=12.29 as=1.74 ps=12.29 w=12 l=8
X55 a_8677_3419# a_7877_3393# a_7819_3419# vss sky130_fd_pr__nfet_01v8 ad=0.87 pd=6.29 as=0.87 ps=6.29 w=6 l=4
X56 a_5130_11080# a_24276_5019# vss sky130_fd_pr__res_high_po w=1 l=37.65
X57 vss vss a_810_9710# sky130_fd_pr__pnp_05v5_W3p40L3p40
**devattr s=462400,2720
X58 i1 vgi vdd vdd sky130_fd_pr__pfet_01v8_lvt ad=1.16 pd=8.29 as=1.16 ps=8.29 w=8 l=4
X59 vgi vbg a_18619_429# vss sky130_fd_pr__nfet_01v8 ad=0.87 pd=6.29 as=0.87 ps=6.29 w=6 l=4
X60 a_3119_13856# a_7273_2383# a_10273_1327# vss sky130_fd_pr__nfet_01v8 ad=0.58 pd=4.29 as=0.58 ps=4.29 w=4 l=4
X61 a_18619_429# vss vss vss sky130_fd_pr__nfet_01v8 ad=0.87 pd=6.29 as=1.74 ps=12.58 w=6 l=4
X62 a_5519_16918# a_3119_13856# vdd vdd sky130_fd_pr__pfet_01v8_lvt ad=2.03 pd=14.29 as=2.03 ps=14.29 w=14 l=12
X63 a_11300_13364# a_5519_13953# vss vss sky130_fd_pr__nfet_01v8 ad=0.58 pd=4.58 as=0.58 ps=4.58 w=2 l=1
X64 a_29080_13115# g0 vss vss sky130_fd_pr__nfet_01v8 ad=0.75 pd=5.3 as=0.75 ps=5.3 w=5 l=0.18
X65 vdd a_3119_13856# a_7877_3393# vdd sky130_fd_pr__pfet_01v8_lvt ad=2.03 pd=14.29 as=2.03 ps=14.29 w=14 l=12
X66 a_29080_13115# g1 a_28784_10985# vss sky130_fd_pr__nfet_01v8 ad=0.75 pd=5.3 as=0.75 ps=5.3 w=5 l=0.18
X67 a_23388_12949# a_23684_5019# vss sky130_fd_pr__res_high_po w=1 l=37.65
X68 vss a_7653_4996# a_7215_2409# vss sky130_fd_pr__nfet_01v8 ad=0.58 pd=4.29 as=0.58 ps=4.29 w=4 l=8
X69 a_28784_10985# g1 a_29080_13115# vss sky130_fd_pr__nfet_01v8 ad=0.75 pd=5.3 as=0.75 ps=5.3 w=5 l=0.18
X70 a_27600_13114# a_27896_5934# vss sky130_fd_pr__res_high_po w=1 l=33.9
X71 a_7215_2409# a_7273_2383# a_7653_4996# vss sky130_fd_pr__nfet_01v8 ad=1.16 pd=8.58 as=0.58 ps=4.29 w=4 l=4
X72 vdd vgi i2 vdd sky130_fd_pr__pfet_01v8_lvt ad=1.16 pd=8.29 as=1.16 ps=8.29 w=8 l=4
X73 vss vdd vdd vdd sky130_fd_pr__pfet_01v8_lvt ad=2.32 pd=16.58 as=1.16 ps=8.29 w=8 l=4
X74 vdd vdd vbg vdd sky130_fd_pr__pfet_01v8_lvt ad=2.03 pd=14.29 as=4.06 ps=28.58 w=14 l=12
X75 a_7653_4996# a_7153_4899# a_7095_4996# vdd sky130_fd_pr__pfet_01v8_lvt ad=1.74 pd=12.29 as=3.48 ps=24.58 w=12 l=2.5
X76 a_20040_13104# a_19448_4864# vss sky130_fd_pr__res_high_po w=1 l=39.2
X77 vdd vdd vdd vdd sky130_fd_pr__pfet_01v8_lvt ad=3.48 pd=24.58 as=0 ps=0 w=12 l=8
X78 a_25232_13115# g4 a_25232_5085# vss sky130_fd_pr__nfet_01v8 ad=0.75 pd=5.3 as=1.475 ps=10.59 w=5 l=0.18
X79 vss vss a_5130_11080# sky130_fd_pr__pnp_05v5_W3p40L3p40
**devattr s=462400,2720
X80 vdd a_3119_13856# vbg vdd sky130_fd_pr__pfet_01v8_lvt ad=2.03 pd=14.29 as=2.03 ps=14.29 w=14 l=12
X81 vss vbg sky130_fd_pr__cap_mim_m3_2 l=22.2 w=22.2
X82 a_19744_13104# a_2250_11080# vss sky130_fd_pr__res_high_po w=1 l=39.2
X83 vss vss a_18619_429# vss sky130_fd_pr__nfet_01v8 ad=1.74 pd=12.58 as=0.87 ps=6.29 w=6 l=4
X84 a_7153_4899# a_5519_13953# vss vss sky130_fd_pr__nfet_01v8 ad=0.87 pd=6.58 as=0.87 ps=6.58 w=3 l=4
X85 a_7095_4996# a_8813_7656# vdd vdd sky130_fd_pr__pfet_01v8_lvt ad=1.74 pd=12.29 as=1.74 ps=12.29 w=12 l=8
X86 a_7819_3419# a_5519_13953# vss vss sky130_fd_pr__nfet_01v8 ad=0.435 pd=3.29 as=0.87 ps=6.58 w=3 l=4
X87 a_28488_13114# g2 a_28784_10985# vss sky130_fd_pr__nfet_01v8 ad=0.75 pd=5.3 as=1.475 ps=10.59 w=5 l=0.18
X88 vdd vgi sky130_fd_pr__cap_mim_m3_2 l=22.2 w=22.2
X89 a_8677_3419# a_7153_4899# a_3119_13856# vdd sky130_fd_pr__pfet_01v8_lvt ad=1.74 pd=12.29 as=1.74 ps=12.29 w=12 l=2.5
X90 a_7095_4996# a_7153_4899# a_7653_4996# vdd sky130_fd_pr__pfet_01v8_lvt ad=3.48 pd=24.58 as=1.74 ps=12.29 w=12 l=2.5
X91 a_10273_1327# a_7273_2383# a_3119_13856# vss sky130_fd_pr__nfet_01v8 ad=0.58 pd=4.29 as=0.58 ps=4.29 w=4 l=4
X92 a_27008_13114# a_26712_5934# vss sky130_fd_pr__res_high_po w=1 l=33.9
X93 vgi vbg a_2233_3855# vss sky130_fd_pr__nfet_01v8_lvt ad=0.58 pd=4.58 as=0.58 ps=4.58 w=2 l=4
X94 a_8677_3419# a_8813_7656# vdd vdd sky130_fd_pr__pfet_01v8_lvt ad=1.74 pd=12.29 as=1.74 ps=12.29 w=12 l=8
X95 a_7653_4996# a_7273_2383# a_7215_2409# vss sky130_fd_pr__nfet_01v8 ad=0.58 pd=4.29 as=0.58 ps=4.29 w=4 l=4
X96 a_5519_13953# a_3119_13856# vdd vdd sky130_fd_pr__pfet_01v8_lvt ad=2.03 pd=14.29 as=2.03 ps=14.29 w=14 l=12
X97 i3 vgi vdd vdd sky130_fd_pr__pfet_01v8_lvt ad=1.16 pd=8.29 as=1.16 ps=8.29 w=8 l=4
X98 i2 vgi vdd vdd sky130_fd_pr__pfet_01v8_lvt ad=1.16 pd=8.29 as=1.16 ps=8.29 w=8 l=4
X99 a_18619_429# vbg vgi vss sky130_fd_pr__nfet_01v8 ad=0.87 pd=6.29 as=0.87 ps=6.29 w=6 l=4
X100 a_18619_429# a_2233_3855# a_19477_429# vss sky130_fd_pr__nfet_01v8 ad=0.87 pd=6.29 as=0.87 ps=6.29 w=6 l=4
X101 a_25232_5085# g3 a_28488_13114# vss sky130_fd_pr__nfet_01v8 ad=0.75 pd=5.3 as=1.475 ps=10.59 w=5 l=0.18
X102 vdd vdd vdd vdd sky130_fd_pr__pfet_01v8_lvt ad=1.74 pd=12.29 as=0 ps=0 w=12 l=8
X103 vss vss vss vss sky130_fd_pr__nfet_01v8 ad=1.16 pd=8.58 as=95.645 ps=589.85999 w=4 l=8
X104 a_8677_3419# a_7877_3393# a_7819_3419# vss sky130_fd_pr__nfet_01v8 ad=0.87 pd=6.29 as=0.87 ps=6.29 w=6 l=4
X105 vss vss a_810_9710# sky130_fd_pr__pnp_05v5_W3p40L3p40
**devattr s=462400,2720
X106 vdd a_3119_13856# a_9593_3393# vdd sky130_fd_pr__pfet_01v8_lvt ad=2.03 pd=14.29 as=2.03 ps=14.29 w=14 l=12
X107 vdd vdd vdd vdd sky130_fd_pr__pfet_01v8_lvt ad=3.48 pd=24.58 as=0 ps=0 w=12 l=8
X108 vbg vss sky130_fd_pr__cap_mim_m3_1 l=22.2 w=22.2
X109 vdd vdd vss vdd sky130_fd_pr__pfet_01v8_lvt ad=1.16 pd=8.29 as=2.32 ps=16.58 w=8 l=4
X110 a_18560_13104# a_19152_4864# vss sky130_fd_pr__res_high_po w=1 l=39.2
X111 a_7819_3419# vss vss vss sky130_fd_pr__nfet_01v8 ad=0.87 pd=6.29 as=1.74 ps=12.58 w=6 l=4
X112 vdd vdd vss vdd sky130_fd_pr__pfet_01v8_lvt ad=1.16 pd=8.29 as=2.32 ps=16.58 w=8 l=4
X113 a_7095_4996# a_9593_3393# a_7819_3419# vss sky130_fd_pr__nfet_01v8 ad=0.87 pd=6.29 as=0.87 ps=6.29 w=6 l=4
X114 vdd vgi i0 vdd sky130_fd_pr__pfet_01v8_lvt ad=1.16 pd=8.29 as=1.16 ps=8.29 w=8 l=4
X115 a_28784_10985# g1 a_29080_13115# vss sky130_fd_pr__nfet_01v8 ad=0.75 pd=5.3 as=1.475 ps=10.59 w=5 l=0.18
X116 vgi vdd sky130_fd_pr__cap_mim_m3_1 l=22.2 w=22.2
X117 a_9593_3393# a_18264_4864# vss sky130_fd_pr__res_high_po w=1 l=39.2
X118 a_18856_13104# a_19448_4864# vss sky130_fd_pr__res_high_po w=1 l=39.2
X119 vdd vdd vdd vdd sky130_fd_pr__pfet_01v8_lvt ad=3.48 pd=24.58 as=0 ps=0 w=12 l=8
X120 a_7215_2409# a_7653_4996# vss vss sky130_fd_pr__nfet_01v8 ad=0.58 pd=4.29 as=0.58 ps=4.29 w=4 l=8
X121 vdd vgi a_2233_3855# vdd sky130_fd_pr__pfet_01v8_lvt ad=1.16 pd=8.29 as=1.16 ps=8.29 w=8 l=4
X122 i1 vgi vdd vdd sky130_fd_pr__pfet_01v8_lvt ad=1.16 pd=8.29 as=1.16 ps=8.29 w=8 l=4
X123 vss vss vss vss sky130_fd_pr__nfet_01v8 ad=0.58 pd=4.29 as=0 ps=0 w=4 l=8
X124 a_3119_13856# a_7273_2383# a_10273_1327# vss sky130_fd_pr__nfet_01v8 ad=0.58 pd=4.29 as=1.16 ps=8.58 w=4 l=4
X125 i0 vgi vdd vdd sky130_fd_pr__pfet_01v8_lvt ad=1.16 pd=8.29 as=1.16 ps=8.29 w=8 l=4
X126 a_5519_16918# a_5519_16918# vss vss sky130_fd_pr__nfet_01v8 ad=0.435 pd=3.29 as=0.87 ps=6.58 w=3 l=4
X127 vdd vgi i3 vdd sky130_fd_pr__pfet_01v8_lvt ad=1.16 pd=8.29 as=1.16 ps=8.29 w=8 l=4
X128 a_7095_4996# a_7153_4899# a_7653_4996# vdd sky130_fd_pr__pfet_01v8_lvt ad=1.74 pd=12.29 as=1.74 ps=12.29 w=12 l=2.5
X129 a_23980_12949# a_23684_5019# vss sky130_fd_pr__res_high_po w=1 l=37.65
X130 vss a_7653_4996# a_7215_2409# vss sky130_fd_pr__nfet_01v8 ad=0.58 pd=4.29 as=0.58 ps=4.29 w=4 l=8
X131 a_7819_3419# a_9593_3393# a_7095_4996# vss sky130_fd_pr__nfet_01v8 ad=0.87 pd=6.29 as=0.87 ps=6.29 w=6 l=4
X132 a_21884_12949# a_22180_5019# vss sky130_fd_pr__res_high_po w=1 l=37.65
X133 vss vss a_810_9710# sky130_fd_pr__pnp_05v5_W3p40L3p40
**devattr s=462400,2720
X134 vgi a_19477_429# vdd vdd sky130_fd_pr__pfet_01v8_lvt ad=1.74 pd=12.29 as=1.74 ps=12.29 w=12 l=8
X135 vdd a_19477_429# a_19477_429# vdd sky130_fd_pr__pfet_01v8_lvt ad=1.74 pd=12.29 as=1.74 ps=12.29 w=12 l=8
X136 vss g0 a_29080_13115# vss sky130_fd_pr__nfet_01v8 ad=1.475 pd=10.59 as=0.75 ps=5.3 w=5 l=0.18
X137 a_18619_429# a_2233_3855# a_19477_429# vss sky130_fd_pr__nfet_01v8 ad=0.87 pd=6.29 as=0.87 ps=6.29 w=6 l=4
X138 a_25232_5085# g4 a_25232_13115# vss sky130_fd_pr__nfet_01v8 ad=1.475 pd=10.59 as=0.75 ps=5.3 w=5 l=0.18
X139 vss vss a_810_9710# sky130_fd_pr__pnp_05v5_W3p40L3p40
**devattr s=462400,2720
X140 vdd vgi i1 vdd sky130_fd_pr__pfet_01v8_lvt ad=1.16 pd=8.29 as=1.16 ps=8.29 w=8 l=4
X141 vdd a_8813_7656# a_8677_3419# vdd sky130_fd_pr__pfet_01v8_lvt ad=1.74 pd=12.29 as=1.74 ps=12.29 w=12 l=8
X142 a_20040_13104# a_20632_4864# vss sky130_fd_pr__res_high_po w=1 l=39.2
X143 a_22476_12949# a_22180_5019# vss sky130_fd_pr__res_high_po w=1 l=37.65
X144 a_7273_2383# a_8813_7656# vdd vdd sky130_fd_pr__pfet_01v8_lvt ad=6.96 pd=48.58 as=6.96 ps=48.58 w=24 l=8
X145 a_8813_7656# a_5519_13953# vss vss sky130_fd_pr__nfet_01v8 ad=0.87 pd=6.58 as=0.87 ps=6.58 w=3 l=4
X146 a_2233_3855# vgi vdd vdd sky130_fd_pr__pfet_01v8_lvt ad=1.16 pd=8.29 as=1.16 ps=8.29 w=8 l=4
X147 vss vss a_810_9710# sky130_fd_pr__pnp_05v5_W3p40L3p40
**devattr s=462400,2720
X148 vbg a_21588_5019# vss sky130_fd_pr__res_high_po w=1 l=37.65
X149 a_28784_10985# g2 a_28488_13114# vss sky130_fd_pr__nfet_01v8 ad=1.475 pd=10.59 as=0.75 ps=5.3 w=5 l=0.18
X150 a_10273_1327# a_7653_4996# vss vss sky130_fd_pr__nfet_01v8 ad=0.58 pd=4.29 as=0.58 ps=4.29 w=4 l=8
X151 vss vss a_2250_11080# sky130_fd_pr__pnp_05v5_W3p40L3p40
**devattr s=462400,2720
X152 a_27008_13114# a_27304_5934# vss sky130_fd_pr__res_high_po w=1 l=33.9
X153 a_25824_13114# a_26120_5934# vss sky130_fd_pr__res_high_po w=1 l=33.9
X154 a_3119_13856# a_7153_4899# a_8677_3419# vdd sky130_fd_pr__pfet_01v8_lvt ad=1.74 pd=12.29 as=1.74 ps=12.29 w=12 l=2.5
X155 i2 vgi vdd vdd sky130_fd_pr__pfet_01v8_lvt ad=1.16 pd=8.29 as=1.16 ps=8.29 w=8 l=4
X156 a_19477_429# a_2233_3855# a_18619_429# vss sky130_fd_pr__nfet_01v8 ad=0.87 pd=6.29 as=0.87 ps=6.29 w=6 l=4
X157 vgi vbg a_18619_429# vss sky130_fd_pr__nfet_01v8 ad=0.87 pd=6.29 as=0.87 ps=6.29 w=6 l=4
X158 vss vss a_810_9710# sky130_fd_pr__pnp_05v5_W3p40L3p40
**devattr s=462400,2720
X159 a_29080_13115# g0 vss vss sky130_fd_pr__nfet_01v8 ad=0.75 pd=5.3 as=1.475 ps=10.59 w=5 l=0.18
X160 a_26416_13114# a_26120_5934# vss sky130_fd_pr__res_high_po w=1 l=33.9
X161 a_7095_4996# a_8813_7656# vdd vdd sky130_fd_pr__pfet_01v8_lvt ad=1.74 pd=12.29 as=1.74 ps=12.29 w=12 l=8
X162 a_7273_2383# a_7273_2383# vss vss sky130_fd_pr__nfet_01v8 ad=0.435 pd=3.58 as=0.435 ps=3.58 w=1.5 l=10
X163 a_28488_13114# g3 a_25232_5085# vss sky130_fd_pr__nfet_01v8 ad=1.475 pd=10.59 as=0.75 ps=5.3 w=5 l=0.18
X164 vss a_5519_13953# a_5519_13953# vss sky130_fd_pr__nfet_01v8 ad=0.87 pd=6.58 as=0.435 ps=3.29 w=3 l=4
X165 vdd a_8813_7656# a_8677_3419# vdd sky130_fd_pr__pfet_01v8_lvt ad=1.74 pd=12.29 as=1.74 ps=12.29 w=12 l=8
X166 vss vbg sky130_fd_pr__cap_mim_m3_2 l=22.2 w=22.2
X167 vss a_7653_4996# a_10273_1327# vss sky130_fd_pr__nfet_01v8 ad=0.58 pd=4.29 as=0.58 ps=4.29 w=4 l=8
X168 i0 vgi vdd vdd sky130_fd_pr__pfet_01v8_lvt ad=1.16 pd=8.29 as=1.16 ps=8.29 w=8 l=4
X169 a_25232_13115# a_25528_5934# vss sky130_fd_pr__res_high_po w=1 l=33.9
X170 vss vdd vdd vdd sky130_fd_pr__pfet_01v8_lvt ad=2.32 pd=16.58 as=1.16 ps=8.29 w=8 l=4
X171 vdd a_19477_429# vgi vdd sky130_fd_pr__pfet_01v8_lvt ad=1.74 pd=12.29 as=1.74 ps=12.29 w=12 l=8
X172 a_19744_13104# a_19152_4864# vss sky130_fd_pr__res_high_po w=1 l=39.2
X173 a_29080_13115# g1 a_28784_10985# vss sky130_fd_pr__nfet_01v8 ad=1.475 pd=10.59 as=0.75 ps=5.3 w=5 l=0.18
X174 a_18560_13104# a_17968_4864# vss sky130_fd_pr__res_high_po w=1 l=39.2
X175 a_28488_13114# a_25232_5085# vss sky130_fd_pr__res_high_po w=1 l=18.48
X176 a_18856_13104# a_18264_4864# vss sky130_fd_pr__res_high_po w=1 l=39.2
X177 vdd vgi i2 vdd sky130_fd_pr__pfet_01v8_lvt ad=1.16 pd=8.29 as=1.16 ps=8.29 w=8 l=4
X178 vss vss vss vss sky130_fd_pr__nfet_01v8 ad=0.58 pd=4.29 as=0 ps=0 w=4 l=8
X179 vss g0 a_29080_13115# vss sky130_fd_pr__nfet_01v8 ad=0.75 pd=5.3 as=0.75 ps=5.3 w=5 l=0.18
X180 a_7153_4899# a_7153_4899# vdd vdd sky130_fd_pr__pfet_01v8_lvt ad=0.87 pd=6.58 as=0.87 ps=6.58 w=3 l=4
X181 a_5519_13953# a_5519_13953# vss vss sky130_fd_pr__nfet_01v8 ad=0.435 pd=3.29 as=0.87 ps=6.58 w=3 l=4
X182 a_7877_3393# a_17968_4864# vss sky130_fd_pr__res_high_po w=1 l=39.2
X183 vbg vss sky130_fd_pr__cap_mim_m3_1 l=22.2 w=22.2
X184 vdd a_3119_13856# a_9593_3393# vdd sky130_fd_pr__pfet_01v8_lvt ad=2.03 pd=14.29 as=2.03 ps=14.29 w=14 l=12
X185 vss vdd vdd vdd sky130_fd_pr__pfet_01v8_lvt ad=2.32 pd=16.58 as=1.16 ps=8.29 w=8 l=4
X186 vss vss vss vss sky130_fd_pr__nfet_01v8 ad=1.16 pd=8.58 as=0 ps=0 w=4 l=8
X187 a_7819_3419# a_9593_3393# a_7095_4996# vss sky130_fd_pr__nfet_01v8 ad=0.87 pd=6.29 as=0.87 ps=6.29 w=6 l=4
X188 a_7877_3393# a_3119_13856# vdd vdd sky130_fd_pr__pfet_01v8_lvt ad=2.03 pd=14.29 as=2.03 ps=14.29 w=14 l=12
X189 a_29080_13115# vss vss sky130_fd_pr__res_high_po w=1 l=1.27
X190 a_2233_3855# a_27896_5934# vss sky130_fd_pr__res_high_po w=1 l=33.9
X191 vdd a_8813_7656# a_7095_4996# vdd sky130_fd_pr__pfet_01v8_lvt ad=1.74 pd=12.29 as=1.74 ps=12.29 w=12 l=8
X192 a_7215_2409# a_7273_2383# a_7653_4996# vss sky130_fd_pr__nfet_01v8 ad=0.58 pd=4.29 as=0.58 ps=4.29 w=4 l=4
X193 a_22476_12949# a_22772_5019# vss sky130_fd_pr__res_high_po w=1 l=37.65
X194 vss vss a_810_9710# sky130_fd_pr__pnp_05v5_W3p40L3p40
**devattr s=462400,2720
X195 vdd vdd vss vdd sky130_fd_pr__pfet_01v8_lvt ad=1.16 pd=8.29 as=2.32 ps=16.58 w=8 l=4
X196 a_9593_3393# a_3119_13856# vdd vdd sky130_fd_pr__pfet_01v8_lvt ad=2.03 pd=14.29 as=2.03 ps=14.29 w=14 l=12
X197 vbg a_3119_13856# vdd vdd sky130_fd_pr__pfet_01v8_lvt ad=2.03 pd=14.29 as=2.03 ps=14.29 w=14 l=12
X198 vbg vdd vdd vdd sky130_fd_pr__pfet_01v8_lvt ad=4.06 pd=28.58 as=2.03 ps=14.29 w=14 l=12
X199 a_23980_12949# a_24276_5019# vss sky130_fd_pr__res_high_po w=1 l=37.65
X200 a_2233_3855# vgi vdd vdd sky130_fd_pr__pfet_01v8_lvt ad=1.16 pd=8.29 as=1.16 ps=8.29 w=8 l=4
X201 vdd a_3119_13856# a_5519_13953# vdd sky130_fd_pr__pfet_01v8_lvt ad=2.03 pd=14.29 as=2.03 ps=14.29 w=14 l=12
X202 a_18619_429# vbg vgi vss sky130_fd_pr__nfet_01v8 ad=0.87 pd=6.29 as=0.87 ps=6.29 w=6 l=4
X203 a_21884_12949# a_21588_5019# vss sky130_fd_pr__res_high_po w=1 l=37.65
X204 vss vbg sky130_fd_pr__cap_mim_m3_2 l=22.2 w=22.2
X205 a_23388_12949# a_22772_5019# vss sky130_fd_pr__res_high_po w=1 l=37.65
X206 vdd a_3119_13856# a_5519_16918# vdd sky130_fd_pr__pfet_01v8_lvt ad=2.03 pd=14.29 as=2.03 ps=14.29 w=14 l=12
X207 a_11300_13364# vss vdd vdd sky130_fd_pr__pfet_01v8 ad=0.1218 pd=1.42 as=0.1218 ps=1.42 w=0.42 l=20
X208 a_3119_13856# a_7153_4899# a_8677_3419# vdd sky130_fd_pr__pfet_01v8_lvt ad=1.74 pd=12.29 as=3.48 ps=24.58 w=12 l=2.5
X209 a_27600_13114# a_27304_5934# vss sky130_fd_pr__res_high_po w=1 l=33.9
X210 a_5519_13953# a_3119_13856# vdd vdd sky130_fd_pr__pfet_01v8_lvt ad=2.03 pd=14.29 as=2.03 ps=14.29 w=14 l=12
X211 vdd vgi i0 vdd sky130_fd_pr__pfet_01v8_lvt ad=1.16 pd=8.29 as=1.16 ps=8.29 w=8 l=4
C0 a_2233_3855# a_20040_13104# 0.00555f
C1 a_28488_13114# g4 0.00382f
C2 vbg a_24276_5019# 0.04524f
C3 a_2250_11080# a_7273_2383# 0.37543f
C4 a_2233_3855# a_2250_11080# 4.0216f
C5 vdd a_7273_2383# 5.0875f
C6 a_22180_5019# a_21588_5019# 0.15162f
C7 a_25232_5085# g4 0.503f
C8 a_5519_13953# a_8677_3419# 0.92193f
C9 a_27896_5934# a_25232_5085# 0.11857f
C10 a_2233_3855# vdd 9.25027f
C11 a_5519_16918# a_3119_13856# 11.4758f
C12 a_19477_429# a_7273_2383# 0.01843f
C13 a_17968_4864# vbg 0.03056f
C14 g3 g4 0.17479f
C15 a_7877_3393# a_17968_4864# 0.00196f
C16 a_2233_3855# a_19477_429# 3.90688f
C17 a_2233_3855# a_22476_12949# 0.01356f
C18 a_3119_13856# vgi 0.04746f
C19 a_8677_3419# a_10273_1327# 0.01666f
C20 a_20040_13104# a_18856_13104# 0.00955f
C21 a_17968_4864# a_18264_4864# 0.70798f
C22 a_25232_13115# a_29080_13115# 0.14982f
C23 a_7819_3419# a_7273_2383# 0.11826f
C24 a_20040_13104# a_810_9710# 0.1633f
C25 a_2233_3855# a_7819_3419# 0
C26 a_22180_5019# vgi 0.02652f
C27 a_2250_11080# a_810_9710# 0.28816f
C28 a_25232_13115# a_27304_5934# 0.0011f
C29 vdd a_18856_13104# 0.19055f
C30 g0 a_28784_10985# 0.0035f
C31 a_23980_12949# a_23388_12949# 0.15162f
C32 a_26416_13114# a_27008_13114# 0.15162f
C33 vdd a_810_9710# 0.56309f
C34 a_28488_13114# a_28784_10985# 2.78149f
C35 a_5519_16918# a_11300_13364# 0.56147f
C36 a_7215_2409# a_2250_11080# 0.14753f
C37 a_2250_11080# a_7095_4996# 0.00907f
C38 a_5130_11080# a_25232_13115# 0.02619f
C39 a_25232_5085# a_28784_10985# 0.00564f
C40 a_25232_13115# vbg 0.12313f
C41 a_22476_12949# a_810_9710# 0.3905f
C42 a_5519_16918# a_7153_4899# 0.27872f
C43 a_7215_2409# vdd 0.01235f
C44 a_2233_3855# a_7273_2383# 0.54468f
C45 a_7095_4996# vdd 5.58705f
C46 i0 i1 0.19879f
C47 a_23684_5019# a_25232_5085# 0
C48 g3 a_28784_10985# 0.00382f
C49 vgi a_7153_4899# 0.03811f
C50 a_9593_3393# a_5519_16918# 1.22636f
C51 vbg a_29080_13115# 0.05552f
C52 vdd a_27008_13114# 0.04729f
C53 a_7877_3393# a_7653_4996# 0.13202f
C54 vdd a_22772_5019# 1.15863f
C55 a_23684_5019# vgi 0.02652f
C56 a_9593_3393# vgi 0.06206f
C57 vbg a_27304_5934# 0.02393f
C58 a_7819_3419# a_7215_2409# 0
C59 a_25232_13115# a_8813_7656# 0.00231f
C60 a_7819_3419# a_7095_4996# 0.44816f
C61 a_5519_13953# a_2250_11080# 0.01145f
C62 vbg a_20632_4864# 0.00186f
C63 a_19477_429# a_22772_5019# 0.02498f
C64 g1 a_28784_10985# 0.49376f
C65 a_5519_13953# vdd 8.15171f
C66 a_2233_3855# a_18856_13104# 0.00555f
C67 vdd a_27600_13114# 0.07808f
C68 a_5130_11080# vbg 0.53683f
C69 a_18560_13104# a_5130_11080# 0.01234f
C70 a_7877_3393# a_5130_11080# 0.05097f
C71 a_19152_4864# vgi 0.13406f
C72 a_2250_11080# a_10273_1327# 0.14338f
C73 a_2233_3855# a_810_9710# 0.19818f
C74 a_18560_13104# vbg 0.2769f
C75 a_7877_3393# vbg 1.37511f
C76 a_18560_13104# a_7877_3393# 0
C77 a_5519_13953# a_19477_429# 0.00119f
C78 i0 vdd 1.76511f
C79 a_7653_4996# a_8813_7656# 1.06561f
C80 a_18264_4864# vbg 0.00977f
C81 a_7215_2409# a_7273_2383# 1.93509f
C82 a_7095_4996# a_7273_2383# 0.03538f
C83 a_7877_3393# a_18264_4864# 0
C84 vbg a_26120_5934# 0.02501f
C85 a_2233_3855# a_7215_2409# 0.98327f
C86 a_2233_3855# a_7095_4996# 0.00456f
C87 a_8677_3419# vgi 0.02258f
C88 a_5519_13953# a_7819_3419# 1.88126f
C89 i2 i1 0.30864f
C90 a_20040_13104# a_21884_12949# 0
C91 a_26712_5934# a_27304_5934# 0.15162f
C92 a_5130_11080# a_8813_7656# 0.57616f
C93 vbg a_8813_7656# 0.36047f
C94 a_7273_2383# a_22772_5019# 0.09335f
C95 i1 i3 0.1169f
C96 a_7877_3393# a_8813_7656# 0.80321f
C97 a_810_9710# a_18856_13104# 0.1633f
C98 a_2233_3855# a_27008_13114# 0.02038f
C99 a_7819_3419# a_10273_1327# 0
C100 a_2233_3855# a_22772_5019# 0.01751f
C101 vdd a_21884_12949# 0.02814f
C102 a_23684_5019# a_24276_5019# 0.15162f
C103 a_3119_13856# a_25232_13115# 0.03971f
C104 vbg a_26712_5934# 0.02027f
C105 a_25232_13115# g4 0.4633f
C106 a_5519_13953# a_7273_2383# 2.69861f
C107 a_22476_12949# a_21884_12949# 0.15162f
C108 a_27896_5934# a_25232_13115# 0.00557f
C109 a_2233_3855# a_5519_13953# 1.40619f
C110 a_19448_4864# a_21588_5019# 0
C111 a_7095_4996# a_810_9710# 0
C112 a_2233_3855# a_27600_13114# 0.1723f
C113 a_26712_5934# a_26120_5934# 0.15162f
C114 vgi i1 4.25644f
C115 a_10273_1327# a_7273_2383# 1.86177f
C116 a_3119_13856# a_7653_4996# 1.83188f
C117 vdd i2 2.2939f
C118 a_9593_3393# a_17968_4864# 0.0028f
C119 a_2233_3855# a_10273_1327# 0.98069f
C120 a_2250_11080# a_21588_5019# 0
C121 a_7215_2409# a_7095_4996# 0
C122 a_23980_12949# vdd 0.02814f
C123 vdd a_18619_429# 0.11201f
C124 vdd a_21588_5019# 0.45092f
C125 vdd i3 2.42324f
C126 a_27896_5934# a_27304_5934# 0.15162f
C127 a_28488_13114# vdd 0.14797f
C128 a_19448_4864# vgi 0.12582f
C129 a_19152_4864# a_17968_4864# 0.00346f
C130 a_5519_16918# a_2250_11080# 0.06929f
C131 a_5130_11080# a_3119_13856# 0.08647f
C132 a_19477_429# a_21588_5019# 0.02022f
C133 a_18619_429# a_19477_429# 1.19051f
C134 a_25232_5085# vdd 0.04328f
C135 a_5519_13953# a_810_9710# 0.32808f
C136 a_3119_13856# vbg 22.975f
C137 a_18560_13104# a_3119_13856# 0.06943f
C138 a_22180_5019# a_20632_4864# 0.01759f
C139 vbg g4 0
C140 a_7877_3393# a_3119_13856# 8.20056f
C141 a_5519_16918# vdd 6.97668f
C142 a_2233_3855# a_21884_12949# 0.01356f
C143 a_27896_5934# vbg 0.03614f
C144 a_2250_11080# vgi 0.58547f
C145 a_25232_13115# a_28784_10985# 0.41694f
C146 a_25232_5085# a_19477_429# 0.00749f
C147 a_25232_13115# a_23388_12949# 0
C148 vbg a_22180_5019# 0
C149 a_5519_13953# a_7215_2409# 0.00293f
C150 a_5519_13953# a_7095_4996# 0.9626f
C151 vgi vdd 0.13378p
C152 a_5519_16918# a_19477_429# 1.36668f
C153 a_25528_5934# vdd 0.01305f
C154 a_7653_4996# a_7153_4899# 4.19997f
C155 a_29080_13115# a_28784_10985# 2.29253f
C156 vgi a_19477_429# 6.57683f
C157 a_3119_13856# a_8813_7656# 1.15383f
C158 a_7819_3419# a_5519_16918# 0.00568f
C159 a_25528_5934# a_19477_429# 0
C160 a_7215_2409# a_10273_1327# 0.6074f
C161 g4 a_8813_7656# 0.05124f
C162 a_7095_4996# a_10273_1327# 0
C163 a_2233_3855# i2 0.10678f
C164 a_27008_13114# a_27600_13114# 0.15162f
C165 a_5130_11080# a_19744_13104# 0.01234f
C166 a_25824_13114# a_25232_13115# 0.47791f
C167 a_9593_3393# a_7653_4996# 0.00898f
C168 a_23980_12949# a_2233_3855# 0.01521f
C169 a_21588_5019# a_7273_2383# 0.06939f
C170 a_5130_11080# a_11300_13364# 0.06423f
C171 a_7819_3419# vgi 0.0238f
C172 a_21884_12949# a_810_9710# 0.29892f
C173 a_19744_13104# vbg 0.2666f
C174 a_18560_13104# a_19744_13104# 0.00342f
C175 a_2233_3855# a_18619_429# 2.70695f
C176 a_2233_3855# a_21588_5019# 0
C177 a_2233_3855# i3 0.12029f
C178 a_11300_13364# vbg 0.01098f
C179 a_2233_3855# a_28488_13114# 0.1536f
C180 a_7877_3393# a_11300_13364# 0.07606f
C181 a_23684_5019# a_20632_4864# 0
C182 vbg a_7153_4899# 0.12774f
C183 a_25232_5085# a_7273_2383# 0.79742f
C184 a_7877_3393# a_7153_4899# 0.71566f
C185 a_5130_11080# a_23388_12949# 0.18865f
C186 a_2233_3855# a_25232_5085# 0.00855f
C187 vbg a_28784_10985# 0.10749f
C188 a_5519_16918# a_7273_2383# 0.46541f
C189 vbg a_23388_12949# 0.03137f
C190 a_9593_3393# a_5130_11080# 0.05245f
C191 a_2233_3855# a_5519_16918# 1.15335f
C192 a_23684_5019# vbg 0
C193 a_9593_3393# vbg 4.15867f
C194 a_18560_13104# a_9593_3393# 0.15974f
C195 a_5519_13953# a_10273_1327# 0.00188f
C196 a_7877_3393# a_9593_3393# 6.45575f
C197 a_19152_4864# a_20632_4864# 0
C198 vgi a_7273_2383# 0.54728f
C199 a_25528_5934# a_7273_2383# 0.00375f
C200 a_8677_3419# a_7653_4996# 0.01481f
C201 a_11300_13364# a_8813_7656# 0.46994f
C202 a_2233_3855# vgi 6.42721f
C203 a_9593_3393# a_18264_4864# 0
C204 a_2233_3855# a_25528_5934# 0.0013f
C205 a_23980_12949# a_810_9710# 0.00289f
C206 a_24276_5019# vdd 0.339f
C207 a_7153_4899# a_8813_7656# 3.05131f
C208 a_5130_11080# a_25824_13114# 0
C209 a_810_9710# i3 0.00291f
C210 a_19152_4864# vbg 0.00156f
C211 a_25824_13114# vbg 0.01803f
C212 a_24276_5019# a_19477_429# 0.01751f
C213 a_17968_4864# a_2250_11080# 0.03303f
C214 a_19152_4864# a_18264_4864# 0.16105f
C215 a_9593_3393# a_8813_7656# 0.16055f
C216 a_8677_3419# a_5130_11080# 0.07025f
C217 a_17968_4864# vdd 0.15197f
C218 a_8677_3419# vbg 0
C219 a_5519_16918# a_810_9710# 0.05512f
C220 a_7877_3393# a_8677_3419# 2.39911f
C221 a_28488_13114# g2 0.49012f
C222 a_26416_13114# a_25232_13115# 0.32627f
C223 a_17968_4864# a_19477_429# 0
C224 vgi a_810_9710# 0.06586f
C225 a_25232_5085# g2 0.00214f
C226 a_21588_5019# a_22772_5019# 0.00206f
C227 a_28488_13114# a_27008_13114# 0
C228 a_7215_2409# vgi 0.22325f
C229 g2 g3 0.17479f
C230 a_7095_4996# vgi 0.00596f
C231 a_8677_3419# a_8813_7656# 7.84095f
C232 a_19744_13104# a_3119_13856# 0.06539f
C233 a_24276_5019# a_7273_2383# 0.0694f
C234 a_3119_13856# a_11300_13364# 0.33922f
C235 i0 i2 0.08307f
C236 a_2233_3855# a_24276_5019# 0.00827f
C237 a_28488_13114# a_27600_13114# 0
C238 a_3119_13856# a_7153_4899# 6.36299f
C239 a_25232_13115# vdd 0.11208f
C240 i0 i3 0.11689f
C241 a_3119_13856# a_23388_12949# 0.02311f
C242 vgi a_22772_5019# 0.03135f
C243 a_5519_13953# a_5519_16918# 0.4927f
C244 a_26416_13114# vbg 0.02354f
C245 g1 g2 0.17479f
C246 a_9593_3393# a_3119_13856# 7.60366f
C247 a_17968_4864# a_7273_2383# 0.02459f
C248 a_2250_11080# a_7653_4996# 1.01912f
C249 a_29080_13115# vdd 0.11941f
C250 a_2233_3855# a_17968_4864# 0.00393f
C251 a_7653_4996# vdd 1.5771f
C252 a_5519_13953# vgi 0.12262f
C253 a_19448_4864# vbg 0
C254 a_2250_11080# a_20632_4864# 0.20316f
C255 a_5130_11080# a_20040_13104# 0.01192f
C256 a_3119_13856# a_25824_13114# 0.03476f
C257 a_20040_13104# vbg 0.19042f
C258 i0 vgi 3.55482f
C259 vdd a_20632_4864# 2.06659f
C260 a_5130_11080# a_2250_11080# 0.21707f
C261 a_19448_4864# a_18264_4864# 0.01007f
C262 a_10273_1327# vgi 0.21612f
C263 a_2250_11080# vbg 0.34744f
C264 a_7877_3393# a_2250_11080# 0.00138f
C265 a_5130_11080# vdd 1.52278f
C266 a_11300_13364# a_7153_4899# 0.18348f
C267 a_20632_4864# a_19477_429# 0.11313f
C268 a_7819_3419# a_7653_4996# 0.01772f
C269 vbg vdd 29.5941f
C270 a_18560_13104# vdd 0.17697f
C271 a_8677_3419# a_3119_13856# 1.40349f
C272 a_7877_3393# vdd 4.48919f
C273 a_2250_11080# a_18264_4864# 0.04674f
C274 a_9593_3393# a_19744_13104# 0.00355f
C275 a_25232_13115# a_7273_2383# 0.21333f
C276 a_5130_11080# a_22476_12949# 0.11592f
C277 a_9593_3393# a_11300_13364# 0.07852f
C278 a_18264_4864# vdd 0.14273f
C279 a_2233_3855# a_25232_13115# 0.40986f
C280 vbg a_19477_429# 2.69051f
C281 a_22476_12949# vbg 0.02848f
C282 a_9593_3393# a_7153_4899# 0.97429f
C283 i2 i3 0.64746f
C284 a_24276_5019# a_22772_5019# 0.00206f
C285 a_2250_11080# a_8813_7656# 0.05656f
C286 a_18264_4864# a_19477_429# 0
C287 a_28488_13114# g0 0
C288 a_7819_3419# vbg 0
C289 a_7819_3419# a_7877_3393# 2.87072f
C290 a_2233_3855# a_29080_13115# 0.00213f
C291 a_7653_4996# a_7273_2383# 2.20308f
C292 vdd a_8813_7656# 42.2202f
C293 a_2233_3855# a_7653_4996# 0.18236f
C294 a_7273_2383# a_27304_5934# 0.08577f
C295 a_28488_13114# a_25232_5085# 2.213f
C296 a_19477_429# a_8813_7656# 0.02479f
C297 a_20632_4864# a_7273_2383# 0.08101f
C298 a_8677_3419# a_11300_13364# 0.01976f
C299 a_5519_16918# a_18619_429# 2.52593f
C300 a_2233_3855# a_20632_4864# 0.20932f
C301 vgi i2 5.45027f
C302 a_8677_3419# a_7153_4899# 5.07157f
C303 a_28488_13114# g3 0.49993f
C304 vbg a_7273_2383# 0.45923f
C305 a_26416_13114# a_3119_13856# 0.0342f
C306 a_2233_3855# a_5130_11080# 0.5243f
C307 a_7819_3419# a_8813_7656# 0.13896f
C308 a_7877_3393# a_7273_2383# 1.25838f
C309 vgi a_21588_5019# 0.03683f
C310 vgi i3 6.74686f
C311 vgi a_18619_429# 0.51562f
C312 a_2233_3855# vbg 4.74616f
C313 a_2233_3855# a_18560_13104# 0.02501f
C314 a_2233_3855# a_7877_3393# 0.05839f
C315 a_25232_5085# g3 0.4876f
C316 a_18264_4864# a_7273_2383# 0.04958f
C317 a_8677_3419# a_9593_3393# 0.99527f
C318 a_2233_3855# a_18264_4864# 0.00175f
C319 a_7273_2383# a_26120_5934# 0.06717f
C320 a_25232_5085# vgi 0
C321 a_25528_5934# a_25232_5085# 0.10674f
C322 a_25232_13115# g2 0
C323 g1 g0 0.17023f
C324 a_3119_13856# a_20040_13104# 0.0181f
C325 a_5519_16918# vgi 1.07512f
C326 g1 a_28488_13114# 0
C327 a_2250_11080# a_3119_13856# 0.05943f
C328 a_25232_13115# a_27008_13114# 0.32638f
C329 a_7273_2383# a_8813_7656# 3.12117f
C330 a_5130_11080# a_18856_13104# 0.01192f
C331 a_7215_2409# a_7653_4996# 4.05574f
C332 a_7653_4996# a_7095_4996# 0.92959f
C333 a_2233_3855# a_8813_7656# 0.3629f
C334 g1 a_25232_5085# 0.00292f
C335 g2 a_29080_13115# 0.00382f
C336 a_3119_13856# vdd 0.10561p
C337 vbg a_18856_13104# 0.17562f
C338 a_18560_13104# a_18856_13104# 0.70681f
C339 a_25528_5934# vgi 0.00194f
C340 vdd g4 0.10375f
C341 a_7877_3393# a_18856_13104# 0
C342 a_5130_11080# a_810_9710# 3.96918f
C343 vbg a_810_9710# 0.44609f
C344 a_18560_13104# a_810_9710# 0.12314f
C345 a_26712_5934# a_7273_2383# 0.08577f
C346 a_7877_3393# a_810_9710# 0.18636f
C347 a_3119_13856# a_22476_12949# 0.02108f
C348 a_22180_5019# vdd 0.39373f
C349 a_25232_13115# a_27600_13114# 0.32779f
C350 a_5130_11080# a_7095_4996# 0.00414f
C351 a_7877_3393# a_7215_2409# 0.00812f
C352 a_7877_3393# a_7095_4996# 0.17001f
C353 a_7819_3419# a_3119_13856# 0.00634f
C354 a_22180_5019# a_19477_429# 0.02022f
C355 a_19744_13104# a_20040_13104# 0.70681f
C356 g2 vbg 0.00148f
C357 a_20632_4864# a_22772_5019# 0.38324f
C358 a_5519_13953# a_7653_4996# 0.55231f
C359 a_8813_7656# a_810_9710# 0.01686f
C360 vbg a_27008_13114# 0.02409f
C361 vbg a_22772_5019# 0.00319f
C362 a_2250_11080# a_7153_4899# 0.00313f
C363 a_25232_5085# a_24276_5019# 0.0345f
C364 a_19744_13104# vdd 0.08672f
C365 a_11300_13364# vdd 3.07817f
C366 a_7653_4996# a_10273_1327# 3.00596f
C367 a_26416_13114# a_25824_13114# 0.15162f
C368 vdd a_7153_4899# 10.2477f
C369 a_7215_2409# a_8813_7656# 0.06732f
C370 a_7095_4996# a_8813_7656# 7.11489f
C371 a_5519_13953# a_5130_11080# 0.17066f
C372 a_3119_13856# a_7273_2383# 3.61604f
C373 vdd a_28784_10985# 0
C374 a_7273_2383# g4 0.10675f
C375 a_9593_3393# a_2250_11080# 0.00139f
C376 vdd a_23388_12949# 0.02814f
C377 a_5519_13953# vbg 1.29489f
C378 a_2233_3855# a_3119_13856# 5.13818f
C379 a_27896_5934# a_7273_2383# 0.06475f
C380 a_5519_13953# a_7877_3393# 1.57702f
C381 a_19152_4864# a_19448_4864# 0.70798f
C382 a_24276_5019# vgi 0.00804f
C383 vbg a_27600_13114# 0.01653f
C384 a_23684_5019# vdd 0.39662f
C385 a_19477_429# a_7153_4899# 0
C386 a_9593_3393# vdd 4.13646f
C387 a_22180_5019# a_7273_2383# 0.06939f
C388 a_22476_12949# a_23388_12949# 0.02234f
C389 a_17968_4864# a_5519_16918# 0.00143f
C390 a_2233_3855# a_22180_5019# 0
C391 a_23684_5019# a_19477_429# 0.02022f
C392 a_19152_4864# a_2250_11080# 0.0268f
C393 a_7819_3419# a_7153_4899# 0.09684f
C394 a_7877_3393# a_10273_1327# 0.00814f
C395 a_19152_4864# vdd 0.34317f
C396 a_17968_4864# vgi 0.03292f
C397 a_25824_13114# vdd 0.04729f
C398 a_5519_13953# a_8813_7656# 1.58519f
C399 a_23980_12949# a_25232_13115# 0
C400 a_3119_13856# a_18856_13104# 0.01825f
C401 a_7819_3419# a_9593_3393# 2.70423f
C402 a_25232_13115# g0 0
C403 a_8677_3419# a_2250_11080# 0.00516f
C404 a_19152_4864# a_19477_429# 0.02f
C405 a_28488_13114# a_25232_13115# 0.84429f
C406 a_3119_13856# a_810_9710# 0.1763f
C407 a_5130_11080# a_21884_12949# 0.11398f
C408 a_11300_13364# a_7273_2383# 0.00405f
C409 a_8677_3419# vdd 5.88037f
C410 vbg a_21884_12949# 0.20088f
C411 a_2233_3855# a_19744_13104# 0.02501f
C412 a_2233_3855# a_11300_13364# 0.20412f
C413 a_10273_1327# a_8813_7656# 0.75128f
C414 a_7273_2383# a_7153_4899# 0.65284f
C415 a_25232_13115# a_25232_5085# 2.68094f
C416 a_29080_13115# g0 0.50889f
C417 a_2233_3855# a_7153_4899# 0.06483f
C418 a_28488_13114# a_29080_13115# 0.6362f
C419 a_7215_2409# a_3119_13856# 0.23941f
C420 a_5519_16918# a_25232_13115# 0
C421 a_3119_13856# a_7095_4996# 0.88167f
C422 a_2233_3855# a_23388_12949# 0.01521f
C423 a_23684_5019# a_7273_2383# 0.06939f
C424 a_25232_13115# g3 0
C425 a_9593_3393# a_7273_2383# 0.93446f
C426 a_2233_3855# a_23684_5019# 0.00559f
C427 a_25232_5085# a_29080_13115# 0.00579f
C428 a_2233_3855# a_9593_3393# 0.06598f
C429 a_7819_3419# a_8677_3419# 1.60379f
C430 a_20632_4864# a_21588_5019# 0.03432f
C431 a_3119_13856# a_27008_13114# 0.03419f
C432 a_23980_12949# a_5130_11080# 0.35037f
C433 a_19744_13104# a_18856_13104# 0.16058f
C434 a_25232_5085# a_27304_5934# 0.10674f
C435 a_23980_12949# vbg 0.02765f
C436 a_19152_4864# a_7273_2383# 0.02357f
C437 vbg g0 0.00133f
C438 a_19744_13104# a_810_9710# 0.12314f
C439 vbg a_18619_429# 2.4372f
C440 a_2233_3855# a_19152_4864# 0.00255f
C441 vbg a_21588_5019# 0
C442 a_11300_13364# a_810_9710# 0.14476f
C443 a_28488_13114# vbg 0.09259f
C444 g1 a_25232_13115# 0
C445 a_2233_3855# a_25824_13114# 0.02034f
C446 vdd i1 1.86485f
C447 a_7653_4996# vgi 1.0391f
C448 a_22180_5019# a_22772_5019# 0.1674f
C449 a_5519_13953# a_3119_13856# 16.2379f
C450 a_3119_13856# a_27600_13114# 0.00284f
C451 a_25232_5085# vbg 0.2188f
C452 a_26416_13114# vdd 0.04729f
C453 a_23388_12949# a_810_9710# 0.09698f
C454 a_8677_3419# a_7273_2383# 0.26675f
C455 a_5130_11080# a_5519_16918# 0.05292f
C456 a_9593_3393# a_18856_13104# 0.00889f
C457 a_2233_3855# a_8677_3419# 0.11774f
C458 a_2250_11080# a_19448_4864# 0.22673f
C459 vgi a_20632_4864# 0.0469f
C460 a_5519_16918# vbg 1.96229f
C461 a_18560_13104# a_5519_16918# 0
C462 g1 a_29080_13115# 0.50436f
C463 a_9593_3393# a_810_9710# 0.1244f
C464 a_7877_3393# a_5519_16918# 3.04844f
C465 a_7215_2409# a_7153_4899# 0
C466 a_7095_4996# a_7153_4899# 5.38482f
C467 a_3119_13856# a_10273_1327# 0.46821f
C468 vbg g3 0.0036f
C469 a_19448_4864# vdd 0.524f
C470 a_25232_5085# a_26120_5934# 0.10674f
C471 a_5519_16918# a_18264_4864# 0
C472 a_18619_429# a_8813_7656# 0.17334f
C473 vbg vgi 5.03826f
C474 a_28488_13114# a_8813_7656# 0
C475 a_7877_3393# vgi 0.06801f
C476 a_20040_13104# vdd 0.04514f
C477 a_25528_5934# vbg 0.06879f
C478 g2 a_28784_10985# 0.50156f
C479 a_9593_3393# a_7215_2409# 0.00616f
C480 a_9593_3393# a_7095_4996# 2.52856f
C481 a_19448_4864# a_19477_429# 0.01366f
C482 a_2250_11080# vdd 3.8596f
C483 a_18264_4864# vgi 0.05451f
C484 a_25232_5085# a_8813_7656# 0.0162f
C485 a_25528_5934# a_26120_5934# 0.15162f
C486 a_5519_16918# a_8813_7656# 1.26891f
C487 g1 vbg 0
C488 a_3119_13856# a_21884_12949# 0.02311f
C489 a_5519_13953# a_11300_13364# 1.10703f
C490 a_2250_11080# a_19477_429# 0.04305f
C491 a_23684_5019# a_22772_5019# 0.1674f
C492 a_25232_5085# a_26712_5934# 0.10674f
C493 a_8677_3419# a_810_9710# 0.06144f
C494 a_5519_13953# a_7153_4899# 1.78841f
C495 vdd a_19477_429# 25.6244f
C496 a_22476_12949# vdd 0.03021f
C497 vgi a_8813_7656# 0.1727f
C498 a_2233_3855# i1 0.01535f
C499 a_7819_3419# a_2250_11080# 0
C500 a_2233_3855# a_26416_13114# 0.02035f
C501 a_8677_3419# a_7215_2409# 0.01321f
C502 a_5519_13953# a_9593_3393# 2.02309f
C503 a_8677_3419# a_7095_4996# 2.42997f
C504 a_10273_1327# a_7153_4899# 0.14609f
C505 a_7819_3419# vdd 0.039f
C506 a_19448_4864# a_7273_2383# 0.04949f
C507 a_24276_5019# a_20632_4864# 0
C508 a_2233_3855# a_19448_4864# 0
C509 a_23980_12949# a_3119_13856# 0.02309f
C510 a_9593_3393# a_10273_1327# 0.00623f
C511 g4 vss 1.07525f
C512 g3 vss 1.00604f
C513 g2 vss 1.01165f
C514 g1 vss 1.02274f
C515 g0 vss 1.78147f
C516 i2 vss 0.14343f
C517 i3 vss 0.58216f
C518 vgi vss 14.11f
C519 vbg vss 0.27192p
C520 vdd vss 1.04105p
C521 a_18619_429# vss 1.6556f
C522 a_19477_429# vss 3.69156f
C523 a_10273_1327# vss 1.36f
C524 a_7215_2409# vss 2.47473f
C525 a_7819_3419# vss 1.72027f
C526 a_7273_2383# vss 20.3527f
C527 a_25232_5085# vss 8.76762f
C528 a_28784_10985# vss 6.0718f
C529 a_29080_13115# vss 6.67795f
C530 a_28488_13114# vss 4.95035f
C531 a_27896_5934# vss 1.13951f
C532 a_27600_13114# vss 0.71477f
C533 a_27304_5934# vss 0.84576f
C534 a_27008_13114# vss 0.71391f
C535 a_26712_5934# vss 0.84236f
C536 a_26416_13114# vss 0.71391f
C537 a_26120_5934# vss 0.8799f
C538 a_25824_13114# vss 0.724f
C539 a_25528_5934# vss 1.21354f
C540 a_25232_13115# vss 7.68728f
C541 a_24276_5019# vss 0.72166f
C542 a_23980_12949# vss 0.82416f
C543 a_23684_5019# vss 0.59943f
C544 a_23388_12949# vss 0.85838f
C545 a_22772_5019# vss 0.82932f
C546 a_22476_12949# vss 0.82987f
C547 a_22180_5019# vss 0.59943f
C548 a_21884_12949# vss 0.7602f
C549 a_21588_5019# vss 0.76709f
C550 a_20632_4864# vss 1.32023f
C551 a_20040_13104# vss 0.70376f
C552 a_19744_13104# vss 0.66203f
C553 a_19448_4864# vss 0.52597f
C554 a_19152_4864# vss 0.66087f
C555 a_18856_13104# vss 0.47458f
C556 a_18560_13104# vss 0.61933f
C557 a_18264_4864# vss 0.55029f
C558 a_17968_4864# vss 0.87228f
C559 a_7653_4996# vss 22.6017f
C560 a_7153_4899# vss 1.3453f
C561 a_8677_3419# vss 1.22124f
C562 a_7095_4996# vss 0.32261f
C563 a_8813_7656# vss 11.6259f
C564 a_2233_3855# vss 9.92412f
C565 a_5130_11080# vss 4.04287f
C566 a_2250_11080# vss 6.295f
C567 a_11300_13364# vss 2.55656f
C568 a_810_9710# vss 8.79329f
C569 a_5519_13953# vss 11.3901f
C570 a_7877_3393# vss 3.95058f
C571 a_9593_3393# vss 3.94177f
C572 a_5519_16918# vss 8.23898f
C573 a_3119_13856# vss 19.8647f
.ends
