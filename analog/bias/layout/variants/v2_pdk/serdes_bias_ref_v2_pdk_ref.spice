* BIAS v2 serdes_bias_ref_v2_pdk (Folded-cascode BG + V->I + stacked MIM1+MIM2)
.subckt serdes_bias_ref_v2_pdk vbg i0 i1 i2 i3 vgi g4 g3 g2 g1 g0 vdd vss
Xm1 ta vg vdd vdd sky130_fd_pr__pfet_01v8_lvt w=56 l=12
Xm2 tb vg vdd vdd sky130_fd_pr__pfet_01v8_lvt w=56 l=12
Xm3 vbg vg vdd vdd sky130_fd_pr__pfet_01v8_lvt w=56 l=12
Xm4 nb vg vdd vdd sky130_fd_pr__pfet_01v8_lvt w=56 l=12
Xm5 nb2 vg vdd vdd sky130_fd_pr__pfet_01v8_lvt w=56 l=12
Xrsa0 ta rsa1 vss sky130_fd_pr__res_high_po w=1 l=39.200
Xrsa1 rsa1 rsa2 vss sky130_fd_pr__res_high_po w=1 l=39.200
Xrsa2 rsa2 rsa3 vss sky130_fd_pr__res_high_po w=1 l=39.200
Xrsa3 rsa3 rsa4 vss sky130_fd_pr__res_high_po w=1 l=39.200
Xrsa4 rsa4 a vss sky130_fd_pr__res_high_po w=1 l=39.200
Xrsb0 tb rsb1 vss sky130_fd_pr__res_high_po w=1 l=39.200
Xrsb1 rsb1 rsb2 vss sky130_fd_pr__res_high_po w=1 l=39.200
Xrsb2 rsb2 rsb3 vss sky130_fd_pr__res_high_po w=1 l=39.200
Xrsb3 rsb3 rsb4 vss sky130_fd_pr__res_high_po w=1 l=39.200
Xrsb4 rsb4 b vss sky130_fd_pr__res_high_po w=1 l=39.200
Xq1 vss vss a sky130_fd_pr__pnp_05v5_W3p40L3p40
Xq2_0 vss vss c sky130_fd_pr__pnp_05v5_W3p40L3p40
Xq2_1 vss vss c sky130_fd_pr__pnp_05v5_W3p40L3p40
Xq2_2 vss vss c sky130_fd_pr__pnp_05v5_W3p40L3p40
Xq2_3 vss vss c sky130_fd_pr__pnp_05v5_W3p40L3p40
Xq2_4 vss vss c sky130_fd_pr__pnp_05v5_W3p40L3p40
Xq2_5 vss vss c sky130_fd_pr__pnp_05v5_W3p40L3p40
Xq2_6 vss vss c sky130_fd_pr__pnp_05v5_W3p40L3p40
Xq2_7 vss vss c sky130_fd_pr__pnp_05v5_W3p40L3p40
Xq3 vss vss d sky130_fd_pr__pnp_05v5_W3p40L3p40
Xr1 b c vss sky130_fd_pr__res_high_po w=1 l=39.790
Xr2_0 vbg r2_1 vss sky130_fd_pr__res_high_po w=1 l=37.650
Xr2_1 r2_1 r2_2 vss sky130_fd_pr__res_high_po w=1 l=37.650
Xr2_2 r2_2 r2_3 vss sky130_fd_pr__res_high_po w=1 l=37.650
Xr2_3 r2_3 r2_4 vss sky130_fd_pr__res_high_po w=1 l=37.650
Xr2_4 r2_4 r2_5 vss sky130_fd_pr__res_high_po w=1 l=37.650
Xr2_5 r2_5 r2_6 vss sky130_fd_pr__res_high_po w=1 l=37.650
Xr2_6 r2_6 r2_7 vss sky130_fd_pr__res_high_po w=1 l=37.650
Xr2_7 r2_7 r2_8 vss sky130_fd_pr__res_high_po w=1 l=37.650
Xr2_8 r2_8 r2_9 vss sky130_fd_pr__res_high_po w=1 l=37.650
Xr2_9 r2_9 d vss sky130_fd_pr__res_high_po w=1 l=37.650
Xbd nb nb vss vss sky130_fd_pr__nfet_01v8 w=6 l=4
Xfc_t fc_tail nb vss vss sky130_fd_pr__nfet_01v8 w=6 l=4
Xfc_a fc_fa ta fc_tail vss sky130_fd_pr__nfet_01v8 w=24 l=4
Xfc_b fc_fb tb fc_tail vss sky130_fd_pr__nfet_01v8 w=24 l=4
Xfc_ab_dl fc_tail vss vss vss sky130_fd_pr__nfet_01v8 w=6 l=4
Xfc_ab_dr fc_tail vss vss vss sky130_fd_pr__nfet_01v8 w=6 l=4
Xfc_nbp vbp_src nb vss vss sky130_fd_pr__nfet_01v8 w=3 l=4
Xfc_pb vbp_src vbp_src vdd vdd sky130_fd_pr__pfet_01v8_lvt w=24 l=8
Xfc_nbpc vbp_c nb vss vss sky130_fd_pr__nfet_01v8 w=3 l=4
Xfc_pbc vbp_c vbp_c vdd vdd sky130_fd_pr__pfet_01v8_lvt w=3 l=4
Xfc_pbnc vbn_c vbp_src vdd vdd sky130_fd_pr__pfet_01v8_lvt w=24 l=8
Xfc_nbc vbn_c vbn_c vss vss sky130_fd_pr__nfet_01v8 w=1.5 l=10
Xfc_fa fc_fa vbp_src vdd vdd sky130_fd_pr__pfet_01v8_lvt w=48 l=8
Xfc_fb fc_fb vbp_src vdd vdd sky130_fd_pr__pfet_01v8_lvt w=48 l=8
Xfc_pca fc_da vbp_c fc_fb vdd sky130_fd_pr__pfet_01v8_lvt w=48 l=2.5
Xfc_pcb vg vbp_c fc_fa vdd sky130_fd_pr__pfet_01v8_lvt w=48 l=2.5
Xfc_nca fc_da vbn_c fc_na vss sky130_fd_pr__nfet_01v8 w=16 l=4
Xfc_ncb vg vbn_c fc_nbn vss sky130_fd_pr__nfet_01v8 w=16 l=4
Xfc_na fc_na fc_da vss vss sky130_fd_pr__nfet_01v8 w=16 l=8
Xfc_nb fc_nbn fc_da vss vss sky130_fd_pr__nfet_01v8 w=16 l=8
Xfc_nm_d vss vss vss vss sky130_fd_pr__nfet_01v8 w=16 l=8
Xsp st vss vdd vdd sky130_fd_pr__pfet_01v8 w=0.42 l=20
Xsn st nb vss vss sky130_fd_pr__nfet_01v8 w=2 l=1
Xsu vg st vss vss sky130_fd_pr__nfet_01v8 w=1 l=1
Xbd2 nb2 nb2 vss vss sky130_fd_pr__nfet_01v8 w=6 l=4
Xota_t ota_tail nb2 vss vss sky130_fd_pr__nfet_01v8 w=1 l=6
Xota_a ota_da s ota_tail vss sky130_fd_pr__nfet_01v8 w=24 l=4
Xota_b vgi vbg ota_tail vss sky130_fd_pr__nfet_01v8 w=24 l=4
Xota_ab_dl ota_tail vss vss vss sky130_fd_pr__nfet_01v8 w=6 l=4
Xota_ab_dr ota_tail vss vss vss sky130_fd_pr__nfet_01v8 w=6 l=4
Xota_la ota_da ota_da vdd vdd sky130_fd_pr__pfet_01v8_lvt w=24 l=8
Xota_lb vgi ota_da vdd vdd sky130_fd_pr__pfet_01v8_lvt w=24 l=8
Xk vgi vbg s vss sky130_fd_pr__nfet_01v8_lvt w=2 l=4
Xmv s vgi vdd vdd sky130_fd_pr__pfet_01v8_lvt w=32 l=4
Xo0 i0 vgi vdd vdd sky130_fd_pr__pfet_01v8_lvt w=32 l=4
Xo1 i1 vgi vdd vdd sky130_fd_pr__pfet_01v8_lvt w=32 l=4
Xo2 i2 vgi vdd vdd sky130_fd_pr__pfet_01v8_lvt w=32 l=4
Xo3 i3 vgi vdd vdd sky130_fd_pr__pfet_01v8_lvt w=32 l=4
Xmv_dum0 vss vdd vdd vdd sky130_fd_pr__pfet_01v8_lvt w=8 l=4
Xmv_dum1 vss vdd vdd vdd sky130_fd_pr__pfet_01v8_lvt w=8 l=4
Xmv_dum2 vss vdd vdd vdd sky130_fd_pr__pfet_01v8_lvt w=8 l=4
Xmv_dum3 vss vdd vdd vdd sky130_fd_pr__pfet_01v8_lvt w=8 l=4
Xmv_dum4 vss vdd vdd vdd sky130_fd_pr__pfet_01v8_lvt w=8 l=4
Xmv_dum5 vss vdd vdd vdd sky130_fd_pr__pfet_01v8_lvt w=8 l=4
Xmv_dum6 vss vdd vdd vdd sky130_fd_pr__pfet_01v8_lvt w=8 l=4
Xmv_dum7 vss vdd vdd vdd sky130_fd_pr__pfet_01v8_lvt w=8 l=4
Xmv_dum8 vss vdd vdd vdd sky130_fd_pr__pfet_01v8_lvt w=8 l=4
Xmv_dum9 vss vdd vdd vdd sky130_fd_pr__pfet_01v8_lvt w=8 l=4
Xpl_dum vdd vdd vdd vdd sky130_fd_pr__pfet_01v8_lvt w=72 l=8
Xxm_dum vbg vdd vdd vdd sky130_fd_pr__pfet_01v8_lvt w=56 l=12
Xrref0 s rr1 vss sky130_fd_pr__res_high_po w=1 l=33.900
Xrref1 rr1 rr2 vss sky130_fd_pr__res_high_po w=1 l=33.900
Xrref2 rr2 rr3 vss sky130_fd_pr__res_high_po w=1 l=33.900
Xrref3 rr3 rr4 vss sky130_fd_pr__res_high_po w=1 l=33.900
Xrref4 rr4 rr5 vss sky130_fd_pr__res_high_po w=1 l=33.900
Xrref5 rr5 rr6 vss sky130_fd_pr__res_high_po w=1 l=33.900
Xrref6 rr6 rr7 vss sky130_fd_pr__res_high_po w=1 l=33.900
Xrref7 rr7 rr8 vss sky130_fd_pr__res_high_po w=1 l=33.900
Xrref8 rr8 rr9 vss sky130_fd_pr__res_high_po w=1 l=33.900
Xrref9 rr9 rt5 vss sky130_fd_pr__res_high_po w=1 l=33.900
Xrt4 rt5 rt4 vss sky130_fd_pr__res_high_po w=1 l=38.150
Xrt3 rt4 rt3 vss sky130_fd_pr__res_high_po w=1 l=18.480
Xrt2 rt3 rt2 vss sky130_fd_pr__res_high_po w=1 l=8.645
Xrt1 rt2 rt1 vss sky130_fd_pr__res_high_po w=1 l=3.725
Xrt0 rt1 vss vss sky130_fd_pr__res_high_po w=1 l=1.265
Xs4 rt5 g4 rt4 vss sky130_fd_pr__nfet_01v8 w=20 l=0.18
Xs3 rt4 g3 rt3 vss sky130_fd_pr__nfet_01v8 w=20 l=0.18
Xs2 rt3 g2 rt2 vss sky130_fd_pr__nfet_01v8 w=20 l=0.18
Xs1 rt2 g1 rt1 vss sky130_fd_pr__nfet_01v8 w=20 l=0.18
Xs0 rt1 g0 vss vss sky130_fd_pr__nfet_01v8 w=20 l=0.18
Xcbg1_0 vbg vss sky130_fd_pr__cap_mim_m3_1 w=22.1965 l=22.1965
Xcbg2_0 vss vbg sky130_fd_pr__cap_mim_m3_2 w=22.1965 l=22.1965
Xcbg1_1 vbg vss sky130_fd_pr__cap_mim_m3_1 w=22.1965 l=22.1965
Xcbg2_1 vss vbg sky130_fd_pr__cap_mim_m3_2 w=22.1965 l=22.1965
Xcbg1_2 vbg vss sky130_fd_pr__cap_mim_m3_1 w=22.1965 l=22.1965
Xcbg2_2 vss vbg sky130_fd_pr__cap_mim_m3_2 w=22.1965 l=22.1965
Xcgi1 vgi vdd sky130_fd_pr__cap_mim_m3_1 w=22.1965 l=22.1965
Xcgi2 vdd vgi sky130_fd_pr__cap_mim_m3_2 w=22.1965 l=22.1965
.ends serdes_bias_ref_v2_pdk
