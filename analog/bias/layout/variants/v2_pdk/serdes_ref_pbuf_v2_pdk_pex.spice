* NGSPICE file created from serdes_ref_pbuf_v2_pdk.ext - technology: sky130A

.subckt serdes_ref_pbuf_v2_pdk iin ibias out en c0 c1 c2 c3 vdd vss
X0 vss en a_18877_1769# vss sky130_fd_pr__nfet_01v8 ad=0.75 pd=5.3 as=0.75 ps=5.3 w=5 l=0.18
X1 a_18877_1769# en vss vss sky130_fd_pr__nfet_01v8 ad=0.75 pd=5.3 as=1.475 ps=10.59 w=5 l=0.18
X2 vss a_7147_10701# a_11664_10479# vss sky130_fd_pr__nfet_01v8 ad=0.29 pd=2.58 as=0.29 ps=2.58 w=1 l=0.18
X3 a_4548_8000# a_4844_6128# vss sky130_fd_pr__res_high_po w=1 l=7.36
X4 vss a_11664_10479# a_12704_10479# vss sky130_fd_pr__nfet_01v8 ad=0.29 pd=2.58 as=0.29 ps=2.58 w=1 l=0.18
X5 vss en a_18877_1769# vss sky130_fd_pr__nfet_01v8 ad=1.475 pd=10.59 as=0.75 ps=5.3 w=5 l=0.18
X6 a_18877_1769# en vss vss sky130_fd_pr__nfet_01v8 ad=0.75 pd=5.3 as=0.75 ps=5.3 w=5 l=0.18
X7 a_3956_2480# a_4252_608# vss sky130_fd_pr__res_high_po w=1 l=7.36
X8 a_9478_4176# a_7147_3381# a_9384_3159# vdd sky130_fd_pr__pfet_01v8 ad=1.16 pd=8.58 as=1.16 ps=8.58 w=4 l=0.18
X9 a_4548_5240# a_4844_3368# vss sky130_fd_pr__res_high_po w=1 l=7.36
X10 a_18877_1769# en vss vss sky130_fd_pr__nfet_01v8 ad=0.75 pd=5.3 as=0.75 ps=5.3 w=5 l=0.18
X11 vss en a_18877_1769# vss sky130_fd_pr__nfet_01v8 ad=0.75 pd=5.3 as=0.75 ps=5.3 w=5 l=0.18
X12 ibias ibias vss vss sky130_fd_pr__nfet_01v8 ad=0.29 pd=2.58 as=0.29 ps=2.58 w=1 l=1
X13 out out a_18619_4169# vss sky130_fd_pr__nfet_01v8_lvt ad=0.87 pd=6.29 as=0.87 ps=6.29 w=6 l=1
X14 a_8858_3159# a_9384_10479# a_4548_8000# vss sky130_fd_pr__nfet_01v8 ad=0.29 pd=2.58 as=0.29 ps=2.58 w=1 l=0.18
X15 a_8858_3159# a_13944_10479# iin vss sky130_fd_pr__nfet_01v8 ad=0.29 pd=2.58 as=0.29 ps=2.58 w=1 l=0.18
X16 vss vss vss sky130_fd_pr__res_high_po w=1 l=36.55
X17 a_3956_8000# a_3956_6128# vss sky130_fd_pr__res_high_po w=1 l=7.36
X18 vss c1 a_7304_719# vss sky130_fd_pr__nfet_01v8 ad=0.29 pd=2.58 as=0.29 ps=2.58 w=1 l=0.18
X19 a_4548_2480# a_4252_608# vss sky130_fd_pr__res_high_po w=1 l=7.36
X20 vss a_10864_619# a_11664_3159# vss sky130_fd_pr__nfet_01v8 ad=0.29 pd=2.58 as=0.29 ps=2.58 w=1 l=0.18
X21 vdd a_7784_719# a_7147_8261# vdd sky130_fd_pr__pfet_01v8 ad=0.58 pd=4.58 as=0.58 ps=4.58 w=2 l=0.18
X22 vss a_7147_10701# a_13944_10479# vss sky130_fd_pr__nfet_01v8 ad=0.29 pd=2.58 as=0.29 ps=2.58 w=1 l=0.18
X23 a_17645_7756# a_17645_7756# vdd vdd sky130_fd_pr__pfet_01v8_lvt ad=0.87 pd=6.29 as=0.87 ps=6.29 w=6 l=1
X24 a_8858_3159# a_7104_5599# a_4844_608# vss sky130_fd_pr__nfet_01v8 ad=0.29 pd=2.58 as=0.29 ps=2.58 w=1 l=0.18
X25 vss c2 a_7784_719# vss sky130_fd_pr__nfet_01v8 ad=0.29 pd=2.58 as=0.29 ps=2.58 w=1 l=0.18
X26 a_8858_3159# a_13944_3159# a_4548_2480# vss sky130_fd_pr__nfet_01v8 ad=0.29 pd=2.58 as=0.29 ps=2.58 w=1 l=0.18
X27 vss a_13944_10479# a_14984_10479# vss sky130_fd_pr__nfet_01v8 ad=0.29 pd=2.58 as=0.29 ps=2.58 w=1 l=0.18
X28 a_7198_9056# a_7147_8261# a_7104_8039# vdd sky130_fd_pr__pfet_01v8 ad=1.16 pd=8.58 as=1.16 ps=8.58 w=4 l=0.18
X29 vdd vdd vdd vdd sky130_fd_pr__pfet_01v8_lvt ad=0.87 pd=6.29 as=77.72 ps=578.91998 w=6 l=1
X30 a_3956_5240# a_3956_3368# vss sky130_fd_pr__res_high_po w=1 l=7.36
X31 a_2262_8839# a_1966_1129# vss sky130_fd_pr__res_high_po w=1 l=36.55
X32 vdd a_9817_3381# a_9478_9056# vdd sky130_fd_pr__pfet_01v8 ad=1.16 pd=8.58 as=1.16 ps=8.58 w=4 l=0.18
X33 vdd c2 a_7784_719# vdd sky130_fd_pr__pfet_01v8 ad=0.58 pd=4.58 as=0.58 ps=4.58 w=2 l=0.18
X34 vss a_11664_3159# a_12704_3159# vss sky130_fd_pr__nfet_01v8 ad=0.29 pd=2.58 as=0.29 ps=2.58 w=1 l=0.18
X35 a_18619_4169# ibias a_18877_1769# vss sky130_fd_pr__nfet_01v8 ad=0.725 pd=5.29 as=1.45 ps=10.58 w=5 l=1
X36 vdd c0 a_9817_3381# vdd sky130_fd_pr__pfet_01v8 ad=0.58 pd=4.58 as=0.58 ps=4.58 w=2 l=0.18
X37 a_1078_8839# a_1374_1129# vss sky130_fd_pr__res_high_po w=1 l=36.55
X38 a_2262_8839# a_2558_1129# vss sky130_fd_pr__res_high_po w=1 l=36.55
X39 a_8858_3159# a_11664_8039# a_3956_6128# vss sky130_fd_pr__nfet_01v8 ad=0.29 pd=2.58 as=0.29 ps=2.58 w=1 l=0.18
X40 a_8858_3159# a_12704_5599# a_3956_5240# vdd sky130_fd_pr__pfet_01v8 ad=0.58 pd=4.58 as=0.58 ps=4.58 w=2 l=0.18
X41 vss a_7104_5599# a_8144_5599# vss sky130_fd_pr__nfet_01v8 ad=0.29 pd=2.58 as=0.29 ps=2.58 w=1 l=0.18
X42 a_8858_3159# a_8144_3159# a_782_8839# vdd sky130_fd_pr__pfet_01v8 ad=0.58 pd=4.58 as=0.58 ps=4.58 w=2 l=0.18
X43 vss a_13944_3159# a_14984_3159# vss sky130_fd_pr__nfet_01v8 ad=0.29 pd=2.58 as=0.29 ps=2.58 w=1 l=0.18
X44 vdd a_11684_619# a_14038_4176# vdd sky130_fd_pr__pfet_01v8 ad=1.16 pd=8.58 as=1.16 ps=8.58 w=4 l=0.18
X45 vss a_7147_8261# a_11664_8039# vss sky130_fd_pr__nfet_01v8 ad=0.29 pd=2.58 as=0.29 ps=2.58 w=1 l=0.18
X46 vdd a_8264_719# a_7147_3381# vdd sky130_fd_pr__pfet_01v8 ad=0.58 pd=4.58 as=0.58 ps=4.58 w=2 l=0.18
X47 a_11758_11496# a_7147_10701# a_11664_10479# vdd sky130_fd_pr__pfet_01v8 ad=1.16 pd=8.58 as=1.16 ps=8.58 w=4 l=0.18
X48 vss a_9384_8039# a_10424_8039# vss sky130_fd_pr__nfet_01v8 ad=0.29 pd=2.58 as=0.29 ps=2.58 w=1 l=0.18
X49 vss a_7147_8261# a_13944_8039# vss sky130_fd_pr__nfet_01v8 ad=0.29 pd=2.58 as=0.29 ps=2.58 w=1 l=0.18
X50 vdd a_17645_7756# out vdd sky130_fd_pr__pfet_01v8_lvt ad=0.87 pd=6.29 as=0.87 ps=6.29 w=6 l=1
X51 vdd a_9384_5599# a_10424_5599# vdd sky130_fd_pr__pfet_01v8 ad=0.58 pd=4.58 as=0.58 ps=4.58 w=2 l=0.18
X52 vdd a_17645_7756# a_17645_7756# vdd sky130_fd_pr__pfet_01v8_lvt ad=0.87 pd=6.29 as=0.87 ps=6.29 w=6 l=1
X53 vdd a_17645_7756# out vdd sky130_fd_pr__pfet_01v8_lvt ad=0.87 pd=6.29 as=0.87 ps=6.29 w=6 l=1
X54 a_17645_7756# a_17645_7756# vdd vdd sky130_fd_pr__pfet_01v8_lvt ad=0.87 pd=6.29 as=0.87 ps=6.29 w=6 l=1
X55 vdd a_7104_3159# a_8144_3159# vdd sky130_fd_pr__pfet_01v8 ad=0.58 pd=4.58 as=0.58 ps=4.58 w=2 l=0.18
X56 vdd a_7304_719# a_7537_3381# vdd sky130_fd_pr__pfet_01v8 ad=0.58 pd=4.58 as=0.58 ps=4.58 w=2 l=0.18
X57 a_8858_3159# a_9384_8039# a_4844_3368# vss sky130_fd_pr__nfet_01v8 ad=0.29 pd=2.58 as=0.29 ps=2.58 w=1 l=0.18
X58 a_8858_3159# a_10424_5599# a_3956_3368# vdd sky130_fd_pr__pfet_01v8 ad=0.58 pd=4.58 as=0.58 ps=4.58 w=2 l=0.18
X59 vdd a_10864_619# a_11758_4176# vdd sky130_fd_pr__pfet_01v8 ad=1.16 pd=8.58 as=1.16 ps=8.58 w=4 l=0.18
X60 vdd vdd vdd vdd sky130_fd_pr__pfet_01v8_lvt ad=1.74 pd=12.58 as=0 ps=0 w=6 l=1
X61 vss a_7147_3381# a_7104_3159# vss sky130_fd_pr__nfet_01v8 ad=0.29 pd=2.58 as=0.29 ps=2.58 w=1 l=0.18
X62 a_14038_11496# a_7147_10701# a_13944_10479# vdd sky130_fd_pr__pfet_01v8 ad=1.16 pd=8.58 as=1.16 ps=8.58 w=4 l=0.18
X63 vdd a_17645_7756# out vdd sky130_fd_pr__pfet_01v8_lvt ad=0.87 pd=6.29 as=0.87 ps=6.29 w=6 l=1
X64 vss a_9817_3381# a_9384_3159# vss sky130_fd_pr__nfet_01v8 ad=0.29 pd=2.58 as=0.29 ps=2.58 w=1 l=0.18
X65 out a_17645_7756# vdd vdd sky130_fd_pr__pfet_01v8_lvt ad=0.87 pd=6.29 as=0.87 ps=6.29 w=6 l=1
X66 a_9478_6616# a_7147_5821# a_9384_5599# vdd sky130_fd_pr__pfet_01v8 ad=1.16 pd=8.58 as=1.16 ps=8.58 w=4 l=0.18
X67 vdd a_17645_7756# out vdd sky130_fd_pr__pfet_01v8_lvt ad=0.87 pd=6.29 as=0.87 ps=6.29 w=6 l=1
X68 a_11758_9056# a_7147_8261# a_11664_8039# vdd sky130_fd_pr__pfet_01v8 ad=1.16 pd=8.58 as=1.16 ps=8.58 w=4 l=0.18
X69 vdd c2 a_7147_5821# vdd sky130_fd_pr__pfet_01v8 ad=0.58 pd=4.58 as=0.58 ps=4.58 w=2 l=0.18
X70 vss a_7537_3381# a_7104_8039# vss sky130_fd_pr__nfet_01v8 ad=0.29 pd=2.58 as=0.29 ps=2.58 w=1 l=0.18
X71 a_18619_4169# out out vss sky130_fd_pr__nfet_01v8_lvt ad=0.87 pd=6.29 as=0.87 ps=6.29 w=6 l=1
X72 out a_17645_7756# vdd vdd sky130_fd_pr__pfet_01v8_lvt ad=0.87 pd=6.29 as=0.87 ps=6.29 w=6 l=1
X73 a_15098_619# c3 a_7147_10701# vss sky130_fd_pr__nfet_01v8 ad=0.58 pd=4.58 as=0.58 ps=4.58 w=2 l=0.18
X74 vss c0 a_6824_719# vss sky130_fd_pr__nfet_01v8 ad=0.29 pd=2.58 as=0.29 ps=2.58 w=1 l=0.18
X75 a_14038_9056# a_7147_8261# a_13944_8039# vdd sky130_fd_pr__pfet_01v8 ad=1.16 pd=8.58 as=1.16 ps=8.58 w=4 l=0.18
X76 vdd a_17645_7756# a_17645_7756# vdd sky130_fd_pr__pfet_01v8_lvt ad=0.87 pd=6.29 as=0.87 ps=6.29 w=6 l=1
X77 a_8858_3159# a_8144_10479# a_4252_6128# vdd sky130_fd_pr__pfet_01v8 ad=0.58 pd=4.58 as=0.58 ps=4.58 w=2 l=0.18
X78 a_18619_4169# out out vss sky130_fd_pr__nfet_01v8_lvt ad=0.87 pd=6.29 as=0.87 ps=6.29 w=6 l=1
X79 a_8858_3159# a_14984_8039# a_3956_8000# vdd sky130_fd_pr__pfet_01v8 ad=0.58 pd=4.58 as=0.58 ps=4.58 w=2 l=0.18
X80 a_7198_4176# a_7147_3381# a_7104_3159# vdd sky130_fd_pr__pfet_01v8 ad=1.16 pd=8.58 as=1.16 ps=8.58 w=4 l=0.18
X81 vss c2 a_15098_619# vss sky130_fd_pr__nfet_01v8 ad=0.58 pd=4.58 as=0.58 ps=4.58 w=2 l=0.18
X82 out out a_18619_4169# vss sky130_fd_pr__nfet_01v8_lvt ad=0.87 pd=6.29 as=0.87 ps=6.29 w=6 l=1
X83 vdd a_7104_10479# a_8144_10479# vdd sky130_fd_pr__pfet_01v8 ad=0.58 pd=4.58 as=0.58 ps=4.58 w=2 l=0.18
X84 a_8858_3159# a_7104_8039# a_4548_5240# vss sky130_fd_pr__nfet_01v8 ad=0.29 pd=2.58 as=0.29 ps=2.58 w=1 l=0.18
X85 a_8858_3159# a_8144_5599# a_4844_608# vdd sky130_fd_pr__pfet_01v8 ad=0.58 pd=4.58 as=0.58 ps=4.58 w=2 l=0.18
X86 vdd a_11684_619# a_14038_6616# vdd sky130_fd_pr__pfet_01v8 ad=1.16 pd=8.58 as=1.16 ps=8.58 w=4 l=0.18
X87 vss a_7147_5821# a_9384_5599# vss sky130_fd_pr__nfet_01v8 ad=0.29 pd=2.58 as=0.29 ps=2.58 w=1 l=0.18
X88 a_4548_2480# a_4844_608# vss sky130_fd_pr__res_high_po w=1 l=7.36
X89 vdd a_9817_3381# a_9478_4176# vdd sky130_fd_pr__pfet_01v8 ad=1.16 pd=8.58 as=1.16 ps=8.58 w=4 l=0.18
X90 vdd a_11664_8039# a_12704_8039# vdd sky130_fd_pr__pfet_01v8 ad=0.58 pd=4.58 as=0.58 ps=4.58 w=2 l=0.18
X91 vss a_7537_3381# a_7104_10479# vss sky130_fd_pr__nfet_01v8 ad=0.29 pd=2.58 as=0.29 ps=2.58 w=1 l=0.18
X92 vdd a_17645_7756# a_17645_7756# vdd sky130_fd_pr__pfet_01v8_lvt ad=0.87 pd=6.29 as=0.87 ps=6.29 w=6 l=1
X93 out a_17645_7756# vdd vdd sky130_fd_pr__pfet_01v8_lvt ad=0.87 pd=6.29 as=0.87 ps=6.29 w=6 l=1
X94 vdd a_9384_10479# a_10424_10479# vdd sky130_fd_pr__pfet_01v8 ad=0.58 pd=4.58 as=0.58 ps=4.58 w=2 l=0.18
X95 a_18877_1769# ibias a_18619_4169# vss sky130_fd_pr__nfet_01v8 ad=0.725 pd=5.29 as=0.725 ps=5.29 w=5 l=1
X96 a_8858_3159# a_11664_3159# a_4252_608# vss sky130_fd_pr__nfet_01v8 ad=0.29 pd=2.58 as=0.29 ps=2.58 w=1 l=0.18
X97 vss a_7147_3381# a_11664_3159# vss sky130_fd_pr__nfet_01v8 ad=0.29 pd=2.58 as=0.29 ps=2.58 w=1 l=0.18
X98 vdd a_13944_8039# a_14984_8039# vdd sky130_fd_pr__pfet_01v8 ad=0.58 pd=4.58 as=0.58 ps=4.58 w=2 l=0.18
X99 a_17645_7756# a_17645_7756# vdd vdd sky130_fd_pr__pfet_01v8_lvt ad=0.87 pd=6.29 as=0.87 ps=6.29 w=6 l=1
X100 a_3956_2480# a_782_8839# vss sky130_fd_pr__res_high_po w=1 l=7.36
X101 a_8858_3159# a_12704_10479# a_4844_6128# vdd sky130_fd_pr__pfet_01v8 ad=0.58 pd=4.58 as=0.58 ps=4.58 w=2 l=0.18
X102 vdd a_7537_3381# a_7198_9056# vdd sky130_fd_pr__pfet_01v8 ad=1.16 pd=8.58 as=1.16 ps=8.58 w=4 l=0.18
X103 vss a_7104_8039# a_8144_8039# vss sky130_fd_pr__nfet_01v8 ad=0.29 pd=2.58 as=0.29 ps=2.58 w=1 l=0.18
X104 vdd a_7104_5599# a_8144_5599# vdd sky130_fd_pr__pfet_01v8 ad=0.58 pd=4.58 as=0.58 ps=4.58 w=2 l=0.18
X105 vss a_2558_1129# vss sky130_fd_pr__res_high_po w=1 l=36.55
X106 vdd a_10864_619# a_11758_6616# vdd sky130_fd_pr__pfet_01v8 ad=1.16 pd=8.58 as=1.16 ps=8.58 w=4 l=0.18
X107 vss a_7147_3381# a_13944_3159# vss sky130_fd_pr__nfet_01v8 ad=0.29 pd=2.58 as=0.29 ps=2.58 w=1 l=0.18
X108 vss a_9384_3159# a_10424_3159# vss sky130_fd_pr__nfet_01v8 ad=0.29 pd=2.58 as=0.29 ps=2.58 w=1 l=0.18
X109 a_1670_8839# a_1374_1129# vss sky130_fd_pr__res_high_po w=1 l=36.55
X110 out a_17645_7756# vdd vdd sky130_fd_pr__pfet_01v8_lvt ad=0.87 pd=6.29 as=0.87 ps=6.29 w=6 l=1
X111 a_14278_619# c3 a_7147_8261# vss sky130_fd_pr__nfet_01v8 ad=0.58 pd=4.58 as=0.58 ps=4.58 w=2 l=0.18
X112 a_8858_3159# a_9384_3159# a_3956_2480# vss sky130_fd_pr__nfet_01v8 ad=0.29 pd=2.58 as=0.29 ps=2.58 w=1 l=0.18
X113 a_1670_8839# a_1966_1129# vss sky130_fd_pr__res_high_po w=1 l=36.55
X114 vdd a_17645_7756# a_17645_7756# vdd sky130_fd_pr__pfet_01v8_lvt ad=0.87 pd=6.29 as=0.87 ps=6.29 w=6 l=1
X115 vss a_11684_619# a_13944_5599# vss sky130_fd_pr__nfet_01v8 ad=0.29 pd=2.58 as=0.29 ps=2.58 w=1 l=0.18
X116 vdd c0 a_11684_619# vdd sky130_fd_pr__pfet_01v8 ad=0.58 pd=4.58 as=0.58 ps=4.58 w=2 l=0.18
X117 a_17645_7756# a_8858_3159# a_18619_4169# vss sky130_fd_pr__nfet_01v8_lvt ad=0.87 pd=6.29 as=0.87 ps=6.29 w=6 l=1
X118 vss a_7147_10701# a_7104_10479# vss sky130_fd_pr__nfet_01v8 ad=0.29 pd=2.58 as=0.29 ps=2.58 w=1 l=0.18
X119 vss c0 a_11778_619# vss sky130_fd_pr__nfet_01v8 ad=0.58 pd=4.58 as=0.58 ps=4.58 w=2 l=0.18
X120 vdd a_7537_3381# a_7198_11496# vdd sky130_fd_pr__pfet_01v8 ad=1.16 pd=8.58 as=1.16 ps=8.58 w=4 l=0.18
X121 vss a_7784_719# a_14278_619# vss sky130_fd_pr__nfet_01v8 ad=0.58 pd=4.58 as=0.58 ps=4.58 w=2 l=0.18
X122 vdd a_6824_719# a_7537_3381# vdd sky130_fd_pr__pfet_01v8 ad=0.58 pd=4.58 as=0.58 ps=4.58 w=2 l=0.18
X123 vss a_10864_619# a_11664_5599# vss sky130_fd_pr__nfet_01v8 ad=0.29 pd=2.58 as=0.29 ps=2.58 w=1 l=0.18
X124 vss vss vss sky130_fd_pr__res_high_po w=1 l=36.55
X125 vss a_7537_3381# a_7104_3159# vss sky130_fd_pr__nfet_01v8 ad=0.29 pd=2.58 as=0.29 ps=2.58 w=1 l=0.18
X126 a_11758_4176# a_7147_3381# a_11664_3159# vdd sky130_fd_pr__pfet_01v8 ad=1.16 pd=8.58 as=1.16 ps=8.58 w=4 l=0.18
X127 vss a_9817_3381# a_9384_10479# vss sky130_fd_pr__nfet_01v8 ad=0.29 pd=2.58 as=0.29 ps=2.58 w=1 l=0.18
X128 a_8858_3159# a_13944_5599# a_4252_3368# vss sky130_fd_pr__nfet_01v8 ad=0.29 pd=2.58 as=0.29 ps=2.58 w=1 l=0.18
X129 vdd c3 a_7147_10701# vdd sky130_fd_pr__pfet_01v8 ad=0.58 pd=4.58 as=0.58 ps=4.58 w=2 l=0.18
X130 vss c0 a_10138_619# vss sky130_fd_pr__nfet_01v8 ad=0.58 pd=4.58 as=0.58 ps=4.58 w=2 l=0.18
X131 vdd a_7304_719# a_9817_3381# vdd sky130_fd_pr__pfet_01v8 ad=0.58 pd=4.58 as=0.58 ps=4.58 w=2 l=0.18
X132 vdd a_11664_10479# a_12704_10479# vdd sky130_fd_pr__pfet_01v8 ad=0.58 pd=4.58 as=0.58 ps=4.58 w=2 l=0.18
X133 vdd a_17645_7756# a_17645_7756# vdd sky130_fd_pr__pfet_01v8_lvt ad=0.87 pd=6.29 as=0.87 ps=6.29 w=6 l=1
X134 a_14038_4176# a_7147_3381# a_13944_3159# vdd sky130_fd_pr__pfet_01v8 ad=1.16 pd=8.58 as=1.16 ps=8.58 w=4 l=0.18
X135 vdd a_17645_7756# out vdd sky130_fd_pr__pfet_01v8_lvt ad=0.87 pd=6.29 as=0.87 ps=6.29 w=6 l=1
X136 vss a_7784_719# a_12638_619# vss sky130_fd_pr__nfet_01v8 ad=0.58 pd=4.58 as=0.58 ps=4.58 w=2 l=0.18
X137 a_7198_6616# a_7147_5821# a_7104_5599# vdd sky130_fd_pr__pfet_01v8 ad=1.16 pd=8.58 as=1.16 ps=8.58 w=4 l=0.18
X138 vss a_11664_5599# a_12704_5599# vss sky130_fd_pr__nfet_01v8 ad=0.29 pd=2.58 as=0.29 ps=2.58 w=1 l=0.18
X139 a_18619_4169# vss vss vss sky130_fd_pr__nfet_01v8_lvt ad=0.87 pd=6.29 as=1.74 ps=12.58 w=6 l=1
X140 a_8858_3159# a_10424_10479# a_4548_8000# vdd sky130_fd_pr__pfet_01v8 ad=0.58 pd=4.58 as=0.58 ps=4.58 w=2 l=0.18
X141 a_8858_3159# a_14984_10479# iin vdd sky130_fd_pr__pfet_01v8 ad=0.58 pd=4.58 as=0.58 ps=4.58 w=2 l=0.18
X142 out a_17645_7756# vdd vdd sky130_fd_pr__pfet_01v8_lvt ad=0.87 pd=6.29 as=0.87 ps=6.29 w=6 l=1
X143 a_17645_7756# a_17645_7756# vdd vdd sky130_fd_pr__pfet_01v8_lvt ad=0.87 pd=6.29 as=0.87 ps=6.29 w=6 l=1
X144 vdd a_9817_3381# a_9478_6616# vdd sky130_fd_pr__pfet_01v8 ad=1.16 pd=8.58 as=1.16 ps=8.58 w=4 l=0.18
X145 a_8858_3159# a_14984_3159# a_4548_2480# vdd sky130_fd_pr__pfet_01v8 ad=0.58 pd=4.58 as=0.58 ps=4.58 w=2 l=0.18
X146 vss a_13944_5599# a_14984_5599# vss sky130_fd_pr__nfet_01v8 ad=0.29 pd=2.58 as=0.29 ps=2.58 w=1 l=0.18
X147 vdd a_13944_10479# a_14984_10479# vdd sky130_fd_pr__pfet_01v8 ad=0.58 pd=4.58 as=0.58 ps=4.58 w=2 l=0.18
X148 vdd a_17645_7756# out vdd sky130_fd_pr__pfet_01v8_lvt ad=0.87 pd=6.29 as=0.87 ps=6.29 w=6 l=1
X149 a_13458_619# a_8264_719# a_7147_5821# vss sky130_fd_pr__nfet_01v8 ad=0.58 pd=4.58 as=0.58 ps=4.58 w=2 l=0.18
X150 a_8858_3159# a_7104_3159# a_782_8839# vss sky130_fd_pr__nfet_01v8 ad=0.29 pd=2.58 as=0.29 ps=2.58 w=1 l=0.18
X151 a_18619_4169# ibias a_18877_1769# vss sky130_fd_pr__nfet_01v8 ad=0.725 pd=5.29 as=0.725 ps=5.29 w=5 l=1
X152 vss a_11684_619# a_13944_10479# vss sky130_fd_pr__nfet_01v8 ad=0.29 pd=2.58 as=0.29 ps=2.58 w=1 l=0.18
X153 vdd a_11664_3159# a_12704_3159# vdd sky130_fd_pr__pfet_01v8 ad=0.58 pd=4.58 as=0.58 ps=4.58 w=2 l=0.18
X154 a_7198_11496# a_7147_10701# a_7104_10479# vdd sky130_fd_pr__pfet_01v8 ad=1.16 pd=8.58 as=1.16 ps=8.58 w=4 l=0.18
X155 vss a_7147_8261# a_9384_8039# vss sky130_fd_pr__nfet_01v8 ad=0.29 pd=2.58 as=0.29 ps=2.58 w=1 l=0.18
X156 a_17645_7756# a_17645_7756# vdd vdd sky130_fd_pr__pfet_01v8_lvt ad=0.87 pd=6.29 as=0.87 ps=6.29 w=6 l=1
X157 vss a_6824_719# a_10958_619# vss sky130_fd_pr__nfet_01v8 ad=0.58 pd=4.58 as=0.58 ps=4.58 w=2 l=0.18
X158 a_8858_3159# a_12704_8039# a_3956_6128# vdd sky130_fd_pr__pfet_01v8 ad=0.58 pd=4.58 as=0.58 ps=4.58 w=2 l=0.18
X159 iin a_4844_6128# vss sky130_fd_pr__res_high_po w=1 l=7.36
X160 vdd a_13944_3159# a_14984_3159# vdd sky130_fd_pr__pfet_01v8 ad=0.58 pd=4.58 as=0.58 ps=4.58 w=2 l=0.18
X161 vss a_7147_10701# a_9384_10479# vss sky130_fd_pr__nfet_01v8 ad=0.29 pd=2.58 as=0.29 ps=2.58 w=1 l=0.18
X162 vss c2 a_13458_619# vss sky130_fd_pr__nfet_01v8 ad=0.58 pd=4.58 as=0.58 ps=4.58 w=2 l=0.18
X163 a_18619_4169# ibias a_18877_1769# vss sky130_fd_pr__nfet_01v8 ad=0.725 pd=5.29 as=0.725 ps=5.29 w=5 l=1
X164 vdd a_17645_7756# out vdd sky130_fd_pr__pfet_01v8_lvt ad=0.87 pd=6.29 as=0.87 ps=6.29 w=6 l=1
X165 vss a_7147_5821# a_7104_5599# vss sky130_fd_pr__nfet_01v8 ad=0.29 pd=2.58 as=0.29 ps=2.58 w=1 l=0.18
X166 vdd a_7537_3381# a_7198_4176# vdd sky130_fd_pr__pfet_01v8 ad=1.16 pd=8.58 as=1.16 ps=8.58 w=4 l=0.18
X167 a_9318_619# a_7304_719# a_7537_3381# vss sky130_fd_pr__nfet_01v8 ad=0.58 pd=4.58 as=0.58 ps=4.58 w=2 l=0.18
X168 vdd a_6824_719# a_10864_619# vdd sky130_fd_pr__pfet_01v8 ad=0.58 pd=4.58 as=0.58 ps=4.58 w=2 l=0.18
X169 vss a_7104_3159# a_8144_3159# vss sky130_fd_pr__nfet_01v8 ad=0.29 pd=2.58 as=0.29 ps=2.58 w=1 l=0.18
X170 vdd a_9817_3381# a_9478_11496# vdd sky130_fd_pr__pfet_01v8 ad=1.16 pd=8.58 as=1.16 ps=8.58 w=4 l=0.18
X171 vdd a_9384_8039# a_10424_8039# vdd sky130_fd_pr__pfet_01v8 ad=0.58 pd=4.58 as=0.58 ps=4.58 w=2 l=0.18
X172 a_3956_6128# a_4844_3368# vss sky130_fd_pr__res_high_po w=1 l=7.36
X173 a_11778_619# c1 a_11684_619# vss sky130_fd_pr__nfet_01v8 ad=0.58 pd=4.58 as=0.58 ps=4.58 w=2 l=0.18
X174 out a_17645_7756# vdd vdd sky130_fd_pr__pfet_01v8_lvt ad=0.87 pd=6.29 as=0.87 ps=6.29 w=6 l=1
X175 vss a_9817_3381# a_9384_5599# vss sky130_fd_pr__nfet_01v8 ad=0.29 pd=2.58 as=0.29 ps=2.58 w=1 l=0.18
X176 a_18877_1769# ibias a_18619_4169# vss sky130_fd_pr__nfet_01v8 ad=0.725 pd=5.29 as=0.725 ps=5.29 w=5 l=1
X177 a_3956_8000# a_4252_6128# vss sky130_fd_pr__res_high_po w=1 l=7.36
X178 vss vss a_18619_4169# vss sky130_fd_pr__nfet_01v8_lvt ad=1.74 pd=12.58 as=0.87 ps=6.29 w=6 l=1
X179 a_18619_4169# a_8858_3159# a_17645_7756# vss sky130_fd_pr__nfet_01v8_lvt ad=0.87 pd=6.29 as=0.87 ps=6.29 w=6 l=1
X180 a_8858_3159# a_10424_8039# a_4844_3368# vdd sky130_fd_pr__pfet_01v8 ad=0.58 pd=4.58 as=0.58 ps=4.58 w=2 l=0.18
X181 a_3956_5240# a_4252_3368# vss sky130_fd_pr__res_high_po w=1 l=7.36
X182 a_4548_8000# a_4252_6128# vss sky130_fd_pr__res_high_po w=1 l=7.36
X183 vss a_6824_719# a_9318_619# vss sky130_fd_pr__nfet_01v8 ad=0.58 pd=4.58 as=0.58 ps=4.58 w=2 l=0.18
X184 vdd a_7784_719# a_7147_3381# vdd sky130_fd_pr__pfet_01v8 ad=0.58 pd=4.58 as=0.58 ps=4.58 w=2 l=0.18
X185 vdd c1 a_7304_719# vdd sky130_fd_pr__pfet_01v8 ad=0.58 pd=4.58 as=0.58 ps=4.58 w=2 l=0.18
X186 vss a_11684_619# a_13944_8039# vss sky130_fd_pr__nfet_01v8 ad=0.29 pd=2.58 as=0.29 ps=2.58 w=1 l=0.18
X187 a_17645_7756# a_17645_7756# vdd vdd sky130_fd_pr__pfet_01v8_lvt ad=0.87 pd=6.29 as=0.87 ps=6.29 w=6 l=1
X188 a_10138_619# a_7304_719# a_9817_3381# vss sky130_fd_pr__nfet_01v8 ad=0.58 pd=4.58 as=0.58 ps=4.58 w=2 l=0.18
X189 vdd c3 a_7147_8261# vdd sky130_fd_pr__pfet_01v8 ad=0.58 pd=4.58 as=0.58 ps=4.58 w=2 l=0.18
X190 a_4548_5240# a_4252_3368# vss sky130_fd_pr__res_high_po w=1 l=7.36
X191 vdd a_11684_619# a_14038_11496# vdd sky130_fd_pr__pfet_01v8 ad=1.16 pd=8.58 as=1.16 ps=8.58 w=4 l=0.18
X192 a_11758_6616# a_7147_5821# a_11664_5599# vdd sky130_fd_pr__pfet_01v8 ad=1.16 pd=8.58 as=1.16 ps=8.58 w=4 l=0.18
X193 a_12638_619# a_8264_719# a_7147_3381# vss sky130_fd_pr__nfet_01v8 ad=0.58 pd=4.58 as=0.58 ps=4.58 w=2 l=0.18
X194 a_9478_9056# a_7147_8261# a_9384_8039# vdd sky130_fd_pr__pfet_01v8 ad=1.16 pd=8.58 as=1.16 ps=8.58 w=4 l=0.18
X195 a_14038_6616# a_7147_5821# a_13944_5599# vdd sky130_fd_pr__pfet_01v8 ad=1.16 pd=8.58 as=1.16 ps=8.58 w=4 l=0.18
X196 a_18619_4169# a_8858_3159# a_17645_7756# vss sky130_fd_pr__nfet_01v8_lvt ad=0.87 pd=6.29 as=0.87 ps=6.29 w=6 l=1
X197 vss a_10864_619# a_11664_10479# vss sky130_fd_pr__nfet_01v8 ad=0.29 pd=2.58 as=0.29 ps=2.58 w=1 l=0.18
X198 vdd vdd vdd vdd sky130_fd_pr__pfet_01v8_lvt ad=0.87 pd=6.29 as=0 ps=0 w=6 l=1
X199 a_9478_11496# a_7147_10701# a_9384_10479# vdd sky130_fd_pr__pfet_01v8 ad=1.16 pd=8.58 as=1.16 ps=8.58 w=4 l=0.18
X200 vdd c1 a_11684_619# vdd sky130_fd_pr__pfet_01v8 ad=0.58 pd=4.58 as=0.58 ps=4.58 w=2 l=0.18
X201 a_17645_7756# a_8858_3159# a_18619_4169# vss sky130_fd_pr__nfet_01v8_lvt ad=0.87 pd=6.29 as=0.87 ps=6.29 w=6 l=1
X202 a_8858_3159# a_7104_10479# a_4252_6128# vss sky130_fd_pr__nfet_01v8 ad=0.29 pd=2.58 as=0.29 ps=2.58 w=1 l=0.18
X203 vss a_10864_619# a_11664_8039# vss sky130_fd_pr__nfet_01v8 ad=0.29 pd=2.58 as=0.29 ps=2.58 w=1 l=0.18
X204 a_8858_3159# a_13944_8039# a_3956_8000# vss sky130_fd_pr__nfet_01v8 ad=0.29 pd=2.58 as=0.29 ps=2.58 w=1 l=0.18
X205 a_8858_3159# a_14984_5599# a_4252_3368# vdd sky130_fd_pr__pfet_01v8 ad=0.58 pd=4.58 as=0.58 ps=4.58 w=2 l=0.18
X206 a_18877_1769# ibias a_18619_4169# vss sky130_fd_pr__nfet_01v8 ad=1.45 pd=10.58 as=0.725 ps=5.29 w=5 l=1
X207 a_782_8839# a_782_1129# vss sky130_fd_pr__res_high_po w=1 l=36.55
X208 vdd c3 a_8264_719# vdd sky130_fd_pr__pfet_01v8 ad=0.58 pd=4.58 as=0.58 ps=4.58 w=2 l=0.18
X209 vss a_7104_10479# a_8144_10479# vss sky130_fd_pr__nfet_01v8 ad=0.29 pd=2.58 as=0.29 ps=2.58 w=1 l=0.18
X210 a_1078_8839# a_782_1129# vss sky130_fd_pr__res_high_po w=1 l=36.55
X211 a_10958_619# c1 a_10864_619# vss sky130_fd_pr__nfet_01v8 ad=0.58 pd=4.58 as=0.58 ps=4.58 w=2 l=0.18
X212 vss c3 a_8264_719# vss sky130_fd_pr__nfet_01v8 ad=0.29 pd=2.58 as=0.29 ps=2.58 w=1 l=0.18
X213 vss a_11664_8039# a_12704_8039# vss sky130_fd_pr__nfet_01v8 ad=0.29 pd=2.58 as=0.29 ps=2.58 w=1 l=0.18
X214 vdd a_17645_7756# a_17645_7756# vdd sky130_fd_pr__pfet_01v8_lvt ad=0.87 pd=6.29 as=0.87 ps=6.29 w=6 l=1
X215 vdd a_11664_5599# a_12704_5599# vdd sky130_fd_pr__pfet_01v8 ad=0.58 pd=4.58 as=0.58 ps=4.58 w=2 l=0.18
X216 a_8858_3159# a_11664_5599# a_3956_5240# vss sky130_fd_pr__nfet_01v8 ad=0.29 pd=2.58 as=0.29 ps=2.58 w=1 l=0.18
X217 vss a_7147_5821# a_11664_5599# vss sky130_fd_pr__nfet_01v8 ad=0.29 pd=2.58 as=0.29 ps=2.58 w=1 l=0.18
X218 vss a_9384_10479# a_10424_10479# vss sky130_fd_pr__nfet_01v8 ad=0.29 pd=2.58 as=0.29 ps=2.58 w=1 l=0.18
X219 vdd c2 a_7147_10701# vdd sky130_fd_pr__pfet_01v8 ad=0.58 pd=4.58 as=0.58 ps=4.58 w=2 l=0.18
X220 a_8858_3159# a_8144_8039# a_4548_5240# vdd sky130_fd_pr__pfet_01v8 ad=0.58 pd=4.58 as=0.58 ps=4.58 w=2 l=0.18
X221 vss a_13944_8039# a_14984_8039# vss sky130_fd_pr__nfet_01v8 ad=0.29 pd=2.58 as=0.29 ps=2.58 w=1 l=0.18
X222 vdd a_17645_7756# out vdd sky130_fd_pr__pfet_01v8_lvt ad=0.87 pd=6.29 as=0.87 ps=6.29 w=6 l=1
X223 vdd a_17645_7756# a_17645_7756# vdd sky130_fd_pr__pfet_01v8_lvt ad=0.87 pd=6.29 as=0.87 ps=6.29 w=6 l=1
X224 a_17645_7756# a_17645_7756# vdd vdd sky130_fd_pr__pfet_01v8_lvt ad=0.87 pd=6.29 as=0.87 ps=6.29 w=6 l=1
X225 vdd a_11684_619# a_14038_9056# vdd sky130_fd_pr__pfet_01v8 ad=1.16 pd=8.58 as=1.16 ps=8.58 w=4 l=0.18
X226 vdd a_13944_5599# a_14984_5599# vdd sky130_fd_pr__pfet_01v8 ad=0.58 pd=4.58 as=0.58 ps=4.58 w=2 l=0.18
X227 vss a_9384_5599# a_10424_5599# vss sky130_fd_pr__nfet_01v8 ad=0.29 pd=2.58 as=0.29 ps=2.58 w=1 l=0.18
X228 a_8858_3159# a_11664_10479# a_4844_6128# vss sky130_fd_pr__nfet_01v8 ad=0.29 pd=2.58 as=0.29 ps=2.58 w=1 l=0.18
X229 vss a_7147_5821# a_13944_5599# vss sky130_fd_pr__nfet_01v8 ad=0.29 pd=2.58 as=0.29 ps=2.58 w=1 l=0.18
X230 out a_17645_7756# vdd vdd sky130_fd_pr__pfet_01v8_lvt ad=0.87 pd=6.29 as=0.87 ps=6.29 w=6 l=1
X231 vdd a_7537_3381# a_7198_6616# vdd sky130_fd_pr__pfet_01v8 ad=1.16 pd=8.58 as=1.16 ps=8.58 w=4 l=0.18
X232 vss a_7147_3381# a_9384_3159# vss sky130_fd_pr__nfet_01v8 ad=0.29 pd=2.58 as=0.29 ps=2.58 w=1 l=0.18
X233 a_8858_3159# a_12704_3159# a_4252_608# vdd sky130_fd_pr__pfet_01v8 ad=0.58 pd=4.58 as=0.58 ps=4.58 w=2 l=0.18
X234 vdd vdd vdd vdd sky130_fd_pr__pfet_01v8_lvt ad=1.74 pd=12.58 as=0 ps=0 w=6 l=1
X235 a_8858_3159# a_9384_5599# a_3956_3368# vss sky130_fd_pr__nfet_01v8 ad=0.29 pd=2.58 as=0.29 ps=2.58 w=1 l=0.18
X236 vdd a_17645_7756# a_17645_7756# vdd sky130_fd_pr__pfet_01v8_lvt ad=0.87 pd=6.29 as=0.87 ps=6.29 w=6 l=1
X237 vdd a_10864_619# a_11758_11496# vdd sky130_fd_pr__pfet_01v8 ad=1.16 pd=8.58 as=1.16 ps=8.58 w=4 l=0.18
X238 vdd a_7104_8039# a_8144_8039# vdd sky130_fd_pr__pfet_01v8 ad=0.58 pd=4.58 as=0.58 ps=4.58 w=2 l=0.18
X239 out a_17645_7756# vdd vdd sky130_fd_pr__pfet_01v8_lvt ad=0.87 pd=6.29 as=0.87 ps=6.29 w=6 l=1
X240 vdd a_9384_3159# a_10424_3159# vdd sky130_fd_pr__pfet_01v8 ad=0.58 pd=4.58 as=0.58 ps=4.58 w=2 l=0.18
X241 vdd a_10864_619# a_11758_9056# vdd sky130_fd_pr__pfet_01v8 ad=1.16 pd=8.58 as=1.16 ps=8.58 w=4 l=0.18
X242 a_17645_7756# a_17645_7756# vdd vdd sky130_fd_pr__pfet_01v8_lvt ad=0.87 pd=6.29 as=0.87 ps=6.29 w=6 l=1
X243 vdd a_8264_719# a_7147_5821# vdd sky130_fd_pr__pfet_01v8 ad=0.58 pd=4.58 as=0.58 ps=4.58 w=2 l=0.18
X244 vss a_7147_8261# a_7104_8039# vss sky130_fd_pr__nfet_01v8 ad=0.29 pd=2.58 as=0.29 ps=2.58 w=1 l=0.18
X245 vss a_9817_3381# a_9384_8039# vss sky130_fd_pr__nfet_01v8 ad=0.29 pd=2.58 as=0.29 ps=2.58 w=1 l=0.18
X246 a_8858_3159# a_10424_3159# a_3956_2480# vdd sky130_fd_pr__pfet_01v8 ad=0.58 pd=4.58 as=0.58 ps=4.58 w=2 l=0.18
X247 a_3956_3368# a_4844_608# vss sky130_fd_pr__res_high_po w=1 l=7.36
X248 vss a_7537_3381# a_7104_5599# vss sky130_fd_pr__nfet_01v8 ad=0.29 pd=2.58 as=0.29 ps=2.58 w=1 l=0.18
X249 vdd c1 a_10864_619# vdd sky130_fd_pr__pfet_01v8 ad=0.58 pd=4.58 as=0.58 ps=4.58 w=2 l=0.18
X250 vdd c0 a_6824_719# vdd sky130_fd_pr__pfet_01v8 ad=0.58 pd=4.58 as=0.58 ps=4.58 w=2 l=0.18
X251 vss a_11684_619# a_13944_3159# vss sky130_fd_pr__nfet_01v8 ad=0.29 pd=2.58 as=0.29 ps=2.58 w=1 l=0.18
C0 a_7147_5821# a_9384_5599# 0.77354f
C1 a_3956_5240# a_8858_3159# 0.41213f
C2 a_4252_608# a_3956_6128# 0.00431f
C3 c1 vdd 0.70438f
C4 c2 a_14278_619# 0.00183f
C5 a_8264_719# a_13458_619# 0.03701f
C6 a_1670_8839# a_3956_6128# 0.05946f
C7 a_10424_8039# a_4252_3368# 0
C8 vdd a_7104_3159# 0.68447f
C9 a_7147_3381# a_4252_608# 0.07359f
C10 a_13944_5599# a_14984_8039# 0
C11 a_8264_719# c3 2.25116f
C12 a_3956_8000# a_7147_10701# 0.19465f
C13 a_13944_8039# a_11664_8039# 0.004f
C14 c2 a_7147_3381# 0.05371f
C15 c0 a_10958_619# 0.00388f
C16 a_9817_3381# a_4252_3368# 0.06765f
C17 c2 a_6824_719# 0.16455f
C18 a_10864_619# a_3956_3368# 0
C19 a_782_8839# a_3956_6128# 0.19398f
C20 a_1670_8839# a_2262_8839# 0.15162f
C21 a_4844_608# a_4252_3368# 0.04357f
C22 vdd a_11758_4176# 0.75642f
C23 a_7147_8261# a_8264_719# 0.16648f
C24 a_7537_3381# iin 0.00307f
C25 a_782_8839# a_2262_8839# 0.32656f
C26 a_9478_6616# a_3956_3368# 0.10781f
C27 a_10424_8039# a_9478_9056# 0
C28 a_4252_6128# a_9478_11496# 0
C29 c0 a_10864_619# 0.30348f
C30 a_7147_3381# a_782_8839# 0.09026f
C31 a_4844_6128# a_11664_10479# 0.25664f
C32 a_13944_5599# a_8858_3159# 0.34007f
C33 a_9817_3381# a_7784_719# 0.09035f
C34 a_4844_3368# iin 0.04312f
C35 a_12704_10479# a_8858_3159# 0.12575f
C36 a_4548_5240# a_4252_6128# 0.06317f
C37 a_7104_5599# a_4252_3368# 0.01219f
C38 a_9817_3381# a_9478_9056# 0.12089f
C39 a_9384_3159# a_9384_5599# 0
C40 a_3956_5240# a_13944_5599# 0.00594f
C41 a_9384_5599# a_8858_3159# 0.33457f
C42 a_4252_6128# a_4548_8000# 2.31093f
C43 a_8144_10479# a_7147_10701# 0.05358f
C44 a_7147_5821# a_3956_6128# 0.03633f
C45 a_7537_3381# a_3956_2480# 0.05659f
C46 a_3956_5240# a_9384_5599# 0.04701f
C47 a_4252_6128# a_7104_10479# 0.27513f
C48 a_4252_6128# a_8858_3159# 0.28141f
C49 a_7537_3381# a_8144_5599# 0.05328f
C50 a_7147_5821# a_7147_3381# 2.10423f
C51 a_3956_5240# a_4252_6128# 0.06437f
C52 a_7147_5821# a_6824_719# 0.02113f
C53 a_7198_11496# a_4844_6128# 0.08456f
C54 a_4844_3368# a_3956_2480# 0.05448f
C55 a_4252_608# a_3956_3368# 0.03862f
C56 a_18619_4169# a_17645_7756# 1.3238f
C57 a_14984_10479# a_8858_3159# 0.13084f
C58 a_14038_11496# vdd 0.75642f
C59 a_14038_6616# a_11684_619# 0.12794f
C60 a_1670_8839# a_3956_3368# 0
C61 a_9817_3381# a_8264_719# 0.20391f
C62 a_8144_8039# a_3956_8000# 0.00153f
C63 a_9318_619# c1 0.0013f
C64 c2 c0 0.1842f
C65 a_7147_8261# a_3956_8000# 0.02471f
C66 a_13944_3159# a_4252_608# 0.00594f
C67 a_782_8839# a_3956_3368# 0.25139f
C68 a_10864_619# a_12638_619# 0.00139f
C69 a_4548_5240# a_3956_6128# 0.98205f
C70 iin a_7147_10701# 0.02727f
C71 a_11758_11496# a_4548_8000# 0
C72 a_11778_619# vdd 0.01471f
C73 c2 a_13944_3159# 0
C74 a_7147_3381# a_10138_619# 0
C75 a_4548_8000# a_3956_6128# 0.03238f
C76 a_6824_719# a_10138_619# 0.00203f
C77 a_11758_11496# a_8858_3159# 0.01739f
C78 a_4548_5240# a_2262_8839# 0.01401f
C79 a_12704_3159# a_11684_619# 0
C80 a_7147_5821# a_13944_8039# 0
C81 a_7104_10479# a_3956_6128# 0
C82 a_3956_6128# a_8858_3159# 0.41213f
C83 a_4548_8000# a_2262_8839# 0.07153f
C84 a_3956_5240# a_3956_6128# 0.11694f
C85 a_7147_3381# a_8858_3159# 0.49231f
C86 a_9384_3159# a_7147_3381# 0.77359f
C87 vdd a_9478_4176# 0.75642f
C88 a_6824_719# a_8858_3159# 0
C89 a_7198_4176# a_3956_2480# 0.08646f
C90 a_9384_3159# a_6824_719# 0
C91 a_3956_2480# a_7147_10701# 0.04455f
C92 a_14984_3159# a_12704_3159# 0.00109f
C93 a_7147_5821# a_3956_3368# 0.07546f
C94 a_3956_5240# a_2262_8839# 0
C95 a_13944_8039# a_14984_8039# 0.46091f
C96 a_10864_619# a_12704_5599# 0.05397f
C97 a_14984_10479# a_12704_10479# 0.00109f
C98 a_9384_10479# a_4844_6128# 0.04701f
C99 a_7147_5821# c0 0.00919f
C100 a_10424_8039# a_3956_8000# 0.00153f
C101 a_10864_619# a_4252_3368# 0.06765f
C102 a_7537_3381# a_7104_8039# 0.21944f
C103 a_7147_5821# a_13944_3159# 0
C104 a_7784_719# a_10958_619# 0
C105 c2 a_12638_619# 0
C106 a_11664_3159# a_11684_619# 0
C107 a_9817_3381# a_3956_8000# 0.06765f
C108 a_8144_3159# a_7537_3381# 0.05328f
C109 a_11664_5599# vdd 0.68879f
C110 a_13944_8039# a_8858_3159# 0.33972f
C111 a_4844_608# a_3956_8000# 0
C112 a_12704_5599# a_11664_8039# 0
C113 a_9478_6616# a_4252_3368# 0.02359f
C114 a_4844_3368# a_7104_8039# 0.05082f
C115 a_11664_8039# a_4252_3368# 0.01903f
C116 a_12704_8039# vdd 0.7114f
C117 a_11758_11496# a_12704_10479# 0
C118 a_10864_619# a_7784_719# 0.09511f
C119 a_4548_5240# a_3956_3368# 0.032f
C120 a_11684_619# a_4844_6128# 0
C121 a_7147_3381# a_13944_5599# 0
C122 a_13944_10479# a_3956_8000# 0.04071f
C123 a_4548_8000# a_3956_3368# 0.00114f
C124 c0 a_10138_619# 0.05085f
C125 a_7147_8261# iin 0.01043f
C126 a_7147_3381# a_9384_5599# 0
C127 a_7147_5821# a_7198_6616# 0.06762f
C128 a_4252_6128# a_3956_6128# 0.75565f
C129 a_3956_3368# a_8858_3159# 0.38019f
C130 a_11664_5599# a_12704_8039# 0
C131 a_4252_6128# a_2262_8839# 0.0205f
C132 a_9817_3381# a_8144_10479# 0
C133 a_9384_3159# c0 0
C134 a_3956_5240# a_3956_3368# 2.53873f
C135 a_8264_719# a_10958_619# 0
C136 a_4252_608# a_4252_3368# 0.0447f
C137 a_13944_3159# a_8858_3159# 0.33008f
C138 a_7147_8261# a_3956_2480# 0.03355f
C139 a_7147_5821# a_12638_619# 0
C140 a_7537_3381# a_4844_6128# 0.00273f
C141 a_3956_2480# a_4548_2480# 0.94581f
C142 a_13944_8039# a_13944_5599# 0
C143 a_1670_8839# a_4252_3368# 0
C144 a_12704_3159# a_7147_10701# 0
C145 a_8264_719# a_10864_619# 0.21105f
C146 a_7104_8039# a_7147_10701# 0.0114f
C147 a_7147_5821# a_14984_5599# 0
C148 a_2558_1129# a_1966_1129# 0.15162f
C149 a_782_8839# a_4252_3368# 0.2559f
C150 a_8144_5599# a_4548_2480# 0
C151 a_4844_3368# a_4844_6128# 0.03154f
C152 a_9318_619# vdd 0.01471f
C153 a_8144_3159# a_7147_10701# 0
C154 a_8144_3159# a_7198_4176# 0
C155 c2 a_7784_719# 2.37566f
C156 a_9817_3381# iin 0.00307f
C157 iin a_4844_608# 0
C158 a_7198_9056# a_3956_8000# 0.02359f
C159 a_3956_6128# a_2262_8839# 0.00104f
C160 a_3956_5240# a_7198_6616# 0.08456f
C161 a_9384_5599# a_3956_3368# 0.26381f
C162 a_7147_5821# a_12704_5599# 0.05358f
C163 a_13944_8039# a_14984_10479# 0
C164 a_13944_3159# a_13944_5599# 0
C165 iin a_13944_10479# 0.22483f
C166 a_7147_5821# a_4252_3368# 0.02585f
C167 a_4252_6128# a_3956_3368# 0.04545f
C168 a_6824_719# a_7147_3381# 0.08348f
C169 a_9384_8039# vdd 0.686f
C170 a_11664_3159# a_7147_10701# 0.01852f
C171 vdd a_11664_10479# 0.68879f
C172 c1 a_11684_619# 0.28197f
C173 a_7147_8261# a_14038_6616# 0
C174 vdd a_10424_5599# 0.70625f
C175 a_9817_3381# a_3956_2480# 0.0733f
C176 a_4844_608# a_3956_2480# 0.09125f
C177 a_14984_5599# a_8858_3159# 0.12365f
C178 a_10424_10479# a_3956_8000# 0
C179 c2 a_8264_719# 0.35098f
C180 a_7147_10701# a_4844_6128# 0.07521f
C181 a_7147_5821# a_7784_719# 0.13051f
C182 a_9817_3381# a_8144_5599# 0
C183 a_13944_8039# a_3956_6128# 0.00594f
C184 a_10864_619# a_3956_8000# 0.06765f
C185 a_4844_608# a_8144_5599# 0.24177f
C186 a_11664_5599# a_10424_5599# 0.0024f
C187 a_14984_8039# a_4252_3368# 0.00108f
C188 vdd a_15098_619# 0.01477f
C189 a_12704_3159# a_14038_4176# 0
C190 a_7104_8039# a_8144_8039# 0.45397f
C191 a_8144_3159# c3 0
C192 a_12704_8039# a_11664_10479# 0
C193 a_7104_5599# a_3956_2480# 0
C194 a_12704_3159# a_4548_2480# 0.00853f
C195 a_7147_8261# a_7104_8039# 0.77457f
C196 a_4548_5240# a_4252_3368# 0.4715f
C197 a_7537_3381# c1 0.26355f
C198 vdd a_7198_11496# 0.75642f
C199 a_3956_8000# a_11664_8039# 0.01219f
C200 a_12704_5599# a_8858_3159# 0.12319f
C201 a_4548_8000# a_4252_3368# 0.0226f
C202 a_7537_3381# a_7104_3159# 0.21944f
C203 a_10424_3159# a_3956_2480# 0.21091f
C204 a_7104_5599# a_8144_5599# 0.45397f
C205 a_3956_3368# a_3956_6128# 0.03969f
C206 a_8144_10479# a_10424_10479# 0.00109f
C207 a_8144_3159# a_4548_2480# 0.00153f
C208 a_4252_3368# a_8858_3159# 0.51222f
C209 a_10138_619# a_7784_719# 0
C210 a_3956_5240# a_12704_5599# 0.18303f
C211 a_3956_3368# a_2262_8839# 0
C212 a_13944_5599# a_14984_5599# 0.46091f
C213 a_4548_5240# a_9478_9056# 0
C214 a_7147_3381# a_3956_3368# 0.04939f
C215 a_3956_5240# a_4252_3368# 3.07432f
C216 a_7147_5821# a_8264_719# 0.38585f
C217 a_11664_3159# c3 0
C218 a_9384_3159# a_7784_719# 0
C219 a_7784_719# a_8858_3159# 0
C220 c0 a_7147_3381# 0.08019f
C221 a_9478_9056# a_8858_3159# 0.01442f
C222 a_6824_719# c0 1.77961f
C223 ibias out 0.01106f
C224 a_7147_8261# a_11664_3159# 0
C225 a_13944_3159# a_7147_3381# 0.35866f
C226 a_11664_3159# a_4548_2480# 0.01219f
C227 a_14038_11496# a_11684_619# 0.06813f
C228 out a_8858_3159# 0.87215f
C229 a_1670_8839# a_3956_8000# 0.06612f
C230 a_1966_1129# a_1374_1129# 0.15162f
C231 a_13944_5599# a_12704_5599# 0.0024f
C232 iin a_10424_10479# 0.00153f
C233 a_8264_719# a_10138_619# 0
C234 a_7147_8261# a_4844_6128# 0.01201f
C235 a_782_8839# a_3956_8000# 0.16311f
C236 a_4548_2480# a_4844_6128# 0
C237 a_9817_3381# a_7104_8039# 0
C238 a_13944_5599# a_4252_3368# 0.22483f
C239 a_7104_8039# a_4844_608# 0
C240 a_11778_619# a_11684_619# 0.17305f
C241 iin a_10864_619# 0.00307f
C242 c1 a_7147_10701# 0.00114f
C243 a_8144_3159# a_9817_3381# 0
C244 vdd a_9384_10479# 0.686f
C245 a_8144_3159# a_4844_608# 0
C246 a_9384_5599# a_4252_3368# 0.01219f
C247 a_7198_4176# a_7104_3159# 0.32985f
C248 a_7104_3159# a_7147_10701# 0.02987f
C249 a_782_1129# a_1374_1129# 0.15162f
C250 a_8264_719# a_8858_3159# 0
C251 a_9384_3159# a_8264_719# 0
C252 a_7104_5599# a_7104_8039# 0
C253 a_4252_6128# a_4252_3368# 0.05452f
C254 a_9384_8039# a_10424_5599# 0
C255 a_10424_3159# a_12704_3159# 0.00109f
C256 c1 a_7304_719# 1.64587f
C257 a_10864_619# a_3956_2480# 0
C258 a_8144_3159# a_7104_5599# 0
C259 a_7147_3381# a_12638_619# 0.16388f
C260 vdd a_11684_619# 3.09502f
C261 a_8144_3159# a_10424_3159# 0.00109f
C262 vdd a_11758_9056# 0.75642f
C263 vdd a_14038_9056# 0.75642f
C264 a_14984_3159# vdd 0.71516f
C265 a_11664_5599# a_11684_619# 0
C266 a_9817_3381# a_4844_6128# 0.00273f
C267 a_4844_608# a_4844_6128# 0.08091f
C268 a_9478_6616# a_8144_5599# 0
C269 a_14984_8039# a_3956_8000# 0.17595f
C270 a_12704_5599# a_3956_6128# 0
C271 a_12704_8039# a_11684_619# 0
C272 a_4548_5240# a_3956_8000# 0.0424f
C273 a_7537_3381# vdd 3.0577f
C274 c1 c3 0.16803f
C275 a_7198_6616# a_3956_3368# 0.08646f
C276 a_3956_6128# a_4252_3368# 0.05059f
C277 a_13944_10479# a_4844_6128# 0.00594f
C278 a_3956_8000# a_4548_8000# 0.66454f
C279 a_12704_8039# a_11758_9056# 0
C280 iin a_782_8839# 0.21272f
C281 a_10424_3159# a_11664_3159# 0.0024f
C282 c3 a_7104_3159# 0
C283 a_12704_8039# a_14038_9056# 0
C284 a_13944_8039# a_14984_5599# 0
C285 a_2262_8839# a_4252_3368# 0
C286 a_7198_9056# a_7104_8039# 0.32985f
C287 a_4252_608# a_3956_2480# 2.79345f
C288 a_3956_8000# a_7104_10479# 0.01903f
C289 a_3956_8000# a_8858_3159# 0.51217f
C290 a_7147_3381# a_4252_3368# 0.00475f
C291 a_14038_11496# a_7147_10701# 0.06706f
C292 a_7147_8261# c1 0.00142f
C293 a_4844_3368# vdd 0.89064f
C294 a_7147_8261# a_7104_3159# 0.00156f
C295 a_14278_619# a_7784_719# 0.03722f
C296 a_3956_5240# a_3956_8000# 0.00152f
C297 a_9478_9056# a_3956_6128# 0.08456f
C298 a_8144_10479# a_9478_11496# 0
C299 a_7104_3159# a_4548_2480# 0.01219f
C300 a_7147_3381# a_7784_719# 0.1577f
C301 vdd a_17645_7756# 29.5894f
C302 a_782_8839# a_3956_2480# 2.43998f
C303 a_6824_719# a_7784_719# 0.12039f
C304 a_11758_4176# a_4548_2480# 0.02359f
C305 a_8144_10479# a_4548_8000# 0.03664f
C306 a_10864_619# a_12704_3159# 0.05397f
C307 a_8144_10479# a_7104_10479# 0.45397f
C308 a_13944_8039# a_4252_3368# 0.04071f
C309 a_8144_10479# a_8858_3159# 0.12226f
C310 vdd a_11758_6616# 0.75642f
C311 a_13944_3159# a_14984_5599# 0
C312 a_11778_619# a_7304_719# 0
C313 a_9384_8039# a_9384_10479# 0
C314 a_9384_10479# a_11664_10479# 0.004f
C315 iin a_9478_11496# 0.02359f
C316 iin a_14984_8039# 0
C317 vdd a_7198_4176# 0.75642f
C318 vdd a_7147_10701# 4.4963f
C319 a_8264_719# a_14278_619# 0
C320 a_7147_5821# a_3956_2480# 0.04388f
C321 a_3956_8000# a_12704_10479# 0
C322 a_11664_5599# a_11758_6616# 0.33051f
C323 a_3956_3368# a_4252_3368# 0.75798f
C324 ibias a_18877_1769# 2.15544f
C325 c1 a_9817_3381# 0.09323f
C326 iin a_4548_5240# 0.09374f
C327 a_8264_719# a_7147_3381# 0.56028f
C328 a_7147_5821# a_8144_5599# 0.05358f
C329 a_9817_3381# a_7104_3159# 0
C330 a_6824_719# a_8264_719# 0.13579f
C331 iin a_4548_8000# 0.71212f
C332 a_3956_8000# a_4252_6128# 0.47708f
C333 a_9318_619# a_7537_3381# 0.16467f
C334 a_11684_619# a_11664_10479# 0
C335 a_7304_719# vdd 0.95657f
C336 iin a_8858_3159# 1.01416f
C337 a_11664_3159# a_10864_619# 0.22213f
C338 iin a_7104_10479# 0.01219f
C339 a_11778_619# c3 0
C340 a_12704_3159# a_4252_608# 0.18303f
C341 a_10424_10479# a_4844_6128# 0.01144f
C342 ibias a_18619_4169# 2.31644f
C343 a_3956_5240# iin 0
C344 a_3956_8000# a_14984_10479# 0.00108f
C345 a_18619_4169# a_8858_3159# 1.54969f
C346 a_7104_5599# a_7104_3159# 0
C347 c0 a_7784_719# 0.13132f
C348 a_10864_619# a_4844_6128# 0.00871f
C349 a_4548_5240# a_3956_2480# 0.00284f
C350 a_7147_8261# a_11778_619# 0
C351 c1 a_10424_3159# 0
C352 a_8144_3159# a_4252_608# 0.00308f
C353 a_13944_3159# a_7784_719# 0
C354 a_3956_2480# a_8858_3159# 0.37811f
C355 a_9384_3159# a_3956_2480# 0.26381f
C356 a_4548_5240# a_8144_5599# 0
C357 a_7198_6616# a_4252_3368# 0.02359f
C358 a_8144_10479# a_4252_6128# 0.24177f
C359 vdd a_13458_619# 0.01479f
C360 a_7147_5821# a_14038_6616# 0.06706f
C361 vdd c3 1.05311f
C362 a_10424_3159# a_11758_4176# 0
C363 a_9478_4176# a_4548_2480# 0.02359f
C364 a_3956_5240# a_3956_2480# 0.00288f
C365 a_3956_8000# a_3956_6128# 2.82128f
C366 a_8144_3159# a_782_8839# 0.24177f
C367 a_8144_5599# a_8858_3159# 0.12227f
C368 a_4844_3368# a_9384_8039# 0.26381f
C369 vdd a_14038_4176# 0.75642f
C370 vdd a_8144_8039# 0.70093f
C371 a_4844_3368# a_10424_5599# 0
C372 a_11664_3159# a_4252_608# 0.25664f
C373 a_3956_8000# a_2262_8839# 0.00433f
C374 a_7147_8261# vdd 2.90883f
C375 a_3956_5240# a_8144_5599# 0.00308f
C376 vdd a_4548_2480# 2.98956f
C377 iin a_12704_10479# 0.00853f
C378 a_12704_5599# a_14984_5599# 0.00109f
C379 c2 a_11664_3159# 0
C380 a_8264_719# c0 0.15367f
C381 a_14984_5599# a_4252_3368# 0.17595f
C382 a_1966_1129# a_4548_2480# 0
C383 a_7537_3381# a_7198_11496# 0.06799f
C384 a_4252_608# a_4844_6128# 0
C385 a_7147_5821# a_7104_8039# 0
C386 a_13944_3159# a_8264_719# 0
C387 a_11664_5599# a_7147_8261# 0
C388 a_11664_5599# a_4548_2480# 0.01903f
C389 iin a_4252_6128# 0.05676f
C390 a_14038_11496# a_13944_10479# 0.33075f
C391 a_7784_719# a_12638_619# 0.03722f
C392 a_12704_8039# a_7147_8261# 0.05358f
C393 a_10424_5599# a_11758_6616# 0
C394 a_9318_619# a_7304_719# 0.03765f
C395 a_14038_6616# a_8858_3159# 0.01647f
C396 a_782_8839# a_4844_6128# 0.18591f
C397 a_9384_5599# a_3956_2480# 0
C398 a_13944_8039# a_3956_8000# 0.22483f
C399 c1 a_10958_619# 0.03808f
C400 iin a_14984_10479# 0.17595f
C401 a_9384_8039# a_7147_10701# 0
C402 a_782_1129# a_4548_2480# 0
C403 a_12704_5599# a_4252_3368# 0.00853f
C404 a_7147_10701# a_11664_10479# 0.77372f
C405 a_9817_3381# a_9478_4176# 0.12089f
C406 a_3956_5240# a_14038_6616# 0
C407 a_9384_5599# a_8144_5599# 0.0024f
C408 a_4252_6128# a_3956_2480# 0
C409 a_10424_8039# vdd 0.70625f
C410 a_7104_8039# a_4548_5240# 0.27432f
C411 c1 a_10864_619# 0.31206f
C412 a_7147_5821# a_11664_3159# 0
C413 a_3956_8000# a_3956_3368# 0.00115f
C414 a_9817_3381# vdd 2.95148f
C415 a_12704_3159# a_8858_3159# 0.12273f
C416 vdd a_4844_608# 0.64203f
C417 a_7104_8039# a_7104_10479# 0
C418 a_7104_8039# a_8858_3159# 0.10261f
C419 a_11758_11496# iin 0.02359f
C420 a_7147_10701# a_15098_619# 0.16388f
C421 iin a_3956_6128# 0.04316f
C422 a_8264_719# a_12638_619# 0.03701f
C423 a_3956_5240# a_12704_3159# 0
C424 a_7147_5821# a_4844_6128# 0.00347f
C425 a_2558_1129# a_4548_2480# 0
C426 a_9318_619# c3 0.00287f
C427 a_1966_1129# a_4844_608# 0.00792f
C428 a_10864_619# a_11758_4176# 0.12441f
C429 a_8144_3159# a_8858_3159# 0.12181f
C430 a_8144_3159# a_9384_3159# 0.0024f
C431 a_3956_5240# a_7104_8039# 0
C432 a_13944_10479# vdd 0.70096f
C433 iin a_2262_8839# 0.07263f
C434 a_12704_8039# a_10424_8039# 0.00109f
C435 a_7198_11496# a_7147_10701# 0.06762f
C436 a_14038_6616# a_13944_5599# 0.33075f
C437 a_10424_3159# a_9478_4176# 0
C438 a_9318_619# a_7147_8261# 0
C439 a_7104_5599# vdd 0.68314f
C440 a_11684_619# a_14038_9056# 0.12794f
C441 a_3956_2480# a_3956_6128# 0.00309f
C442 a_14984_3159# a_11684_619# 0.05446f
C443 a_10424_3159# vdd 0.70625f
C444 a_9478_11496# a_4844_6128# 0.08456f
C445 a_4844_3368# a_9384_10479# 0
C446 a_4844_608# a_782_1129# 0.12231f
C447 a_11664_3159# a_8858_3159# 0.32718f
C448 a_9384_3159# a_11664_3159# 0.004f
C449 a_4548_5240# a_4844_6128# 0.06378f
C450 a_7147_3381# a_3956_2480# 0.07254f
C451 c2 c1 0.20434f
C452 a_4252_608# a_7104_3159# 0.04638f
C453 a_4548_8000# a_4844_6128# 2.81263f
C454 a_9384_8039# a_8144_8039# 0.0024f
C455 c2 a_7104_3159# 0
C456 a_7147_8261# a_9384_8039# 0.77354f
C457 a_7104_10479# a_4844_6128# 0.04719f
C458 a_7147_8261# a_11664_10479# 0
C459 a_4844_6128# a_8858_3159# 0.41512f
C460 a_4252_608# a_11758_4176# 0.10473f
C461 a_10424_5599# a_4548_2480# 0
C462 c3 a_15098_619# 0.0371f
C463 a_2558_1129# a_4844_608# 0.0018f
C464 a_782_8839# a_7104_3159# 0.27432f
C465 a_3956_5240# a_4844_6128# 0.05449f
C466 a_4844_3368# a_11758_9056# 0
C467 a_8264_719# a_7784_719# 0.30695f
C468 iin a_3956_3368# 0
C469 a_3956_8000# a_14984_5599# 0
C470 a_7198_9056# vdd 0.75642f
C471 a_9318_619# a_9817_3381# 0.01662f
C472 a_9384_10479# a_7147_10701# 0.77354f
C473 a_11778_619# a_10864_619# 0.11618f
C474 a_4844_3368# a_7537_3381# 0.05659f
C475 a_7147_5821# c1 0.00889f
C476 a_14984_3159# a_17645_7756# 0
C477 a_7147_5821# a_7104_3159# 0.00127f
C478 vdd a_10958_619# 0.01471f
C479 a_3956_2480# a_3956_3368# 0.11611f
C480 a_10424_8039# a_9384_8039# 0.45427f
C481 vdd a_10424_10479# 0.70625f
C482 a_11684_619# a_7147_10701# 0.14479f
C483 a_12704_10479# a_4844_6128# 0.18303f
C484 a_9817_3381# a_9384_8039# 0.22089f
C485 a_8144_5599# a_3956_3368# 0.03664f
C486 a_7147_5821# a_11758_4176# 0
C487 a_3956_8000# a_4252_3368# 0.06664f
C488 vdd a_10864_619# 2.98303f
C489 a_7104_8039# a_3956_6128# 0.04638f
C490 a_9817_3381# a_10424_5599# 0.0538f
C491 a_11758_9056# a_7147_10701# 0
C492 c1 a_10138_619# 0.0013f
C493 a_7147_10701# a_14038_9056# 0
C494 a_7147_3381# a_12704_3159# 0.05358f
C495 a_4252_6128# a_4844_6128# 1.04043f
C496 a_14984_3159# a_7147_10701# 0
C497 a_4548_2480# a_1374_1129# 0
C498 a_9478_6616# vdd 0.75642f
C499 a_13944_10479# a_11664_10479# 0.004f
C500 a_7304_719# a_11684_619# 0.0379f
C501 vdd a_11664_8039# 0.68879f
C502 a_11664_5599# a_10864_619# 0.22213f
C503 c2 a_11778_619# 0
C504 a_8144_3159# a_7147_3381# 0.05358f
C505 a_3956_8000# a_9478_9056# 0.02359f
C506 a_7537_3381# a_7147_10701# 0.43262f
C507 a_7537_3381# a_7198_4176# 0.11738f
C508 a_9384_3159# c1 0
C509 a_12704_8039# a_10864_619# 0.05397f
C510 a_7104_3159# a_8858_3159# 0.10013f
C511 a_9384_3159# a_7104_3159# 0.004f
C512 a_11664_5599# a_11664_8039# 0
C513 a_9478_4176# a_4252_608# 0.08456f
C514 a_4844_3368# a_7147_10701# 0.0555f
C515 a_7147_8261# a_9384_10479# 0
C516 a_12704_8039# a_11664_8039# 0.45438f
C517 a_7198_6616# a_8144_5599# 0
C518 a_11758_4176# a_8858_3159# 0.01545f
C519 a_7537_3381# a_7304_719# 0.31243f
C520 a_11684_619# a_13458_619# 0.03182f
C521 vdd a_4252_608# 1.23561f
C522 a_11758_11496# a_4844_6128# 0.10473f
C523 a_11664_3159# a_7147_3381# 0.77375f
C524 a_782_8839# a_9478_4176# 0
C525 a_3956_6128# a_4844_6128# 0.682f
C526 c2 vdd 1.02699f
C527 c3 a_11684_619# 0.18081f
C528 a_1966_1129# a_4252_608# 0
C529 a_14038_4176# a_11684_619# 0.12794f
C530 a_11664_5599# a_4252_608# 0
C531 a_2262_8839# a_4844_6128# 0.05944f
C532 a_7147_8261# a_11684_619# 0.24351f
C533 a_4844_608# a_1374_1129# 0.02882f
C534 a_11684_619# a_4548_2480# 0.08649f
C535 a_7147_5821# a_11778_619# 0
C536 vdd a_782_8839# 0.64203f
C537 a_7104_8039# a_3956_3368# 0
C538 a_14984_3159# c3 0
C539 iin a_4252_3368# 0.01371f
C540 a_7147_8261# a_11758_9056# 0.06762f
C541 a_1966_1129# a_782_8839# 0.01376f
C542 a_7147_8261# a_14038_9056# 0.06706f
C543 a_14984_3159# a_14038_4176# 0
C544 a_9318_619# a_10864_619# 0
C545 a_13944_3159# a_12704_3159# 0.0024f
C546 a_782_1129# a_4252_608# 0.0619f
C547 a_7537_3381# c3 0.15773f
C548 a_10424_8039# a_9384_10479# 0
C549 a_7147_5821# a_9478_4176# 0
C550 a_14984_3159# a_4548_2480# 0.17595f
C551 a_7198_4176# a_7147_10701# 0.00342f
C552 a_7537_3381# a_8144_8039# 0.05328f
C553 a_9817_3381# a_9384_10479# 0.13911f
C554 a_7147_8261# a_7537_3381# 0.2486f
C555 a_14038_11496# a_8858_3159# 0.01856f
C556 a_7537_3381# a_4548_2480# 0.06872f
C557 a_9384_8039# a_10424_10479# 0
C558 a_7147_5821# vdd 2.64317f
C559 a_3956_2480# a_4252_3368# 0.06398f
C560 a_10424_10479# a_11664_10479# 0.0024f
C561 a_782_8839# a_782_1129# 0.01006f
C562 a_4844_3368# a_8144_8039# 0.03664f
C563 a_7304_719# a_7147_10701# 0.00198f
C564 a_9384_8039# a_10864_619# 0
C565 a_8144_5599# a_4252_3368# 0.00153f
C566 a_4844_3368# a_7147_8261# 0.07372f
C567 a_2558_1129# a_4252_608# 0
C568 a_10864_619# a_11664_10479# 0.1393f
C569 a_4844_3368# a_4548_2480# 0.08258f
C570 a_10864_619# a_10424_5599# 0
C571 a_14038_6616# a_14984_5599# 0
C572 a_11664_5599# a_7147_5821# 0.77372f
C573 a_18619_4169# out 2.6926f
C574 a_11664_3159# c0 0
C575 ibias en 0.10378f
C576 a_3956_3368# a_4844_6128# 0.05017f
C577 a_10424_8039# a_11758_9056# 0
C578 a_9817_3381# a_11684_619# 0
C579 vdd a_9478_11496# 0.75642f
C580 vdd a_14984_8039# 0.71684f
C581 a_9384_8039# a_11664_8039# 0.004f
C582 a_9478_6616# a_10424_5599# 0
C583 vdd a_10138_619# 0.01471f
C584 a_13944_3159# a_11664_3159# 0.004f
C585 a_11664_8039# a_11664_10479# 0
C586 a_2558_1129# a_782_8839# 0.02238f
C587 a_17645_7756# a_4548_2480# 0
C588 c2 a_9318_619# 0
C589 a_9478_4176# a_8858_3159# 0.01442f
C590 a_9384_3159# a_9478_4176# 0.33022f
C591 vdd a_4548_5240# 0.64203f
C592 a_13944_10479# a_11684_619# 0.15159f
C593 vdd a_4548_8000# 0.89487f
C594 a_7147_8261# a_11758_6616# 0
C595 vdd a_7104_10479# 0.69602f
C596 c3 a_7147_10701# 0.24518f
C597 vdd a_8858_3159# 10.8924f
C598 a_9384_3159# vdd 0.68695f
C599 a_14038_6616# a_12704_5599# 0
C600 c1 a_7147_3381# 0.01708f
C601 a_12704_8039# a_14984_8039# 0.00109f
C602 c1 a_6824_719# 1.5214f
C603 a_14038_11496# a_12704_10479# 0
C604 a_7537_3381# a_9817_3381# 0.03052f
C605 a_7537_3381# a_4844_608# 0.07377f
C606 a_14038_6616# a_4252_3368# 0.04358f
C607 a_8144_10479# a_3956_8000# 0
C608 a_7147_3381# a_7104_3159# 0.77453f
C609 a_3956_5240# vdd 1.23561f
C610 a_4844_3368# a_10424_8039# 0.21091f
C611 a_7147_8261# a_7147_10701# 3.40603f
C612 a_7198_4176# a_4548_2480# 0.02359f
C613 a_7147_10701# a_4548_2480# 0.05354f
C614 a_11664_5599# a_8858_3159# 0.33645f
C615 a_7147_3381# a_11758_4176# 0.06762f
C616 a_4844_3368# a_9817_3381# 0.0733f
C617 a_7304_719# c3 0.17315f
C618 a_4844_3368# a_4844_608# 0.04146f
C619 a_11664_5599# a_3956_5240# 0.25664f
C620 a_12704_8039# a_8858_3159# 0.12319f
C621 a_7537_3381# a_7104_5599# 0.21944f
C622 a_9318_619# a_7147_5821# 0
C623 a_7147_8261# a_7304_719# 0.00351f
C624 a_14038_11496# a_14984_10479# 0
C625 a_7104_8039# a_4252_3368# 0.01903f
C626 c2 a_15098_619# 0.03973f
C627 vdd a_13944_5599# 0.70067f
C628 iin a_3956_8000# 0.06466f
C629 a_12704_3159# a_7784_719# 0
C630 a_10424_10479# a_9384_10479# 0.45427f
C631 vdd a_12704_10479# 0.7114f
C632 c3 a_13458_619# 0
C633 vdd a_9384_5599# 0.686f
C634 a_11664_5599# a_13944_5599# 0.004f
C635 a_10864_619# a_9384_10479# 0
C636 a_7147_5821# a_9384_8039# 0
C637 a_7147_8261# a_13458_619# 0
C638 a_9817_3381# a_7147_10701# 0.19729f
C639 vdd a_4252_6128# 0.65438f
C640 a_11664_3159# a_12704_5599# 0
C641 a_7147_5821# a_10424_5599# 0.05358f
C642 a_4844_608# a_7147_10701# 0.05324f
C643 c1 c0 0.41481f
C644 a_7147_8261# c3 0.24229f
C645 a_11664_5599# a_9384_5599# 0.004f
C646 a_11684_619# a_10958_619# 0
C647 a_7147_8261# a_8144_8039# 0.05358f
C648 a_4252_608# a_1374_1129# 0
C649 a_14038_4176# a_4548_2480# 0.04358f
C650 a_13944_10479# a_7147_10701# 0.35866f
C651 iin a_8144_10479# 0.00153f
C652 a_7198_9056# a_7537_3381# 0.11738f
C653 vdd a_14984_10479# 0.71543f
C654 a_7147_8261# a_4548_2480# 0.04332f
C655 a_4252_3368# a_4844_6128# 0.05917f
C656 a_9817_3381# a_7304_719# 0.31586f
C657 a_10864_619# a_11684_619# 0.35056f
C658 a_7104_5599# a_7147_10701# 0.01135f
C659 a_11778_619# a_7147_3381# 0
C660 a_11778_619# a_6824_719# 0.00203f
C661 a_8264_719# a_12704_3159# 0
C662 a_11664_3159# a_7784_719# 0
C663 a_10864_619# a_11758_9056# 0.12441f
C664 a_9384_8039# a_4548_5240# 0
C665 a_782_8839# a_1374_1129# 0.01006f
C666 a_4844_3368# a_7198_9056# 0.08646f
C667 a_10424_3159# a_7147_10701# 0
C668 a_4548_8000# a_11664_10479# 0.00206f
C669 a_11664_8039# a_11684_619# 0
C670 a_11758_11496# vdd 0.75642f
C671 a_7147_3381# a_9478_4176# 0.06762f
C672 a_9384_8039# a_8858_3159# 0.33457f
C673 vdd a_3956_6128# 1.23579f
C674 a_11664_10479# a_8858_3159# 0.34003f
C675 vdd a_14278_619# 0.0148f
C676 a_11758_9056# a_11664_8039# 0.33051f
C677 a_10424_5599# a_8858_3159# 0.12311f
C678 a_9384_3159# a_10424_5599# 0
C679 a_7537_3381# a_10864_619# 0
C680 a_3956_5240# a_9384_8039# 0
C681 vdd a_7147_3381# 2.70985f
C682 a_18877_1769# a_18619_4169# 1.45908f
C683 a_6824_719# vdd 0.87814f
C684 a_3956_5240# a_10424_5599# 0.01144f
C685 a_9817_3381# c3 0.12043f
C686 a_10424_8039# a_8144_8039# 0.00109f
C687 a_10424_8039# a_7147_8261# 0.05358f
C688 a_11684_619# a_4252_608# 0
C689 a_4844_3368# a_10864_619# 0
C690 a_8264_719# a_11664_3159# 0
C691 a_9817_3381# a_8144_8039# 0
C692 a_12704_8039# a_3956_6128# 0.18303f
C693 a_11664_5599# a_7147_3381# 0
C694 a_4548_8000# a_7198_11496# 0.08646f
C695 a_7147_8261# a_9817_3381# 0.24573f
C696 a_7147_8261# a_4844_608# 0.05351f
C697 c2 a_11684_619# 0.28394f
C698 a_9817_3381# a_4548_2480# 0.06765f
C699 a_4844_608# a_4548_2480# 0.59769f
C700 a_7198_11496# a_8858_3159# 0
C701 a_7198_9056# a_7147_10701# 0.00347f
C702 a_7104_10479# a_7198_11496# 0.32985f
C703 a_4844_3368# a_11664_8039# 0.00206f
C704 a_7147_8261# a_13944_10479# 0
C705 a_13944_8039# vdd 0.70166f
C706 a_7104_8039# a_3956_8000# 0.01219f
C707 a_7104_5599# a_8144_8039# 0
C708 a_11778_619# c0 0.04062f
C709 c2 a_14984_3159# 0
C710 a_7147_8261# a_7104_5599# 0.00147f
C711 a_7104_5599# a_4548_2480# 0.01903f
C712 a_7537_3381# a_4252_608# 0.05655f
C713 a_9384_8039# a_9384_5599# 0
C714 a_12704_10479# a_11664_10479# 0.45438f
C715 a_10864_619# a_11758_6616# 0.12441f
C716 a_9384_5599# a_10424_5599# 0.45427f
C717 a_10424_10479# a_7147_10701# 0.05358f
C718 c2 a_7537_3381# 0.24714f
C719 a_10424_3159# a_4548_2480# 0.00153f
C720 vdd a_3956_3368# 0.89531f
C721 a_10864_619# a_7147_10701# 0.1973f
C722 a_4844_3368# a_4252_608# 0.04972f
C723 a_12704_8039# a_13944_8039# 0.0024f
C724 a_7537_3381# a_782_8839# 0.07377f
C725 a_9384_10479# a_9478_11496# 0.33022f
C726 a_10424_8039# a_9817_3381# 0.0538f
C727 a_1966_1129# a_3956_3368# 0
C728 a_7147_5821# a_11684_619# 0.17566f
C729 c0 vdd 0.72685f
C730 a_7304_719# a_10958_619# 0
C731 c1 a_7784_719# 0.18367f
C732 a_4844_3368# a_1670_8839# 0.06755f
C733 a_7104_8039# a_8144_10479# 0
C734 a_11664_5599# a_3956_3368# 0.00206f
C735 a_7104_3159# a_7784_719# 0
C736 a_9817_3381# a_4844_608# 0
C737 a_13944_3159# vdd 0.70894f
C738 a_11664_8039# a_7147_10701# 0
C739 a_4844_3368# a_782_8839# 0.18257f
C740 a_9318_619# a_7147_3381# 0
C741 a_9384_10479# a_4548_8000# 0.26381f
C742 a_7304_719# a_10864_619# 0.07317f
C743 a_9318_619# a_6824_719# 0.03889f
C744 a_9384_10479# a_7104_10479# 0.004f
C745 a_9384_10479# a_8858_3159# 0.33805f
C746 a_3956_8000# a_4844_6128# 0.1017f
C747 a_14984_8039# a_11684_619# 0.05446f
C748 a_782_1129# a_3956_3368# 0
C749 a_7198_9056# a_8144_8039# 0
C750 a_4252_6128# a_7198_11496# 0.12113f
C751 a_9817_3381# a_7104_5599# 0
C752 a_7198_9056# a_7147_8261# 0.06762f
C753 a_7104_5599# a_4844_608# 0.27432f
C754 a_7147_5821# a_7537_3381# 0.27328f
C755 a_11758_11496# a_11664_10479# 0.33051f
C756 a_9384_8039# a_3956_6128# 0.04701f
C757 a_1078_8839# a_1670_8839# 0.15162f
C758 vdd a_7198_6616# 0.75642f
C759 a_3956_6128# a_11664_10479# 0
C760 a_14984_8039# a_14038_9056# 0
C761 c3 a_10958_619# 0
C762 a_7198_4176# a_4252_608# 0.08456f
C763 a_4252_608# a_7147_10701# 0.04455f
C764 a_9817_3381# a_10424_3159# 0.0538f
C765 c1 a_8264_719# 0.12646f
C766 a_1078_8839# a_782_8839# 0.47722f
C767 a_4844_3368# a_7147_5821# 0.00667f
C768 a_10864_619# a_13458_619# 0
C769 c2 a_7147_10701# 0.08921f
C770 a_11684_619# a_8858_3159# 0.59342f
C771 a_8264_719# a_7104_3159# 0
C772 a_7147_8261# a_10958_619# 0
C773 a_10864_619# c3 0.09176f
C774 a_2558_1129# a_3956_3368# 0
C775 a_3956_5240# a_11684_619# 0
C776 a_8144_10479# a_4844_6128# 0.00308f
C777 vdd a_12638_619# 0.01482f
C778 a_11758_9056# a_8858_3159# 0.01545f
C779 a_7537_3381# a_10138_619# 0
C780 a_14038_9056# a_8858_3159# 0.01647f
C781 a_782_8839# a_7198_4176# 0.12113f
C782 a_782_8839# a_7147_10701# 0.05419f
C783 a_14984_3159# a_8858_3159# 0.12284f
C784 a_7147_8261# a_10864_619# 0.24636f
C785 a_7537_3381# a_4548_5240# 0.07377f
C786 vdd a_14984_5599# 0.71516f
C787 c2 a_7304_719# 1.25519f
C788 a_10864_619# a_4548_2480# 0.06765f
C789 a_7537_3381# a_4548_8000# 0.00279f
C790 a_7537_3381# a_7104_10479# 0.13889f
C791 a_9478_6616# a_7147_8261# 0
C792 a_7537_3381# a_8858_3159# 0.19078f
C793 a_8144_3159# a_3956_2480# 0.03664f
C794 a_4844_3368# a_4548_5240# 2.55927f
C795 a_7147_5821# a_11758_6616# 0.06762f
C796 a_7104_8039# a_8144_5599# 0
C797 a_9318_619# c0 0.01391f
C798 a_7147_8261# a_11664_8039# 0.77372f
C799 a_4844_3368# a_4548_8000# 0.03215f
C800 a_4252_6128# a_9384_10479# 0
C801 a_14984_8039# a_17645_7756# 0
C802 a_3956_5240# a_7537_3381# 0.05655f
C803 a_11778_619# a_7784_719# 0
C804 a_7147_5821# a_7198_4176# 0
C805 a_13944_5599# a_11684_619# 0.2385f
C806 a_4844_3368# a_7104_10479# 0
C807 a_4844_3368# a_8858_3159# 0.38019f
C808 a_7147_5821# a_7147_10701# 0.07742f
C809 iin a_4844_6128# 3.2343f
C810 vdd a_12704_5599# 0.7114f
C811 c2 a_13458_619# 0.03739f
C812 a_11684_619# a_12704_10479# 0
C813 a_9384_8039# a_3956_3368# 0
C814 vdd a_4252_3368# 2.98956f
C815 a_4844_3368# a_3956_5240# 0.09004f
C816 ibias a_17645_7756# 0
C817 a_10424_5599# a_3956_3368# 0.21091f
C818 c2 c3 0.44565f
C819 a_14038_4176# a_4252_608# 0
C820 a_11664_3159# a_3956_2480# 0.00206f
C821 a_9817_3381# a_10958_619# 0.00168f
C822 a_14984_3159# a_13944_5599# 0
C823 a_17645_7756# a_8858_3159# 2.40745f
C824 a_9817_3381# a_10424_10479# 0.03935f
C825 a_7147_8261# a_4252_608# 0.03355f
C826 a_1078_8839# a_4548_5240# 0.05976f
C827 a_10424_8039# a_10864_619# 0
C828 a_4252_608# a_4548_2480# 3.1925f
C829 a_11664_5599# a_12704_5599# 0.45438f
C830 a_7147_5821# a_7304_719# 0.02137f
C831 a_7147_10701# a_9478_11496# 0.06762f
C832 c2 a_7147_8261# 0.1218f
C833 a_11664_5599# a_4252_3368# 0.01219f
C834 c2 a_4548_2480# 0
C835 a_3956_2480# a_4844_6128# 0
C836 a_9817_3381# a_10864_619# 0.01227f
C837 vdd a_7784_719# 1.25646f
C838 vdd a_9478_9056# 0.75642f
C839 a_11758_6616# a_8858_3159# 0.01545f
C840 a_4548_5240# a_7147_10701# 0.06356f
C841 a_10424_8039# a_11664_8039# 0.0024f
C842 a_12704_8039# a_4252_3368# 0
C843 a_11684_619# a_14984_10479# 0.03935f
C844 a_9384_10479# a_3956_6128# 0
C845 a_7147_8261# a_782_8839# 0.04319f
C846 a_11778_619# a_8264_719# 0
C847 a_9478_6616# a_9817_3381# 0.12089f
C848 a_3956_5240# a_1078_8839# 0
C849 a_4548_8000# a_7147_10701# 0.07158f
C850 a_9478_6616# a_4844_608# 0
C851 a_782_8839# a_4548_2480# 0.16987f
C852 vdd out 7.13827f
C853 a_3956_5240# a_11758_6616# 0.10473f
C854 a_7104_10479# a_7147_10701# 0.77944f
C855 a_7147_10701# a_8858_3159# 0.52305f
C856 a_9384_3159# a_7147_10701# 0.01852f
C857 a_7304_719# a_10138_619# 0.03765f
C858 a_7537_3381# a_4252_6128# 0.00837f
C859 a_7147_5821# a_13458_619# 0.16388f
C860 a_3956_5240# a_7147_10701# 0.0436f
C861 a_7147_5821# c3 0.04354f
C862 a_10424_3159# a_10864_619# 0
C863 a_13944_5599# a_17645_7756# 0
C864 a_11684_619# a_3956_6128# 0
C865 a_4844_3368# a_4252_6128# 0.03199f
C866 a_14278_619# a_11684_619# 0.02105f
C867 a_7147_5821# a_14038_4176# 0
C868 a_9384_3159# a_7304_719# 0
C869 a_8264_719# vdd 1.48841f
C870 a_7147_5821# a_7147_8261# 2.73297f
C871 a_11758_9056# a_3956_6128# 0.10473f
C872 a_7147_5821# a_4548_2480# 0.19202f
C873 a_9817_3381# a_4252_608# 0.05548f
C874 a_7147_3381# a_11684_619# 0.29055f
C875 a_4844_608# a_4252_608# 1.29586f
C876 a_3956_6128# a_14038_9056# 0
C877 a_3956_3368# a_1374_1129# 0
C878 a_6824_719# a_11684_619# 0.11085f
C879 c2 a_9817_3381# 0.08984f
C880 c3 a_10138_619# 0
C881 a_11664_3159# a_12704_3159# 0.45438f
C882 a_14984_3159# a_7147_3381# 0
C883 a_7537_3381# a_3956_6128# 0.05655f
C884 a_9817_3381# a_782_8839# 0
C885 a_7147_8261# a_14984_8039# 0
C886 a_782_8839# a_4844_608# 0.17408f
C887 a_7104_5599# a_4252_608# 0
C888 a_7147_8261# a_10138_619# 0
C889 a_7147_10701# a_12704_10479# 0.05358f
C890 a_4548_5240# a_8144_8039# 0.24177f
C891 a_7537_3381# a_7147_3381# 0.39867f
C892 c3 a_8858_3159# 0
C893 a_9384_3159# c3 0
C894 a_7147_8261# a_4548_5240# 0.08252f
C895 a_10424_3159# a_4252_608# 0.01144f
C896 a_4548_5240# a_4548_2480# 0.04975f
C897 a_13944_8039# a_11684_619# 0.2385f
C898 a_7537_3381# a_6824_719# 0.12269f
C899 a_9318_619# a_7784_719# 0
C900 a_4844_3368# a_3956_6128# 2.93638f
C901 c1 a_3956_2480# 0
C902 a_7147_8261# a_4548_8000# 0.00618f
C903 a_14038_4176# a_8858_3159# 0.01647f
C904 a_8144_8039# a_7104_10479# 0
C905 a_4252_6128# a_7147_10701# 0.07865f
C906 a_8144_8039# a_8858_3159# 0.12227f
C907 a_7104_5599# a_782_8839# 0
C908 a_12704_5599# a_10424_5599# 0.00109f
C909 a_7104_3159# a_3956_2480# 0.05082f
C910 a_7147_8261# a_7104_10479# 0
C911 a_7147_8261# a_8858_3159# 0.49699f
C912 a_9384_3159# a_7147_8261# 0
C913 a_4548_2480# a_8858_3159# 0.51f
C914 a_9384_3159# a_4548_2480# 0.01219f
C915 a_13944_8039# a_14038_9056# 0.33075f
C916 a_9384_8039# a_4252_3368# 0.01903f
C917 a_4844_3368# a_7147_3381# 0.02505f
C918 a_4844_3368# a_2262_8839# 0.00165f
C919 a_10424_5599# a_4252_3368# 0.00153f
C920 a_10864_619# a_10958_619# 0.26871f
C921 a_7147_5821# a_9817_3381# 0.27009f
C922 a_3956_5240# a_7147_8261# 0.0439f
C923 a_7147_5821# a_4844_608# 0.08639f
C924 a_3956_5240# a_4548_2480# 0.14525f
C925 a_10424_10479# a_10864_619# 0
C926 a_14984_10479# a_7147_10701# 0
C927 a_7104_3159# a_8144_5599# 0
C928 a_11758_4176# a_3956_2480# 0
C929 vdd a_3956_8000# 2.98961f
C930 a_9384_8039# a_9478_9056# 0.33022f
C931 c0 a_11684_619# 0.27611f
C932 a_9318_619# a_8264_719# 0
C933 a_13944_3159# a_11684_619# 0.23851f
C934 a_9817_3381# a_9478_11496# 0.06805f
C935 a_7147_5821# a_7104_5599# 0.77449f
C936 a_11758_11496# a_7147_10701# 0.06762f
C937 a_9817_3381# a_10138_619# 0.17611f
C938 iin a_14038_11496# 0.04358f
C939 a_10424_8039# a_4548_8000# 0
C940 a_10864_619# a_11664_8039# 0.22213f
C941 a_7147_10701# a_3956_6128# 0.05588f
C942 a_14278_619# a_7147_10701# 0
C943 a_12704_8039# a_3956_8000# 0.00853f
C944 a_9817_3381# a_4548_5240# 0
C945 a_7537_3381# a_3956_3368# 0.05659f
C946 a_7784_719# a_15098_619# 0
C947 a_7147_8261# a_13944_5599# 0
C948 a_4548_5240# a_4844_608# 0.04694f
C949 a_10424_8039# a_8858_3159# 0.12311f
C950 a_13944_5599# a_4548_2480# 0.04071f
C951 a_8144_10479# vdd 0.70093f
C952 a_14984_3159# a_13944_3159# 0.46091f
C953 a_13944_10479# a_14984_8039# 0
C954 a_9817_3381# a_4548_8000# 0.00854f
C955 a_4844_608# a_4548_8000# 0
C956 a_7147_3381# a_7198_4176# 0.06762f
C957 a_7147_3381# a_7147_10701# 0.20327f
C958 a_13944_8039# a_17645_7756# 0
C959 a_6824_719# a_7147_10701# 0.00198f
C960 a_18877_1769# en 0.87755f
C961 a_7147_8261# a_9384_5599# 0
C962 a_7537_3381# c0 0.17785f
C963 a_4844_608# a_8858_3159# 0.28135f
C964 a_9817_3381# a_7104_10479# 0
C965 a_9817_3381# a_8858_3159# 0.59183f
C966 a_9384_3159# a_9817_3381# 0.22095f
C967 a_9384_5599# a_4548_2480# 0.01903f
C968 a_4844_3368# a_3956_3368# 0.79143f
C969 c2 a_10958_619# 0
C970 a_8144_8039# a_4252_6128# 0
C971 a_3956_5240# a_9817_3381# 0.05548f
C972 a_3956_5240# a_4844_608# 0.0514f
C973 a_7147_8261# a_4252_6128# 0.00236f
C974 a_4252_6128# a_4548_2480# 0
C975 a_10864_619# a_4252_608# 0.07381f
C976 a_13944_10479# a_8858_3159# 0.34336f
C977 a_7304_719# a_7147_3381# 0.08319f
C978 a_6824_719# a_7304_719# 0.29018f
C979 c2 a_10864_619# 0.08998f
C980 a_7104_5599# a_8858_3159# 0.10261f
C981 a_18619_4169# en 0.01991f
C982 a_11684_619# a_12638_619# 0.03182f
C983 a_13944_8039# a_7147_10701# 0
C984 a_8264_719# a_15098_619# 0
C985 iin vdd 2.99703f
C986 a_3956_5240# a_7104_5599# 0.04638f
C987 a_10424_3159# a_8858_3159# 0.12265f
C988 a_9384_3159# a_10424_3159# 0.45427f
C989 a_7537_3381# a_7198_6616# 0.11738f
C990 a_12704_3159# a_11758_4176# 0
C991 a_1078_8839# a_3956_3368# 0
C992 a_8144_3159# a_7104_3159# 0.45397f
C993 a_11684_619# a_14984_5599# 0.05446f
C994 a_3956_3368# a_11758_6616# 0
C995 a_9478_4176# a_3956_2480# 0.10781f
C996 a_14278_619# c3 0.0371f
C997 a_10424_8039# a_9384_5599# 0
C998 a_8144_8039# a_3956_6128# 0.00308f
C999 a_7147_10701# a_3956_3368# 0.04636f
C1000 a_7147_5821# a_10958_619# 0
C1001 a_7147_3381# c3 0.04631f
C1002 a_9384_5599# a_4844_608# 0
C1003 a_7147_8261# a_3956_6128# 0.07625f
C1004 a_7147_8261# a_14278_619# 0.16388f
C1005 a_9817_3381# a_9384_5599# 0.22089f
C1006 a_6824_719# c3 0.17408f
C1007 vdd a_3956_2480# 0.89064f
C1008 c1 a_11664_3159# 0
C1009 a_3956_6128# a_4548_2480# 0.03085f
C1010 c0 a_7147_10701# 0.00112f
C1011 a_7147_3381# a_14038_4176# 0.06706f
C1012 a_12704_5599# a_11684_619# 0
C1013 a_7147_5821# a_10864_619# 0.27363f
C1014 a_7147_8261# a_7147_3381# 0.06717f
C1015 a_7198_9056# a_4548_5240# 0.12113f
C1016 a_9817_3381# a_4252_6128# 0
C1017 a_4844_608# a_4252_6128# 0.1218f
C1018 a_9384_8039# a_3956_8000# 0.01219f
C1019 a_1966_1129# a_3956_2480# 0.00154f
C1020 a_7147_3381# a_4548_2480# 0.02867f
C1021 vdd a_8144_5599# 0.70093f
C1022 a_13944_3159# a_7147_10701# 0.02714f
C1023 a_7147_8261# a_6824_719# 0.00351f
C1024 a_13944_10479# a_12704_10479# 0.0024f
C1025 a_11684_619# a_4252_3368# 0.08649f
C1026 a_3956_8000# a_11664_10479# 0.01903f
C1027 a_11664_3159# a_11758_4176# 0.33051f
C1028 a_7104_5599# a_9384_5599# 0.004f
C1029 a_10424_10479# a_9478_11496# 0
C1030 a_9478_6616# a_7147_5821# 0.06762f
C1031 a_782_8839# a_4252_608# 1.33352f
C1032 a_7147_5821# a_11664_8039# 0
C1033 a_7304_719# c0 0.34715f
C1034 a_14984_3159# a_4252_3368# 0
C1035 a_10424_3159# a_9384_5599# 0
C1036 a_11684_619# a_7784_719# 0.17942f
C1037 a_1670_8839# a_782_8839# 0.32561f
C1038 a_10864_619# a_10138_619# 0
C1039 a_782_1129# a_3956_2480# 0.00154f
C1040 a_10424_10479# a_4548_8000# 0.21091f
C1041 a_7198_6616# a_7147_10701# 0.00342f
C1042 a_13944_10479# a_14984_10479# 0.46091f
C1043 a_17645_7756# a_14984_5599# 0
C1044 a_7147_8261# a_13944_8039# 0.35866f
C1045 a_10424_8039# a_3956_6128# 0.01144f
C1046 a_7537_3381# a_4252_3368# 0.06872f
C1047 a_10424_10479# a_8858_3159# 0.12563f
C1048 a_10864_619# a_4548_8000# 0
C1049 a_9817_3381# a_3956_6128# 0.05548f
C1050 a_14038_6616# vdd 0.75642f
C1051 a_4844_608# a_3956_6128# 0.06419f
C1052 a_7147_5821# a_4252_608# 0.0439f
C1053 a_10864_619# a_8858_3159# 0.59237f
C1054 a_9384_3159# a_10864_619# 0
C1055 a_4844_3368# a_4252_3368# 1.18396f
C1056 c2 a_7147_5821# 0.09004f
C1057 a_7537_3381# a_7784_719# 0.12962f
C1058 c0 c3 0.19186f
C1059 a_2558_1129# a_3956_2480# 0.00154f
C1060 a_3956_5240# a_10864_619# 0.07381f
C1061 a_7147_8261# a_3956_3368# 0.04666f
C1062 a_9817_3381# a_7147_3381# 0.39359f
C1063 a_9817_3381# a_6824_719# 0.19044f
C1064 a_3956_3368# a_4548_2480# 1.13294f
C1065 a_9478_6616# a_8858_3159# 0.01442f
C1066 a_6824_719# a_4844_608# 0.00183f
C1067 a_13944_3159# c3 0
C1068 a_11664_8039# a_8858_3159# 0.33645f
C1069 a_8264_719# a_11684_619# 0.3114f
C1070 a_7147_8261# c0 0.00139f
C1071 a_17645_7756# a_4252_3368# 0
C1072 a_7147_5821# a_782_8839# 0.05351f
C1073 a_3956_5240# a_9478_6616# 0.08456f
C1074 a_8144_3159# a_9478_4176# 0
C1075 vdd a_12704_3159# 0.7114f
C1076 a_13944_3159# a_14038_4176# 0.33075f
C1077 a_4844_3368# a_9478_9056# 0.10781f
C1078 a_7104_8039# vdd 0.68314f
C1079 a_8144_10479# a_7198_11496# 0
C1080 a_3956_5240# a_11664_8039# 0
C1081 a_14038_11496# a_4844_6128# 0
C1082 a_13944_3159# a_4548_2480# 0.22483f
C1083 a_12704_5599# a_11758_6616# 0
C1084 iin a_11664_10479# 0.01219f
C1085 a_7104_5599# a_7147_3381# 0
C1086 a_4548_5240# a_4252_608# 0.00441f
C1087 a_1078_8839# a_4252_3368# 0
C1088 c2 a_10138_619# 0
C1089 a_14984_3159# a_8264_719# 0
C1090 a_8144_3159# vdd 0.70093f
C1091 a_4252_3368# a_11758_6616# 0.02359f
C1092 a_11664_5599# a_12704_3159# 0
C1093 a_10424_3159# a_7147_3381# 0.05358f
C1094 a_10424_10479# a_12704_10479# 0.00109f
C1095 a_4548_5240# a_1670_8839# 0.03828f
C1096 a_4252_608# a_8858_3159# 0.41005f
C1097 a_9384_3159# a_4252_608# 0.04701f
C1098 c1 a_7104_3159# 0
C1099 a_7537_3381# a_8264_719# 0.16462f
C1100 a_7147_10701# a_4252_3368# 0.05329f
C1101 a_17645_7756# out 9.03007f
C1102 a_3956_8000# a_9384_10479# 0.01903f
C1103 a_10864_619# a_12704_10479# 0.03935f
C1104 a_7147_8261# a_7198_6616# 0
C1105 c2 a_9384_3159# 0
C1106 a_4548_5240# a_782_8839# 0.24544f
C1107 a_9384_5599# a_10864_619# 0
C1108 a_13944_8039# a_13944_10479# 0
C1109 a_3956_5240# a_4252_608# 0.00447f
C1110 a_782_8839# a_4548_8000# 0.12777f
C1111 c3 a_12638_619# 0
C1112 a_9817_3381# a_3956_3368# 0.0733f
C1113 a_11664_3159# vdd 0.69002f
C1114 iin a_7198_11496# 0.02359f
C1115 a_4844_608# a_3956_3368# 2.68254f
C1116 a_9478_6616# a_9384_5599# 0.33022f
C1117 a_3956_5240# a_1670_8839# 0
C1118 a_782_8839# a_8858_3159# 0.27927f
C1119 a_9384_3159# a_782_8839# 0
C1120 a_7784_719# a_7147_10701# 0.11409f
C1121 a_11664_8039# a_12704_10479# 0
C1122 a_9478_9056# a_7147_10701# 0
C1123 a_10424_5599# a_8144_5599# 0.00109f
C1124 a_3956_5240# a_782_8839# 0.15552f
C1125 a_7198_9056# a_3956_6128# 0.08456f
C1126 a_9817_3381# c0 0.17048f
C1127 a_7147_8261# a_12638_619# 0
C1128 c0 a_4844_608# 0.00113f
C1129 vdd a_4844_6128# 1.24118f
C1130 a_3956_8000# a_11684_619# 0.08649f
C1131 a_7147_5821# a_10138_619# 0
C1132 a_11664_5599# a_11664_3159# 0
C1133 a_8144_10479# a_9384_10479# 0.0024f
C1134 a_7104_5599# a_3956_3368# 0.05082f
C1135 a_7147_5821# a_4548_5240# 0.00294f
C1136 a_14984_5599# a_4548_2480# 0.00108f
C1137 a_3956_8000# a_11758_9056# 0.02359f
C1138 a_7304_719# a_7784_719# 0.14525f
C1139 a_3956_8000# a_14038_9056# 0.04358f
C1140 a_10424_3159# a_3956_3368# 0
C1141 a_11758_11496# a_10424_10479# 0
C1142 a_7147_5821# a_8858_3159# 0.49683f
C1143 a_9384_3159# a_7147_5821# 0
C1144 a_9384_5599# a_4252_608# 0
C1145 a_12704_8039# a_4844_6128# 0
C1146 a_7147_3381# a_10958_619# 0
C1147 a_7537_3381# a_3956_8000# 0.06872f
C1148 a_11758_11496# a_10864_619# 0.06809f
C1149 a_10864_619# a_3956_6128# 0.07381f
C1150 a_3956_5240# a_7147_5821# 0.07415f
C1151 a_7198_6616# a_4844_608# 0.12113f
C1152 a_6824_719# a_10958_619# 0.03889f
C1153 a_8264_719# a_7147_10701# 0.15976f
C1154 a_4252_6128# a_4252_608# 0
C1155 a_12704_5599# a_4548_2480# 0
C1156 a_4548_8000# a_9478_11496# 0.10781f
C1157 a_8144_8039# a_4252_3368# 0
C1158 a_7147_3381# a_10864_619# 0.41361f
C1159 a_7784_719# a_13458_619# 0
C1160 a_9478_11496# a_8858_3159# 0.01622f
C1161 a_7147_8261# a_4252_3368# 0.18831f
C1162 a_1670_8839# a_4252_6128# 0.02323f
C1163 a_4548_2480# a_4252_3368# 0.07728f
C1164 a_3956_2480# a_1374_1129# 0.00154f
C1165 a_6824_719# a_10864_619# 0.134f
C1166 a_14984_8039# a_8858_3159# 0.12364f
C1167 a_4844_3368# a_3956_8000# 0.03566f
C1168 a_4548_5240# a_4548_8000# 0.04038f
C1169 iin a_9384_10479# 0.01219f
C1170 a_11664_8039# a_3956_6128# 0.25664f
C1171 c3 a_7784_719# 2.12297f
C1172 a_11778_619# c1 0.03808f
C1173 a_7104_5599# a_7198_6616# 0.32985f
C1174 a_782_8839# a_4252_6128# 0.1179f
C1175 a_4548_5240# a_7104_10479# 0
C1176 a_8264_719# a_7304_719# 0.12801f
C1177 a_4548_5240# a_8858_3159# 0.28135f
C1178 a_9384_8039# a_7104_8039# 0.004f
C1179 a_7104_10479# a_4548_8000# 0.05163f
C1180 a_4548_8000# a_8858_3159# 0.38168f
C1181 a_7147_8261# a_7784_719# 0.08177f
C1182 a_8144_8039# a_9478_9056# 0
C1183 ibias a_8858_3159# 0.00641f
C1184 a_3956_8000# a_17645_7756# 0
C1185 a_3956_5240# a_4548_5240# 0.79832f
C1186 a_7147_8261# a_9478_9056# 0.06762f
C1187 a_7147_5821# a_13944_5599# 0.35866f
C1188 a_7537_3381# a_8144_10479# 0.03935f
C1189 a_7104_10479# a_8858_3159# 0.10266f
C1190 a_9384_3159# a_8858_3159# 0.3253f
C1191 a_3956_5240# a_4548_8000# 0.0015f
C1192 iin a_11684_619# 0.00916f
C1193 en vss 2.77602f
C1194 c3 vss 1.1079f
C1195 c2 vss 1.45248f
C1196 c1 vss 1.14827f
C1197 c0 vss 1.89688f
C1198 ibias vss 3.79449f
C1199 out vss 6.34135f
C1200 iin vss 3.71826f
C1201 vdd vss 0.24563p
C1202 a_15098_619# vss 0.40304f
C1203 a_14278_619# vss 0.40304f
C1204 a_13458_619# vss 0.40304f
C1205 a_12638_619# vss 0.40304f
C1206 a_11778_619# vss 0.40273f
C1207 a_10958_619# vss 0.40281f
C1208 a_10138_619# vss 0.40278f
C1209 a_9318_619# vss 0.40284f
C1210 a_7784_719# vss 0.82579f
C1211 a_8264_719# vss 0.72309f
C1212 a_6824_719# vss 1.27282f
C1213 a_7304_719# vss 0.90849f
C1214 a_18877_1769# vss 3.88377f
C1215 a_18619_4169# vss 1.83516f
C1216 a_4548_2480# vss 2.67403f
C1217 a_14984_3159# vss 0.38039f
C1218 a_4252_608# vss 1.89555f
C1219 a_12704_3159# vss 0.36448f
C1220 a_13944_3159# vss 1.29029f
C1221 a_3956_2480# vss 2.23788f
C1222 a_10424_3159# vss 0.36461f
C1223 a_11664_3159# vss 1.11419f
C1224 a_8144_3159# vss 0.3682f
C1225 a_9384_3159# vss 1.11435f
C1226 a_7104_3159# vss 1.2978f
C1227 a_7147_3381# vss 3.14436f
C1228 a_4252_3368# vss 2.99542f
C1229 a_14984_5599# vss 0.38039f
C1230 a_3956_5240# vss 1.79028f
C1231 a_12704_5599# vss 0.36448f
C1232 a_13944_5599# vss 1.26499f
C1233 a_3956_3368# vss 2.60537f
C1234 a_10424_5599# vss 0.36461f
C1235 a_11664_5599# vss 1.1131f
C1236 a_4844_608# vss 4.40936f
C1237 a_8144_5599# vss 0.3682f
C1238 a_9384_5599# vss 1.11356f
C1239 a_7104_5599# vss 1.29643f
C1240 a_7147_5821# vss 3.20339f
C1241 a_17645_7756# vss 2.70976f
C1242 a_3956_8000# vss 3.26004f
C1243 a_14984_8039# vss 0.37703f
C1244 a_3956_6128# vss 2.6726f
C1245 a_12704_8039# vss 0.36448f
C1246 a_13944_8039# vss 1.2639f
C1247 a_4844_3368# vss 2.36627f
C1248 a_10424_8039# vss 0.36461f
C1249 a_11664_8039# vss 1.1131f
C1250 a_4548_5240# vss 2.5217f
C1251 a_8144_8039# vss 0.3682f
C1252 a_9384_8039# vss 1.11356f
C1253 a_2558_1129# vss 0.76872f
C1254 a_2262_8839# vss 0.78198f
C1255 a_1966_1129# vss 0.6171f
C1256 a_1670_8839# vss 0.63004f
C1257 a_1374_1129# vss 0.61713f
C1258 a_1078_8839# vss 0.63006f
C1259 a_782_1129# vss 0.76884f
C1260 a_782_8839# vss 7.92844f
C1261 a_7104_8039# vss 1.29643f
C1262 a_7147_8261# vss 3.32392f
C1263 a_14984_10479# vss 0.37401f
C1264 a_4844_6128# vss 2.16454f
C1265 a_12704_10479# vss 0.36561f
C1266 a_13944_10479# vss 1.26607f
C1267 a_4548_8000# vss 1.58024f
C1268 a_10424_10479# vss 0.36573f
C1269 a_11664_10479# vss 1.11419f
C1270 a_8858_3159# vss 14.6712f
C1271 a_4252_6128# vss 2.98241f
C1272 a_8144_10479# vss 0.36943f
C1273 a_9384_10479# vss 1.11466f
C1274 a_7104_10479# vss 1.36978f
C1275 a_11684_619# vss 3.69743f
C1276 a_10864_619# vss 3.36622f
C1277 a_9817_3381# vss 3.15943f
C1278 a_7537_3381# vss 4.02356f
C1279 a_7147_10701# vss 4.65953f
.ends
