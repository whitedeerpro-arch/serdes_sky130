* PNP bandgap (voltage mode, PMOS sources) + constant-swing V->I reference (exploratory, 2026-11-03).
* Core: matched PMOS sources (gate vg) feed Q1 (1x) and R1 + Q2 (n x) -> PTAT current I = dVBE / R1;
* a third copy gives vbg = VBE3 + I R2 (flat for R2 / R1 ~ 10).  Rs above both core branches lifts the
* error-amplifier inputs from VBE (0.57-0.84 V) to ~0.9-1.05 V so a regular nfet pair works at 1.65 V
* over -40..85 C; the branch currents are forced equal by the mirror, so Rs adds no offset gain.  Only
* the zero-current state is degenerate (no resistor-only path as in a current-mode core, which had a
* continuum of false equilibria with the PNPs off): startup pulls vg down while the amplifier bias
* is off.
* V->I: a second amplifier holds vbg across r_ref (high_po, the CML load type) through PMOS Mv;
* PMOS copies of Mv (gate vgi) give iout0..3 = vbg / r_ref: constant swing for loads of the same type
* (docs/design/bias.md).  Mv and the copies are fingers of W 6 / L 4 (nfv = 4), the unit of the
* distribution copies in bias_dist.spice.  Resistors high_po; current sources pfet_lvt (|Vgs| 0.76-0.89 V at -40 C;
* a regular pfet needs ~1.3 V there, beyond the amplifier output range at 1.65 V).

.subckt serdes_bg_amp inp inn out vbn vdd vss
+ params: win=24 lin=5 wl=48 ll=12 wt=8 lt=4 w2=2 l2=2 wp2=48 lp2=4 cc=6p rz=20k
* out = +A (inp - inn).  First stage: NMOS pair (gates inn on the diode side, inp on the output side o1)
* with an LVT PMOS mirror.  Second stage: NMOS common source (gate o1) with an LVT PMOS load on the
* first-stage diode voltage: if the first stage collapses (inputs above its common-mode range) o1
* falls and the output goes high, which lowers the bandgap current -- no high-current lock-up.  (A PMOS
* common-source second stage with an NMOS sink on the self-bias had a DC solution at ~100 uA: more core
* current -> stronger sink -> lower vg -> more current.)  Systematic offset is kept small by long
* mirror loads (L 12) and a second-stage NMOS of W/L ~1 whose Vgs is near the diode voltage.  All PMOS
* are LVT: a regular pfet needs |Vgs| ~1.3 V at -40 C, which at 1.65 V left the input pair ~0.1 V of Vds.
Xt tail vbn vss vss serdes_nfet w={wt} l={lt}
Xa da inn tail vss serdes_nfet w={win} l={lin}
Xb o1 inp tail vss serdes_nfet w={win} l={lin}
Xla da da vdd vdd serdes_pfet_lvt w={wl} l={ll}
Xlb o1 da vdd vdd serdes_pfet_lvt w={wl} l={ll}
X2 out o1 vss vss serdes_nfet w={w2} l={l2}
Xp2 out da vdd vdd serdes_pfet_lvt w={wp2} l={lp2}
Rz o1 cz {rz}
Cc cz out {cc}
.ends serdes_bg_amp

.subckt serdes_bg_ota inp inn out vbn vdd vss
+ params: win=24 lin=5 wl=48 ll=12 wt=1 lt=8
* Single-stage OTA, out = +A (inp - inn) (diode side gate = inp, output side gate = inn).  Low current
* (tail ~1/8 of the bias diode's): the output node with its load capacitance is the dominant pole.
Xt tail vbn vss vss serdes_nfet w={wt} l={lt}
Xa da inp tail vss serdes_nfet w={win} l={lin}
Xb out inn tail vss serdes_nfet w={win} l={lin}
Xla da da vdd vdd serdes_pfet_lvt w={wl} l={ll}
Xlb out da vdd vdd serdes_pfet_lvt w={wl} l={ll}
.ends serdes_bg_ota

.subckt serdes_bandgap vbg iout0 iout1 iout2 iout3 vg vgi vdd vss
+ params: r1=11k r2=106.5k rs=50k n=8 wp=24 lp=8 wv=24 lv=4 wo=24 lo=4 nfv=4 cvgi=10p trim=15 lsb=780
* core PMOS sources: A, B, vbg branch, amplifier biases
Xm1 ta vg vdd vdd serdes_pfet_lvt w={wp} l={lp}
Xm2 tb vg vdd vdd serdes_pfet_lvt w={wp} l={lp}
Xm3 vbg vg vdd vdd serdes_pfet_lvt w={wp} l={lp}
Xm4 nb vg vdd vdd serdes_pfet_lvt w={wp} l={lp}
Xm5 nb2 vg vdd vdd serdes_pfet_lvt w={wp} l={lp}
Xrsa ta a vss sky130_fd_pr__res_high_po w=1 l={rs/317}
Xrsb tb b vss sky130_fd_pr__res_high_po w=1 l={rs/317}
Xq1 vss vss a sky130_fd_pr__pnp_05v5_W3p40L3p40
Xr1 b c vss sky130_fd_pr__res_high_po w=1 l={r1/317}
Xq2 vss vss c sky130_fd_pr__pnp_05v5_W3p40L3p40 m={n}
Xr2 vbg d vss sky130_fd_pr__res_high_po w=1 l={r2/317}
Xq3 vss vss d sky130_fd_pr__pnp_05v5_W3p40L3p40
* core amplifier: vg rises when tb > ta (current above the PTAT equilibrium)
Xbd nb nb vss vss serdes_nfet w=4 l=4
Xamp tb ta vg nb vdd vss serdes_bg_amp
* startup: while nb is low, st is high and Xsu pulls vg down
Xsp st vss vdd vdd serdes_pfet w=0.42 l=20
Xsn st nb vss vss serdes_nfet w=2 l=1
Xsu vg st vss vss serdes_nfet w=1 l=1
* V->I: Mv drives r_ref; a single-stage OTA holds its top (s) at vbg; outputs are copies of Mv.  The
* loop has an extra gain beta = gm(Mv) r_ref = (gm/Id) vbg ~ 10 (independent of the current): a
* two-stage amplifier put the crossing at 10-30 MHz beyond the s-node pole (oscillation).  The OTA
* runs at ~0.6 uA with cvgi (to vdd) as the dominant pole: crossing ~1 MHz below the s pole (~4 MHz).
Xbd2 nb2 nb2 vss vss serdes_nfet w=4 l=4
Xamp2 s vbg vgi nb2 vdd vss serdes_bg_ota
Cvgi vgi vdd {cvgi}
* slew helper: the OTA slews vgi at ~0.06 V/us (I_tail / cvgi, fixed by the stability choice), >10 us
* from Mv off at power-up.  Xk (gate vbg, source s) pulls vgi down while s < vbg - Vth; off (Vgs ~ 0)
* in regulation.
Xk vgi vbg s vss serdes_nfet w=1 l=4
Xmv s vgi vdd vdd serdes_pfet_lvt w={wv} l={lv} nf={nfv}
* r_ref with a 5-bit trim at its grounded end: 112 k fixed + binary segments lsb * 2^k, each shorted
* by an NMOS switch when its bit is 1 (gate at vdd; the segments sit below ~0.3 V, so Vgs is large).
* r_ref = 112k + sum (1 - b_k) lsb 2^k: code 31 -> 112 k (-10 %), code 0 -> 136.2 k (+9.4 %),
* code 15 -> 124.5 k (nominal).  (Bit gates: plain parentheses; braces inside a B-source expression
* lose their grouping once the parameter is substituted.)  Trimming r_ref sets the reference current and vcm (= vbg r_vcm / r_ref)
* without touching the vbg temperature coefficient (a PTAT-gain trim on R2 would).
Xrref s rt5 vss sky130_fd_pr__res_high_po w=1 l={(112k-378)/317}
Xrt4 rt5 rt4 vss sky130_fd_pr__res_high_po w=1 l={(16*lsb-378)/317}
Xrt3 rt4 rt3 vss sky130_fd_pr__res_high_po w=1 l={(8*lsb-378)/317}
Xrt2 rt3 rt2 vss sky130_fd_pr__res_high_po w=1 l={(4*lsb-378)/317}
Xrt1 rt2 rt1 vss sky130_fd_pr__res_high_po w=1 l={(2*lsb-378)/317}
Xrt0 rt1 vss vss sky130_fd_pr__res_high_po w=1 l={(lsb-378)/317}
Bg4 g4 vss V=(floor(trim/16)-2*floor(trim/32))*v(vdd)
Bg3 g3 vss V=(floor(trim/8)-2*floor(trim/16))*v(vdd)
Bg2 g2 vss V=(floor(trim/4)-2*floor(trim/8))*v(vdd)
Bg1 g1 vss V=(floor(trim/2)-2*floor(trim/4))*v(vdd)
Bg0 g0 vss V=(trim-2*floor(trim/2))*v(vdd)
Xs4 rt5 g4 rt4 vss serdes_nfet w=20 l=0.15
Xs3 rt4 g3 rt3 vss serdes_nfet w=20 l=0.15
Xs2 rt3 g2 rt2 vss serdes_nfet w=20 l=0.15
Xs1 rt2 g1 rt1 vss serdes_nfet w=20 l=0.15
Xs0 rt1 g0 vss vss serdes_nfet w=20 l=0.15
Xo0 iout0 vgi vdd vdd serdes_pfet_lvt w={wo} l={lo} nf={nfv}
Xo1 iout1 vgi vdd vdd serdes_pfet_lvt w={wo} l={lo} nf={nfv}
Xo2 iout2 vgi vdd vdd serdes_pfet_lvt w={wo} l={lo} nf={nfv}
Xo3 iout3 vgi vdd vdd serdes_pfet_lvt w={wo} l={lo} nf={nfv}
.ends serdes_bandgap

* Voltage reference from the constant-swing current: v = I * r (high_po, so v = vbg * r / r_ref, a pure
* ratio) buffered by a single-stage OTA in unity gain whose output pole is the external decap (stable
* for any large load capacitance; ~40 dB gain -> ~10 mV systematic error).  For the RX termination
* centre tap (DC load ~0; charging the external AC-coupling capacitors at start-up is slow: ~10 uA).
* iin: a bandgap current copy (I ~10 uA); ibias: a second copy for the OTA tail.
.subckt serdes_ref_vbuf iin ibias out vdd vss
+ params: r=105.2k win=24 lin=5 wl=48 ll=12
Xr iin vss vss sky130_fd_pr__res_high_po w=1 l={r/317}
Xbd ibias ibias vss vss serdes_nfet w=4 l=4
Xt tail ibias vss vss serdes_nfet w=4 l=4
* follower: out = -a (V(output-side gate) - V(diode-side gate)) -> input on the diode side, out fed back
Xa da iin tail vss serdes_nfet w={win} l={lin}
Xb out out tail vss serdes_nfet w={win} l={lin}
Xla da da vdd vdd serdes_pfet_lvt w={wl} l={ll}
Xlb out da vdd vdd serdes_pfet_lvt w={wl} l={ll}
.ends serdes_ref_vbuf
