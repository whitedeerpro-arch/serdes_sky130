* Bias distribution from the constant-swing reference (bandgap.spice), 2026-11-04.
* The modules get currents, not gate voltages: PMOS copies of the V->I device Mv (gate vgi; pfet_lvt
* fingers of W 6 / L 4, Mv = 4 fingers, I_unit = vbg / r_ref / 4 = 2.5 uA) drive each module's own
* diode.  Nominal (r_ref code 15, 10 uA):
*   ocml  85 fingers  212.5 uA -> CML diode nfet 5 / 0.5 (one finger of the former 20 / 0.5 nf 4 diode
*                                at 0.85 mA: same current density, same vbias, 1/4 of the power)
*   octle 20 fingers   50 uA   -> CTLE diode nfet_lvt 8 / 0.5 nf 4 (unchanged)
*   ocp   20 fingers   50 uA   -> CP vbn diode nfet 5 / 1; serdes_bias_cp mirrors it to sink 50 uA from
*                                the vbp diode (pfet 20 / 1 nf 4)
* serdes_bias_ref is the bandgap with its V->I gate line vgi exported; every module copy is a
* serdes_bias_pcopy on vgi.  The copies' gate capacitance adds to cvgi, the dominant pole of the V->I
* loop: with the CML + CTLE + CP copies (~24 pF) cvgi is 2 pF instead of 10 pF; more copies only lower
* the crossing further (power-up: bandgap_startup --dist, 7-15 us over 135 conditions).
* cvbg is outside every loop (vbg only feeds gates): it low-passes the supply ripple the core PMOS
* sources put on vbg above the core loop's bandwidth (1.8 V/V at 1 MHz without it, dist_psrr).
.subckt serdes_bias_ref vbg i0 i1 i2 i3 vgi vdd vss params: trim=15 cvgi=2p cvbg=5p
Xbg vbg i0 i1 i2 i3 vg vgi vdd vss serdes_bandgap trim={trim} cvgi={cvgi}
Cvbg vbg vss {cvbg}
.ends serdes_bias_ref

* One module copy: n fingers of the unit (W 6 / L 4), I = n * vbg / r_ref / 4.
.subckt serdes_bias_pcopy out vgi vdd params: n=4
Xp out vgi vdd vdd serdes_pfet_lvt w={6*n} l=4 nf={n}
.ends serdes_bias_pcopy

* Module-side diodes.  CML: the global tail-bias line (vbias) of a module.  The copy's drain capacitance
* couples vdd onto the line; cdec shunts it (vbias / vdd ~0.5 V/V at 1 GHz without it, dist_psrr).
.subckt serdes_bias_cml iin vss params: cdec=5p
Xd iin iin vss vss serdes_nfet w=5 l=0.5
Cdec iin vss {cdec}
.ends serdes_bias_cml

* CTLE LVT branch bias.
.subckt serdes_bias_ctle iin vss
Xd iin iin vss vss serdes_nfet_lvt w=8 l=0.5 nf=4
.ends serdes_bias_ctle

* Charge pump: the current into vbn sets the pull-down bias (diode); a copy of it sinks the same
* current from the vbp PMOS diode (pull-up bias, on the CP supply vcp).
.subckt serdes_bias_cp vbn vbp vcp vss
Xdn vbn vbn vss vss serdes_nfet w=5 l=1
Xmn vbp vbn vss vss serdes_nfet w=5 l=1
Xdp vbp vbp vcp vcp serdes_pfet w=20 l=1 nf=4
.ends serdes_bias_cp

* LF precharge reference (B2): v_target = I * R(code), I a bandgap copy (iin, 10 uA = 4 fingers), R a
* high_po string r0 + code * rstep (code 0..15: 0.95 .. 1.35 V at nominal, the ratio vbg * R / r_ref
* holds over resistor corners; the top stays at 1.35 V so the copy keeps >= 0.3 V at 1.65 V).  The tap
* goes through a 16:1 transmission-gate mux to the buffer input (no DC current).  Buffer: single-stage
* LVT-input OTA follower (as serdes_ref_vbuf) whose output pole is the loop filter (42 pF through the
* precharge gates): stable for any load capacitance; slew = I_tail / C.  ibias (a bandgap copy, 10 uA =
* 4 fingers) sets the tail at 30 x 10 uA = 300 uA, switched by en (precharge window only).  Both copies
* stay on: switching a copy's drain kicks the shared gate line vgi through Cgd, and the slow V->I loop
* takes ~1 us to recover (every module current moved ~10 %; the tap too, so the buffer tracked a moving
* target past the 512 ns window).  Static cost 2 x 10 uA.  Mux gates: behavioural decode of the code
* parameter (one tap at vdd).
.subckt serdes_ref_pbuf iin ibias out en vdd vss
+ params: code=7 r0=95k rstep=2.667k win=24 lin=1 wl=96 ll=1 ntail=6
Xr0 t0 vss vss sky130_fd_pr__res_high_po w=1 l={(r0-378)/317}
Xr1 t1 t0 vss sky130_fd_pr__res_high_po w=1 l={(rstep-378)/317}
Xr2 t2 t1 vss sky130_fd_pr__res_high_po w=1 l={(rstep-378)/317}
Xr3 t3 t2 vss sky130_fd_pr__res_high_po w=1 l={(rstep-378)/317}
Xr4 t4 t3 vss sky130_fd_pr__res_high_po w=1 l={(rstep-378)/317}
Xr5 t5 t4 vss sky130_fd_pr__res_high_po w=1 l={(rstep-378)/317}
Xr6 t6 t5 vss sky130_fd_pr__res_high_po w=1 l={(rstep-378)/317}
Xr7 t7 t6 vss sky130_fd_pr__res_high_po w=1 l={(rstep-378)/317}
Xr8 t8 t7 vss sky130_fd_pr__res_high_po w=1 l={(rstep-378)/317}
Xr9 t9 t8 vss sky130_fd_pr__res_high_po w=1 l={(rstep-378)/317}
Xr10 t10 t9 vss sky130_fd_pr__res_high_po w=1 l={(rstep-378)/317}
Xr11 t11 t10 vss sky130_fd_pr__res_high_po w=1 l={(rstep-378)/317}
Xr12 t12 t11 vss sky130_fd_pr__res_high_po w=1 l={(rstep-378)/317}
Xr13 t13 t12 vss sky130_fd_pr__res_high_po w=1 l={(rstep-378)/317}
Xr14 t14 t13 vss sky130_fd_pr__res_high_po w=1 l={(rstep-378)/317}
Xr15 iin t14 vss sky130_fd_pr__res_high_po w=1 l={(rstep-378)/317}
Vt15 iin t15 0
Bs0 s0 vss V=(abs(code-0)<0.5)*v(vdd)
Bs1 s1 vss V=(abs(code-1)<0.5)*v(vdd)
Bs2 s2 vss V=(abs(code-2)<0.5)*v(vdd)
Bs3 s3 vss V=(abs(code-3)<0.5)*v(vdd)
Bs4 s4 vss V=(abs(code-4)<0.5)*v(vdd)
Bs5 s5 vss V=(abs(code-5)<0.5)*v(vdd)
Bs6 s6 vss V=(abs(code-6)<0.5)*v(vdd)
Bs7 s7 vss V=(abs(code-7)<0.5)*v(vdd)
Bs8 s8 vss V=(abs(code-8)<0.5)*v(vdd)
Bs9 s9 vss V=(abs(code-9)<0.5)*v(vdd)
Bs10 s10 vss V=(abs(code-10)<0.5)*v(vdd)
Bs11 s11 vss V=(abs(code-11)<0.5)*v(vdd)
Bs12 s12 vss V=(abs(code-12)<0.5)*v(vdd)
Bs13 s13 vss V=(abs(code-13)<0.5)*v(vdd)
Bs14 s14 vss V=(abs(code-14)<0.5)*v(vdd)
Bs15 s15 vss V=(abs(code-15)<0.5)*v(vdd)
Xi0 s0 sb0 vdd vss serdes_cmos_inv
Xi1 s1 sb1 vdd vss serdes_cmos_inv
Xi2 s2 sb2 vdd vss serdes_cmos_inv
Xi3 s3 sb3 vdd vss serdes_cmos_inv
Xi4 s4 sb4 vdd vss serdes_cmos_inv
Xi5 s5 sb5 vdd vss serdes_cmos_inv
Xi6 s6 sb6 vdd vss serdes_cmos_inv
Xi7 s7 sb7 vdd vss serdes_cmos_inv
Xi8 s8 sb8 vdd vss serdes_cmos_inv
Xi9 s9 sb9 vdd vss serdes_cmos_inv
Xi10 s10 sb10 vdd vss serdes_cmos_inv
Xi11 s11 sb11 vdd vss serdes_cmos_inv
Xi12 s12 sb12 vdd vss serdes_cmos_inv
Xi13 s13 sb13 vdd vss serdes_cmos_inv
Xi14 s14 sb14 vdd vss serdes_cmos_inv
Xi15 s15 sb15 vdd vss serdes_cmos_inv
Xg0 t0 tap s0 sb0 vdd vss serdes_cmos_tgate
Xg1 t1 tap s1 sb1 vdd vss serdes_cmos_tgate
Xg2 t2 tap s2 sb2 vdd vss serdes_cmos_tgate
Xg3 t3 tap s3 sb3 vdd vss serdes_cmos_tgate
Xg4 t4 tap s4 sb4 vdd vss serdes_cmos_tgate
Xg5 t5 tap s5 sb5 vdd vss serdes_cmos_tgate
Xg6 t6 tap s6 sb6 vdd vss serdes_cmos_tgate
Xg7 t7 tap s7 sb7 vdd vss serdes_cmos_tgate
Xg8 t8 tap s8 sb8 vdd vss serdes_cmos_tgate
Xg9 t9 tap s9 sb9 vdd vss serdes_cmos_tgate
Xg10 t10 tap s10 sb10 vdd vss serdes_cmos_tgate
Xg11 t11 tap s11 sb11 vdd vss serdes_cmos_tgate
Xg12 t12 tap s12 sb12 vdd vss serdes_cmos_tgate
Xg13 t13 tap s13 sb13 vdd vss serdes_cmos_tgate
Xg14 t14 tap s14 sb14 vdd vss serdes_cmos_tgate
Xg15 t15 tap s15 sb15 vdd vss serdes_cmos_tgate
* OTA: diode side gate = tap (input), output side gate = out (feedback)
Xbd ibias ibias vss vss serdes_nfet w=1 l=1
Xt tail ibias ts vss serdes_nfet w={5*ntail} l=1 nf={ntail}
* L 0.18: at L 0.15 these fingers fall in a model bin with Pclm < 0 at FS (ngspice stops if the first
* analysis is at 27 C or above; later temperatures run on without the check)
Xst ts en vss vss serdes_nfet w={5*ntail} l=0.18 nf={ntail}
Xa da tap tail vss serdes_nfet_lvt w={win} l={lin}
Xb out out tail vss serdes_nfet_lvt w={win} l={lin}
Xla da da vdd vdd serdes_pfet_lvt w={wl} l={ll}
Xlb out da vdd vdd serdes_pfet_lvt w={wl} l={ll}
.ends serdes_ref_pbuf
