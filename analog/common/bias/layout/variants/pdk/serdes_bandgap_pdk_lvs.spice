* NGSPICE file created from serdes_bandgap_pdk.ext - technology: sky130A

.subckt serdes_bandgap_pdk g4 g3 g2 g1 g0 iout0 iout1 iout2 iout3 vbg vg vgi vdd vss
X0 vg a_10355_8086# vdd vdd sky130_fd_pr__pfet_01v8_lvt ad=0.87 pd=6.29 as=0.87 ps=6.29 w=6 l=4
X1 iout2 vgi vdd vdd sky130_fd_pr__pfet_01v8_lvt ad=0.87 pd=6.29 as=0.87 ps=6.29 w=6 l=4
X2 vss a_1011_12232# a_1242_15518# vss sky130_fd_pr__nfet_01v8 ad=0.58 pd=4.58 as=0.58 ps=4.58 w=2 l=1
X3 a_32099_740# g0 vss vss sky130_fd_pr__nfet_01v8 ad=0.825 pd=5.33 as=1.55 ps=10.62 w=5 l=0.15
X4 vdd a_24955_13946# a_24955_13946# vdd sky130_fd_pr__pfet_01v8_lvt ad=0.87 pd=6.29 as=0.87 ps=6.29 w=6 l=12
X5 a_5748_8704# a_6044_1584# vss sky130_fd_pr__res_high_po w=1 l=33.6
X6 a_32099_740# g0 vss vss sky130_fd_pr__nfet_01v8 ad=0.825 pd=5.33 as=0.825 ps=5.33 w=5 l=0.15
X7 a_26312_9906# a_26016_702# vss sky130_fd_pr__res_high_po w=1 l=44.02
X8 a_25639_12140# vbg vgi vss sky130_fd_pr__nfet_01v8 ad=0.87 pd=6.29 as=0.87 ps=6.29 w=6 l=5
X9 vss g0 a_32099_740# vss sky130_fd_pr__nfet_01v8 ad=0.825 pd=5.33 as=0.825 ps=5.33 w=5 l=0.15
X10 vss g0 a_32099_740# vss sky130_fd_pr__nfet_01v8 ad=1.55 pd=10.62 as=0.825 ps=5.33 w=5 l=0.15
X11 a_25424_9906# vgi vdd vdd sky130_fd_pr__pfet_01v8_lvt ad=0.87 pd=6.29 as=0.87 ps=6.29 w=6 l=4
X12 vdd vgi a_25424_9906# vdd sky130_fd_pr__pfet_01v8_lvt ad=0.87 pd=6.29 as=0.87 ps=6.29 w=6 l=4
X13 a_25424_9906# vbg vgi vss sky130_fd_pr__nfet_01v8 ad=0.29 pd=2.58 as=0.29 ps=2.58 w=1 l=4
X14 a_26312_9906# a_26608_702# vss sky130_fd_pr__res_high_po w=1 l=44.02
X15 a_25424_9906# a_25424_702# vss sky130_fd_pr__res_high_po w=1 l=44.02
X16 vgi a_24955_13946# vdd vdd sky130_fd_pr__pfet_01v8_lvt ad=1.74 pd=12.58 as=0.87 ps=6.29 w=6 l=12
X17 vss a_1011_12232# a_11039_5880# vss sky130_fd_pr__nfet_01v8 ad=1.16 pd=8.58 as=0.58 ps=4.29 w=4 l=4
X18 iout3 vgi vdd vdd sky130_fd_pr__pfet_01v8_lvt ad=0.87 pd=6.29 as=0.87 ps=6.29 w=6 l=4
X19 a_5156_8704# a_4564_1584# vss sky130_fd_pr__res_high_po w=1 l=33.6
X20 a_30979_740# g1 a_32099_740# vss sky130_fd_pr__nfet_01v8 ad=0.825 pd=5.33 as=1.55 ps=10.62 w=5 l=0.15
X21 iout3 vgi vdd vdd sky130_fd_pr__pfet_01v8_lvt ad=0.87 pd=6.29 as=1.74 ps=12.58 w=6 l=4
X22 a_25639_12140# a_13813_19996# vss vss sky130_fd_pr__nfet_01v8 ad=0.29 pd=2.58 as=0.29 ps=2.58 w=1 l=8
X23 a_30979_740# g1 a_32099_740# vss sky130_fd_pr__nfet_01v8 ad=0.825 pd=5.33 as=0.825 ps=5.33 w=5 l=0.15
X24 a_27496_9906# a_28739_740# vss sky130_fd_pr__res_high_po w=1 l=38.18
X25 a_32099_740# g1 a_30979_740# vss sky130_fd_pr__nfet_01v8 ad=0.825 pd=5.33 as=0.825 ps=5.33 w=5 l=0.15
X26 a_28739_740# g3 a_29859_740# vss sky130_fd_pr__nfet_01v8 ad=0.825 pd=5.33 as=1.55 ps=10.62 w=5 l=0.15
X27 vdd a_10355_8086# a_10355_8086# vdd sky130_fd_pr__pfet_01v8_lvt ad=0.87 pd=6.29 as=0.87 ps=6.29 w=6 l=12
X28 vgi vdd sky130_fd_pr__cap_mim_m3_1 l=22.2 w=22.2
X29 a_4268_8704# a_3972_1584# vss sky130_fd_pr__res_high_po w=1 l=33.6
X30 a_32099_740# g1 a_30979_740# vss sky130_fd_pr__nfet_01v8 ad=1.55 pd=10.62 as=0.825 ps=5.33 w=5 l=0.15
X31 a_19734_4302# vg sky130_fd_pr__cap_mim_m3_1 l=22.2 w=22.2
X32 iout1 vgi vdd vdd sky130_fd_pr__pfet_01v8_lvt ad=0.87 pd=6.29 as=0.87 ps=6.29 w=6 l=4
X33 a_29859_740# g2 a_30979_740# vss sky130_fd_pr__nfet_01v8 ad=0.825 pd=5.33 as=1.55 ps=10.62 w=5 l=0.15
X34 a_29859_740# g2 a_30979_740# vss sky130_fd_pr__nfet_01v8 ad=0.825 pd=5.33 as=0.825 ps=5.33 w=5 l=0.15
X35 a_27496_9906# g4 a_28739_740# vss sky130_fd_pr__nfet_01v8 ad=0.825 pd=5.33 as=1.55 ps=10.62 w=5 l=0.15
X36 vdd a_10355_8086# a_10355_9522# vdd sky130_fd_pr__pfet_01v8_lvt ad=0.87 pd=6.29 as=1.74 ps=12.58 w=6 l=12
X37 a_30979_740# g2 a_29859_740# vss sky130_fd_pr__nfet_01v8 ad=0.825 pd=5.33 as=0.825 ps=5.33 w=5 l=0.15
X38 a_28739_740# a_29859_740# vss sky130_fd_pr__res_high_po w=1 l=18.49
X39 a_30979_740# g2 a_29859_740# vss sky130_fd_pr__nfet_01v8 ad=1.55 pd=10.62 as=0.825 ps=5.33 w=5 l=0.15
X40 iout0 vgi vdd vdd sky130_fd_pr__pfet_01v8_lvt ad=0.87 pd=6.29 as=1.74 ps=12.58 w=6 l=4
X41 a_1512_9288# a_2104_1000# vss sky130_fd_pr__res_high_po w=1 l=39.44
X42 a_28739_740# g3 a_29859_740# vss sky130_fd_pr__nfet_01v8 ad=0.825 pd=5.33 as=0.825 ps=5.33 w=5 l=0.15
X43 a_29859_740# a_30979_740# vss sky130_fd_pr__res_high_po w=1 l=8.65
X44 vdd a_10355_8086# a_10355_9522# vdd sky130_fd_pr__pfet_01v8_lvt ad=0.87 pd=6.29 as=0.87 ps=6.29 w=6 l=12
X45 a_29859_740# g3 a_28739_740# vss sky130_fd_pr__nfet_01v8 ad=0.825 pd=5.33 as=0.825 ps=5.33 w=5 l=0.15
X46 a_25639_12140# a_25424_9906# a_24955_13946# vss sky130_fd_pr__nfet_01v8 ad=0.87 pd=6.29 as=0.87 ps=6.29 w=6 l=5
X47 a_920_9288# a_920_1000# vss sky130_fd_pr__res_high_po w=1 l=39.44
X48 a_1216_9288# a_920_1000# vss sky130_fd_pr__res_high_po w=1 l=39.44
X49 a_29859_740# g3 a_28739_740# vss sky130_fd_pr__nfet_01v8 ad=1.55 pd=10.62 as=0.825 ps=5.33 w=5 l=0.15
X50 a_624_9288# vg vdd vdd sky130_fd_pr__pfet_01v8_lvt ad=0.87 pd=6.29 as=1.74 ps=12.58 w=6 l=8
X51 vgi vdd sky130_fd_pr__cap_mim_m3_1 l=22.2 w=22.2
X52 vdd a_10355_8086# a_10355_8086# vdd sky130_fd_pr__pfet_01v8_lvt ad=0.87 pd=6.29 as=1.74 ps=12.58 w=6 l=12
X53 a_10355_9522# a_920_9288# a_11039_5880# vss sky130_fd_pr__nfet_01v8 ad=0.87 pd=6.29 as=0.87 ps=6.29 w=6 l=5
X54 vgi vdd sky130_fd_pr__cap_mim_m3_1 l=22.2 w=22.2
X55 vdd vgi iout0 vdd sky130_fd_pr__pfet_01v8_lvt ad=1.74 pd=12.58 as=0.87 ps=6.29 w=6 l=4
X56 a_2696_9288# a_1530_17870# vss sky130_fd_pr__res_high_po w=1 l=34.7
X57 a_30979_740# a_32099_740# vss sky130_fd_pr__res_high_po w=1 l=3.73
X58 a_13813_19996# a_13813_19996# vss vss sky130_fd_pr__nfet_01v8 ad=0.29 pd=2.29 as=0.58 ps=4.58 w=2 l=4
X59 vdd vg a_13813_19996# vdd sky130_fd_pr__pfet_01v8_lvt ad=0.87 pd=6.29 as=0.87 ps=6.29 w=6 l=8
X60 a_27496_9906# a_27200_702# vss sky130_fd_pr__res_high_po w=1 l=44.02
X61 vdd vg a_1011_12232# vdd sky130_fd_pr__pfet_01v8_lvt ad=0.87 pd=6.29 as=0.87 ps=6.29 w=6 l=8
X62 vss a_1242_15518# vg vss sky130_fd_pr__nfet_01v8 ad=0.29 pd=2.58 as=0.29 ps=2.58 w=1 l=1
X63 a_24955_13946# a_24955_13946# vdd vdd sky130_fd_pr__pfet_01v8_lvt ad=0.87 pd=6.29 as=0.87 ps=6.29 w=6 l=12
X64 a_11039_5880# a_1011_12232# vss vss sky130_fd_pr__nfet_01v8 ad=0.58 pd=4.29 as=1.16 ps=8.58 w=4 l=4
X65 vdd vss a_1242_15518# vdd sky130_fd_pr__pfet_01v8 ad=0.1218 pd=1.42 as=0.1218 ps=1.42 w=0.42 l=20
X66 vdd vg a_1011_12232# vdd sky130_fd_pr__pfet_01v8_lvt ad=1.74 pd=12.58 as=0.87 ps=6.29 w=6 l=8
X67 a_13813_19996# vg vdd vdd sky130_fd_pr__pfet_01v8_lvt ad=0.87 pd=6.29 as=0.87 ps=6.29 w=6 l=8
X68 vdd vgi iout1 vdd sky130_fd_pr__pfet_01v8_lvt ad=0.87 pd=6.29 as=0.87 ps=6.29 w=6 l=4
X69 a_3050_22430# a_6044_1584# vss sky130_fd_pr__res_high_po w=1 l=33.6
X70 a_19734_4302# vg sky130_fd_pr__cap_mim_m3_1 l=22.2 w=22.2
X71 a_32099_740# vss vss sky130_fd_pr__res_high_po w=1 l=1.27
X72 a_624_9288# vg vdd vdd sky130_fd_pr__pfet_01v8_lvt ad=0.87 pd=6.29 as=0.87 ps=6.29 w=6 l=8
X73 a_920_9288# vg vdd vdd sky130_fd_pr__pfet_01v8_lvt ad=0.87 pd=6.29 as=1.74 ps=12.58 w=6 l=8
X74 a_26904_9906# a_26608_702# vss sky130_fd_pr__res_high_po w=1 l=44.02
X75 a_25720_9906# a_25424_702# vss sky130_fd_pr__res_high_po w=1 l=44.02
X76 vdd vgi iout3 vdd sky130_fd_pr__pfet_01v8_lvt ad=1.74 pd=12.58 as=0.87 ps=6.29 w=6 l=4
X77 a_5156_8704# a_5452_1584# vss sky130_fd_pr__res_high_po w=1 l=33.6
X78 vg a_10355_8086# vdd vdd sky130_fd_pr__pfet_01v8_lvt ad=0.87 pd=6.29 as=0.87 ps=6.29 w=6 l=4
X79 a_11039_5880# a_624_9288# a_10355_8086# vss sky130_fd_pr__nfet_01v8 ad=1.74 pd=12.58 as=0.87 ps=6.29 w=6 l=5
X80 a_24955_13946# a_25424_9906# a_25639_12140# vss sky130_fd_pr__nfet_01v8 ad=0.87 pd=6.29 as=0.87 ps=6.29 w=6 l=5
X81 vdd vgi iout3 vdd sky130_fd_pr__pfet_01v8_lvt ad=0.87 pd=6.29 as=0.87 ps=6.29 w=6 l=4
X82 vgi vdd sky130_fd_pr__cap_mim_m3_1 l=22.2 w=22.2
X83 a_5748_8704# a_5452_1584# vss sky130_fd_pr__res_high_po w=1 l=33.6
X84 vgi vdd sky130_fd_pr__cap_mim_m3_1 l=22.2 w=22.2
X85 vbg a_3380_1584# vss sky130_fd_pr__res_high_po w=1 l=33.6
X86 a_4268_8704# a_4564_1584# vss sky130_fd_pr__res_high_po w=1 l=33.6
X87 vss vss a_1530_17870# sky130_fd_pr__pnp_05v5_W3p40L3p40
**devattr s=462400,2720
X88 a_19142_4302# a_18846_806# vss sky130_fd_pr__res_high_po w=1 l=15.48
X89 vdd vg vbg vdd sky130_fd_pr__pfet_01v8_lvt ad=1.74 pd=12.58 as=0.87 ps=6.29 w=6 l=8
X90 vdd vg vbg vdd sky130_fd_pr__pfet_01v8_lvt ad=0.87 pd=6.29 as=0.87 ps=6.29 w=6 l=8
X91 vdd vgi iout2 vdd sky130_fd_pr__pfet_01v8_lvt ad=0.87 pd=6.29 as=0.87 ps=6.29 w=6 l=4
X92 a_3676_8704# a_3380_1584# vss sky130_fd_pr__res_high_po w=1 l=33.6
X93 vgi vdd sky130_fd_pr__cap_mim_m3_1 l=22.2 w=22.2
X94 vss vss a_1530_17870# sky130_fd_pr__pnp_05v5_W3p40L3p40
**devattr s=462400,2720
X95 a_19142_4302# a_19438_806# vss sky130_fd_pr__res_high_po w=1 l=15.48
X96 a_10355_9522# a_10355_8086# vdd vdd sky130_fd_pr__pfet_01v8_lvt ad=1.74 pd=12.58 as=0.87 ps=6.29 w=6 l=12
X97 a_920_9288# vg vdd vdd sky130_fd_pr__pfet_01v8_lvt ad=0.87 pd=6.29 as=0.87 ps=6.29 w=6 l=8
X98 a_2400_9288# a_2104_1000# vss sky130_fd_pr__res_high_po w=1 l=39.44
X99 vdd a_10355_8086# vg vdd sky130_fd_pr__pfet_01v8_lvt ad=0.87 pd=6.29 as=0.87 ps=6.29 w=6 l=4
X100 vdd vgi iout0 vdd sky130_fd_pr__pfet_01v8_lvt ad=0.87 pd=6.29 as=0.87 ps=6.29 w=6 l=4
X101 vgi vbg a_25639_12140# vss sky130_fd_pr__nfet_01v8 ad=0.87 pd=6.29 as=0.87 ps=6.29 w=6 l=5
X102 vss vss a_2400_9288# sky130_fd_pr__pnp_05v5_W3p40L3p40
**devattr s=462400,2720
X103 vgi a_24955_13946# vdd vdd sky130_fd_pr__pfet_01v8_lvt ad=0.87 pd=6.29 as=0.87 ps=6.29 w=6 l=12
X104 vgi a_24955_13946# vdd vdd sky130_fd_pr__pfet_01v8_lvt ad=0.87 pd=6.29 as=0.87 ps=6.29 w=6 l=12
X105 a_10355_8086# a_624_9288# a_11039_5880# vss sky130_fd_pr__nfet_01v8 ad=0.87 pd=6.29 as=1.74 ps=12.58 w=6 l=5
X106 vgi vdd sky130_fd_pr__cap_mim_m3_1 l=22.2 w=22.2
X107 a_1512_9288# a_624_1000# vss sky130_fd_pr__res_high_po w=1 l=39.44
X108 a_10355_8086# a_10355_8086# vdd vdd sky130_fd_pr__pfet_01v8_lvt ad=0.87 pd=6.29 as=0.87 ps=6.29 w=6 l=12
X109 a_19734_4302# vg sky130_fd_pr__cap_mim_m3_1 l=22.2 w=22.2
X110 a_19734_4302# vg sky130_fd_pr__cap_mim_m3_1 l=22.2 w=22.2
X111 a_19734_4302# vg sky130_fd_pr__cap_mim_m3_1 l=22.2 w=22.2
X112 a_1216_9288# a_1808_1000# vss sky130_fd_pr__res_high_po w=1 l=39.44
X113 vdd a_24955_13946# vgi vdd sky130_fd_pr__pfet_01v8_lvt ad=0.87 pd=6.29 as=1.74 ps=12.58 w=6 l=12
X114 vss a_1011_12232# a_1011_12232# vss sky130_fd_pr__nfet_01v8 ad=0.58 pd=4.58 as=0.29 ps=2.29 w=2 l=4
X115 a_11039_5880# a_920_9288# a_10355_9522# vss sky130_fd_pr__nfet_01v8 ad=0.87 pd=6.29 as=0.87 ps=6.29 w=6 l=5
X116 vdd a_24955_13946# a_24955_13946# vdd sky130_fd_pr__pfet_01v8_lvt ad=0.87 pd=6.29 as=0.87 ps=6.29 w=6 l=12
X117 vdd vgi iout2 vdd sky130_fd_pr__pfet_01v8_lvt ad=0.87 pd=6.29 as=0.87 ps=6.29 w=6 l=4
X118 vgi vbg a_25639_12140# vss sky130_fd_pr__nfet_01v8 ad=0.87 pd=6.29 as=0.87 ps=6.29 w=6 l=5
X119 vg a_10355_8086# vdd vdd sky130_fd_pr__pfet_01v8_lvt ad=0.87 pd=6.29 as=0.87 ps=6.29 w=6 l=4
X120 a_10355_8086# a_10355_8086# vdd vdd sky130_fd_pr__pfet_01v8_lvt ad=1.74 pd=12.58 as=0.87 ps=6.29 w=6 l=12
X121 a_10355_9522# a_10355_8086# vdd vdd sky130_fd_pr__pfet_01v8_lvt ad=1.74 pd=12.58 as=0.87 ps=6.29 w=6 l=12
X122 a_28739_740# g4 a_27496_9906# vss sky130_fd_pr__nfet_01v8 ad=1.55 pd=10.62 as=0.825 ps=5.33 w=5 l=0.15
X123 vgi a_24955_13946# vdd vdd sky130_fd_pr__pfet_01v8_lvt ad=1.74 pd=12.58 as=0.87 ps=6.29 w=6 l=12
X124 iout1 vgi vdd vdd sky130_fd_pr__pfet_01v8_lvt ad=0.87 pd=6.29 as=0.87 ps=6.29 w=6 l=4
X125 vss vss a_3050_22430# sky130_fd_pr__pnp_05v5_W3p40L3p40
**devattr s=462400,2720
X126 a_24955_13946# a_24955_13946# vdd vdd sky130_fd_pr__pfet_01v8_lvt ad=0.87 pd=6.29 as=0.87 ps=6.29 w=6 l=12
X127 a_13813_19996# vg vdd vdd sky130_fd_pr__pfet_01v8_lvt ad=0.87 pd=6.29 as=1.74 ps=12.58 w=6 l=8
X128 a_1011_12232# vg vdd vdd sky130_fd_pr__pfet_01v8_lvt ad=0.87 pd=6.29 as=1.74 ps=12.58 w=6 l=8
X129 a_10355_8086# a_10355_8086# vdd vdd sky130_fd_pr__pfet_01v8_lvt ad=0.87 pd=6.29 as=0.87 ps=6.29 w=6 l=12
X130 a_10355_9522# a_10355_8086# vdd vdd sky130_fd_pr__pfet_01v8_lvt ad=0.87 pd=6.29 as=0.87 ps=6.29 w=6 l=12
X131 a_19734_4302# vg sky130_fd_pr__cap_mim_m3_1 l=22.2 w=22.2
X132 a_3676_8704# a_3972_1584# vss sky130_fd_pr__res_high_po w=1 l=33.6
X133 vdd a_10355_8086# a_10355_8086# vdd sky130_fd_pr__pfet_01v8_lvt ad=0.87 pd=6.29 as=0.87 ps=6.29 w=6 l=12
X134 a_25720_9906# a_26016_702# vss sky130_fd_pr__res_high_po w=1 l=44.02
X135 a_24955_13946# a_25424_9906# a_25639_12140# vss sky130_fd_pr__nfet_01v8 ad=0.87 pd=6.29 as=1.74 ps=12.58 w=6 l=5
X136 a_19734_4302# a_19438_806# vss sky130_fd_pr__res_high_po w=1 l=15.48
X137 vgi vdd sky130_fd_pr__cap_mim_m3_1 l=22.2 w=22.2
X138 vss vss a_1530_17870# sky130_fd_pr__pnp_05v5_W3p40L3p40
**devattr s=462400,2720
X139 vdd vgi iout1 vdd sky130_fd_pr__pfet_01v8_lvt ad=0.87 pd=6.29 as=0.87 ps=6.29 w=6 l=4
X140 a_2696_9288# a_1808_1000# vss sky130_fd_pr__res_high_po w=1 l=39.44
X141 a_10355_8086# a_10355_8086# vdd vdd sky130_fd_pr__pfet_01v8_lvt ad=1.74 pd=12.58 as=0.87 ps=6.29 w=6 l=12
X142 vgi vdd sky130_fd_pr__cap_mim_m3_1 l=22.2 w=22.2
X143 vdd a_24955_13946# a_24955_13946# vdd sky130_fd_pr__pfet_01v8_lvt ad=0.87 pd=6.29 as=1.74 ps=12.58 w=6 l=12
X144 vss a_10355_9522# vg vss sky130_fd_pr__nfet_01v8 ad=0.58 pd=4.58 as=0.58 ps=4.58 w=2 l=2
X145 vdd a_10355_8086# vg vdd sky130_fd_pr__pfet_01v8_lvt ad=0.87 pd=6.29 as=0.87 ps=6.29 w=6 l=4
X146 a_25639_12140# vbg vgi vss sky130_fd_pr__nfet_01v8 ad=0.87 pd=6.29 as=0.87 ps=6.29 w=6 l=5
X147 vdd a_24955_13946# a_24955_13946# vdd sky130_fd_pr__pfet_01v8_lvt ad=0.87 pd=6.29 as=1.74 ps=12.58 w=6 l=12
X148 a_10355_9522# a_18846_806# vss sky130_fd_pr__res_high_po w=1 l=15.48
X149 vdd vg a_13813_19996# vdd sky130_fd_pr__pfet_01v8_lvt ad=1.74 pd=12.58 as=0.87 ps=6.29 w=6 l=8
X150 iout2 vgi vdd vdd sky130_fd_pr__pfet_01v8_lvt ad=0.87 pd=6.29 as=0.87 ps=6.29 w=6 l=4
X151 vdd a_10355_8086# vg vdd sky130_fd_pr__pfet_01v8_lvt ad=0.87 pd=6.29 as=0.87 ps=6.29 w=6 l=4
X152 vss vss a_1530_17870# sky130_fd_pr__pnp_05v5_W3p40L3p40
**devattr s=462400,2720
X153 vss vss a_1530_17870# sky130_fd_pr__pnp_05v5_W3p40L3p40
**devattr s=462400,2720
X154 vdd vg a_624_9288# vdd sky130_fd_pr__pfet_01v8_lvt ad=1.74 pd=12.58 as=0.87 ps=6.29 w=6 l=8
X155 vdd a_10355_8086# a_10355_9522# vdd sky130_fd_pr__pfet_01v8_lvt ad=0.87 pd=6.29 as=1.74 ps=12.58 w=6 l=12
X156 a_10355_9522# a_10355_8086# vdd vdd sky130_fd_pr__pfet_01v8_lvt ad=0.87 pd=6.29 as=0.87 ps=6.29 w=6 l=12
X157 vdd vg a_624_9288# vdd sky130_fd_pr__pfet_01v8_lvt ad=0.87 pd=6.29 as=0.87 ps=6.29 w=6 l=8
X158 vdd a_24955_13946# vgi vdd sky130_fd_pr__pfet_01v8_lvt ad=0.87 pd=6.29 as=0.87 ps=6.29 w=6 l=12
X159 vdd a_24955_13946# vgi vdd sky130_fd_pr__pfet_01v8_lvt ad=0.87 pd=6.29 as=0.87 ps=6.29 w=6 l=12
X160 vss vss a_1530_17870# sky130_fd_pr__pnp_05v5_W3p40L3p40
**devattr s=462400,2720
X161 vss vss a_1530_17870# sky130_fd_pr__pnp_05v5_W3p40L3p40
**devattr s=462400,2720
X162 a_25639_12140# a_25424_9906# a_24955_13946# vss sky130_fd_pr__nfet_01v8 ad=1.74 pd=12.58 as=0.87 ps=6.29 w=6 l=5
X163 vgi vdd sky130_fd_pr__cap_mim_m3_1 l=22.2 w=22.2
X164 vbg vg vdd vdd sky130_fd_pr__pfet_01v8_lvt ad=0.87 pd=6.29 as=1.74 ps=12.58 w=6 l=8
X165 vdd a_10355_8086# vg vdd sky130_fd_pr__pfet_01v8_lvt ad=1.74 pd=12.58 as=0.87 ps=6.29 w=6 l=4
X166 a_1011_12232# vg vdd vdd sky130_fd_pr__pfet_01v8_lvt ad=0.87 pd=6.29 as=0.87 ps=6.29 w=6 l=8
X167 vss a_13813_19996# a_13813_19996# vss sky130_fd_pr__nfet_01v8 ad=0.58 pd=4.58 as=0.29 ps=2.29 w=2 l=4
X168 a_24955_13946# a_24955_13946# vdd vdd sky130_fd_pr__pfet_01v8_lvt ad=1.74 pd=12.58 as=0.87 ps=6.29 w=6 l=12
X169 a_24955_13946# a_24955_13946# vdd vdd sky130_fd_pr__pfet_01v8_lvt ad=1.74 pd=12.58 as=0.87 ps=6.29 w=6 l=12
X170 vss vss a_1530_17870# sky130_fd_pr__pnp_05v5_W3p40L3p40
**devattr s=462400,2720
X171 a_11039_5880# a_624_9288# a_10355_8086# vss sky130_fd_pr__nfet_01v8 ad=0.87 pd=6.29 as=0.87 ps=6.29 w=6 l=5
X172 a_11039_5880# a_920_9288# a_10355_9522# vss sky130_fd_pr__nfet_01v8 ad=0.87 pd=6.29 as=0.87 ps=6.29 w=6 l=5
X173 a_27496_9906# g4 a_28739_740# vss sky130_fd_pr__nfet_01v8 ad=0.825 pd=5.33 as=0.825 ps=5.33 w=5 l=0.15
X174 a_624_9288# a_624_1000# vss sky130_fd_pr__res_high_po w=1 l=39.44
X175 a_28739_740# g4 a_27496_9906# vss sky130_fd_pr__nfet_01v8 ad=0.825 pd=5.33 as=0.825 ps=5.33 w=5 l=0.15
X176 vdd vg a_920_9288# vdd sky130_fd_pr__pfet_01v8_lvt ad=0.87 pd=6.29 as=0.87 ps=6.29 w=6 l=8
X177 vdd a_10355_8086# a_10355_9522# vdd sky130_fd_pr__pfet_01v8_lvt ad=0.87 pd=6.29 as=0.87 ps=6.29 w=6 l=12
X178 vg a_10355_8086# vdd vdd sky130_fd_pr__pfet_01v8_lvt ad=0.87 pd=6.29 as=1.74 ps=12.58 w=6 l=4
X179 vdd vg a_920_9288# vdd sky130_fd_pr__pfet_01v8_lvt ad=1.74 pd=12.58 as=0.87 ps=6.29 w=6 l=8
X180 a_1011_12232# a_1011_12232# vss vss sky130_fd_pr__nfet_01v8 ad=0.29 pd=2.29 as=0.58 ps=4.58 w=2 l=4
X181 a_25424_9906# vgi vdd vdd sky130_fd_pr__pfet_01v8_lvt ad=0.87 pd=6.29 as=0.87 ps=6.29 w=6 l=4
X182 vdd vgi a_25424_9906# vdd sky130_fd_pr__pfet_01v8_lvt ad=0.87 pd=6.29 as=0.87 ps=6.29 w=6 l=4
X183 vbg vg vdd vdd sky130_fd_pr__pfet_01v8_lvt ad=0.87 pd=6.29 as=0.87 ps=6.29 w=6 l=8
X184 iout0 vgi vdd vdd sky130_fd_pr__pfet_01v8_lvt ad=0.87 pd=6.29 as=0.87 ps=6.29 w=6 l=4
X185 vdd a_24955_13946# vgi vdd sky130_fd_pr__pfet_01v8_lvt ad=0.87 pd=6.29 as=1.74 ps=12.58 w=6 l=12
X186 vdd a_10355_8086# a_10355_8086# vdd sky130_fd_pr__pfet_01v8_lvt ad=0.87 pd=6.29 as=1.74 ps=12.58 w=6 l=12
X187 a_26904_9906# a_27200_702# vss sky130_fd_pr__res_high_po w=1 l=44.02
X188 a_10355_8086# a_624_9288# a_11039_5880# vss sky130_fd_pr__nfet_01v8 ad=0.87 pd=6.29 as=0.87 ps=6.29 w=6 l=5
X189 a_10355_9522# a_920_9288# a_11039_5880# vss sky130_fd_pr__nfet_01v8 ad=0.87 pd=6.29 as=0.87 ps=6.29 w=6 l=5
.ends
