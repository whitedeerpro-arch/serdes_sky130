* NGSPICE file created from serdes_bandgap_pdk.ext - technology: sky130A

.subckt serdes_bandgap_pdk g4 g3 g2 g1 g0 iout0 iout1 iout2 iout3 vbg vg vgi vdd vss
X0 vg a_10355_8086# vdd vdd sky130_fd_pr__pfet_01v8_lvt ad=0.87 pd=6.29 as=0.87 ps=6.29 w=6 l=4
X1 iout2 vgi vdd vdd sky130_fd_pr__pfet_01v8_lvt ad=0.87 pd=6.29 as=0.87 ps=6.29 w=6 l=4
X2 vss a_1011_12232# a_1242_15518# vss sky130_fd_pr__nfet_01v8 ad=0.58 pd=4.58 as=0.58 ps=4.58 w=2 l=1
X3 a_32099_740# g0 vss vss sky130_fd_pr__nfet_01v8 ad=0.825 pd=5.33 as=1.55 ps=10.62 w=5 l=0.15
X4 vdd a_24955_13946# a_24955_13946# vdd sky130_fd_pr__pfet_01v8_lvt ad=0.87 pd=6.29 as=0.87 ps=6.29 w=6 l=12
X5 a_5748_8704# a_6044_1584# vss sky130_fd_pr__res_high_po w=1 l=33.6
X6 a_32099_740# g0 vss vss sky130_fd_pr__nfet_01v8 ad=0.825 pd=5.33 as=0.825 ps=5.33 w=5 l=0.15
X7 a_26312_9906# a_26016_702# vss sky130_fd_pr__res_high_po w=1 l=44.02
X8 a_25639_12140# vbg vgi vss sky130_fd_pr__nfet_01v8 ad=0.87 pd=6.29 as=0.87 ps=6.29 w=6 l=5
X9 vss g0 a_32099_740# vss sky130_fd_pr__nfet_01v8 ad=0.825 pd=5.33 as=0.825 ps=5.33 w=5 l=0.15
X10 vss g0 a_32099_740# vss sky130_fd_pr__nfet_01v8 ad=1.55 pd=10.62 as=0.825 ps=5.33 w=5 l=0.15
X11 a_25424_9906# vgi vdd vdd sky130_fd_pr__pfet_01v8_lvt ad=0.87 pd=6.29 as=0.87 ps=6.29 w=6 l=4
X12 vdd vgi a_25424_9906# vdd sky130_fd_pr__pfet_01v8_lvt ad=0.87 pd=6.29 as=0.87 ps=6.29 w=6 l=4
X13 a_25424_9906# vbg vgi vss sky130_fd_pr__nfet_01v8 ad=0.29 pd=2.58 as=0.29 ps=2.58 w=1 l=4
X14 a_26312_9906# a_26608_702# vss sky130_fd_pr__res_high_po w=1 l=44.02
X15 a_25424_9906# a_25424_702# vss sky130_fd_pr__res_high_po w=1 l=44.02
X16 vgi a_24955_13946# vdd vdd sky130_fd_pr__pfet_01v8_lvt ad=1.74 pd=12.58 as=0.87 ps=6.29 w=6 l=12
X17 vss a_1011_12232# a_11039_5880# vss sky130_fd_pr__nfet_01v8 ad=1.16 pd=8.58 as=0.58 ps=4.29 w=4 l=4
X18 iout3 vgi vdd vdd sky130_fd_pr__pfet_01v8_lvt ad=0.87 pd=6.29 as=0.87 ps=6.29 w=6 l=4
X19 a_5156_8704# a_4564_1584# vss sky130_fd_pr__res_high_po w=1 l=33.6
X20 a_30979_740# g1 a_32099_740# vss sky130_fd_pr__nfet_01v8 ad=0.825 pd=5.33 as=1.55 ps=10.62 w=5 l=0.15
X21 iout3 vgi vdd vdd sky130_fd_pr__pfet_01v8_lvt ad=0.87 pd=6.29 as=1.74 ps=12.58 w=6 l=4
X22 a_25639_12140# a_13813_19996# vss vss sky130_fd_pr__nfet_01v8 ad=0.29 pd=2.58 as=0.29 ps=2.58 w=1 l=8
X23 a_30979_740# g1 a_32099_740# vss sky130_fd_pr__nfet_01v8 ad=0.825 pd=5.33 as=0.825 ps=5.33 w=5 l=0.15
X24 a_27496_9906# a_28739_740# vss sky130_fd_pr__res_high_po w=1 l=38.18
X25 a_32099_740# g1 a_30979_740# vss sky130_fd_pr__nfet_01v8 ad=0.825 pd=5.33 as=0.825 ps=5.33 w=5 l=0.15
X26 a_28739_740# g3 a_29859_740# vss sky130_fd_pr__nfet_01v8 ad=0.825 pd=5.33 as=1.55 ps=10.62 w=5 l=0.15
X27 vdd a_10355_8086# a_10355_8086# vdd sky130_fd_pr__pfet_01v8_lvt ad=0.87 pd=6.29 as=0.87 ps=6.29 w=6 l=12
X28 vgi vdd sky130_fd_pr__cap_mim_m3_1 l=22.2 w=22.2
X29 a_4268_8704# a_3972_1584# vss sky130_fd_pr__res_high_po w=1 l=33.6
X30 a_32099_740# g1 a_30979_740# vss sky130_fd_pr__nfet_01v8 ad=1.55 pd=10.62 as=0.825 ps=5.33 w=5 l=0.15
X31 a_19734_4302# vg sky130_fd_pr__cap_mim_m3_1 l=22.2 w=22.2
X32 iout1 vgi vdd vdd sky130_fd_pr__pfet_01v8_lvt ad=0.87 pd=6.29 as=0.87 ps=6.29 w=6 l=4
X33 a_29859_740# g2 a_30979_740# vss sky130_fd_pr__nfet_01v8 ad=0.825 pd=5.33 as=1.55 ps=10.62 w=5 l=0.15
X34 a_29859_740# g2 a_30979_740# vss sky130_fd_pr__nfet_01v8 ad=0.825 pd=5.33 as=0.825 ps=5.33 w=5 l=0.15
X35 a_27496_9906# g4 a_28739_740# vss sky130_fd_pr__nfet_01v8 ad=0.825 pd=5.33 as=1.55 ps=10.62 w=5 l=0.15
X36 vdd a_10355_8086# a_10355_9522# vdd sky130_fd_pr__pfet_01v8_lvt ad=0.87 pd=6.29 as=1.74 ps=12.58 w=6 l=12
X37 a_30979_740# g2 a_29859_740# vss sky130_fd_pr__nfet_01v8 ad=0.825 pd=5.33 as=0.825 ps=5.33 w=5 l=0.15
X38 a_28739_740# a_29859_740# vss sky130_fd_pr__res_high_po w=1 l=18.49
X39 a_30979_740# g2 a_29859_740# vss sky130_fd_pr__nfet_01v8 ad=1.55 pd=10.62 as=0.825 ps=5.33 w=5 l=0.15
X40 iout0 vgi vdd vdd sky130_fd_pr__pfet_01v8_lvt ad=0.87 pd=6.29 as=1.74 ps=12.58 w=6 l=4
X41 a_1512_9288# a_2104_1000# vss sky130_fd_pr__res_high_po w=1 l=39.44
X42 a_28739_740# g3 a_29859_740# vss sky130_fd_pr__nfet_01v8 ad=0.825 pd=5.33 as=0.825 ps=5.33 w=5 l=0.15
X43 a_29859_740# a_30979_740# vss sky130_fd_pr__res_high_po w=1 l=8.65
X44 vdd a_10355_8086# a_10355_9522# vdd sky130_fd_pr__pfet_01v8_lvt ad=0.87 pd=6.29 as=0.87 ps=6.29 w=6 l=12
X45 a_29859_740# g3 a_28739_740# vss sky130_fd_pr__nfet_01v8 ad=0.825 pd=5.33 as=0.825 ps=5.33 w=5 l=0.15
X46 a_25639_12140# a_25424_9906# a_24955_13946# vss sky130_fd_pr__nfet_01v8 ad=0.87 pd=6.29 as=0.87 ps=6.29 w=6 l=5
X47 a_920_9288# a_920_1000# vss sky130_fd_pr__res_high_po w=1 l=39.44
X48 a_1216_9288# a_920_1000# vss sky130_fd_pr__res_high_po w=1 l=39.44
X49 a_29859_740# g3 a_28739_740# vss sky130_fd_pr__nfet_01v8 ad=1.55 pd=10.62 as=0.825 ps=5.33 w=5 l=0.15
X50 a_624_9288# vg vdd vdd sky130_fd_pr__pfet_01v8_lvt ad=0.87 pd=6.29 as=1.74 ps=12.58 w=6 l=8
X51 vgi vdd sky130_fd_pr__cap_mim_m3_1 l=22.2 w=22.2
X52 vdd a_10355_8086# a_10355_8086# vdd sky130_fd_pr__pfet_01v8_lvt ad=0.87 pd=6.29 as=1.74 ps=12.58 w=6 l=12
X53 a_10355_9522# a_920_9288# a_11039_5880# vss sky130_fd_pr__nfet_01v8 ad=0.87 pd=6.29 as=0.87 ps=6.29 w=6 l=5
X54 vgi vdd sky130_fd_pr__cap_mim_m3_1 l=22.2 w=22.2
X55 vdd vgi iout0 vdd sky130_fd_pr__pfet_01v8_lvt ad=1.74 pd=12.58 as=0.87 ps=6.29 w=6 l=4
X56 a_2696_9288# a_1530_17870# vss sky130_fd_pr__res_high_po w=1 l=34.7
X57 a_30979_740# a_32099_740# vss sky130_fd_pr__res_high_po w=1 l=3.73
X58 a_13813_19996# a_13813_19996# vss vss sky130_fd_pr__nfet_01v8 ad=0.29 pd=2.29 as=0.58 ps=4.58 w=2 l=4
X59 vdd vg a_13813_19996# vdd sky130_fd_pr__pfet_01v8_lvt ad=0.87 pd=6.29 as=0.87 ps=6.29 w=6 l=8
X60 a_27496_9906# a_27200_702# vss sky130_fd_pr__res_high_po w=1 l=44.02
X61 vdd vg a_1011_12232# vdd sky130_fd_pr__pfet_01v8_lvt ad=0.87 pd=6.29 as=0.87 ps=6.29 w=6 l=8
X62 vss a_1242_15518# vg vss sky130_fd_pr__nfet_01v8 ad=0.29 pd=2.58 as=0.29 ps=2.58 w=1 l=1
X63 a_24955_13946# a_24955_13946# vdd vdd sky130_fd_pr__pfet_01v8_lvt ad=0.87 pd=6.29 as=0.87 ps=6.29 w=6 l=12
X64 a_11039_5880# a_1011_12232# vss vss sky130_fd_pr__nfet_01v8 ad=0.58 pd=4.29 as=1.16 ps=8.58 w=4 l=4
X65 vdd vss a_1242_15518# vdd sky130_fd_pr__pfet_01v8 ad=0.1218 pd=1.42 as=0.1218 ps=1.42 w=0.42 l=20
X66 vdd vg a_1011_12232# vdd sky130_fd_pr__pfet_01v8_lvt ad=1.74 pd=12.58 as=0.87 ps=6.29 w=6 l=8
X67 a_13813_19996# vg vdd vdd sky130_fd_pr__pfet_01v8_lvt ad=0.87 pd=6.29 as=0.87 ps=6.29 w=6 l=8
X68 vdd vgi iout1 vdd sky130_fd_pr__pfet_01v8_lvt ad=0.87 pd=6.29 as=0.87 ps=6.29 w=6 l=4
X69 a_3050_22430# a_6044_1584# vss sky130_fd_pr__res_high_po w=1 l=33.6
X70 a_19734_4302# vg sky130_fd_pr__cap_mim_m3_1 l=22.2 w=22.2
X71 a_32099_740# vss vss sky130_fd_pr__res_high_po w=1 l=1.27
X72 a_624_9288# vg vdd vdd sky130_fd_pr__pfet_01v8_lvt ad=0.87 pd=6.29 as=0.87 ps=6.29 w=6 l=8
X73 a_920_9288# vg vdd vdd sky130_fd_pr__pfet_01v8_lvt ad=0.87 pd=6.29 as=1.74 ps=12.58 w=6 l=8
X74 a_26904_9906# a_26608_702# vss sky130_fd_pr__res_high_po w=1 l=44.02
X75 a_25720_9906# a_25424_702# vss sky130_fd_pr__res_high_po w=1 l=44.02
X76 vdd vgi iout3 vdd sky130_fd_pr__pfet_01v8_lvt ad=1.74 pd=12.58 as=0.87 ps=6.29 w=6 l=4
X77 a_5156_8704# a_5452_1584# vss sky130_fd_pr__res_high_po w=1 l=33.6
X78 vg a_10355_8086# vdd vdd sky130_fd_pr__pfet_01v8_lvt ad=0.87 pd=6.29 as=0.87 ps=6.29 w=6 l=4
X79 a_11039_5880# a_624_9288# a_10355_8086# vss sky130_fd_pr__nfet_01v8 ad=1.74 pd=12.58 as=0.87 ps=6.29 w=6 l=5
X80 a_24955_13946# a_25424_9906# a_25639_12140# vss sky130_fd_pr__nfet_01v8 ad=0.87 pd=6.29 as=0.87 ps=6.29 w=6 l=5
X81 vdd vgi iout3 vdd sky130_fd_pr__pfet_01v8_lvt ad=0.87 pd=6.29 as=0.87 ps=6.29 w=6 l=4
X82 vgi vdd sky130_fd_pr__cap_mim_m3_1 l=22.2 w=22.2
X83 a_5748_8704# a_5452_1584# vss sky130_fd_pr__res_high_po w=1 l=33.6
X84 vgi vdd sky130_fd_pr__cap_mim_m3_1 l=22.2 w=22.2
X85 vbg a_3380_1584# vss sky130_fd_pr__res_high_po w=1 l=33.6
X86 a_4268_8704# a_4564_1584# vss sky130_fd_pr__res_high_po w=1 l=33.6
X87 vss vss a_1530_17870# sky130_fd_pr__pnp_05v5_W3p40L3p40
**devattr s=462400,2720
X88 a_19142_4302# a_18846_806# vss sky130_fd_pr__res_high_po w=1 l=15.48
X89 vdd vg vbg vdd sky130_fd_pr__pfet_01v8_lvt ad=1.74 pd=12.58 as=0.87 ps=6.29 w=6 l=8
X90 vdd vg vbg vdd sky130_fd_pr__pfet_01v8_lvt ad=0.87 pd=6.29 as=0.87 ps=6.29 w=6 l=8
X91 vdd vgi iout2 vdd sky130_fd_pr__pfet_01v8_lvt ad=0.87 pd=6.29 as=0.87 ps=6.29 w=6 l=4
X92 a_3676_8704# a_3380_1584# vss sky130_fd_pr__res_high_po w=1 l=33.6
X93 vgi vdd sky130_fd_pr__cap_mim_m3_1 l=22.2 w=22.2
X94 vss vss a_1530_17870# sky130_fd_pr__pnp_05v5_W3p40L3p40
**devattr s=462400,2720
X95 a_19142_4302# a_19438_806# vss sky130_fd_pr__res_high_po w=1 l=15.48
X96 a_10355_9522# a_10355_8086# vdd vdd sky130_fd_pr__pfet_01v8_lvt ad=1.74 pd=12.58 as=0.87 ps=6.29 w=6 l=12
X97 a_920_9288# vg vdd vdd sky130_fd_pr__pfet_01v8_lvt ad=0.87 pd=6.29 as=0.87 ps=6.29 w=6 l=8
X98 a_2400_9288# a_2104_1000# vss sky130_fd_pr__res_high_po w=1 l=39.44
X99 vdd a_10355_8086# vg vdd sky130_fd_pr__pfet_01v8_lvt ad=0.87 pd=6.29 as=0.87 ps=6.29 w=6 l=4
X100 vdd vgi iout0 vdd sky130_fd_pr__pfet_01v8_lvt ad=0.87 pd=6.29 as=0.87 ps=6.29 w=6 l=4
X101 vgi vbg a_25639_12140# vss sky130_fd_pr__nfet_01v8 ad=0.87 pd=6.29 as=0.87 ps=6.29 w=6 l=5
X102 vss vss a_2400_9288# sky130_fd_pr__pnp_05v5_W3p40L3p40
**devattr s=462400,2720
X103 vgi a_24955_13946# vdd vdd sky130_fd_pr__pfet_01v8_lvt ad=0.87 pd=6.29 as=0.87 ps=6.29 w=6 l=12
X104 vgi a_24955_13946# vdd vdd sky130_fd_pr__pfet_01v8_lvt ad=0.87 pd=6.29 as=0.87 ps=6.29 w=6 l=12
X105 a_10355_8086# a_624_9288# a_11039_5880# vss sky130_fd_pr__nfet_01v8 ad=0.87 pd=6.29 as=1.74 ps=12.58 w=6 l=5
X106 vgi vdd sky130_fd_pr__cap_mim_m3_1 l=22.2 w=22.2
X107 a_1512_9288# a_624_1000# vss sky130_fd_pr__res_high_po w=1 l=39.44
X108 a_10355_8086# a_10355_8086# vdd vdd sky130_fd_pr__pfet_01v8_lvt ad=0.87 pd=6.29 as=0.87 ps=6.29 w=6 l=12
X109 a_19734_4302# vg sky130_fd_pr__cap_mim_m3_1 l=22.2 w=22.2
X110 a_19734_4302# vg sky130_fd_pr__cap_mim_m3_1 l=22.2 w=22.2
X111 a_19734_4302# vg sky130_fd_pr__cap_mim_m3_1 l=22.2 w=22.2
X112 a_1216_9288# a_1808_1000# vss sky130_fd_pr__res_high_po w=1 l=39.44
X113 vdd a_24955_13946# vgi vdd sky130_fd_pr__pfet_01v8_lvt ad=0.87 pd=6.29 as=1.74 ps=12.58 w=6 l=12
X114 vss a_1011_12232# a_1011_12232# vss sky130_fd_pr__nfet_01v8 ad=0.58 pd=4.58 as=0.29 ps=2.29 w=2 l=4
X115 a_11039_5880# a_920_9288# a_10355_9522# vss sky130_fd_pr__nfet_01v8 ad=0.87 pd=6.29 as=0.87 ps=6.29 w=6 l=5
X116 vdd a_24955_13946# a_24955_13946# vdd sky130_fd_pr__pfet_01v8_lvt ad=0.87 pd=6.29 as=0.87 ps=6.29 w=6 l=12
X117 vdd vgi iout2 vdd sky130_fd_pr__pfet_01v8_lvt ad=0.87 pd=6.29 as=0.87 ps=6.29 w=6 l=4
X118 vgi vbg a_25639_12140# vss sky130_fd_pr__nfet_01v8 ad=0.87 pd=6.29 as=0.87 ps=6.29 w=6 l=5
X119 vg a_10355_8086# vdd vdd sky130_fd_pr__pfet_01v8_lvt ad=0.87 pd=6.29 as=0.87 ps=6.29 w=6 l=4
X120 a_10355_8086# a_10355_8086# vdd vdd sky130_fd_pr__pfet_01v8_lvt ad=1.74 pd=12.58 as=0.87 ps=6.29 w=6 l=12
X121 a_10355_9522# a_10355_8086# vdd vdd sky130_fd_pr__pfet_01v8_lvt ad=1.74 pd=12.58 as=0.87 ps=6.29 w=6 l=12
X122 a_28739_740# g4 a_27496_9906# vss sky130_fd_pr__nfet_01v8 ad=1.55 pd=10.62 as=0.825 ps=5.33 w=5 l=0.15
X123 vgi a_24955_13946# vdd vdd sky130_fd_pr__pfet_01v8_lvt ad=1.74 pd=12.58 as=0.87 ps=6.29 w=6 l=12
X124 iout1 vgi vdd vdd sky130_fd_pr__pfet_01v8_lvt ad=0.87 pd=6.29 as=0.87 ps=6.29 w=6 l=4
X125 vss vss a_3050_22430# sky130_fd_pr__pnp_05v5_W3p40L3p40
**devattr s=462400,2720
X126 a_24955_13946# a_24955_13946# vdd vdd sky130_fd_pr__pfet_01v8_lvt ad=0.87 pd=6.29 as=0.87 ps=6.29 w=6 l=12
X127 a_13813_19996# vg vdd vdd sky130_fd_pr__pfet_01v8_lvt ad=0.87 pd=6.29 as=1.74 ps=12.58 w=6 l=8
X128 a_1011_12232# vg vdd vdd sky130_fd_pr__pfet_01v8_lvt ad=0.87 pd=6.29 as=1.74 ps=12.58 w=6 l=8
X129 a_10355_8086# a_10355_8086# vdd vdd sky130_fd_pr__pfet_01v8_lvt ad=0.87 pd=6.29 as=0.87 ps=6.29 w=6 l=12
X130 a_10355_9522# a_10355_8086# vdd vdd sky130_fd_pr__pfet_01v8_lvt ad=0.87 pd=6.29 as=0.87 ps=6.29 w=6 l=12
X131 a_19734_4302# vg sky130_fd_pr__cap_mim_m3_1 l=22.2 w=22.2
X132 a_3676_8704# a_3972_1584# vss sky130_fd_pr__res_high_po w=1 l=33.6
X133 vdd a_10355_8086# a_10355_8086# vdd sky130_fd_pr__pfet_01v8_lvt ad=0.87 pd=6.29 as=0.87 ps=6.29 w=6 l=12
X134 a_25720_9906# a_26016_702# vss sky130_fd_pr__res_high_po w=1 l=44.02
X135 a_24955_13946# a_25424_9906# a_25639_12140# vss sky130_fd_pr__nfet_01v8 ad=0.87 pd=6.29 as=1.74 ps=12.58 w=6 l=5
X136 a_19734_4302# a_19438_806# vss sky130_fd_pr__res_high_po w=1 l=15.48
X137 vgi vdd sky130_fd_pr__cap_mim_m3_1 l=22.2 w=22.2
X138 vss vss a_1530_17870# sky130_fd_pr__pnp_05v5_W3p40L3p40
**devattr s=462400,2720
X139 vdd vgi iout1 vdd sky130_fd_pr__pfet_01v8_lvt ad=0.87 pd=6.29 as=0.87 ps=6.29 w=6 l=4
X140 a_2696_9288# a_1808_1000# vss sky130_fd_pr__res_high_po w=1 l=39.44
X141 a_10355_8086# a_10355_8086# vdd vdd sky130_fd_pr__pfet_01v8_lvt ad=1.74 pd=12.58 as=0.87 ps=6.29 w=6 l=12
X142 vgi vdd sky130_fd_pr__cap_mim_m3_1 l=22.2 w=22.2
X143 vdd a_24955_13946# a_24955_13946# vdd sky130_fd_pr__pfet_01v8_lvt ad=0.87 pd=6.29 as=1.74 ps=12.58 w=6 l=12
X144 vss a_10355_9522# vg vss sky130_fd_pr__nfet_01v8 ad=0.58 pd=4.58 as=0.58 ps=4.58 w=2 l=2
X145 vdd a_10355_8086# vg vdd sky130_fd_pr__pfet_01v8_lvt ad=0.87 pd=6.29 as=0.87 ps=6.29 w=6 l=4
X146 a_25639_12140# vbg vgi vss sky130_fd_pr__nfet_01v8 ad=0.87 pd=6.29 as=0.87 ps=6.29 w=6 l=5
X147 vdd a_24955_13946# a_24955_13946# vdd sky130_fd_pr__pfet_01v8_lvt ad=0.87 pd=6.29 as=1.74 ps=12.58 w=6 l=12
X148 a_10355_9522# a_18846_806# vss sky130_fd_pr__res_high_po w=1 l=15.48
X149 vdd vg a_13813_19996# vdd sky130_fd_pr__pfet_01v8_lvt ad=1.74 pd=12.58 as=0.87 ps=6.29 w=6 l=8
X150 iout2 vgi vdd vdd sky130_fd_pr__pfet_01v8_lvt ad=0.87 pd=6.29 as=0.87 ps=6.29 w=6 l=4
X151 vdd a_10355_8086# vg vdd sky130_fd_pr__pfet_01v8_lvt ad=0.87 pd=6.29 as=0.87 ps=6.29 w=6 l=4
X152 vss vss a_1530_17870# sky130_fd_pr__pnp_05v5_W3p40L3p40
**devattr s=462400,2720
X153 vss vss a_1530_17870# sky130_fd_pr__pnp_05v5_W3p40L3p40
**devattr s=462400,2720
X154 vdd vg a_624_9288# vdd sky130_fd_pr__pfet_01v8_lvt ad=1.74 pd=12.58 as=0.87 ps=6.29 w=6 l=8
X155 vdd a_10355_8086# a_10355_9522# vdd sky130_fd_pr__pfet_01v8_lvt ad=0.87 pd=6.29 as=1.74 ps=12.58 w=6 l=12
X156 a_10355_9522# a_10355_8086# vdd vdd sky130_fd_pr__pfet_01v8_lvt ad=0.87 pd=6.29 as=0.87 ps=6.29 w=6 l=12
X157 vdd vg a_624_9288# vdd sky130_fd_pr__pfet_01v8_lvt ad=0.87 pd=6.29 as=0.87 ps=6.29 w=6 l=8
X158 vdd a_24955_13946# vgi vdd sky130_fd_pr__pfet_01v8_lvt ad=0.87 pd=6.29 as=0.87 ps=6.29 w=6 l=12
X159 vdd a_24955_13946# vgi vdd sky130_fd_pr__pfet_01v8_lvt ad=0.87 pd=6.29 as=0.87 ps=6.29 w=6 l=12
X160 vss vss a_1530_17870# sky130_fd_pr__pnp_05v5_W3p40L3p40
**devattr s=462400,2720
X161 vss vss a_1530_17870# sky130_fd_pr__pnp_05v5_W3p40L3p40
**devattr s=462400,2720
X162 a_25639_12140# a_25424_9906# a_24955_13946# vss sky130_fd_pr__nfet_01v8 ad=1.74 pd=12.58 as=0.87 ps=6.29 w=6 l=5
X163 vgi vdd sky130_fd_pr__cap_mim_m3_1 l=22.2 w=22.2
X164 vbg vg vdd vdd sky130_fd_pr__pfet_01v8_lvt ad=0.87 pd=6.29 as=1.74 ps=12.58 w=6 l=8
X165 vdd a_10355_8086# vg vdd sky130_fd_pr__pfet_01v8_lvt ad=1.74 pd=12.58 as=0.87 ps=6.29 w=6 l=4
X166 a_1011_12232# vg vdd vdd sky130_fd_pr__pfet_01v8_lvt ad=0.87 pd=6.29 as=0.87 ps=6.29 w=6 l=8
X167 vss a_13813_19996# a_13813_19996# vss sky130_fd_pr__nfet_01v8 ad=0.58 pd=4.58 as=0.29 ps=2.29 w=2 l=4
X168 a_24955_13946# a_24955_13946# vdd vdd sky130_fd_pr__pfet_01v8_lvt ad=1.74 pd=12.58 as=0.87 ps=6.29 w=6 l=12
X169 a_24955_13946# a_24955_13946# vdd vdd sky130_fd_pr__pfet_01v8_lvt ad=1.74 pd=12.58 as=0.87 ps=6.29 w=6 l=12
X170 vss vss a_1530_17870# sky130_fd_pr__pnp_05v5_W3p40L3p40
**devattr s=462400,2720
X171 a_11039_5880# a_624_9288# a_10355_8086# vss sky130_fd_pr__nfet_01v8 ad=0.87 pd=6.29 as=0.87 ps=6.29 w=6 l=5
X172 a_11039_5880# a_920_9288# a_10355_9522# vss sky130_fd_pr__nfet_01v8 ad=0.87 pd=6.29 as=0.87 ps=6.29 w=6 l=5
X173 a_27496_9906# g4 a_28739_740# vss sky130_fd_pr__nfet_01v8 ad=0.825 pd=5.33 as=0.825 ps=5.33 w=5 l=0.15
X174 a_624_9288# a_624_1000# vss sky130_fd_pr__res_high_po w=1 l=39.44
X175 a_28739_740# g4 a_27496_9906# vss sky130_fd_pr__nfet_01v8 ad=0.825 pd=5.33 as=0.825 ps=5.33 w=5 l=0.15
X176 vdd vg a_920_9288# vdd sky130_fd_pr__pfet_01v8_lvt ad=0.87 pd=6.29 as=0.87 ps=6.29 w=6 l=8
X177 vdd a_10355_8086# a_10355_9522# vdd sky130_fd_pr__pfet_01v8_lvt ad=0.87 pd=6.29 as=0.87 ps=6.29 w=6 l=12
X178 vg a_10355_8086# vdd vdd sky130_fd_pr__pfet_01v8_lvt ad=0.87 pd=6.29 as=1.74 ps=12.58 w=6 l=4
X179 vdd vg a_920_9288# vdd sky130_fd_pr__pfet_01v8_lvt ad=1.74 pd=12.58 as=0.87 ps=6.29 w=6 l=8
X180 a_1011_12232# a_1011_12232# vss vss sky130_fd_pr__nfet_01v8 ad=0.29 pd=2.29 as=0.58 ps=4.58 w=2 l=4
X181 a_25424_9906# vgi vdd vdd sky130_fd_pr__pfet_01v8_lvt ad=0.87 pd=6.29 as=0.87 ps=6.29 w=6 l=4
X182 vdd vgi a_25424_9906# vdd sky130_fd_pr__pfet_01v8_lvt ad=0.87 pd=6.29 as=0.87 ps=6.29 w=6 l=4
X183 vbg vg vdd vdd sky130_fd_pr__pfet_01v8_lvt ad=0.87 pd=6.29 as=0.87 ps=6.29 w=6 l=8
X184 iout0 vgi vdd vdd sky130_fd_pr__pfet_01v8_lvt ad=0.87 pd=6.29 as=0.87 ps=6.29 w=6 l=4
X185 vdd a_24955_13946# vgi vdd sky130_fd_pr__pfet_01v8_lvt ad=0.87 pd=6.29 as=1.74 ps=12.58 w=6 l=12
X186 vdd a_10355_8086# a_10355_8086# vdd sky130_fd_pr__pfet_01v8_lvt ad=0.87 pd=6.29 as=1.74 ps=12.58 w=6 l=12
X187 a_26904_9906# a_27200_702# vss sky130_fd_pr__res_high_po w=1 l=44.02
X188 a_10355_8086# a_624_9288# a_11039_5880# vss sky130_fd_pr__nfet_01v8 ad=0.87 pd=6.29 as=0.87 ps=6.29 w=6 l=5
X189 a_10355_9522# a_920_9288# a_11039_5880# vss sky130_fd_pr__nfet_01v8 ad=0.87 pd=6.29 as=0.87 ps=6.29 w=6 l=5
C0 g4 a_29859_740# 0
C1 vbg a_3676_8704# 0.15223f
C2 a_1512_9288# vbg 0
C3 a_10355_8086# a_920_9288# 1.34589f
C4 a_13813_19996# vg 3.67521f
C5 a_624_1000# a_1808_1000# 0.15915f
C6 a_4564_1584# a_3972_1584# 0.15632f
C7 a_26312_9906# vbg 0.00226f
C8 vdd a_26016_702# 0.33483f
C9 a_19734_4302# vg 0.26612p
C10 vgi a_26016_702# 0.02159f
C11 a_25639_12140# vbg 3.46839f
C12 vbg a_5156_8704# 0
C13 a_24955_13946# iout0 0
C14 a_1530_17870# a_2400_9288# 0.32237f
C15 a_32099_740# g1 0.47717f
C16 a_4268_8704# a_3050_22430# 0
C17 a_2400_9288# a_1242_15518# 0.10871f
C18 vbg vg 5.81195f
C19 a_1530_17870# a_3972_1584# 0.00226f
C20 iout0 iout1 2.02514f
C21 a_1530_17870# a_1011_12232# 0.08893f
C22 a_10355_9522# a_1011_12232# 0.00147f
C23 a_1242_15518# a_1011_12232# 0.51866f
C24 a_24955_13946# a_25424_9906# 3.44389f
C25 a_1530_17870# a_920_9288# 0.08739f
C26 a_10355_9522# a_920_9288# 2.71483f
C27 a_26312_9906# vdd 0.2978f
C28 iout1 a_25424_9906# 0.42748f
C29 g3 a_30979_740# 0
C30 vgi a_26312_9906# 0.01743f
C31 a_25639_12140# vdd 7.16659f
C32 a_2104_1000# a_1808_1000# 0.63493f
C33 g4 a_28739_740# 0.47717f
C34 a_25639_12140# vgi 0.92823f
C35 a_26608_702# vdd 0.33483f
C36 vgi a_26608_702# 0.02159f
C37 a_27496_9906# a_28739_740# 2.08714f
C38 a_30979_740# g1 0.43554f
C39 a_28739_740# a_13813_19996# 0.00155f
C40 vdd vg 0.11293p
C41 a_26312_9906# a_26904_9906# 0.15162f
C42 a_24955_13946# iout1 0
C43 a_29859_740# vdd 2.86812f
C44 vgi a_29859_740# 0.11349f
C45 a_4268_8704# a_920_9288# 0
C46 a_1530_17870# a_2696_9288# 0.00876f
C47 a_5748_8704# a_1530_17870# 0.13724f
C48 a_10355_8086# vg 88.1211f
C49 a_19734_4302# a_624_9288# 0.28378f
C50 a_27496_9906# g4 0.43513f
C51 a_3380_1584# a_3972_1584# 0.15162f
C52 a_10355_9522# a_19438_806# 0.00571f
C53 a_624_1000# a_920_1000# 0.6345f
C54 a_19142_4302# vg 0.32303f
C55 a_1530_17870# a_5156_8704# 0.03015f
C56 a_27496_9906# a_13813_19996# 0.10769f
C57 a_27496_9906# a_25720_9906# 0
C58 vbg a_624_9288# 2.03348f
C59 a_4268_8704# a_2696_9288# 0.12163f
C60 g2 vdd 0.49416f
C61 vgi g2 0.01754f
C62 a_1530_17870# vg 0.09191f
C63 a_10355_9522# vg 28.0427f
C64 a_25424_702# a_26016_702# 0.15162f
C65 a_1242_15518# vg 0.28228f
C66 iout3 vdd 7.452f
C67 a_4268_8704# a_3676_8704# 0.15162f
C68 iout3 vgi 3.37372f
C69 a_2400_9288# a_1216_9288# 0.00492f
C70 a_11039_5880# a_1011_12232# 1.14686f
C71 a_28739_740# vdd 3.1742f
C72 a_27496_9906# vbg 0.0899f
C73 a_6044_1584# a_1011_12232# 0
C74 vgi a_28739_740# 0.13001f
C75 a_3050_22430# a_1011_12232# 0.08338f
C76 vbg a_13813_19996# 1.01594f
C77 a_25720_9906# vbg 0.00226f
C78 vbg a_19734_4302# 0.07053f
C79 a_11039_5880# a_920_9288# 3.63896f
C80 a_4268_8704# a_5156_8704# 0.01213f
C81 a_920_9288# a_3050_22430# 0.08708f
C82 a_624_9288# vdd 2.8807f
C83 a_920_9288# a_1216_9288# 0.19489f
C84 g4 vdd 0.50012f
C85 g4 vgi 0.01709f
C86 a_25424_9906# a_26312_9906# 0.02359f
C87 a_2400_9288# a_1011_12232# 0.36445f
C88 a_10355_8086# a_624_9288# 3.30075f
C89 a_25639_12140# a_25424_9906# 3.16061f
C90 a_27496_9906# vdd 4.25885f
C91 a_27496_9906# vgi 0.1885f
C92 a_13813_19996# vdd 12.9812f
C93 a_920_9288# a_2400_9288# 0.10294f
C94 vgi a_13813_19996# 2.09908f
C95 a_25720_9906# vdd 0.2978f
C96 iout2 iout3 2.26645f
C97 a_19734_4302# vdd 2.12538f
C98 a_25720_9906# vgi 0.01743f
C99 a_2696_9288# a_3050_22430# 0.00136f
C100 a_5748_8704# a_3050_22430# 0.22251f
C101 a_25424_9906# vg 0
C102 a_920_9288# a_1011_12232# 0.41853f
C103 a_19142_4302# a_624_9288# 0.00741f
C104 a_25639_12140# a_24955_13946# 1.31179f
C105 a_10355_8086# a_19734_4302# 3.99926f
C106 a_27496_9906# a_26904_9906# 0.16859f
C107 vbg vdd 13.6954f
C108 a_32099_740# g2 0
C109 vgi vbg 4.99431f
C110 a_1512_9288# a_1216_9288# 0.79766f
C111 a_18846_806# a_19438_806# 0.15162f
C112 a_30979_740# a_29859_740# 2.0915f
C113 a_1530_17870# a_624_9288# 0.08055f
C114 a_3050_22430# a_5156_8704# 0.00104f
C115 a_10355_9522# a_624_9288# 1.00745f
C116 a_2400_9288# a_2696_9288# 0.21034f
C117 a_10355_8086# vbg 0.0011f
C118 a_19142_4302# a_19734_4302# 0.17852f
C119 g3 a_29859_740# 0.47717f
C120 a_11039_5880# vg 8.05734f
C121 a_18846_806# vg 0.34907f
C122 vbg a_26904_9906# 0.00226f
C123 a_3050_22430# vg 0.08376f
C124 a_1512_9288# a_2400_9288# 0.16285f
C125 iout3 iout0 0.2239f
C126 a_27200_702# a_26608_702# 0.15162f
C127 a_920_9288# a_2696_9288# 0.25227f
C128 a_10355_9522# a_19734_4302# 1.44395f
C129 a_5748_8704# a_920_9288# 0.00263f
C130 vgi vdd 0.54394p
C131 a_4268_8704# a_624_9288# 0
C132 a_30979_740# g2 0.47717f
C133 iout3 a_25424_9906# 0.28422f
C134 a_3676_8704# a_920_9288# 0
C135 a_1512_9288# a_920_9288# 0.01492f
C136 a_10355_8086# vdd 97.8221f
C137 a_1530_17870# vbg 0.09155f
C138 a_10355_9522# vbg 0
C139 vbg a_1242_15518# 0
C140 g3 g2 0.02512f
C141 a_26904_9906# vdd 0.2978f
C142 a_920_9288# a_5156_8704# 0.00265f
C143 vgi a_26904_9906# 0.02029f
C144 a_1011_12232# vg 8.59245f
C145 iout3 a_24955_13946# 0
C146 a_624_1000# a_2104_1000# 0.00119f
C147 a_5748_8704# a_2696_9288# 0
C148 g2 g1 0.02512f
C149 g3 a_28739_740# 0.43541f
C150 a_19142_4302# vdd 0
C151 a_920_9288# vg 11.419f
C152 iout3 iout1 0.22683f
C153 g0 vdd 0.49744f
C154 vgi g0 0.01761f
C155 a_3676_8704# a_2696_9288# 0.00462f
C156 a_1512_9288# a_2696_9288# 0
C157 a_26608_702# a_26016_702# 0.15162f
C158 a_27496_9906# a_25424_9906# 0.23356f
C159 a_4268_8704# vbg 0
C160 iout2 vdd 6.69436f
C161 a_10355_8086# a_19142_4302# 0
C162 a_25424_9906# a_13813_19996# 2.0886f
C163 a_1530_17870# vdd 0.12364f
C164 iout2 vgi 3.77227f
C165 a_25720_9906# a_25424_9906# 0.18013f
C166 a_10355_9522# vdd 4.61053f
C167 a_1242_15518# vdd 0.11026f
C168 a_2696_9288# a_5156_8704# 0.1176f
C169 a_4564_1584# a_5452_1584# 0.15632f
C170 a_5748_8704# a_5156_8704# 0.15162f
C171 a_11039_5880# a_624_9288# 3.06418f
C172 g4 g3 0.02512f
C173 a_27200_702# a_28739_740# 0.00826f
C174 a_624_9288# a_3050_22430# 0.07593f
C175 a_10355_9522# a_10355_8086# 16.0659f
C176 a_624_9288# a_1216_9288# 0
C177 a_25424_9906# vbg 4.18476f
C178 a_24955_13946# a_13813_19996# 0.00496f
C179 a_32099_740# vdd 2.583f
C180 a_1530_17870# a_5452_1584# 0.30347f
C181 vgi a_32099_740# 0.12637f
C182 a_4564_1584# a_1530_17870# 0.47436f
C183 a_11039_5880# a_19734_4302# 0.36728f
C184 a_18846_806# a_19734_4302# 0.02056f
C185 a_10355_9522# a_19142_4302# 0.40379f
C186 a_27200_702# g4 0
C187 iout0 vdd 7.76321f
C188 vg a_19438_806# 0.33294f
C189 iout0 vgi 3.34816f
C190 a_2400_9288# a_624_9288# 0.08998f
C191 a_24955_13946# vbg 1.1967f
C192 a_27200_702# a_27496_9906# 0
C193 a_1808_1000# a_920_1000# 0.00119f
C194 a_624_9288# a_1011_12232# 3.54658f
C195 a_1530_17870# a_1242_15518# 0.01503f
C196 a_25424_702# vdd 0.35286f
C197 vbg a_3050_22430# 0.08594f
C198 a_25424_9906# vdd 20.9757f
C199 vgi a_25424_9906# 6.34857f
C200 a_25424_702# vgi 0.02159f
C201 a_920_9288# a_624_9288# 5.02865f
C202 vbg a_1216_9288# 0
C203 a_32099_740# g0 0.43803f
C204 a_30979_740# vdd 2.74625f
C205 vgi a_30979_740# 0.13503f
C206 a_19734_4302# a_1011_12232# 0.16047f
C207 a_25424_9906# a_26904_9906# 0.02304f
C208 a_24955_13946# vdd 0.14715p
C209 a_1530_17870# a_4268_8704# 0.0044f
C210 g3 vdd 0.40971f
C211 a_24955_13946# vgi 20.6575f
C212 g3 vgi 0.01365f
C213 vbg a_2400_9288# 0.00427f
C214 a_19734_4302# a_920_9288# 0.26071f
C215 a_11039_5880# vdd 0.31249f
C216 iout2 iout0 0.22454f
C217 iout1 vdd 6.67907f
C218 a_3380_1584# a_4564_1584# 0
C219 iout1 vgi 3.78752f
C220 a_3050_22430# vdd 0.2863f
C221 a_2696_9288# a_624_9288# 0
C222 vdd g1 0.49109f
C223 vbg a_1011_12232# 0.33479f
C224 vgi g1 0.02042f
C225 a_5748_8704# a_624_9288# 0
C226 a_11039_5880# a_10355_8086# 1.71657f
C227 iout2 a_25424_9906# 0.42748f
C228 vbg a_920_9288# 2.8363f
C229 a_3676_8704# a_624_9288# 0
C230 a_1512_9288# a_624_9288# 0
C231 a_29859_740# g2 0.43541f
C232 a_10355_9522# a_25424_9906# 0
C233 a_27200_702# vdd 0.36802f
C234 a_3380_1584# a_1530_17870# 0
C235 a_27200_702# vgi 0.02159f
C236 a_6044_1584# a_5452_1584# 0.15162f
C237 a_4564_1584# a_6044_1584# 0
C238 a_2400_9288# vdd 0.09217f
C239 a_624_9288# a_5156_8704# 0
C240 a_28739_740# a_29859_740# 2.11136f
C241 a_11039_5880# a_19142_4302# 0.0012f
C242 iout2 a_24955_13946# 0.00105f
C243 a_1011_12232# vdd 2.31721f
C244 g0 g1 0.02512f
C245 a_27496_9906# a_26312_9906# 0.00214f
C246 a_624_9288# vg 12.6534f
C247 iout2 iout1 1.25141f
C248 vbg a_2696_9288# 0.11551f
C249 a_6044_1584# a_1530_17870# 0.0766f
C250 a_10355_9522# a_11039_5880# 0.67037f
C251 a_25720_9906# a_26312_9906# 0.15162f
C252 a_25639_12140# a_13813_19996# 0.21514f
C253 a_5748_8704# vbg 0
C254 a_920_9288# vdd 3.08298f
C255 a_10355_9522# a_18846_806# 0.00571f
C256 a_19734_4302# a_19438_806# 0.01639f
C257 a_1530_17870# a_3050_22430# 1.16373f
C258 a_30979_740# a_32099_740# 2.0903f
C259 a_10355_8086# a_1011_12232# 0.03296f
C260 a_1242_15518# a_3050_22430# 0.00161f
C261 iout0 a_25424_9906# 0.28422f
C262 g0 vss 1.87895f
C263 g1 vss 1.34957f
C264 g2 vss 1.34959f
C265 g3 vss 1.34959f
C266 g4 vss 1.40908f
C267 iout0 vss 0.53758f
C268 iout1 vss 0.51158f
C269 iout2 vss 0.6765f
C270 iout3 vss 1.94028f
C271 vgi vss 21.7505f
C272 vbg vss 20.9555f
C273 vg vss 50.3414f
C274 vdd vss 0.74149p
C275 a_32099_740# vss 4.81519f
C276 a_30979_740# vss 2.98413f
C277 a_29859_740# vss 3.38749f
C278 a_28739_740# vss 4.2363f
C279 a_27496_9906# vss 5.36985f
C280 a_27200_702# vss 0.73208f
C281 a_26904_9906# vss 0.612f
C282 a_26608_702# vss 0.60645f
C283 a_26312_9906# vss 0.61203f
C284 a_26016_702# vss 0.6065f
C285 a_25720_9906# vss 0.6121f
C286 a_25424_702# vss 0.72867f
C287 a_25639_12140# vss 1.57515f
C288 a_24955_13946# vss 4.00149f
C289 a_19734_4302# vss 9.34298f
C290 a_19438_806# vss 1.09723f
C291 a_19142_4302# vss 0.61211f
C292 a_18846_806# vss 1.0968f
C293 a_11039_5880# vss 2.82262f
C294 a_10355_9522# vss 7.94183f
C295 a_10355_8086# vss 10.3101f
C296 a_6044_1584# vss 0.78931f
C297 a_5748_8704# vss 0.69191f
C298 a_5452_1584# vss 0.66066f
C299 a_5156_8704# vss 0.71479f
C300 a_4564_1584# vss 0.8124f
C301 a_4268_8704# vss 0.71475f
C302 a_3972_1584# vss 0.66058f
C303 a_3676_8704# vss 0.68955f
C304 a_3380_1584# vss 0.81686f
C305 a_2696_9288# vss 1.80418f
C306 a_2104_1000# vss 0.6124f
C307 a_1808_1000# vss 0.99338f
C308 a_1512_9288# vss 0.70034f
C309 a_1216_9288# vss 0.65428f
C310 a_920_1000# vss 0.61251f
C311 a_624_1000# vss 0.97453f
C312 a_1242_15518# vss 3.80332f
C313 a_25424_9906# vss 15.9374f
C314 a_13813_19996# vss 15.5378f
C315 a_920_9288# vss 15.0599f
C316 a_1011_12232# vss 16.4256f
C317 a_624_9288# vss 14.0467f
C318 a_2400_9288# vss 5.20742f
C319 a_1530_17870# vss 11.7611f
C320 a_3050_22430# vss 6.05338f
.ends
