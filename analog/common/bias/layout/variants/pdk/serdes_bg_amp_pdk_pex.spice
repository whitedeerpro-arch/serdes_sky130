* NGSPICE file created from serdes_bg_amp_pdk.ext - technology: sky130A

.subckt serdes_bg_amp_pdk inp inn vbn out vdd vss
X0 out a_n4945_7806# vdd vdd sky130_fd_pr__pfet_01v8_lvt ad=0.87 pd=6.29 as=0.87 ps=6.29 w=6 l=4
X1 a_n4945_7806# a_n4945_7806# vdd vdd sky130_fd_pr__pfet_01v8_lvt ad=1.74 pd=12.58 as=0.87 ps=6.29 w=6 l=12
X2 a_n4945_7806# a_n4945_7806# vdd vdd sky130_fd_pr__pfet_01v8_lvt ad=1.74 pd=12.58 as=0.87 ps=6.29 w=6 l=12
X3 a_n4945_9242# inp a_n4261_5600# vss sky130_fd_pr__nfet_01v8 ad=0.87 pd=6.29 as=0.87 ps=6.29 w=6 l=5
X4 out a_n4945_7806# vdd vdd sky130_fd_pr__pfet_01v8_lvt ad=0.87 pd=6.29 as=1.74 ps=12.58 w=6 l=4
X5 a_n4261_5600# vbn vss vss sky130_fd_pr__nfet_01v8 ad=0.58 pd=4.29 as=1.16 ps=8.58 w=4 l=4
X6 a_4434_4022# out sky130_fd_pr__cap_mim_m3_1 l=22.2 w=22.2
X7 vdd a_n4945_7806# a_n4945_7806# vdd sky130_fd_pr__pfet_01v8_lvt ad=0.87 pd=6.29 as=1.74 ps=12.58 w=6 l=12
X8 vdd a_n4945_7806# out vdd sky130_fd_pr__pfet_01v8_lvt ad=1.74 pd=12.58 as=0.87 ps=6.29 w=6 l=4
X9 vdd a_n4945_7806# a_n4945_7806# vdd sky130_fd_pr__pfet_01v8_lvt ad=0.87 pd=6.29 as=1.74 ps=12.58 w=6 l=12
X10 a_n4945_9242# a_n4945_7806# vdd vdd sky130_fd_pr__pfet_01v8_lvt ad=1.74 pd=12.58 as=0.87 ps=6.29 w=6 l=12
X11 vdd a_n4945_7806# out vdd sky130_fd_pr__pfet_01v8_lvt ad=0.87 pd=6.29 as=0.87 ps=6.29 w=6 l=4
X12 vdd a_n4945_7806# a_n4945_9242# vdd sky130_fd_pr__pfet_01v8_lvt ad=0.87 pd=6.29 as=1.74 ps=12.58 w=6 l=12
X13 a_n4945_9242# a_n4945_7806# vdd vdd sky130_fd_pr__pfet_01v8_lvt ad=1.74 pd=12.58 as=0.87 ps=6.29 w=6 l=12
X14 vdd a_n4945_7806# out vdd sky130_fd_pr__pfet_01v8_lvt ad=0.87 pd=6.29 as=0.87 ps=6.29 w=6 l=4
X15 vdd a_n4945_7806# out vdd sky130_fd_pr__pfet_01v8_lvt ad=0.87 pd=6.29 as=0.87 ps=6.29 w=6 l=4
X16 a_4434_4022# a_4138_526# vss sky130_fd_pr__res_high_po w=1 l=15.48
X17 a_n4945_9242# a_3546_526# vss sky130_fd_pr__res_high_po w=1 l=15.48
X18 vdd a_n4945_7806# a_n4945_9242# vdd sky130_fd_pr__pfet_01v8_lvt ad=0.87 pd=6.29 as=1.74 ps=12.58 w=6 l=12
X19 a_n4945_7806# inn a_n4261_5600# vss sky130_fd_pr__nfet_01v8 ad=0.87 pd=6.29 as=0.87 ps=6.29 w=6 l=5
X20 vss vbn a_n4261_5600# vss sky130_fd_pr__nfet_01v8 ad=1.16 pd=8.58 as=0.58 ps=4.29 w=4 l=4
X21 a_n4945_9242# inp a_n4261_5600# vss sky130_fd_pr__nfet_01v8 ad=0.87 pd=6.29 as=0.87 ps=6.29 w=6 l=5
X22 out a_n4945_7806# vdd vdd sky130_fd_pr__pfet_01v8_lvt ad=0.87 pd=6.29 as=0.87 ps=6.29 w=6 l=4
X23 a_n4945_9242# a_n4945_7806# vdd vdd sky130_fd_pr__pfet_01v8_lvt ad=0.87 pd=6.29 as=0.87 ps=6.29 w=6 l=12
X24 a_4434_4022# out sky130_fd_pr__cap_mim_m3_1 l=22.2 w=22.2
X25 a_4434_4022# out sky130_fd_pr__cap_mim_m3_1 l=22.2 w=22.2
X26 a_n4945_7806# a_n4945_7806# vdd vdd sky130_fd_pr__pfet_01v8_lvt ad=0.87 pd=6.29 as=0.87 ps=6.29 w=6 l=12
X27 a_n4261_5600# inn a_n4945_7806# vss sky130_fd_pr__nfet_01v8 ad=0.87 pd=6.29 as=0.87 ps=6.29 w=6 l=5
X28 a_n4261_5600# inp a_n4945_9242# vss sky130_fd_pr__nfet_01v8 ad=0.87 pd=6.29 as=0.87 ps=6.29 w=6 l=5
X29 a_4434_4022# out sky130_fd_pr__cap_mim_m3_1 l=22.2 w=22.2
X30 vdd a_n4945_7806# a_n4945_9242# vdd sky130_fd_pr__pfet_01v8_lvt ad=0.87 pd=6.29 as=0.87 ps=6.29 w=6 l=12
X31 a_n4945_9242# a_n4945_7806# vdd vdd sky130_fd_pr__pfet_01v8_lvt ad=0.87 pd=6.29 as=0.87 ps=6.29 w=6 l=12
X32 vss a_n4945_9242# out vss sky130_fd_pr__nfet_01v8 ad=0.58 pd=4.58 as=0.58 ps=4.58 w=2 l=2
X33 out a_n4945_7806# vdd vdd sky130_fd_pr__pfet_01v8_lvt ad=0.87 pd=6.29 as=0.87 ps=6.29 w=6 l=4
X34 vdd a_n4945_7806# a_n4945_7806# vdd sky130_fd_pr__pfet_01v8_lvt ad=0.87 pd=6.29 as=0.87 ps=6.29 w=6 l=12
X35 a_n4261_5600# inn a_n4945_7806# vss sky130_fd_pr__nfet_01v8 ad=1.74 pd=12.58 as=0.87 ps=6.29 w=6 l=5
X36 a_3842_4022# a_3546_526# vss sky130_fd_pr__res_high_po w=1 l=15.48
X37 a_n4945_7806# a_n4945_7806# vdd vdd sky130_fd_pr__pfet_01v8_lvt ad=0.87 pd=6.29 as=0.87 ps=6.29 w=6 l=12
X38 vdd a_n4945_7806# a_n4945_9242# vdd sky130_fd_pr__pfet_01v8_lvt ad=0.87 pd=6.29 as=0.87 ps=6.29 w=6 l=12
X39 a_4434_4022# out sky130_fd_pr__cap_mim_m3_1 l=22.2 w=22.2
X40 a_n4945_7806# inn a_n4261_5600# vss sky130_fd_pr__nfet_01v8 ad=0.87 pd=6.29 as=1.74 ps=12.58 w=6 l=5
X41 a_3842_4022# a_4138_526# vss sky130_fd_pr__res_high_po w=1 l=15.48
X42 a_4434_4022# out sky130_fd_pr__cap_mim_m3_1 l=22.2 w=22.2
X43 vdd a_n4945_7806# a_n4945_7806# vdd sky130_fd_pr__pfet_01v8_lvt ad=0.87 pd=6.29 as=0.87 ps=6.29 w=6 l=12
X44 a_n4261_5600# inp a_n4945_9242# vss sky130_fd_pr__nfet_01v8 ad=0.87 pd=6.29 as=0.87 ps=6.29 w=6 l=5
C0 inn vdd 0.38944f
C1 a_4434_4022# a_n4261_5600# 0.36728f
C2 vdd vbn 0.06173f
C3 a_4434_4022# a_3842_4022# 0.17852f
C4 a_n4945_7806# vdd 97.77229f
C5 a_3842_4022# a_n4261_5600# 0.0012f
C6 vdd a_n4945_9242# 4.61053f
C7 out a_4138_526# 0.33294f
C8 a_4434_4022# a_3546_526# 0.02056f
C9 inp out 6.94433f
C10 inn a_4434_4022# 0.28263f
C11 inn a_n4261_5600# 3.06418f
C12 vbn a_4434_4022# 0.1593f
C13 inn a_3842_4022# 0.00741f
C14 a_n4945_7806# a_4434_4022# 3.99926f
C15 vbn a_n4261_5600# 1.14528f
C16 a_4434_4022# a_n4945_9242# 1.44395f
C17 a_n4945_7806# a_n4261_5600# 1.71657f
C18 a_n4261_5600# a_n4945_9242# 0.67037f
C19 a_n4945_7806# a_3842_4022# 0
C20 a_3842_4022# a_n4945_9242# 0.40379f
C21 inp vdd 0.1884f
C22 a_3546_526# a_n4945_9242# 0.00571f
C23 a_n4945_7806# inn 3.30032f
C24 inn a_n4945_9242# 1.00745f
C25 a_n4945_7806# vbn 0.03296f
C26 a_4434_4022# a_4138_526# 0.01639f
C27 vbn a_n4945_9242# 0.00147f
C28 a_n4945_7806# a_n4945_9242# 16.0659f
C29 inp a_4434_4022# 0.25956f
C30 inp a_n4261_5600# 3.6389f
C31 vdd out 36.4892f
C32 a_4138_526# a_3546_526# 0.15162f
C33 inp inn 2.04989f
C34 a_4138_526# a_n4945_9242# 0.00571f
C35 out a_4434_4022# 0.26579p
C36 a_n4945_7806# inp 1.34513f
C37 out a_n4261_5600# 8.05665f
C38 inp a_n4945_9242# 2.71483f
C39 out a_3842_4022# 0.32303f
C40 out a_3546_526# 0.34907f
C41 inn out 8.47184f
C42 vdd a_4434_4022# 2.12187f
C43 vdd a_n4261_5600# 0.31249f
C44 vbn out 1.79597f
C45 a_n4945_7806# out 88.1125f
C46 vdd a_3842_4022# 0
C47 out a_n4945_9242# 26.7784f
C48 vbn vss 4.50681f
C49 out vss 38.035f
C50 inp vss 8.33832f
C51 inn vss 8.64741f
C52 vdd vss 0.2171p
C53 a_4434_4022# vss 9.5824f
C54 a_4138_526# vss 1.09723f
C55 a_3842_4022# vss 0.61211f
C56 a_3546_526# vss 1.0968f
C57 a_n4261_5600# vss 2.8265f
C58 a_n4945_9242# vss 9.33017f
C59 a_n4945_7806# vss 10.3717f
.ends
