* Compact 3D-Shielded 2D Common-Centroid serdes_bg_amp_pdk
.subckt serdes_bg_amp_pdk inp inn out vbn vdd vss
Xt tail vbn vss vss sky130_fd_pr__nfet_01v8 w=8 l=4
Xa da inn tail vss sky130_fd_pr__nfet_01v8 w=24 l=5
Xb o1 inp tail vss sky130_fd_pr__nfet_01v8 w=24 l=5
Xla da da vdd vdd sky130_fd_pr__pfet_01v8_lvt w=48 l=12
Xlb o1 da vdd vdd sky130_fd_pr__pfet_01v8_lvt w=48 l=12
X2 out o1 vss vss sky130_fd_pr__nfet_01v8 w=2 l=2
Xp2 out da vdd vdd sky130_fd_pr__pfet_01v8_lvt w=48 l=4
Xrz o1 cz vss sky130_fd_pr__res_high_po w=1 l=61.90
Xc0 cz out sky130_fd_pr__cap_mim_m3_1 w=22.2 l=22.2
Xc1 cz out sky130_fd_pr__cap_mim_m3_1 w=22.2 l=22.2
Xc2 cz out sky130_fd_pr__cap_mim_m3_1 w=22.2 l=22.2
Xc3 cz out sky130_fd_pr__cap_mim_m3_1 w=22.2 l=22.2
Xc4 cz out sky130_fd_pr__cap_mim_m3_1 w=22.2 l=22.2
Xc5 cz out sky130_fd_pr__cap_mim_m3_1 w=22.2 l=22.2
.ends serdes_bg_amp_pdk
