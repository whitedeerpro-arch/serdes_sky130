* NGSPICE file created from serdes_bg_ota_pdk.ext - technology: sky130A

.subckt serdes_bg_ota_pdk vbn inp inn out vdd vss
X0 out a_n4945_2786# vdd vdd sky130_fd_pr__pfet_01v8_lvt ad=1.74 pd=12.58 as=0.87 ps=6.29 w=6 l=12
X1 a_n4945_2786# a_n4945_2786# vdd vdd sky130_fd_pr__pfet_01v8_lvt ad=1.74 pd=12.58 as=0.87 ps=6.29 w=6 l=12
X2 a_n4945_2786# a_n4945_2786# vdd vdd sky130_fd_pr__pfet_01v8_lvt ad=1.74 pd=12.58 as=0.87 ps=6.29 w=6 l=12
X3 a_n4945_2786# inp a_n4261_980# vss sky130_fd_pr__nfet_01v8 ad=0.87 pd=6.29 as=0.87 ps=6.29 w=6 l=5
X4 vdd a_n4945_2786# out vdd sky130_fd_pr__pfet_01v8_lvt ad=0.87 pd=6.29 as=1.74 ps=12.58 w=6 l=12
X5 out inn a_n4261_980# vss sky130_fd_pr__nfet_01v8 ad=0.87 pd=6.29 as=0.87 ps=6.29 w=6 l=5
X6 vdd a_n4945_2786# a_n4945_2786# vdd sky130_fd_pr__pfet_01v8_lvt ad=0.87 pd=6.29 as=1.74 ps=12.58 w=6 l=12
X7 vdd a_n4945_2786# a_n4945_2786# vdd sky130_fd_pr__pfet_01v8_lvt ad=0.87 pd=6.29 as=1.74 ps=12.58 w=6 l=12
X8 a_n4261_980# inp a_n4945_2786# vss sky130_fd_pr__nfet_01v8 ad=1.74 pd=12.58 as=0.87 ps=6.29 w=6 l=5
X9 vdd a_n4945_2786# a_n4945_2786# vdd sky130_fd_pr__pfet_01v8_lvt ad=0.87 pd=6.29 as=0.87 ps=6.29 w=6 l=12
X10 a_n4945_2786# a_n4945_2786# vdd vdd sky130_fd_pr__pfet_01v8_lvt ad=0.87 pd=6.29 as=0.87 ps=6.29 w=6 l=12
X11 out inn a_n4261_980# vss sky130_fd_pr__nfet_01v8 ad=0.87 pd=6.29 as=0.87 ps=6.29 w=6 l=5
X12 vdd a_n4945_2786# a_n4945_2786# vdd sky130_fd_pr__pfet_01v8_lvt ad=0.87 pd=6.29 as=0.87 ps=6.29 w=6 l=12
X13 vdd a_n4945_2786# out vdd sky130_fd_pr__pfet_01v8_lvt ad=0.87 pd=6.29 as=0.87 ps=6.29 w=6 l=12
X14 a_n4945_2786# a_n4945_2786# vdd vdd sky130_fd_pr__pfet_01v8_lvt ad=0.87 pd=6.29 as=0.87 ps=6.29 w=6 l=12
X15 vdd a_n4945_2786# out vdd sky130_fd_pr__pfet_01v8_lvt ad=0.87 pd=6.29 as=0.87 ps=6.29 w=6 l=12
X16 a_n4261_980# inp a_n4945_2786# vss sky130_fd_pr__nfet_01v8 ad=0.87 pd=6.29 as=0.87 ps=6.29 w=6 l=5
X17 a_n4261_980# inn out vss sky130_fd_pr__nfet_01v8 ad=0.87 pd=6.29 as=0.87 ps=6.29 w=6 l=5
X18 a_n4261_980# vbn vss vss sky130_fd_pr__nfet_01v8 ad=0.29 pd=2.58 as=0.29 ps=2.58 w=1 l=8
X19 out a_n4945_2786# vdd vdd sky130_fd_pr__pfet_01v8_lvt ad=0.87 pd=6.29 as=0.87 ps=6.29 w=6 l=12
X20 out a_n4945_2786# vdd vdd sky130_fd_pr__pfet_01v8_lvt ad=0.87 pd=6.29 as=0.87 ps=6.29 w=6 l=12
X21 a_n4945_2786# inp a_n4261_980# vss sky130_fd_pr__nfet_01v8 ad=0.87 pd=6.29 as=1.74 ps=12.58 w=6 l=5
X22 out a_n4945_2786# vdd vdd sky130_fd_pr__pfet_01v8_lvt ad=1.74 pd=12.58 as=0.87 ps=6.29 w=6 l=12
X23 vdd a_n4945_2786# out vdd sky130_fd_pr__pfet_01v8_lvt ad=0.87 pd=6.29 as=1.74 ps=12.58 w=6 l=12
X24 a_n4261_980# inn out vss sky130_fd_pr__nfet_01v8 ad=0.87 pd=6.29 as=0.87 ps=6.29 w=6 l=5
C0 a_n4945_2786# vdd 77.7957f
C1 a_n4261_980# inn 3.46839f
C2 vbn inn 0.65852f
C3 a_n4945_2786# inn 1.1967f
C4 vbn a_n4261_980# 0.21514f
C5 a_n4261_980# a_n4945_2786# 1.31344f
C6 vbn a_n4945_2786# 0.00496f
C7 out inp 1.04991f
C8 vdd inp 0.64832f
C9 vdd out 4.66584f
C10 inn inp 2.04983f
C11 out inn 2.71483f
C12 vdd inn 0.16607f
C13 a_n4261_980# inp 3.16061f
C14 a_n4261_980# out 0.65783f
C15 a_n4261_980# vdd 0.00688f
C16 vbn inp 0.2026f
C17 vbn out 0
C18 a_n4945_2786# inp 3.47408f
C19 a_n4945_2786# out 16.8562f
C20 vbn vss 4.71384f
C21 inn vss 7.463f
C22 inp vss 7.65468f
C23 out vss 3.75452f
C24 vdd vss 0.17977p
C25 a_n4261_980# vss 1.57757f
C26 a_n4945_2786# vss 5.47153f
.ends
