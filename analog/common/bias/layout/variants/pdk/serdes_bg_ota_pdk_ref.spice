* Compact 2D Common-Centroid serdes_bg_ota_pdk
.subckt serdes_bg_ota_pdk inp inn out vbn vdd vss
Xt tail vbn vss vss sky130_fd_pr__nfet_01v8 w=1 l=8
Xa da inp tail vss sky130_fd_pr__nfet_01v8 w=24 l=5
Xb out inn tail vss sky130_fd_pr__nfet_01v8 w=24 l=5
Xla da da vdd vdd sky130_fd_pr__pfet_01v8_lvt w=48 l=12
Xlb out da vdd vdd sky130_fd_pr__pfet_01v8_lvt w=48 l=12
.ends serdes_bg_ota_pdk
