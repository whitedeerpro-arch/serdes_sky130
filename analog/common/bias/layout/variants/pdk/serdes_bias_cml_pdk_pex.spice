* NGSPICE file created from serdes_bias_cml_pdk.ext - technology: sky130A

.subckt serdes_bias_cml_pdk iin vss
X0 iin vss sky130_fd_pr__cap_mim_m3_1 l=22.2 w=22.2
X1 iin vss sky130_fd_pr__cap_mim_m3_1 l=22.2 w=22.2
X2 iin iin vss vss sky130_fd_pr__nfet_01v8 ad=1.45 pd=10.58 as=1.45 ps=10.58 w=5 l=0.5
X3 iin vss sky130_fd_pr__cap_mim_m3_1 l=22.2 w=22.2
X4 iin vss sky130_fd_pr__cap_mim_m3_1 l=22.2 w=22.2
X5 iin vss sky130_fd_pr__cap_mim_m3_1 l=22.2 w=22.2
C0 iin vss 0.2415p
.ends
