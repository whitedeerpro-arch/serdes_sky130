* NGSPICE file created from serdes_bias_cp_pdk.ext - technology: sky130A

.subckt serdes_bias_cp_pdk vbn vbp vcp vss
X0 vcp vbp vbp vcp sky130_fd_pr__pfet_01v8 ad=1.45 pd=10.58 as=0.725 ps=5.29 w=5 l=1
X1 vbn vbn vss vss sky130_fd_pr__nfet_01v8 ad=0.725 pd=5.58 as=0.725 ps=5.58 w=2.5 l=1
X2 vbp vbp vcp vcp sky130_fd_pr__pfet_01v8 ad=0.725 pd=5.29 as=0.725 ps=5.29 w=5 l=1
X3 vbn vbn vss vss sky130_fd_pr__nfet_01v8 ad=0.725 pd=5.58 as=0.725 ps=5.58 w=2.5 l=1
X4 vcp vbp vbp vcp sky130_fd_pr__pfet_01v8 ad=0.725 pd=5.29 as=0.725 ps=5.29 w=5 l=1
X5 vbp vbn vss vss sky130_fd_pr__nfet_01v8 ad=0.3625 pd=2.79 as=0.725 ps=5.58 w=2.5 l=1
X6 vss vbn vbp vss sky130_fd_pr__nfet_01v8 ad=0.725 pd=5.58 as=0.3625 ps=2.79 w=2.5 l=1
X7 vbp vbp vcp vcp sky130_fd_pr__pfet_01v8 ad=0.725 pd=5.29 as=1.45 ps=10.58 w=5 l=1
C0 vbp vcp 4.81118f
C1 vcp vbn 0.04696f
C2 vbp vbn 0.61553f
C3 vbn vss 5.02565f
C4 vbp vss 1.19698f
C5 vcp vss 6.33086f
.ends
