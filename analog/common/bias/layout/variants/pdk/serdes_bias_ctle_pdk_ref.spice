* Design-side bias_dist.spice serdes_bias_ctle
.subckt serdes_bias_ctle_pdk iin vss
Xd iin iin vss vss sky130_fd_pr__nfet_01v8_lvt w=8 l=0.5
.ends serdes_bias_ctle_pdk
