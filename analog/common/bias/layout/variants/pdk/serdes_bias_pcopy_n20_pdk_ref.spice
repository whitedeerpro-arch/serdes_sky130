* Design-side bias_dist.spice serdes_bias_pcopy n=20
.subckt serdes_bias_pcopy_n20_pdk out vgi vdd
Xp out vgi vdd vdd sky130_fd_pr__pfet_01v8_lvt w=120 l=4
.ends serdes_bias_pcopy_n20_pdk
