* NGSPICE file created from serdes_bias_pcopy_pdk.ext - technology: sky130A

.subckt serdes_bias_pcopy_pdk out vgi vdd
X0 out vgi vdd vdd sky130_fd_pr__pfet_01v8_lvt ad=0.87 pd=6.29 as=0.87 ps=6.29 w=6 l=4
X1 vdd vgi out vdd sky130_fd_pr__pfet_01v8_lvt ad=1.74 pd=12.58 as=0.87 ps=6.29 w=6 l=4
X2 out vgi vdd vdd sky130_fd_pr__pfet_01v8_lvt ad=0.87 pd=6.29 as=1.74 ps=12.58 w=6 l=4
X3 vdd vgi out vdd sky130_fd_pr__pfet_01v8_lvt ad=0.87 pd=6.29 as=0.87 ps=6.29 w=6 l=4
C0 vgi vdd 9.13703f
C1 vdd out 1.37906f
C2 vgi out 2.5638f
C3 out VSUBS 0.03465f
C4 vgi VSUBS 1.6895f
C5 vdd VSUBS 18.8679f
.ends
