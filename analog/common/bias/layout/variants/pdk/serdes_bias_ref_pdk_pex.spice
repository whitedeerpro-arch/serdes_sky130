* NGSPICE file created from serdes_bias_ref_pdk.ext - technology: sky130A

.subckt serdes_bias_ref_pdk g4 g3 g2 g1 g0 i0 i1 i2 i3 vbg vg vgi vdd vss
X0 vg a_10355_8086# vdd vdd sky130_fd_pr__pfet_01v8_lvt ad=0.87 pd=6.29 as=0.87 ps=6.29 w=6 l=4
X1 i2 vgi vdd vdd sky130_fd_pr__pfet_01v8_lvt ad=0.87 pd=6.29 as=0.87 ps=6.29 w=6 l=4
X2 vss a_1011_12232# a_1242_15518# vss sky130_fd_pr__nfet_01v8 ad=0.58 pd=4.58 as=0.58 ps=4.58 w=2 l=1
X3 a_32099_740# g0 vss vss sky130_fd_pr__nfet_01v8 ad=0.825 pd=5.33 as=1.55 ps=10.62 w=5 l=0.15
X4 vdd a_24955_13946# a_24955_13946# vdd sky130_fd_pr__pfet_01v8_lvt ad=0.87 pd=6.29 as=0.87 ps=6.29 w=6 l=12
X5 a_5748_8704# a_6044_1584# vss sky130_fd_pr__res_high_po w=1 l=33.6
X6 a_32099_740# g0 vss vss sky130_fd_pr__nfet_01v8 ad=0.825 pd=5.33 as=0.825 ps=5.33 w=5 l=0.15
X7 a_26312_9906# a_26016_702# vss sky130_fd_pr__res_high_po w=1 l=44.02
X8 a_25639_12140# vbg vgi vss sky130_fd_pr__nfet_01v8 ad=0.87 pd=6.29 as=0.87 ps=6.29 w=6 l=5
X9 vss g0 a_32099_740# vss sky130_fd_pr__nfet_01v8 ad=0.825 pd=5.33 as=0.825 ps=5.33 w=5 l=0.15
X10 vss g0 a_32099_740# vss sky130_fd_pr__nfet_01v8 ad=1.55 pd=10.62 as=0.825 ps=5.33 w=5 l=0.15
X11 a_25424_9906# vgi vdd vdd sky130_fd_pr__pfet_01v8_lvt ad=0.87 pd=6.29 as=0.87 ps=6.29 w=6 l=4
X12 vdd vgi a_25424_9906# vdd sky130_fd_pr__pfet_01v8_lvt ad=0.87 pd=6.29 as=0.87 ps=6.29 w=6 l=4
X13 a_25424_9906# vbg vgi vss sky130_fd_pr__nfet_01v8 ad=0.29 pd=2.58 as=0.29 ps=2.58 w=1 l=4
X14 a_26312_9906# a_26608_702# vss sky130_fd_pr__res_high_po w=1 l=44.02
X15 a_25424_9906# a_25424_702# vss sky130_fd_pr__res_high_po w=1 l=44.02
X16 vgi a_24955_13946# vdd vdd sky130_fd_pr__pfet_01v8_lvt ad=1.74 pd=12.58 as=0.87 ps=6.29 w=6 l=12
X17 vss a_1011_12232# a_11039_5880# vss sky130_fd_pr__nfet_01v8 ad=1.16 pd=8.58 as=0.58 ps=4.29 w=4 l=4
X18 i3 vgi vdd vdd sky130_fd_pr__pfet_01v8_lvt ad=0.87 pd=6.29 as=0.87 ps=6.29 w=6 l=4
X19 a_5156_8704# a_4564_1584# vss sky130_fd_pr__res_high_po w=1 l=33.6
X20 a_30979_740# g1 a_32099_740# vss sky130_fd_pr__nfet_01v8 ad=0.825 pd=5.33 as=1.55 ps=10.62 w=5 l=0.15
X21 i3 vgi vdd vdd sky130_fd_pr__pfet_01v8_lvt ad=0.87 pd=6.29 as=1.74 ps=12.58 w=6 l=4
X22 a_25639_12140# a_13813_19996# vss vss sky130_fd_pr__nfet_01v8 ad=0.29 pd=2.58 as=0.29 ps=2.58 w=1 l=8
X23 a_30979_740# g1 a_32099_740# vss sky130_fd_pr__nfet_01v8 ad=0.825 pd=5.33 as=0.825 ps=5.33 w=5 l=0.15
X24 a_27496_9906# a_28739_740# vss sky130_fd_pr__res_high_po w=1 l=38.18
X25 a_32099_740# g1 a_30979_740# vss sky130_fd_pr__nfet_01v8 ad=0.825 pd=5.33 as=0.825 ps=5.33 w=5 l=0.15
X26 a_28739_740# g3 a_29859_740# vss sky130_fd_pr__nfet_01v8 ad=0.825 pd=5.33 as=1.55 ps=10.62 w=5 l=0.15
X27 vdd a_10355_8086# a_10355_8086# vdd sky130_fd_pr__pfet_01v8_lvt ad=0.87 pd=6.29 as=0.87 ps=6.29 w=6 l=12
X28 vbg vss sky130_fd_pr__cap_mim_m3_1 l=22.2 w=22.2
X29 a_4268_8704# a_3972_1584# vss sky130_fd_pr__res_high_po w=1 l=33.6
X30 a_32099_740# g1 a_30979_740# vss sky130_fd_pr__nfet_01v8 ad=1.55 pd=10.62 as=0.825 ps=5.33 w=5 l=0.15
X31 a_19734_4302# vg sky130_fd_pr__cap_mim_m3_1 l=22.2 w=22.2
X32 i1 vgi vdd vdd sky130_fd_pr__pfet_01v8_lvt ad=0.87 pd=6.29 as=0.87 ps=6.29 w=6 l=4
X33 a_29859_740# g2 a_30979_740# vss sky130_fd_pr__nfet_01v8 ad=0.825 pd=5.33 as=1.55 ps=10.62 w=5 l=0.15
X34 a_29859_740# g2 a_30979_740# vss sky130_fd_pr__nfet_01v8 ad=0.825 pd=5.33 as=0.825 ps=5.33 w=5 l=0.15
X35 a_27496_9906# g4 a_28739_740# vss sky130_fd_pr__nfet_01v8 ad=0.825 pd=5.33 as=1.55 ps=10.62 w=5 l=0.15
X36 vdd a_10355_8086# a_10355_9522# vdd sky130_fd_pr__pfet_01v8_lvt ad=0.87 pd=6.29 as=1.74 ps=12.58 w=6 l=12
X37 a_30979_740# g2 a_29859_740# vss sky130_fd_pr__nfet_01v8 ad=0.825 pd=5.33 as=0.825 ps=5.33 w=5 l=0.15
X38 a_28739_740# a_29859_740# vss sky130_fd_pr__res_high_po w=1 l=18.49
X39 a_30979_740# g2 a_29859_740# vss sky130_fd_pr__nfet_01v8 ad=1.55 pd=10.62 as=0.825 ps=5.33 w=5 l=0.15
X40 i0 vgi vdd vdd sky130_fd_pr__pfet_01v8_lvt ad=0.87 pd=6.29 as=1.74 ps=12.58 w=6 l=4
X41 a_1512_9288# a_2104_1000# vss sky130_fd_pr__res_high_po w=1 l=39.44
X42 a_28739_740# g3 a_29859_740# vss sky130_fd_pr__nfet_01v8 ad=0.825 pd=5.33 as=0.825 ps=5.33 w=5 l=0.15
X43 a_29859_740# a_30979_740# vss sky130_fd_pr__res_high_po w=1 l=8.65
X44 vdd a_10355_8086# a_10355_9522# vdd sky130_fd_pr__pfet_01v8_lvt ad=0.87 pd=6.29 as=0.87 ps=6.29 w=6 l=12
X45 a_29859_740# g3 a_28739_740# vss sky130_fd_pr__nfet_01v8 ad=0.825 pd=5.33 as=0.825 ps=5.33 w=5 l=0.15
X46 a_25639_12140# a_25424_9906# a_24955_13946# vss sky130_fd_pr__nfet_01v8 ad=0.87 pd=6.29 as=0.87 ps=6.29 w=6 l=5
X47 a_920_9288# a_920_1000# vss sky130_fd_pr__res_high_po w=1 l=39.44
X48 a_1216_9288# a_920_1000# vss sky130_fd_pr__res_high_po w=1 l=39.44
X49 a_29859_740# g3 a_28739_740# vss sky130_fd_pr__nfet_01v8 ad=1.55 pd=10.62 as=0.825 ps=5.33 w=5 l=0.15
X50 a_624_9288# vg vdd vdd sky130_fd_pr__pfet_01v8_lvt ad=0.87 pd=6.29 as=1.74 ps=12.58 w=6 l=8
X51 vgi vdd sky130_fd_pr__cap_mim_m3_1 l=22.2 w=22.2
X52 vdd a_10355_8086# a_10355_8086# vdd sky130_fd_pr__pfet_01v8_lvt ad=0.87 pd=6.29 as=1.74 ps=12.58 w=6 l=12
X53 vbg vss sky130_fd_pr__cap_mim_m3_1 l=22.2 w=22.2
X54 a_10355_9522# a_920_9288# a_11039_5880# vss sky130_fd_pr__nfet_01v8 ad=0.87 pd=6.29 as=0.87 ps=6.29 w=6 l=5
X55 vdd vgi i0 vdd sky130_fd_pr__pfet_01v8_lvt ad=1.74 pd=12.58 as=0.87 ps=6.29 w=6 l=4
X56 a_2696_9288# a_1530_17870# vss sky130_fd_pr__res_high_po w=1 l=34.7
X57 a_30979_740# a_32099_740# vss sky130_fd_pr__res_high_po w=1 l=3.73
X58 a_13813_19996# a_13813_19996# vss vss sky130_fd_pr__nfet_01v8 ad=0.29 pd=2.29 as=0.58 ps=4.58 w=2 l=4
X59 vdd vg a_13813_19996# vdd sky130_fd_pr__pfet_01v8_lvt ad=0.87 pd=6.29 as=0.87 ps=6.29 w=6 l=8
X60 a_27496_9906# a_27200_702# vss sky130_fd_pr__res_high_po w=1 l=44.02
X61 vdd vg a_1011_12232# vdd sky130_fd_pr__pfet_01v8_lvt ad=0.87 pd=6.29 as=0.87 ps=6.29 w=6 l=8
X62 vss a_1242_15518# vg vss sky130_fd_pr__nfet_01v8 ad=0.29 pd=2.58 as=0.29 ps=2.58 w=1 l=1
X63 a_24955_13946# a_24955_13946# vdd vdd sky130_fd_pr__pfet_01v8_lvt ad=0.87 pd=6.29 as=0.87 ps=6.29 w=6 l=12
X64 a_11039_5880# a_1011_12232# vss vss sky130_fd_pr__nfet_01v8 ad=0.58 pd=4.29 as=1.16 ps=8.58 w=4 l=4
X65 vdd vss a_1242_15518# vdd sky130_fd_pr__pfet_01v8 ad=0.1218 pd=1.42 as=0.1218 ps=1.42 w=0.42 l=20
X66 vdd vg a_1011_12232# vdd sky130_fd_pr__pfet_01v8_lvt ad=1.74 pd=12.58 as=0.87 ps=6.29 w=6 l=8
X67 a_13813_19996# vg vdd vdd sky130_fd_pr__pfet_01v8_lvt ad=0.87 pd=6.29 as=0.87 ps=6.29 w=6 l=8
X68 vdd vgi i1 vdd sky130_fd_pr__pfet_01v8_lvt ad=0.87 pd=6.29 as=0.87 ps=6.29 w=6 l=4
X69 a_3050_22430# a_6044_1584# vss sky130_fd_pr__res_high_po w=1 l=33.6
X70 a_19734_4302# vg sky130_fd_pr__cap_mim_m3_1 l=22.2 w=22.2
X71 a_32099_740# vss vss sky130_fd_pr__res_high_po w=1 l=1.27
X72 a_624_9288# vg vdd vdd sky130_fd_pr__pfet_01v8_lvt ad=0.87 pd=6.29 as=0.87 ps=6.29 w=6 l=8
X73 a_920_9288# vg vdd vdd sky130_fd_pr__pfet_01v8_lvt ad=0.87 pd=6.29 as=1.74 ps=12.58 w=6 l=8
X74 a_26904_9906# a_26608_702# vss sky130_fd_pr__res_high_po w=1 l=44.02
X75 a_25720_9906# a_25424_702# vss sky130_fd_pr__res_high_po w=1 l=44.02
X76 vdd vgi i3 vdd sky130_fd_pr__pfet_01v8_lvt ad=1.74 pd=12.58 as=0.87 ps=6.29 w=6 l=4
X77 a_5156_8704# a_5452_1584# vss sky130_fd_pr__res_high_po w=1 l=33.6
X78 vg a_10355_8086# vdd vdd sky130_fd_pr__pfet_01v8_lvt ad=0.87 pd=6.29 as=0.87 ps=6.29 w=6 l=4
X79 a_11039_5880# a_624_9288# a_10355_8086# vss sky130_fd_pr__nfet_01v8 ad=1.74 pd=12.58 as=0.87 ps=6.29 w=6 l=5
X80 a_24955_13946# a_25424_9906# a_25639_12140# vss sky130_fd_pr__nfet_01v8 ad=0.87 pd=6.29 as=0.87 ps=6.29 w=6 l=5
X81 vdd vgi i3 vdd sky130_fd_pr__pfet_01v8_lvt ad=0.87 pd=6.29 as=0.87 ps=6.29 w=6 l=4
X82 vgi vdd sky130_fd_pr__cap_mim_m3_1 l=22.2 w=22.2
X83 a_5748_8704# a_5452_1584# vss sky130_fd_pr__res_high_po w=1 l=33.6
X84 vbg vss sky130_fd_pr__cap_mim_m3_1 l=22.2 w=22.2
X85 vbg a_3380_1584# vss sky130_fd_pr__res_high_po w=1 l=33.6
X86 a_4268_8704# a_4564_1584# vss sky130_fd_pr__res_high_po w=1 l=33.6
X87 vss vss a_1530_17870# sky130_fd_pr__pnp_05v5_W3p40L3p40
**devattr s=462400,2720
X88 a_19142_4302# a_18846_806# vss sky130_fd_pr__res_high_po w=1 l=15.48
X89 vdd vg vbg vdd sky130_fd_pr__pfet_01v8_lvt ad=1.74 pd=12.58 as=0.87 ps=6.29 w=6 l=8
X90 vdd vg vbg vdd sky130_fd_pr__pfet_01v8_lvt ad=0.87 pd=6.29 as=0.87 ps=6.29 w=6 l=8
X91 vdd vgi i2 vdd sky130_fd_pr__pfet_01v8_lvt ad=0.87 pd=6.29 as=0.87 ps=6.29 w=6 l=4
X92 a_3676_8704# a_3380_1584# vss sky130_fd_pr__res_high_po w=1 l=33.6
X93 vbg vss sky130_fd_pr__cap_mim_m3_1 l=22.2 w=22.2
X94 vss vss a_1530_17870# sky130_fd_pr__pnp_05v5_W3p40L3p40
**devattr s=462400,2720
X95 a_19142_4302# a_19438_806# vss sky130_fd_pr__res_high_po w=1 l=15.48
X96 a_10355_9522# a_10355_8086# vdd vdd sky130_fd_pr__pfet_01v8_lvt ad=1.74 pd=12.58 as=0.87 ps=6.29 w=6 l=12
X97 a_920_9288# vg vdd vdd sky130_fd_pr__pfet_01v8_lvt ad=0.87 pd=6.29 as=0.87 ps=6.29 w=6 l=8
X98 a_2400_9288# a_2104_1000# vss sky130_fd_pr__res_high_po w=1 l=39.44
X99 vdd a_10355_8086# vg vdd sky130_fd_pr__pfet_01v8_lvt ad=0.87 pd=6.29 as=0.87 ps=6.29 w=6 l=4
X100 vdd vgi i0 vdd sky130_fd_pr__pfet_01v8_lvt ad=0.87 pd=6.29 as=0.87 ps=6.29 w=6 l=4
X101 vgi vbg a_25639_12140# vss sky130_fd_pr__nfet_01v8 ad=0.87 pd=6.29 as=0.87 ps=6.29 w=6 l=5
X102 vss vss a_2400_9288# sky130_fd_pr__pnp_05v5_W3p40L3p40
**devattr s=462400,2720
X103 vgi a_24955_13946# vdd vdd sky130_fd_pr__pfet_01v8_lvt ad=0.87 pd=6.29 as=0.87 ps=6.29 w=6 l=12
X104 vgi a_24955_13946# vdd vdd sky130_fd_pr__pfet_01v8_lvt ad=0.87 pd=6.29 as=0.87 ps=6.29 w=6 l=12
X105 a_10355_8086# a_624_9288# a_11039_5880# vss sky130_fd_pr__nfet_01v8 ad=0.87 pd=6.29 as=1.74 ps=12.58 w=6 l=5
X106 a_1512_9288# a_624_1000# vss sky130_fd_pr__res_high_po w=1 l=39.44
X107 a_10355_8086# a_10355_8086# vdd vdd sky130_fd_pr__pfet_01v8_lvt ad=0.87 pd=6.29 as=0.87 ps=6.29 w=6 l=12
X108 a_19734_4302# vg sky130_fd_pr__cap_mim_m3_1 l=22.2 w=22.2
X109 a_19734_4302# vg sky130_fd_pr__cap_mim_m3_1 l=22.2 w=22.2
X110 a_19734_4302# vg sky130_fd_pr__cap_mim_m3_1 l=22.2 w=22.2
X111 a_1216_9288# a_1808_1000# vss sky130_fd_pr__res_high_po w=1 l=39.44
X112 vdd a_24955_13946# vgi vdd sky130_fd_pr__pfet_01v8_lvt ad=0.87 pd=6.29 as=1.74 ps=12.58 w=6 l=12
X113 vss a_1011_12232# a_1011_12232# vss sky130_fd_pr__nfet_01v8 ad=0.58 pd=4.58 as=0.29 ps=2.29 w=2 l=4
X114 a_11039_5880# a_920_9288# a_10355_9522# vss sky130_fd_pr__nfet_01v8 ad=0.87 pd=6.29 as=0.87 ps=6.29 w=6 l=5
X115 vdd a_24955_13946# a_24955_13946# vdd sky130_fd_pr__pfet_01v8_lvt ad=0.87 pd=6.29 as=0.87 ps=6.29 w=6 l=12
X116 vdd vgi i2 vdd sky130_fd_pr__pfet_01v8_lvt ad=0.87 pd=6.29 as=0.87 ps=6.29 w=6 l=4
X117 vgi vbg a_25639_12140# vss sky130_fd_pr__nfet_01v8 ad=0.87 pd=6.29 as=0.87 ps=6.29 w=6 l=5
X118 vg a_10355_8086# vdd vdd sky130_fd_pr__pfet_01v8_lvt ad=0.87 pd=6.29 as=0.87 ps=6.29 w=6 l=4
X119 a_10355_8086# a_10355_8086# vdd vdd sky130_fd_pr__pfet_01v8_lvt ad=1.74 pd=12.58 as=0.87 ps=6.29 w=6 l=12
X120 a_10355_9522# a_10355_8086# vdd vdd sky130_fd_pr__pfet_01v8_lvt ad=1.74 pd=12.58 as=0.87 ps=6.29 w=6 l=12
X121 a_28739_740# g4 a_27496_9906# vss sky130_fd_pr__nfet_01v8 ad=1.55 pd=10.62 as=0.825 ps=5.33 w=5 l=0.15
X122 vgi a_24955_13946# vdd vdd sky130_fd_pr__pfet_01v8_lvt ad=1.74 pd=12.58 as=0.87 ps=6.29 w=6 l=12
X123 i1 vgi vdd vdd sky130_fd_pr__pfet_01v8_lvt ad=0.87 pd=6.29 as=0.87 ps=6.29 w=6 l=4
X124 vss vss a_3050_22430# sky130_fd_pr__pnp_05v5_W3p40L3p40
**devattr s=462400,2720
X125 a_24955_13946# a_24955_13946# vdd vdd sky130_fd_pr__pfet_01v8_lvt ad=0.87 pd=6.29 as=0.87 ps=6.29 w=6 l=12
X126 a_13813_19996# vg vdd vdd sky130_fd_pr__pfet_01v8_lvt ad=0.87 pd=6.29 as=1.74 ps=12.58 w=6 l=8
X127 a_1011_12232# vg vdd vdd sky130_fd_pr__pfet_01v8_lvt ad=0.87 pd=6.29 as=1.74 ps=12.58 w=6 l=8
X128 a_10355_8086# a_10355_8086# vdd vdd sky130_fd_pr__pfet_01v8_lvt ad=0.87 pd=6.29 as=0.87 ps=6.29 w=6 l=12
X129 a_10355_9522# a_10355_8086# vdd vdd sky130_fd_pr__pfet_01v8_lvt ad=0.87 pd=6.29 as=0.87 ps=6.29 w=6 l=12
X130 a_19734_4302# vg sky130_fd_pr__cap_mim_m3_1 l=22.2 w=22.2
X131 a_3676_8704# a_3972_1584# vss sky130_fd_pr__res_high_po w=1 l=33.6
X132 vdd a_10355_8086# a_10355_8086# vdd sky130_fd_pr__pfet_01v8_lvt ad=0.87 pd=6.29 as=0.87 ps=6.29 w=6 l=12
X133 a_25720_9906# a_26016_702# vss sky130_fd_pr__res_high_po w=1 l=44.02
X134 a_24955_13946# a_25424_9906# a_25639_12140# vss sky130_fd_pr__nfet_01v8 ad=0.87 pd=6.29 as=1.74 ps=12.58 w=6 l=5
X135 a_19734_4302# a_19438_806# vss sky130_fd_pr__res_high_po w=1 l=15.48
X136 vss vss a_1530_17870# sky130_fd_pr__pnp_05v5_W3p40L3p40
**devattr s=462400,2720
X137 vdd vgi i1 vdd sky130_fd_pr__pfet_01v8_lvt ad=0.87 pd=6.29 as=0.87 ps=6.29 w=6 l=4
X138 a_2696_9288# a_1808_1000# vss sky130_fd_pr__res_high_po w=1 l=39.44
X139 a_10355_8086# a_10355_8086# vdd vdd sky130_fd_pr__pfet_01v8_lvt ad=1.74 pd=12.58 as=0.87 ps=6.29 w=6 l=12
X140 vbg vss sky130_fd_pr__cap_mim_m3_1 l=22.2 w=22.2
X141 vdd a_24955_13946# a_24955_13946# vdd sky130_fd_pr__pfet_01v8_lvt ad=0.87 pd=6.29 as=1.74 ps=12.58 w=6 l=12
X142 vss a_10355_9522# vg vss sky130_fd_pr__nfet_01v8 ad=0.58 pd=4.58 as=0.58 ps=4.58 w=2 l=2
X143 vdd a_10355_8086# vg vdd sky130_fd_pr__pfet_01v8_lvt ad=0.87 pd=6.29 as=0.87 ps=6.29 w=6 l=4
X144 a_25639_12140# vbg vgi vss sky130_fd_pr__nfet_01v8 ad=0.87 pd=6.29 as=0.87 ps=6.29 w=6 l=5
X145 vdd a_24955_13946# a_24955_13946# vdd sky130_fd_pr__pfet_01v8_lvt ad=0.87 pd=6.29 as=1.74 ps=12.58 w=6 l=12
X146 a_10355_9522# a_18846_806# vss sky130_fd_pr__res_high_po w=1 l=15.48
X147 vdd vg a_13813_19996# vdd sky130_fd_pr__pfet_01v8_lvt ad=1.74 pd=12.58 as=0.87 ps=6.29 w=6 l=8
X148 i2 vgi vdd vdd sky130_fd_pr__pfet_01v8_lvt ad=0.87 pd=6.29 as=0.87 ps=6.29 w=6 l=4
X149 vdd a_10355_8086# vg vdd sky130_fd_pr__pfet_01v8_lvt ad=0.87 pd=6.29 as=0.87 ps=6.29 w=6 l=4
X150 vss vss a_1530_17870# sky130_fd_pr__pnp_05v5_W3p40L3p40
**devattr s=462400,2720
X151 vss vss a_1530_17870# sky130_fd_pr__pnp_05v5_W3p40L3p40
**devattr s=462400,2720
X152 vdd vg a_624_9288# vdd sky130_fd_pr__pfet_01v8_lvt ad=1.74 pd=12.58 as=0.87 ps=6.29 w=6 l=8
X153 vdd a_10355_8086# a_10355_9522# vdd sky130_fd_pr__pfet_01v8_lvt ad=0.87 pd=6.29 as=1.74 ps=12.58 w=6 l=12
X154 a_10355_9522# a_10355_8086# vdd vdd sky130_fd_pr__pfet_01v8_lvt ad=0.87 pd=6.29 as=0.87 ps=6.29 w=6 l=12
X155 vdd vg a_624_9288# vdd sky130_fd_pr__pfet_01v8_lvt ad=0.87 pd=6.29 as=0.87 ps=6.29 w=6 l=8
X156 vdd a_24955_13946# vgi vdd sky130_fd_pr__pfet_01v8_lvt ad=0.87 pd=6.29 as=0.87 ps=6.29 w=6 l=12
X157 vdd a_24955_13946# vgi vdd sky130_fd_pr__pfet_01v8_lvt ad=0.87 pd=6.29 as=0.87 ps=6.29 w=6 l=12
X158 vss vss a_1530_17870# sky130_fd_pr__pnp_05v5_W3p40L3p40
**devattr s=462400,2720
X159 vss vss a_1530_17870# sky130_fd_pr__pnp_05v5_W3p40L3p40
**devattr s=462400,2720
X160 a_25639_12140# a_25424_9906# a_24955_13946# vss sky130_fd_pr__nfet_01v8 ad=1.74 pd=12.58 as=0.87 ps=6.29 w=6 l=5
X161 vbg vg vdd vdd sky130_fd_pr__pfet_01v8_lvt ad=0.87 pd=6.29 as=1.74 ps=12.58 w=6 l=8
X162 vdd a_10355_8086# vg vdd sky130_fd_pr__pfet_01v8_lvt ad=1.74 pd=12.58 as=0.87 ps=6.29 w=6 l=4
X163 a_1011_12232# vg vdd vdd sky130_fd_pr__pfet_01v8_lvt ad=0.87 pd=6.29 as=0.87 ps=6.29 w=6 l=8
X164 vss a_13813_19996# a_13813_19996# vss sky130_fd_pr__nfet_01v8 ad=0.58 pd=4.58 as=0.29 ps=2.29 w=2 l=4
X165 a_24955_13946# a_24955_13946# vdd vdd sky130_fd_pr__pfet_01v8_lvt ad=1.74 pd=12.58 as=0.87 ps=6.29 w=6 l=12
X166 a_24955_13946# a_24955_13946# vdd vdd sky130_fd_pr__pfet_01v8_lvt ad=1.74 pd=12.58 as=0.87 ps=6.29 w=6 l=12
X167 vss vss a_1530_17870# sky130_fd_pr__pnp_05v5_W3p40L3p40
**devattr s=462400,2720
X168 a_11039_5880# a_920_9288# a_10355_9522# vss sky130_fd_pr__nfet_01v8 ad=0.87 pd=6.29 as=0.87 ps=6.29 w=6 l=5
X169 a_11039_5880# a_624_9288# a_10355_8086# vss sky130_fd_pr__nfet_01v8 ad=0.87 pd=6.29 as=0.87 ps=6.29 w=6 l=5
X170 a_27496_9906# g4 a_28739_740# vss sky130_fd_pr__nfet_01v8 ad=0.825 pd=5.33 as=0.825 ps=5.33 w=5 l=0.15
X171 a_624_9288# a_624_1000# vss sky130_fd_pr__res_high_po w=1 l=39.44
X172 a_28739_740# g4 a_27496_9906# vss sky130_fd_pr__nfet_01v8 ad=0.825 pd=5.33 as=0.825 ps=5.33 w=5 l=0.15
X173 vdd vg a_920_9288# vdd sky130_fd_pr__pfet_01v8_lvt ad=0.87 pd=6.29 as=0.87 ps=6.29 w=6 l=8
X174 vdd a_10355_8086# a_10355_9522# vdd sky130_fd_pr__pfet_01v8_lvt ad=0.87 pd=6.29 as=0.87 ps=6.29 w=6 l=12
X175 vg a_10355_8086# vdd vdd sky130_fd_pr__pfet_01v8_lvt ad=0.87 pd=6.29 as=1.74 ps=12.58 w=6 l=4
X176 vdd vg a_920_9288# vdd sky130_fd_pr__pfet_01v8_lvt ad=1.74 pd=12.58 as=0.87 ps=6.29 w=6 l=8
X177 a_1011_12232# a_1011_12232# vss vss sky130_fd_pr__nfet_01v8 ad=0.29 pd=2.29 as=0.58 ps=4.58 w=2 l=4
X178 a_25424_9906# vgi vdd vdd sky130_fd_pr__pfet_01v8_lvt ad=0.87 pd=6.29 as=0.87 ps=6.29 w=6 l=4
X179 vdd vgi a_25424_9906# vdd sky130_fd_pr__pfet_01v8_lvt ad=0.87 pd=6.29 as=0.87 ps=6.29 w=6 l=4
X180 vbg vg vdd vdd sky130_fd_pr__pfet_01v8_lvt ad=0.87 pd=6.29 as=0.87 ps=6.29 w=6 l=8
X181 i0 vgi vdd vdd sky130_fd_pr__pfet_01v8_lvt ad=0.87 pd=6.29 as=0.87 ps=6.29 w=6 l=4
X182 vdd a_24955_13946# vgi vdd sky130_fd_pr__pfet_01v8_lvt ad=0.87 pd=6.29 as=1.74 ps=12.58 w=6 l=12
X183 vdd a_10355_8086# a_10355_8086# vdd sky130_fd_pr__pfet_01v8_lvt ad=0.87 pd=6.29 as=1.74 ps=12.58 w=6 l=12
X184 a_26904_9906# a_27200_702# vss sky130_fd_pr__res_high_po w=1 l=44.02
X185 a_10355_8086# a_624_9288# a_11039_5880# vss sky130_fd_pr__nfet_01v8 ad=0.87 pd=6.29 as=0.87 ps=6.29 w=6 l=5
X186 a_10355_9522# a_920_9288# a_11039_5880# vss sky130_fd_pr__nfet_01v8 ad=0.87 pd=6.29 as=0.87 ps=6.29 w=6 l=5
C0 a_24955_13946# i0 0
C1 a_1530_17870# a_2400_9288# 0.32237f
C2 a_32099_740# g1 0.47717f
C3 a_4268_8704# a_3050_22430# 0
C4 a_2400_9288# a_1242_15518# 0.10871f
C5 vbg vg 5.81195f
C6 a_1530_17870# a_3972_1584# 0.00226f
C7 i0 i1 2.02514f
C8 a_1530_17870# a_1011_12232# 0.08893f
C9 vbg a_29859_740# 0.10419f
C10 a_10355_9522# a_1011_12232# 0.00147f
C11 a_1242_15518# a_1011_12232# 0.51866f
C12 a_24955_13946# a_25424_9906# 3.4778f
C13 a_1530_17870# a_920_9288# 0.08739f
C14 a_10355_9522# a_920_9288# 2.71483f
C15 i1 a_25424_9906# 0.42748f
C16 vgi a_26312_9906# 0.00157f
C17 g3 a_30979_740# 0
C18 a_25639_12140# vdd 0.01112f
C19 a_2104_1000# a_1808_1000# 0.63493f
C20 g4 a_28739_740# 0.47717f
C21 a_25639_12140# vgi 0.65717f
C22 a_27496_9906# a_28739_740# 2.08714f
C23 a_30979_740# g1 0.43554f
C24 a_28739_740# a_13813_19996# 0.00155f
C25 vdd vg 0.11293p
C26 a_26312_9906# a_26904_9906# 0.15162f
C27 a_24955_13946# i1 0
C28 vbg g2 0.01754f
C29 a_4268_8704# a_920_9288# 0
C30 a_1530_17870# a_2696_9288# 0.00876f
C31 a_5748_8704# a_1530_17870# 0.13724f
C32 a_10355_8086# vg 88.1211f
C33 i3 vbg 0.06278f
C34 a_28739_740# vbg 0.13391f
C35 a_19734_4302# a_624_9288# 0.28378f
C36 a_27496_9906# g4 0.43513f
C37 a_3380_1584# a_3972_1584# 0.15162f
C38 a_10355_9522# a_19438_806# 0.00571f
C39 a_624_1000# a_920_1000# 0.6345f
C40 a_19142_4302# vg 0.32303f
C41 a_1530_17870# a_5156_8704# 0.03015f
C42 a_27496_9906# a_13813_19996# 0.10769f
C43 a_27496_9906# a_25720_9906# 0
C44 vbg a_624_9288# 2.03348f
C45 a_4268_8704# a_2696_9288# 0.12163f
C46 g4 vbg 0.00907f
C47 a_1530_17870# vg 0.09191f
C48 a_25424_702# a_26016_702# 0.15162f
C49 i3 vdd 4.5905f
C50 a_4268_8704# a_3676_8704# 0.15162f
C51 a_10355_9522# vg 28.0427f
C52 a_1242_15518# vg 0.28228f
C53 i3 vgi 3.31076f
C54 a_2400_9288# a_1216_9288# 0.00492f
C55 a_11039_5880# a_1011_12232# 1.14686f
C56 a_27496_9906# vbg 0.12751f
C57 a_6044_1584# a_1011_12232# 0
C58 a_3050_22430# a_1011_12232# 0.08338f
C59 vbg a_13813_19996# 1.3618f
C60 a_25720_9906# vbg 0.00226f
C61 vbg a_19734_4302# 0.07053f
C62 a_11039_5880# a_920_9288# 3.63896f
C63 a_4268_8704# a_5156_8704# 0.01213f
C64 a_920_9288# a_3050_22430# 0.08708f
C65 a_624_9288# vdd 2.8807f
C66 a_920_9288# a_1216_9288# 0.19489f
C67 a_25424_9906# a_26312_9906# 0.02359f
C68 a_2400_9288# a_1011_12232# 0.36445f
C69 a_10355_8086# a_624_9288# 3.30075f
C70 a_25639_12140# a_25424_9906# 3.16061f
C71 a_27496_9906# vgi 0.09703f
C72 a_13813_19996# vdd 1.76469f
C73 a_920_9288# a_2400_9288# 0.10294f
C74 vgi a_13813_19996# 1.84725f
C75 a_19734_4302# vdd 2.12538f
C76 i2 i3 2.26645f
C77 a_25720_9906# vgi 0.00157f
C78 a_2696_9288# a_3050_22430# 0.00136f
C79 a_5748_8704# a_3050_22430# 0.22251f
C80 a_25424_9906# vg 0
C81 a_920_9288# a_1011_12232# 0.41853f
C82 a_19142_4302# a_624_9288# 0.00741f
C83 a_25639_12140# a_24955_13946# 1.31344f
C84 a_10355_8086# a_19734_4302# 3.99926f
C85 a_27496_9906# a_26904_9906# 0.16859f
C86 vbg vdd 5.47264f
C87 a_32099_740# g2 0
C88 vgi vbg 6.61481f
C89 a_1512_9288# a_1216_9288# 0.79766f
C90 a_18846_806# a_19438_806# 0.15162f
C91 a_30979_740# a_29859_740# 2.0915f
C92 a_1530_17870# a_624_9288# 0.08055f
C93 a_3050_22430# a_5156_8704# 0.00104f
C94 a_10355_9522# a_624_9288# 1.00745f
C95 a_2400_9288# a_2696_9288# 0.21034f
C96 a_10355_8086# vbg 0.0011f
C97 a_19142_4302# a_19734_4302# 0.17852f
C98 g3 a_29859_740# 0.47717f
C99 a_11039_5880# vg 8.05734f
C100 a_18846_806# vg 0.34907f
C101 vbg a_26904_9906# 0.00226f
C102 a_3050_22430# vg 0.08376f
C103 a_1512_9288# a_2400_9288# 0.16285f
C104 i3 i0 0.2239f
C105 a_27200_702# a_26608_702# 0.15162f
C106 a_920_9288# a_2696_9288# 0.25227f
C107 a_10355_9522# a_19734_4302# 1.44395f
C108 a_5748_8704# a_920_9288# 0.00263f
C109 vgi vdd 0.15777p
C110 vbg g0 0.01761f
C111 a_4268_8704# a_624_9288# 0
C112 a_30979_740# g2 0.47717f
C113 i3 a_25424_9906# 0.28422f
C114 a_3676_8704# a_920_9288# 0
C115 a_1512_9288# a_920_9288# 0.01492f
C116 i2 vbg 0.06231f
C117 a_10355_8086# vdd 97.8221f
C118 a_1530_17870# vbg 0.09155f
C119 a_10355_9522# vbg 0
C120 vbg a_1242_15518# 0
C121 g3 g2 0.02512f
C122 a_920_9288# a_5156_8704# 0.00265f
C123 vgi a_26904_9906# 0.00157f
C124 a_1011_12232# vg 8.59245f
C125 i3 a_24955_13946# 0
C126 a_624_1000# a_2104_1000# 0.00119f
C127 a_5748_8704# a_2696_9288# 0
C128 g2 g1 0.02512f
C129 g3 a_28739_740# 0.43541f
C130 a_19142_4302# vdd 0
C131 a_920_9288# vg 11.419f
C132 i3 i1 0.22683f
C133 vbg a_32099_740# 0.12637f
C134 a_3676_8704# a_2696_9288# 0.00462f
C135 a_1512_9288# a_2696_9288# 0
C136 a_26608_702# a_26016_702# 0.15162f
C137 a_27496_9906# a_25424_9906# 0.23356f
C138 a_4268_8704# vbg 0
C139 i2 vdd 2.65442f
C140 a_25424_9906# a_13813_19996# 2.08064f
C141 a_10355_8086# a_19142_4302# 0
C142 a_1530_17870# vdd 0.12364f
C143 i2 vgi 3.70944f
C144 a_25720_9906# a_25424_9906# 0.18013f
C145 a_10355_9522# vdd 4.61053f
C146 a_1242_15518# vdd 0.11026f
C147 i0 vbg 0.06231f
C148 a_2696_9288# a_5156_8704# 0.1176f
C149 a_4564_1584# a_5452_1584# 0.15632f
C150 a_5748_8704# a_5156_8704# 0.15162f
C151 a_11039_5880# a_624_9288# 3.06418f
C152 g4 g3 0.02512f
C153 a_27200_702# a_28739_740# 0.00826f
C154 a_624_9288# a_3050_22430# 0.07593f
C155 a_10355_9522# a_10355_8086# 16.0659f
C156 a_624_9288# a_1216_9288# 0
C157 a_25424_9906# vbg 5.12884f
C158 a_24955_13946# a_13813_19996# 0.00496f
C159 a_1530_17870# a_5452_1584# 0.30347f
C160 vbg a_30979_740# 0.13503f
C161 a_4564_1584# a_1530_17870# 0.47436f
C162 a_11039_5880# a_19734_4302# 0.36728f
C163 a_18846_806# a_19734_4302# 0.02056f
C164 a_27200_702# g4 0
C165 a_10355_9522# a_19142_4302# 0.40379f
C166 i0 vdd 4.61543f
C167 vg a_19438_806# 0.33294f
C168 i0 vgi 3.28585f
C169 a_2400_9288# a_624_9288# 0.08998f
C170 a_24955_13946# vbg 3.25201f
C171 g3 vbg 0.01365f
C172 a_27200_702# a_27496_9906# 0
C173 a_1808_1000# a_920_1000# 0.00119f
C174 a_1530_17870# a_1242_15518# 0.01503f
C175 a_624_9288# a_1011_12232# 3.54658f
C176 i1 vbg 0.06231f
C177 a_25424_9906# vdd 8.49784f
C178 vbg a_3050_22430# 0.08594f
C179 vgi a_25424_9906# 5.98045f
C180 vbg g1 0.02042f
C181 a_920_9288# a_624_9288# 5.02865f
C182 vbg a_1216_9288# 0
C183 a_32099_740# g0 0.43803f
C184 a_19734_4302# a_1011_12232# 0.16047f
C185 a_25424_9906# a_26904_9906# 0.02304f
C186 a_24955_13946# vdd 0.11146p
C187 a_24955_13946# vgi 18.2793f
C188 a_1530_17870# a_4268_8704# 0.0044f
C189 vbg a_2400_9288# 0.00427f
C190 a_19734_4302# a_920_9288# 0.26071f
C191 a_11039_5880# vdd 0.31249f
C192 i2 i0 0.22454f
C193 i1 vdd 2.65177f
C194 a_3380_1584# a_4564_1584# 0
C195 i1 vgi 3.72521f
C196 a_3050_22430# vdd 0.2863f
C197 vbg a_1011_12232# 0.33479f
C198 a_2696_9288# a_624_9288# 0
C199 a_5748_8704# a_624_9288# 0
C200 a_11039_5880# a_10355_8086# 1.71657f
C201 i2 a_25424_9906# 0.42748f
C202 vbg a_920_9288# 2.8363f
C203 a_3676_8704# a_624_9288# 0
C204 a_1512_9288# a_624_9288# 0
C205 a_29859_740# g2 0.43541f
C206 a_10355_9522# a_25424_9906# 0
C207 a_3380_1584# a_1530_17870# 0
C208 a_6044_1584# a_5452_1584# 0.15162f
C209 a_2400_9288# vdd 0.09217f
C210 a_4564_1584# a_6044_1584# 0
C211 a_624_9288# a_5156_8704# 0
C212 a_28739_740# a_29859_740# 2.11136f
C213 a_11039_5880# a_19142_4302# 0.0012f
C214 i2 a_24955_13946# 0.00105f
C215 a_1011_12232# vdd 2.31721f
C216 g0 g1 0.02512f
C217 a_27496_9906# a_26312_9906# 0.00214f
C218 a_624_9288# vg 12.6534f
C219 i2 i1 1.25141f
C220 vbg a_2696_9288# 0.11551f
C221 a_25720_9906# a_26312_9906# 0.15162f
C222 a_6044_1584# a_1530_17870# 0.0766f
C223 a_25639_12140# a_13813_19996# 0.21514f
C224 a_10355_9522# a_11039_5880# 0.67037f
C225 a_920_9288# vdd 3.08298f
C226 a_5748_8704# vbg 0
C227 a_19734_4302# a_19438_806# 0.01639f
C228 a_10355_9522# a_18846_806# 0.00571f
C229 a_30979_740# a_32099_740# 2.0903f
C230 a_1530_17870# a_3050_22430# 1.16373f
C231 a_1242_15518# a_3050_22430# 0.00161f
C232 a_10355_8086# a_1011_12232# 0.03296f
C233 i0 a_25424_9906# 0.28422f
C234 g4 a_29859_740# 0
C235 vbg a_3676_8704# 0.15223f
C236 a_1512_9288# vbg 0
C237 a_10355_8086# a_920_9288# 1.34589f
C238 a_13813_19996# vg 3.67521f
C239 a_624_1000# a_1808_1000# 0.15915f
C240 a_4564_1584# a_3972_1584# 0.15632f
C241 a_26312_9906# vbg 0.00226f
C242 a_19734_4302# vg 0.26612p
C243 a_25639_12140# vbg 3.63146f
C244 vbg a_5156_8704# 0
C245 g0 vss 2.37639f
C246 g1 vss 1.84066f
C247 g2 vss 1.84306f
C248 g3 vss 1.69643f
C249 g4 vss 1.4712f
C250 i0 vss 3.68536f
C251 i1 vss 4.53888f
C252 i2 vss 4.71644f
C253 i3 vss 4.80178f
C254 vgi vss 47.5467f
C255 vbg vss 0.25281p
C256 vg vss 50.3414f
C257 vdd vss 0.68112p
C258 a_32099_740# vss 7.39819f
C259 a_30979_740# vss 5.73037f
C260 a_29859_740# vss 6.08194f
C261 a_28739_740# vss 5.08528f
C262 a_27496_9906# vss 5.42332f
C263 a_27200_702# vss 0.74704f
C264 a_26904_9906# vss 0.612f
C265 a_26608_702# vss 0.62141f
C266 a_26312_9906# vss 0.61203f
C267 a_26016_702# vss 0.62146f
C268 a_25720_9906# vss 0.6121f
C269 a_25424_702# vss 0.74363f
C270 a_25639_12140# vss 5.63811f
C271 a_24955_13946# vss 34.9027f
C272 a_19734_4302# vss 9.34298f
C273 a_19438_806# vss 1.09723f
C274 a_19142_4302# vss 0.61211f
C275 a_18846_806# vss 1.0968f
C276 a_11039_5880# vss 2.82262f
C277 a_10355_9522# vss 7.94183f
C278 a_10355_8086# vss 10.3101f
C279 a_6044_1584# vss 0.78931f
C280 a_5748_8704# vss 0.69191f
C281 a_5452_1584# vss 0.66066f
C282 a_5156_8704# vss 0.71479f
C283 a_4564_1584# vss 0.8124f
C284 a_4268_8704# vss 0.71475f
C285 a_3972_1584# vss 0.66058f
C286 a_3676_8704# vss 0.68955f
C287 a_3380_1584# vss 0.81686f
C288 a_2696_9288# vss 1.80418f
C289 a_2104_1000# vss 0.6124f
C290 a_1808_1000# vss 0.99338f
C291 a_1512_9288# vss 0.70034f
C292 a_1216_9288# vss 0.65428f
C293 a_920_1000# vss 0.61251f
C294 a_624_1000# vss 0.97453f
C295 a_1242_15518# vss 3.80332f
C296 a_25424_9906# vss 20.7144f
C297 a_13813_19996# vss 21.2132f
C298 a_920_9288# vss 15.0599f
C299 a_1011_12232# vss 16.4256f
C300 a_624_9288# vss 14.0467f
C301 a_2400_9288# vss 5.20742f
C302 a_1530_17870# vss 11.7611f
C303 a_3050_22430# vss 6.05338f
.ends
