* NGSPICE file created from serdes_bias_cml_v2_pdk.ext - technology: sky130A

.subckt serdes_bias_cml_v2_pdk iin vss
X0 iin iin vss.t3 vss.t2 sky130_fd_pr__nfet_01v8 ad=1.45 pd=10.58 as=1.45 ps=10.58 w=5 l=0.5
X1 iin vss sky130_fd_pr__cap_mim_m3_1 l=24.8 w=24.8
X2 vss.t0 iin sky130_fd_pr__cap_mim_m3_2 l=24.8 w=24.8
X3 iin vss.t0 sky130_fd_pr__cap_mim_m3_1 l=24.8 w=24.8
X4 vss.t0 iin sky130_fd_pr__cap_mim_m3_2 l=24.8 w=24.8
R0 vss.n5 vss.n2 4826.5
R1 vss.n8 vss.n4 4826.5
R2 vss.n10 vss.n9 313.601
R3 vss.n9 vss.n3 313.601
R4 vss.n10 vss.n1 313.601
R5 vss.n3 vss.n1 313.601
R6 vss.n10 vss.n2 195
R7 vss.n4 vss.n3 195
R8 vss.n7 vss.n2 180.906
R9 vss.n6 vss.n4 180.906
R10 vss.n8 vss.n7 167.945
R11 vss.n6 vss.n5 167.945
R12 vss.n9 vss.n8 34.4123
R13 vss.n5 vss.n1 34.4123
R14 vss.t3 vss.n10 14.3502
R15 vss.t2 vss.n6 6.78624
R16 vss.n7 vss.t2 6.78624
R17 vss.n0 vss.t3 5.718
R18 vss vss.n0 3.6105
R19 vss vss.n0 3.4105
R20 vss vss.t0 1.38208
C0 iin vss 0.23604p
.ends
