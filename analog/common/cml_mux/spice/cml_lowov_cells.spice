* Independent low-overdrive logic-tail bias; SF/data/line bias remains external.
* ref_scale lowers the reference current while tails widen by tail_scale.
* MOS mirrors only; the upstream0.85mA reference remains a bench ideal current.
.subckt serdes_tx_logic_bias vbias_sf vbias_logic vdd vss
+ params: ref_scale=2 ref_n_w=20 ref_p_w=60
Xsink pdiode vbias_sf vss vss serdes_nfet w={ref_n_w/ref_scale} l=.5
Xpd pdiode pdiode vdd vdd serdes_pfet w={ref_p_w} l=.5 nf=12
Xpm vbias_logic pdiode vdd vdd serdes_pfet w={ref_p_w} l=.5 nf=12
Xref vbias_logic vbias_logic vss vss serdes_nfet w={ref_n_w} l=.5 nf=4
.ends serdes_tx_logic_bias

* Noninverting 2:1 CML data selector, SKY130 prototype.
* sp>sn selects B; sp<sn selects A. Each data pair is high-CM differential.
* Local LVT source followers shift select CM; each rank rebuilds output CM.
* Rload is an ideal on-chip load; no line termination or pad model.
.subckt serdes_cml_mux2_lowov ap an bp bn sp sn qp qn vbias_sf vbias_logic vdd vss
+ params: wdata=20 wselect=64 wtail=12 rload=400 wsf=40 wsf_sink=4 nftail=4
Rp vdd qp {rload}
Rn vdd qn {rload}
Xap qn ap ta vss serdes_nfet_lvt w={wdata} nf=4
Xan qp an ta vss serdes_nfet_lvt w={wdata} nf=4
Xbp qn bp tb vss serdes_nfet_lvt w={wdata} nf=4
Xbn qp bn tb vss serdes_nfet_lvt w={wdata} nf=4
Xsp vdd sp slp vss serdes_nfet_lvt w={wsf} nf=4
Xsn vdd sn sln vss serdes_nfet_lvt w={wsf} nf=4
Xisp slp vbias_sf vss vss serdes_nfet w={wsf_sink} l=0.5
Xisn sln vbias_sf vss vss serdes_nfet w={wsf_sink} l=0.5
Xsa ta sln tail vss serdes_nfet_lvt w={wselect} nf=4
Xsb tb slp tail vss serdes_nfet_lvt w={wselect} nf=4
Xtail tail vbias_logic vss vss serdes_nfet w={wtail} l=0.5 nf={nftail}
.ends serdes_cml_mux2_lowov

* Static CML latch with resistive loads and clock-steered track/hold branches.
* Data and output use the high-common-mode CML domain; the clock pair is LOWER.
* clk_track > clk_hold: noninverting track; opposite polarity: regenerate/hold.
* Dependencies: common/devices/spice/sky130_primitives.spice.
.subckt serdes_cml_data_latch_lowov dp dn qp qn clk_track clk_hold vbias_logic vdd vss
+ params: wdata=40 whold=40 wclock=96 wtail=12 rload=400 nftail=4
Rp vdd qp {rload}
Rn vdd qn {rload}
Xdp qn dp track vss serdes_nfet_lvt w={wdata} nf=4
Xdn qp dn track vss serdes_nfet_lvt w={wdata} nf=4
Xhp qn qp hold vss serdes_nfet_lvt w={whold} nf=4
Xhn qp qn hold vss serdes_nfet_lvt w={whold} nf=4
Xct track clk_track tail vss serdes_nfet_lvt w={wclock} nf=4
Xch hold clk_hold tail vss serdes_nfet_lvt w={wclock} nf=4
Xtail tail vbias_logic vss vss serdes_nfet w={wtail} l=0.5 nf={nftail}
.ends serdes_cml_data_latch_lowov

* Final-rank retiming: A tracks while B is selected; B tracks while A is selected.
* Selected input is held; clock phase must still allow upstream data setup.
* Separate physical select followers for each latch and mux preserve local clock drive.
* Working TX revision: latch nominal current x2; R=300ohm, Whold=40um.
* Two extra common2GHz clock buffers provide setup time to both latches/MUX.
.subckt serdes_cml_latched_mux2_lowov ap an bp bn sp sn qp qn vbias_sf vbias_logic vdd vss
+ params: wdata=40 wselect=64 wtail=12 rload=400 whold=40 wsf=40 wsf_sink=4 latch_tail_scale=2 latch_load_scale=0.75 nftail=4
Xfpa vdd sp sap vss serdes_nfet_lvt w={wsf} nf=4
Xfna vdd sn san vss serdes_nfet_lvt w={wsf} nf=4
Xspa sap vbias_sf vss vss serdes_nfet w={wsf_sink} l=0.5
Xsna san vbias_sf vss vss serdes_nfet w={wsf_sink} l=0.5
Xfpb vdd sp sbp vss serdes_nfet_lvt w={wsf} nf=4
Xfnb vdd sn sbn vss serdes_nfet_lvt w={wsf} nf=4
Xspb sbp vbias_sf vss vss serdes_nfet w={wsf_sink} l=0.5
Xsnb sbn vbias_sf vss vss serdes_nfet w={wsf_sink} l=0.5
Xla ap an ahp ahn sap san vbias_logic vdd vss serdes_cml_data_latch_lowov
+ wdata={wdata} whold={whold} wclock={wselect} wtail={latch_tail_scale*wtail} nftail={nftail} rload={latch_load_scale*rload}
Xlb bp bn bhp bhn sbn sbp vbias_logic vdd vss serdes_cml_data_latch_lowov
+ wdata={wdata} whold={whold} wclock={wselect} wtail={latch_tail_scale*wtail} nftail={nftail} rload={latch_load_scale*rload}
Xm ahp ahn bhp bhn sp sn qp qn vbias_sf vbias_logic vdd vss serdes_cml_mux2_lowov
+ wdata={wdata} wselect={wselect} wtail={wtail} nftail={nftail} rload={rload} wsf={wsf} wsf_sink={wsf_sink}
.ends serdes_cml_latched_mux2_lowov
