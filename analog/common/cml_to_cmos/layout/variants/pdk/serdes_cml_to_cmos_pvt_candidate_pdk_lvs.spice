* NGSPICE file created from serdes_cml_to_cmos_pvt_candidate_pdk.ext - technology: sky130A

.subckt serdes_cml_to_cmos_pvt_candidate_pdk inp inn outp outn vbias vdd vss
X0 vdd a_8869_848# outp vdd sky130_fd_pr__pfet_01v8 ad=0.33 pd=2.33 as=0.33 ps=2.33 w=2 l=0.15
X1 vdd vdd vdd vdd sky130_fd_pr__pfet_01v8 ad=0.62 pd=4.62 as=48.902 ps=361.51999 w=2 l=0.15
X2 vdd a_4059_848# a_4465_848# vdd sky130_fd_pr__pfet_01v8 ad=0.33 pd=2.33 as=0.33 ps=2.33 w=2 l=0.15
X3 vdd vdd vdd vdd sky130_fd_pr__pfet_01v8 ad=0.62 pd=4.62 as=0 ps=0 w=2 l=0.15
X4 outp a_8869_848# vdd vdd sky130_fd_pr__pfet_01v8 ad=0.33 pd=2.33 as=0.33 ps=2.33 w=2 l=0.15
X5 vss vbias a_938_n480# vss sky130_fd_pr__nfet_01v8 ad=0.29 pd=2.29 as=0.29 ps=2.29 w=2 l=0.5
X6 a_4465_848# a_4059_848# vdd vdd sky130_fd_pr__pfet_01v8 ad=0.33 pd=2.33 as=0.33 ps=2.33 w=2 l=0.15
X7 vdd a_4059_848# a_4465_848# vdd sky130_fd_pr__pfet_01v8 ad=0.33 pd=2.33 as=0.33 ps=2.33 w=2 l=0.15
X8 vdd vdd vdd vdd sky130_fd_pr__pfet_01v8 ad=0.33 pd=2.33 as=0 ps=0 w=2 l=0.15
X9 a_6125_n1148# a_4465_n1248# vdd vdd sky130_fd_pr__pfet_01v8 ad=0.2475 pd=1.83 as=0.465 ps=3.62 w=1.5 l=0.15
X10 a_4465_n1248# a_4059_n1208# vdd vdd sky130_fd_pr__pfet_01v8 ad=0.33 pd=2.33 as=0.33 ps=2.33 w=2 l=0.15
X11 vdd inn a_216_n1248# vss sky130_fd_pr__nfet_01v8_lvt ad=0.33 pd=2.33 as=0.33 ps=2.33 w=2 l=0.15
X12 vdd vdd vdd vdd sky130_fd_pr__pfet_01v8 ad=0.62 pd=4.62 as=0 ps=0 w=2 l=0.15
X13 a_4465_848# a_4059_848# vdd vdd sky130_fd_pr__pfet_01v8 ad=0.33 pd=2.33 as=0.33 ps=2.33 w=2 l=0.15
X14 vdd a_6125_n1148# a_6671_630# vdd sky130_fd_pr__pfet_01v8 ad=0.33 pd=2.33 as=0.33 ps=2.33 w=2 l=0.15
X15 outn a_8869_n1148# vss vss sky130_fd_pr__nfet_01v8 ad=0.33 pd=2.33 as=0.33 ps=2.33 w=2 l=0.15
X16 vdd a_4059_848# a_4465_848# vdd sky130_fd_pr__pfet_01v8 ad=0.33 pd=2.33 as=0.33 ps=2.33 w=2 l=0.15
X17 a_4465_848# a_4059_848# vdd vdd sky130_fd_pr__pfet_01v8 ad=0.33 pd=2.33 as=0.33 ps=2.33 w=2 l=0.15
X18 vss a_4059_848# a_4465_848# vss sky130_fd_pr__nfet_01v8 ad=0.33 pd=2.33 as=0.33 ps=2.33 w=2 l=0.15
X19 a_8869_n1148# a_6671_630# vdd vdd sky130_fd_pr__pfet_01v8 ad=0.2475 pd=1.83 as=0.465 ps=3.62 w=1.5 l=0.15
X20 a_8153_n1248# a_6671_630# vdd vdd sky130_fd_pr__pfet_01v8 ad=0.33 pd=2.33 as=0.62 ps=4.62 w=2 l=0.15
X21 vdd vdd vdd vdd sky130_fd_pr__pfet_01v8 ad=0.33 pd=2.33 as=0 ps=0 w=2 l=0.15
X22 vdd a_4059_n1208# a_4465_n1248# vdd sky130_fd_pr__pfet_01v8 ad=0.33 pd=2.33 as=0.33 ps=2.33 w=2 l=0.15
X23 a_3109_n1248# a_216_848# a_938_n480# vss sky130_fd_pr__nfet_01v8_lvt ad=0.33 pd=2.33 as=0.62 ps=4.62 w=2 l=0.15
X24 a_6793_80# a_6125_848# a_6671_n698# vss sky130_fd_pr__nfet_01v8 ad=0.62 pd=4.62 as=0.33 ps=2.33 w=2 l=0.15
X25 a_6671_630# a_6125_n1148# a_6793_n480# vss sky130_fd_pr__nfet_01v8 ad=0.33 pd=2.33 as=0.62 ps=4.62 w=2 l=0.15
X26 a_3109_848# a_2329_800# vdd vdd sky130_fd_pr__pfet_01v8 ad=0.33 pd=2.33 as=0.33 ps=2.33 w=2 l=0.15
X27 vdd a_4465_n1248# a_6125_n1148# vdd sky130_fd_pr__pfet_01v8 ad=0.465 pd=3.62 as=0.2475 ps=1.83 w=1.5 l=0.15
X28 vdd a_6671_630# a_6671_n698# vdd sky130_fd_pr__pfet_01v8 ad=0.33 pd=2.33 as=0.33 ps=2.33 w=2 l=0.15
X29 a_6671_630# a_6125_n1148# vdd vdd sky130_fd_pr__pfet_01v8 ad=0.62 pd=4.62 as=0.33 ps=2.33 w=2 l=0.15
X30 vdd a_4059_n1208# a_4465_n1248# vdd sky130_fd_pr__pfet_01v8 ad=0.33 pd=2.33 as=0.33 ps=2.33 w=2 l=0.15
X31 a_216_n1248# inn vdd vss sky130_fd_pr__nfet_01v8_lvt ad=0.62 pd=4.62 as=0.33 ps=2.33 w=2 l=0.15
X32 vdd a_2329_800# a_3109_848# vdd sky130_fd_pr__pfet_01v8 ad=0.33 pd=2.33 as=0.33 ps=2.33 w=2 l=0.15
X33 vdd vdd vdd vdd sky130_fd_pr__pfet_01v8 ad=0.33 pd=2.33 as=0 ps=0 w=2 l=0.15
X34 a_3109_848# a_2329_800# vdd vdd sky130_fd_pr__pfet_01v8 ad=0.33 pd=2.33 as=0.33 ps=2.33 w=2 l=0.15
X35 vdd a_2329_800# a_3109_848# vdd sky130_fd_pr__pfet_01v8 ad=0.33 pd=2.33 as=0.33 ps=2.33 w=2 l=0.15
X36 a_6671_n698# a_6671_630# vdd vdd sky130_fd_pr__pfet_01v8 ad=0.33 pd=2.33 as=0.62 ps=4.62 w=2 l=0.15
X37 vdd a_6671_n698# a_8869_848# vdd sky130_fd_pr__pfet_01v8 ad=0.465 pd=3.62 as=0.2475 ps=1.83 w=1.5 l=0.15
X38 vss vss vss vss sky130_fd_pr__nfet_01v8 ad=0.33 pd=2.33 as=23.334 ps=179.84 w=2 l=0.15
X39 a_6671_n698# a_6671_630# vdd vdd sky130_fd_pr__pfet_01v8 ad=0.62 pd=4.62 as=0.33 ps=2.33 w=2 l=0.15
X40 a_8869_848# a_6671_n698# vdd vdd sky130_fd_pr__pfet_01v8 ad=0.2475 pd=1.83 as=0.465 ps=3.62 w=1.5 l=0.15
X41 vdd a_6671_630# a_8869_n1148# vdd sky130_fd_pr__pfet_01v8 ad=0.465 pd=3.62 as=0.2475 ps=1.83 w=1.5 l=0.15
X42 vdd a_3109_848# a_4059_848# vdd sky130_fd_pr__pfet_01v8 ad=0.558 pd=4.22 as=0.297 ps=2.13 w=1.8 l=0.15
X43 a_4465_848# a_4059_848# vss vss sky130_fd_pr__nfet_01v8 ad=0.33 pd=2.33 as=0.33 ps=2.33 w=2 l=0.15
X44 a_6793_80# a_6671_630# vss vss sky130_fd_pr__nfet_01v8 ad=0.33 pd=2.33 as=0.62 ps=4.62 w=2 l=0.15
X45 a_2329_n1274# a_216_n1248# a_938_n480# vss sky130_fd_pr__nfet_01v8_lvt ad=0.33 pd=2.33 as=0.62 ps=4.62 w=2 l=0.15
X46 a_4059_848# a_3109_848# vdd vdd sky130_fd_pr__pfet_01v8 ad=0.297 pd=2.13 as=0.558 ps=4.22 w=1.8 l=0.15
X47 vdd a_5663_380# a_6125_848# vdd sky130_fd_pr__pfet_01v8 ad=0.465 pd=3.62 as=0.2475 ps=1.83 w=1.5 l=0.15
X48 a_5457_380# a_5251_380# vss vss sky130_fd_pr__nfet_01v8 ad=0.145 pd=1.58 as=0.145 ps=1.58 w=0.5 l=0.15
X49 a_8559_848# a_8153_848# vss vss sky130_fd_pr__nfet_01v8 ad=0.29 pd=2.58 as=0.29 ps=2.58 w=1 l=0.15
X50 a_216_n1248# inn vdd vss sky130_fd_pr__nfet_01v8_lvt ad=0.33 pd=2.33 as=0.33 ps=2.33 w=2 l=0.15
X51 a_6125_848# a_5663_380# vdd vdd sky130_fd_pr__pfet_01v8 ad=0.2475 pd=1.83 as=0.465 ps=3.62 w=1.5 l=0.15
X52 a_6671_n698# a_6125_848# a_6793_80# vss sky130_fd_pr__nfet_01v8 ad=0.33 pd=2.33 as=0.62 ps=4.62 w=2 l=0.15
X53 a_6671_630# a_6671_n698# vdd vdd sky130_fd_pr__pfet_01v8 ad=0.33 pd=2.33 as=0.62 ps=4.62 w=2 l=0.15
X54 a_6125_n1148# a_5663_n1148# vdd vdd sky130_fd_pr__pfet_01v8 ad=0.2475 pd=1.83 as=0.465 ps=3.62 w=1.5 l=0.15
X55 a_8869_848# a_6671_n698# a_8917_80# vss sky130_fd_pr__nfet_01v8 ad=0.58 pd=4.58 as=0.58 ps=4.58 w=2 l=0.15
X56 a_8559_n1148# a_8153_n1248# vdd vdd sky130_fd_pr__pfet_01v8 ad=0.2475 pd=1.83 as=0.465 ps=3.62 w=1.5 l=0.15
X57 a_8917_n480# a_8559_n1148# vss vss sky130_fd_pr__nfet_01v8 ad=0.58 pd=4.58 as=0.58 ps=4.58 w=2 l=0.15
X58 a_938_n480# vbias vss vss sky130_fd_pr__nfet_01v8 ad=0.29 pd=2.29 as=0.29 ps=2.29 w=2 l=0.5
X59 a_2329_n1274# a_2329_n1274# vdd vdd sky130_fd_pr__pfet_01v8 ad=0.33 pd=2.33 as=0.33 ps=2.33 w=2 l=0.15
X60 a_938_80# a_216_848# a_2329_800# vss sky130_fd_pr__nfet_01v8_lvt ad=0.33 pd=2.33 as=0.33 ps=2.33 w=2 l=0.15
X61 vdd vdd vdd vdd sky130_fd_pr__pfet_01v8 ad=0.62 pd=4.62 as=0 ps=0 w=2 l=0.15
X62 a_8559_n1148# a_8153_n1248# vss vss sky130_fd_pr__nfet_01v8 ad=0.29 pd=2.58 as=0.29 ps=2.58 w=1 l=0.15
X63 vss vbias a_938_80# vss sky130_fd_pr__nfet_01v8 ad=0.29 pd=2.29 as=0.29 ps=2.29 w=2 l=0.5
X64 a_3109_n1248# a_2329_n1274# vdd vdd sky130_fd_pr__pfet_01v8 ad=0.33 pd=2.33 as=0.33 ps=2.33 w=2 l=0.15
X65 a_8153_n1248# a_6671_630# vss vss sky130_fd_pr__nfet_01v8 ad=0.58 pd=4.58 as=0.58 ps=4.58 w=2 l=0.15
X66 a_5457_n1148# a_5251_n1148# vss vss sky130_fd_pr__nfet_01v8 ad=0.145 pd=1.58 as=0.145 ps=1.58 w=0.5 l=0.15
X67 vss vss vss vss sky130_fd_pr__nfet_01v8 ad=0.62 pd=4.62 as=0 ps=0 w=2 l=0.15
X68 a_6793_n480# a_6671_n698# vss vss sky130_fd_pr__nfet_01v8 ad=0.33 pd=2.33 as=0.62 ps=4.62 w=2 l=0.15
X69 vdd vdd vdd vdd sky130_fd_pr__pfet_01v8 ad=0.33 pd=2.33 as=0 ps=0 w=2 l=0.15
X70 a_5251_n1148# a_4465_n1248# vss vss sky130_fd_pr__nfet_01v8 ad=0.145 pd=1.58 as=0.145 ps=1.58 w=0.5 l=0.15
X71 a_6125_n1148# a_4465_n1248# a_6173_n480# vss sky130_fd_pr__nfet_01v8 ad=0.58 pd=4.58 as=0.58 ps=4.58 w=2 l=0.15
X72 vdd a_4465_848# a_6125_848# vdd sky130_fd_pr__pfet_01v8 ad=0.465 pd=3.62 as=0.2475 ps=1.83 w=1.5 l=0.15
X73 vdd inn a_216_n1248# vss sky130_fd_pr__nfet_01v8_lvt ad=0.33 pd=2.33 as=0.33 ps=2.33 w=2 l=0.15
X74 a_6125_848# a_4465_848# vdd vdd sky130_fd_pr__pfet_01v8 ad=0.2475 pd=1.83 as=0.465 ps=3.62 w=1.5 l=0.15
X75 vdd a_8153_n1248# a_8559_n1148# vdd sky130_fd_pr__pfet_01v8 ad=0.465 pd=3.62 as=0.2475 ps=1.83 w=1.5 l=0.15
X76 vdd a_6671_n698# a_6671_630# vdd sky130_fd_pr__pfet_01v8 ad=0.33 pd=2.33 as=0.33 ps=2.33 w=2 l=0.15
X77 vdd a_5663_n1148# a_6125_n1148# vdd sky130_fd_pr__pfet_01v8 ad=0.465 pd=3.62 as=0.2475 ps=1.83 w=1.5 l=0.15
X78 a_6173_n480# a_5663_n1148# vss vss sky130_fd_pr__nfet_01v8 ad=0.58 pd=4.58 as=0.58 ps=4.58 w=2 l=0.15
X79 vdd a_2329_n1274# a_2329_n1274# vdd sky130_fd_pr__pfet_01v8 ad=0.33 pd=2.33 as=0.33 ps=2.33 w=2 l=0.15
X80 vss vss vss vss sky130_fd_pr__nfet_01v8 ad=0.62 pd=4.62 as=0 ps=0 w=2 l=0.15
X81 outn a_8869_n1148# vdd vdd sky130_fd_pr__pfet_01v8 ad=0.33 pd=2.33 as=0.33 ps=2.33 w=2 l=0.15
X82 vss vss vss vss sky130_fd_pr__nfet_01v8 ad=0.33 pd=2.33 as=0 ps=0 w=2 l=0.15
X83 a_2329_800# a_216_848# a_938_80# vss sky130_fd_pr__nfet_01v8_lvt ad=0.33 pd=2.33 as=0.62 ps=4.62 w=2 l=0.15
X84 a_6173_80# a_5663_380# vss vss sky130_fd_pr__nfet_01v8 ad=0.58 pd=4.58 as=0.58 ps=4.58 w=2 l=0.15
X85 vdd a_2329_n1274# a_3109_n1248# vdd sky130_fd_pr__pfet_01v8 ad=0.33 pd=2.33 as=0.33 ps=2.33 w=2 l=0.15
X86 a_938_80# vbias vss vss sky130_fd_pr__nfet_01v8 ad=0.29 pd=2.29 as=0.58 ps=4.58 w=2 l=0.5
X87 vdd vdd vdd vdd sky130_fd_pr__pfet_01v8 ad=0.62 pd=4.62 as=0 ps=0 w=2 l=0.15
X88 a_3109_n1248# a_216_848# a_938_n480# vss sky130_fd_pr__nfet_01v8_lvt ad=0.62 pd=4.62 as=0.33 ps=2.33 w=2 l=0.15
X89 a_5457_380# a_5251_380# vdd vdd sky130_fd_pr__pfet_01v8 ad=0.435 pd=3.58 as=0.435 ps=3.58 w=1.5 l=0.15
X90 vss vss vss vss sky130_fd_pr__nfet_01v8 ad=0.33 pd=2.33 as=0 ps=0 w=2 l=0.15
X91 vdd a_6671_630# a_8153_n1248# vdd sky130_fd_pr__pfet_01v8 ad=0.33 pd=2.33 as=0.33 ps=2.33 w=2 l=0.15
X92 a_2329_n1274# a_2329_n1274# vdd vdd sky130_fd_pr__pfet_01v8 ad=0.33 pd=2.33 as=0.33 ps=2.33 w=2 l=0.15
X93 outp a_8869_848# vss vss sky130_fd_pr__nfet_01v8 ad=0.33 pd=2.33 as=0.33 ps=2.33 w=2 l=0.15
X94 vss vbias a_938_n480# vss sky130_fd_pr__nfet_01v8 ad=0.58 pd=4.58 as=0.29 ps=2.29 w=2 l=0.5
X95 vdd a_8869_n1148# outn vdd sky130_fd_pr__pfet_01v8 ad=0.33 pd=2.33 as=0.33 ps=2.33 w=2 l=0.15
X96 a_3109_n1248# a_2329_n1274# vdd vdd sky130_fd_pr__pfet_01v8 ad=0.33 pd=2.33 as=0.33 ps=2.33 w=2 l=0.15
X97 a_216_n1248# vbias vss vss sky130_fd_pr__nfet_01v8 ad=0.58 pd=4.58 as=0.58 ps=4.58 w=2 l=0.5
X98 a_5663_n1148# a_5457_n1148# vss vss sky130_fd_pr__nfet_01v8 ad=0.145 pd=1.58 as=0.145 ps=1.58 w=0.5 l=0.15
X99 a_2329_n1274# a_216_n1248# a_938_n480# vss sky130_fd_pr__nfet_01v8_lvt ad=0.62 pd=4.62 as=0.33 ps=2.33 w=2 l=0.15
X100 a_4465_n1248# a_4059_n1208# vdd vdd sky130_fd_pr__pfet_01v8 ad=0.33 pd=2.33 as=0.33 ps=2.33 w=2 l=0.15
X101 a_8153_n1248# a_6671_630# vdd vdd sky130_fd_pr__pfet_01v8 ad=0.62 pd=4.62 as=0.33 ps=2.33 w=2 l=0.15
X102 a_8869_n1148# a_6671_630# a_8917_n480# vss sky130_fd_pr__nfet_01v8 ad=0.58 pd=4.58 as=0.58 ps=4.58 w=2 l=0.15
X103 vss a_6671_630# a_6793_80# vss sky130_fd_pr__nfet_01v8 ad=0.62 pd=4.62 as=0.33 ps=2.33 w=2 l=0.15
X104 a_8917_80# a_8559_848# vss vss sky130_fd_pr__nfet_01v8 ad=0.58 pd=4.58 as=0.58 ps=4.58 w=2 l=0.15
X105 vss vss vss vss sky130_fd_pr__nfet_01v8 ad=0.62 pd=4.62 as=0 ps=0 w=2 l=0.15
X106 a_938_n480# vbias vss vss sky130_fd_pr__nfet_01v8 ad=0.29 pd=2.29 as=0.58 ps=4.58 w=2 l=0.5
X107 vdd a_8559_848# a_8869_848# vdd sky130_fd_pr__pfet_01v8 ad=0.465 pd=3.62 as=0.2475 ps=1.83 w=1.5 l=0.15
X108 a_938_80# a_216_n1248# a_3109_848# vss sky130_fd_pr__nfet_01v8_lvt ad=0.33 pd=2.33 as=0.33 ps=2.33 w=2 l=0.15
X109 vss a_8869_n1148# outn vss sky130_fd_pr__nfet_01v8 ad=0.33 pd=2.33 as=0.33 ps=2.33 w=2 l=0.15
X110 a_8869_848# a_8559_848# vdd vdd sky130_fd_pr__pfet_01v8 ad=0.2475 pd=1.83 as=0.465 ps=3.62 w=1.5 l=0.15
X111 a_2329_800# a_216_848# a_938_80# vss sky130_fd_pr__nfet_01v8_lvt ad=0.62 pd=4.62 as=0.33 ps=2.33 w=2 l=0.15
X112 vdd a_4059_n1208# a_4465_n1248# vdd sky130_fd_pr__pfet_01v8 ad=0.33 pd=2.33 as=0.33 ps=2.33 w=2 l=0.15
X113 a_5663_380# a_5457_380# vss vss sky130_fd_pr__nfet_01v8 ad=0.145 pd=1.58 as=0.145 ps=1.58 w=0.5 l=0.15
X114 vdd inn a_216_n1248# vss sky130_fd_pr__nfet_01v8_lvt ad=0.33 pd=2.33 as=0.62 ps=4.62 w=2 l=0.15
X115 vss a_4059_n1208# a_4465_n1248# vss sky130_fd_pr__nfet_01v8 ad=0.33 pd=2.33 as=0.33 ps=2.33 w=2 l=0.15
X116 a_216_n1248# inn vdd vss sky130_fd_pr__nfet_01v8_lvt ad=0.33 pd=2.33 as=0.33 ps=2.33 w=2 l=0.15
X117 a_6671_630# a_6671_n698# vdd vdd sky130_fd_pr__pfet_01v8 ad=0.62 pd=4.62 as=0.33 ps=2.33 w=2 l=0.15
X118 a_3109_848# a_216_n1248# a_938_80# vss sky130_fd_pr__nfet_01v8_lvt ad=0.33 pd=2.33 as=0.62 ps=4.62 w=2 l=0.15
X119 a_4059_n1208# a_3109_n1248# vdd vdd sky130_fd_pr__pfet_01v8 ad=0.297 pd=2.13 as=0.558 ps=4.22 w=1.8 l=0.15
X120 vss vss vss vss sky130_fd_pr__nfet_01v8 ad=0.33 pd=2.33 as=0 ps=0 w=2 l=0.15
X121 a_6671_630# a_6125_n1148# vdd vdd sky130_fd_pr__pfet_01v8 ad=0.33 pd=2.33 as=0.62 ps=4.62 w=2 l=0.15
X122 a_8869_n1148# a_8559_n1148# vdd vdd sky130_fd_pr__pfet_01v8 ad=0.2475 pd=1.83 as=0.465 ps=3.62 w=1.5 l=0.15
X123 vdd a_8153_848# a_8559_848# vdd sky130_fd_pr__pfet_01v8 ad=0.465 pd=3.62 as=0.2475 ps=1.83 w=1.5 l=0.15
X124 a_5251_380# a_4465_848# vss vss sky130_fd_pr__nfet_01v8 ad=0.145 pd=1.58 as=0.145 ps=1.58 w=0.5 l=0.15
X125 a_8559_848# a_8153_848# vdd vdd sky130_fd_pr__pfet_01v8 ad=0.2475 pd=1.83 as=0.465 ps=3.62 w=1.5 l=0.15
X126 a_216_n1248# inn vdd vss sky130_fd_pr__nfet_01v8_lvt ad=0.33 pd=2.33 as=0.33 ps=2.33 w=2 l=0.15
X127 a_5663_n1148# a_5457_n1148# vdd vdd sky130_fd_pr__pfet_01v8 ad=0.435 pd=3.58 as=0.435 ps=3.58 w=1.5 l=0.15
X128 a_6671_n698# a_6125_848# vdd vdd sky130_fd_pr__pfet_01v8 ad=0.33 pd=2.33 as=0.62 ps=4.62 w=2 l=0.15
X129 a_6671_n698# a_6125_848# vdd vdd sky130_fd_pr__pfet_01v8 ad=0.62 pd=4.62 as=0.33 ps=2.33 w=2 l=0.15
X130 vdd vdd vdd vdd sky130_fd_pr__pfet_01v8 ad=0.62 pd=4.62 as=0 ps=0 w=2 l=0.15
X131 a_2329_800# a_2329_800# vdd vdd sky130_fd_pr__pfet_01v8 ad=0.33 pd=2.33 as=0.33 ps=2.33 w=2 l=0.15
X132 a_8153_848# a_6671_n698# vss vss sky130_fd_pr__nfet_01v8 ad=0.58 pd=4.58 as=0.58 ps=4.58 w=2 l=0.15
X133 vdd inn a_216_n1248# vss sky130_fd_pr__nfet_01v8_lvt ad=0.33 pd=2.33 as=0.33 ps=2.33 w=2 l=0.15
X134 vdd a_6125_848# a_6671_n698# vdd sky130_fd_pr__pfet_01v8 ad=0.33 pd=2.33 as=0.33 ps=2.33 w=2 l=0.15
X135 a_6125_848# a_4465_848# a_6173_80# vss sky130_fd_pr__nfet_01v8 ad=0.58 pd=4.58 as=0.58 ps=4.58 w=2 l=0.15
X136 vdd a_2329_800# a_2329_800# vdd sky130_fd_pr__pfet_01v8 ad=0.33 pd=2.33 as=0.33 ps=2.33 w=2 l=0.15
X137 vdd vdd vdd vdd sky130_fd_pr__pfet_01v8 ad=0.33 pd=2.33 as=0 ps=0 w=2 l=0.15
X138 a_2329_800# a_2329_800# vdd vdd sky130_fd_pr__pfet_01v8 ad=0.33 pd=2.33 as=0.33 ps=2.33 w=2 l=0.15
X139 vdd a_2329_800# a_2329_800# vdd sky130_fd_pr__pfet_01v8 ad=0.33 pd=2.33 as=0.33 ps=2.33 w=2 l=0.15
X140 vdd vdd vdd vdd sky130_fd_pr__pfet_01v8 ad=0.33 pd=2.33 as=0 ps=0 w=2 l=0.15
X141 vdd a_3109_n1248# a_4059_n1208# vdd sky130_fd_pr__pfet_01v8 ad=0.558 pd=4.22 as=0.297 ps=2.13 w=1.8 l=0.15
X142 vss a_6671_n698# a_6793_n480# vss sky130_fd_pr__nfet_01v8 ad=0.62 pd=4.62 as=0.33 ps=2.33 w=2 l=0.15
X143 vss a_8869_848# outp vss sky130_fd_pr__nfet_01v8 ad=0.33 pd=2.33 as=0.33 ps=2.33 w=2 l=0.15
X144 vdd a_2329_n1274# a_2329_n1274# vdd sky130_fd_pr__pfet_01v8 ad=0.33 pd=2.33 as=0.33 ps=2.33 w=2 l=0.15
X145 vdd a_8559_n1148# a_8869_n1148# vdd sky130_fd_pr__pfet_01v8 ad=0.465 pd=3.62 as=0.2475 ps=1.83 w=1.5 l=0.15
X146 outn a_8869_n1148# vdd vdd sky130_fd_pr__pfet_01v8 ad=0.33 pd=2.33 as=0.33 ps=2.33 w=2 l=0.15
X147 a_4059_848# a_3109_848# vss vss sky130_fd_pr__nfet_01v8 ad=0.522 pd=4.18 as=0.522 ps=4.18 w=1.8 l=0.15
X148 vdd a_2329_n1274# a_3109_n1248# vdd sky130_fd_pr__pfet_01v8 ad=0.33 pd=2.33 as=0.33 ps=2.33 w=2 l=0.15
X149 a_4059_n1208# a_3109_n1248# vss vss sky130_fd_pr__nfet_01v8 ad=0.522 pd=4.18 as=0.522 ps=4.18 w=1.8 l=0.15
X150 a_5663_380# a_5457_380# vdd vdd sky130_fd_pr__pfet_01v8 ad=0.435 pd=3.58 as=0.435 ps=3.58 w=1.5 l=0.15
X151 vss vss vss vss sky130_fd_pr__nfet_01v8 ad=0.62 pd=4.62 as=0 ps=0 w=2 l=0.15
X152 vdd inn a_216_n1248# vss sky130_fd_pr__nfet_01v8_lvt ad=0.33 pd=2.33 as=0.33 ps=2.33 w=2 l=0.15
X153 vss vbias a_938_80# vss sky130_fd_pr__nfet_01v8 ad=0.58 pd=4.58 as=0.29 ps=2.29 w=2 l=0.5
X154 a_8153_848# a_6671_n698# vdd vdd sky130_fd_pr__pfet_01v8 ad=0.33 pd=2.33 as=0.62 ps=4.62 w=2 l=0.15
X155 vdd inp a_216_848# vss sky130_fd_pr__nfet_01v8_lvt ad=0.33 pd=2.33 as=0.33 ps=2.33 w=2 l=0.15
X156 vdd vdd vdd vdd sky130_fd_pr__pfet_01v8 ad=0.62 pd=4.62 as=0 ps=0 w=2 l=0.15
X157 a_4465_n1248# a_4059_n1208# vss vss sky130_fd_pr__nfet_01v8 ad=0.33 pd=2.33 as=0.33 ps=2.33 w=2 l=0.15
X158 a_938_n480# a_216_848# a_3109_n1248# vss sky130_fd_pr__nfet_01v8_lvt ad=0.33 pd=2.33 as=0.33 ps=2.33 w=2 l=0.15
X159 a_8153_848# a_6671_n698# vdd vdd sky130_fd_pr__pfet_01v8 ad=0.62 pd=4.62 as=0.33 ps=2.33 w=2 l=0.15
X160 a_6793_n480# a_6125_n1148# a_6671_630# vss sky130_fd_pr__nfet_01v8 ad=0.62 pd=4.62 as=0.33 ps=2.33 w=2 l=0.15
X161 a_216_n1248# inn vdd vss sky130_fd_pr__nfet_01v8_lvt ad=0.33 pd=2.33 as=0.33 ps=2.33 w=2 l=0.15
X162 a_216_848# inp vdd vss sky130_fd_pr__nfet_01v8_lvt ad=0.33 pd=2.33 as=0.33 ps=2.33 w=2 l=0.15
X163 vdd inp a_216_848# vss sky130_fd_pr__nfet_01v8_lvt ad=0.33 pd=2.33 as=0.33 ps=2.33 w=2 l=0.15
X164 a_216_848# inp vdd vss sky130_fd_pr__nfet_01v8_lvt ad=0.33 pd=2.33 as=0.33 ps=2.33 w=2 l=0.15
X165 vdd inp a_216_848# vss sky130_fd_pr__nfet_01v8_lvt ad=0.33 pd=2.33 as=0.62 ps=4.62 w=2 l=0.15
X166 vdd a_6671_n698# a_8153_848# vdd sky130_fd_pr__pfet_01v8 ad=0.33 pd=2.33 as=0.33 ps=2.33 w=2 l=0.15
X167 a_216_848# inp vdd vss sky130_fd_pr__nfet_01v8_lvt ad=0.33 pd=2.33 as=0.33 ps=2.33 w=2 l=0.15
X168 vdd inp a_216_848# vss sky130_fd_pr__nfet_01v8_lvt ad=0.33 pd=2.33 as=0.33 ps=2.33 w=2 l=0.15
X169 vdd vdd vdd vdd sky130_fd_pr__pfet_01v8 ad=0.33 pd=2.33 as=0 ps=0 w=2 l=0.15
X170 a_216_848# inp vdd vss sky130_fd_pr__nfet_01v8_lvt ad=0.33 pd=2.33 as=0.33 ps=2.33 w=2 l=0.15
X171 a_3109_848# a_216_n1248# a_938_80# vss sky130_fd_pr__nfet_01v8_lvt ad=0.62 pd=4.62 as=0.33 ps=2.33 w=2 l=0.15
X172 vdd a_8869_n1148# outn vdd sky130_fd_pr__pfet_01v8 ad=0.33 pd=2.33 as=0.33 ps=2.33 w=2 l=0.15
X173 a_5251_380# a_4465_848# vdd vdd sky130_fd_pr__pfet_01v8 ad=0.435 pd=3.58 as=0.435 ps=3.58 w=1.5 l=0.15
X174 vdd vdd vdd vdd sky130_fd_pr__pfet_01v8 ad=0.62 pd=4.62 as=0 ps=0 w=2 l=0.15
X175 vdd vdd vdd vdd sky130_fd_pr__pfet_01v8 ad=0.33 pd=2.33 as=0 ps=0 w=2 l=0.15
X176 a_5251_n1148# a_4465_n1248# vdd vdd sky130_fd_pr__pfet_01v8 ad=0.435 pd=3.58 as=0.435 ps=3.58 w=1.5 l=0.15
X177 a_4465_n1248# a_4059_n1208# vdd vdd sky130_fd_pr__pfet_01v8 ad=0.33 pd=2.33 as=0.33 ps=2.33 w=2 l=0.15
X178 a_216_848# vbias vss vss sky130_fd_pr__nfet_01v8 ad=0.58 pd=4.58 as=0.58 ps=4.58 w=2 l=0.5
X179 a_5457_n1148# a_5251_n1148# vdd vdd sky130_fd_pr__pfet_01v8 ad=0.435 pd=3.58 as=0.435 ps=3.58 w=1.5 l=0.15
X180 a_938_n480# a_216_n1248# a_2329_n1274# vss sky130_fd_pr__nfet_01v8_lvt ad=0.33 pd=2.33 as=0.33 ps=2.33 w=2 l=0.15
X181 a_216_848# inp vdd vss sky130_fd_pr__nfet_01v8_lvt ad=0.62 pd=4.62 as=0.33 ps=2.33 w=2 l=0.15
X182 vdd inp a_216_848# vss sky130_fd_pr__nfet_01v8_lvt ad=0.33 pd=2.33 as=0.33 ps=2.33 w=2 l=0.15
X183 vdd a_8869_848# outp vdd sky130_fd_pr__pfet_01v8 ad=0.33 pd=2.33 as=0.33 ps=2.33 w=2 l=0.15
X184 a_938_80# vbias vss vss sky130_fd_pr__nfet_01v8 ad=0.29 pd=2.29 as=0.29 ps=2.29 w=2 l=0.5
X185 outp a_8869_848# vdd vdd sky130_fd_pr__pfet_01v8 ad=0.33 pd=2.33 as=0.33 ps=2.33 w=2 l=0.15
.ends
