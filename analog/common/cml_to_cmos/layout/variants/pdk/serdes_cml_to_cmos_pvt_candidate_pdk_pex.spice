* NGSPICE file created from serdes_cml_to_cmos_pvt_candidate_pdk.ext - technology: sky130A

.subckt serdes_cml_to_cmos_pvt_candidate_pdk inp inn outp outn vbias vdd vss
X0 vdd a_8869_848# outp vdd sky130_fd_pr__pfet_01v8 ad=0.33 pd=2.33 as=0.33 ps=2.33 w=2 l=0.15
X1 vdd vdd vdd vdd sky130_fd_pr__pfet_01v8 ad=0.62 pd=4.62 as=48.902 ps=361.51999 w=2 l=0.15
X2 vdd a_4059_848# a_4465_848# vdd sky130_fd_pr__pfet_01v8 ad=0.33 pd=2.33 as=0.33 ps=2.33 w=2 l=0.15
X3 vdd vdd vdd vdd sky130_fd_pr__pfet_01v8 ad=0.62 pd=4.62 as=0 ps=0 w=2 l=0.15
X4 outp a_8869_848# vdd vdd sky130_fd_pr__pfet_01v8 ad=0.33 pd=2.33 as=0.33 ps=2.33 w=2 l=0.15
X5 vss vbias a_938_n480# vss sky130_fd_pr__nfet_01v8 ad=0.29 pd=2.29 as=0.29 ps=2.29 w=2 l=0.5
X6 a_4465_848# a_4059_848# vdd vdd sky130_fd_pr__pfet_01v8 ad=0.33 pd=2.33 as=0.33 ps=2.33 w=2 l=0.15
X7 vdd a_4059_848# a_4465_848# vdd sky130_fd_pr__pfet_01v8 ad=0.33 pd=2.33 as=0.33 ps=2.33 w=2 l=0.15
X8 vdd vdd vdd vdd sky130_fd_pr__pfet_01v8 ad=0.33 pd=2.33 as=0 ps=0 w=2 l=0.15
X9 a_6125_n1148# a_4465_n1248# vdd vdd sky130_fd_pr__pfet_01v8 ad=0.2475 pd=1.83 as=0.465 ps=3.62 w=1.5 l=0.15
X10 a_4465_n1248# a_4059_n1208# vdd vdd sky130_fd_pr__pfet_01v8 ad=0.33 pd=2.33 as=0.33 ps=2.33 w=2 l=0.15
X11 vdd inn a_216_n1248# vss sky130_fd_pr__nfet_01v8_lvt ad=0.33 pd=2.33 as=0.33 ps=2.33 w=2 l=0.15
X12 vdd vdd vdd vdd sky130_fd_pr__pfet_01v8 ad=0.62 pd=4.62 as=0 ps=0 w=2 l=0.15
X13 a_4465_848# a_4059_848# vdd vdd sky130_fd_pr__pfet_01v8 ad=0.33 pd=2.33 as=0.33 ps=2.33 w=2 l=0.15
X14 vdd a_6125_n1148# a_6671_630# vdd sky130_fd_pr__pfet_01v8 ad=0.33 pd=2.33 as=0.33 ps=2.33 w=2 l=0.15
X15 outn a_8869_n1148# vss vss sky130_fd_pr__nfet_01v8 ad=0.33 pd=2.33 as=0.33 ps=2.33 w=2 l=0.15
X16 vdd a_4059_848# a_4465_848# vdd sky130_fd_pr__pfet_01v8 ad=0.33 pd=2.33 as=0.33 ps=2.33 w=2 l=0.15
X17 a_4465_848# a_4059_848# vdd vdd sky130_fd_pr__pfet_01v8 ad=0.33 pd=2.33 as=0.33 ps=2.33 w=2 l=0.15
X18 vss a_4059_848# a_4465_848# vss sky130_fd_pr__nfet_01v8 ad=0.33 pd=2.33 as=0.33 ps=2.33 w=2 l=0.15
X19 a_8869_n1148# a_6671_630# vdd vdd sky130_fd_pr__pfet_01v8 ad=0.2475 pd=1.83 as=0.465 ps=3.62 w=1.5 l=0.15
X20 a_8153_n1248# a_6671_630# vdd vdd sky130_fd_pr__pfet_01v8 ad=0.33 pd=2.33 as=0.62 ps=4.62 w=2 l=0.15
X21 vdd vdd vdd vdd sky130_fd_pr__pfet_01v8 ad=0.33 pd=2.33 as=0 ps=0 w=2 l=0.15
X22 vdd a_4059_n1208# a_4465_n1248# vdd sky130_fd_pr__pfet_01v8 ad=0.33 pd=2.33 as=0.33 ps=2.33 w=2 l=0.15
X23 a_3109_n1248# a_216_848# a_938_n480# vss sky130_fd_pr__nfet_01v8_lvt ad=0.33 pd=2.33 as=0.62 ps=4.62 w=2 l=0.15
X24 a_6793_80# a_6125_848# a_6671_n698# vss sky130_fd_pr__nfet_01v8 ad=0.62 pd=4.62 as=0.33 ps=2.33 w=2 l=0.15
X25 a_6671_630# a_6125_n1148# a_6793_n480# vss sky130_fd_pr__nfet_01v8 ad=0.33 pd=2.33 as=0.62 ps=4.62 w=2 l=0.15
X26 a_3109_848# a_2329_800# vdd vdd sky130_fd_pr__pfet_01v8 ad=0.33 pd=2.33 as=0.33 ps=2.33 w=2 l=0.15
X27 vdd a_4465_n1248# a_6125_n1148# vdd sky130_fd_pr__pfet_01v8 ad=0.465 pd=3.62 as=0.2475 ps=1.83 w=1.5 l=0.15
X28 vdd a_6671_630# a_6671_n698# vdd sky130_fd_pr__pfet_01v8 ad=0.33 pd=2.33 as=0.33 ps=2.33 w=2 l=0.15
X29 a_6671_630# a_6125_n1148# vdd vdd sky130_fd_pr__pfet_01v8 ad=0.62 pd=4.62 as=0.33 ps=2.33 w=2 l=0.15
X30 vdd a_4059_n1208# a_4465_n1248# vdd sky130_fd_pr__pfet_01v8 ad=0.33 pd=2.33 as=0.33 ps=2.33 w=2 l=0.15
X31 a_216_n1248# inn vdd vss sky130_fd_pr__nfet_01v8_lvt ad=0.62 pd=4.62 as=0.33 ps=2.33 w=2 l=0.15
X32 vdd a_2329_800# a_3109_848# vdd sky130_fd_pr__pfet_01v8 ad=0.33 pd=2.33 as=0.33 ps=2.33 w=2 l=0.15
X33 vdd vdd vdd vdd sky130_fd_pr__pfet_01v8 ad=0.33 pd=2.33 as=0 ps=0 w=2 l=0.15
X34 a_3109_848# a_2329_800# vdd vdd sky130_fd_pr__pfet_01v8 ad=0.33 pd=2.33 as=0.33 ps=2.33 w=2 l=0.15
X35 vdd a_2329_800# a_3109_848# vdd sky130_fd_pr__pfet_01v8 ad=0.33 pd=2.33 as=0.33 ps=2.33 w=2 l=0.15
X36 a_6671_n698# a_6671_630# vdd vdd sky130_fd_pr__pfet_01v8 ad=0.33 pd=2.33 as=0.62 ps=4.62 w=2 l=0.15
X37 vdd a_6671_n698# a_8869_848# vdd sky130_fd_pr__pfet_01v8 ad=0.465 pd=3.62 as=0.2475 ps=1.83 w=1.5 l=0.15
X38 vss vss vss vss sky130_fd_pr__nfet_01v8 ad=0.33 pd=2.33 as=23.334 ps=179.84 w=2 l=0.15
X39 a_6671_n698# a_6671_630# vdd vdd sky130_fd_pr__pfet_01v8 ad=0.62 pd=4.62 as=0.33 ps=2.33 w=2 l=0.15
X40 a_8869_848# a_6671_n698# vdd vdd sky130_fd_pr__pfet_01v8 ad=0.2475 pd=1.83 as=0.465 ps=3.62 w=1.5 l=0.15
X41 vdd a_6671_630# a_8869_n1148# vdd sky130_fd_pr__pfet_01v8 ad=0.465 pd=3.62 as=0.2475 ps=1.83 w=1.5 l=0.15
X42 vdd a_3109_848# a_4059_848# vdd sky130_fd_pr__pfet_01v8 ad=0.558 pd=4.22 as=0.297 ps=2.13 w=1.8 l=0.15
X43 a_4465_848# a_4059_848# vss vss sky130_fd_pr__nfet_01v8 ad=0.33 pd=2.33 as=0.33 ps=2.33 w=2 l=0.15
X44 a_6793_80# a_6671_630# vss vss sky130_fd_pr__nfet_01v8 ad=0.33 pd=2.33 as=0.62 ps=4.62 w=2 l=0.15
X45 a_2329_n1274# a_216_n1248# a_938_n480# vss sky130_fd_pr__nfet_01v8_lvt ad=0.33 pd=2.33 as=0.62 ps=4.62 w=2 l=0.15
X46 a_4059_848# a_3109_848# vdd vdd sky130_fd_pr__pfet_01v8 ad=0.297 pd=2.13 as=0.558 ps=4.22 w=1.8 l=0.15
X47 vdd a_5663_380# a_6125_848# vdd sky130_fd_pr__pfet_01v8 ad=0.465 pd=3.62 as=0.2475 ps=1.83 w=1.5 l=0.15
X48 a_5457_380# a_5251_380# vss vss sky130_fd_pr__nfet_01v8 ad=0.145 pd=1.58 as=0.145 ps=1.58 w=0.5 l=0.15
X49 a_8559_848# a_8153_848# vss vss sky130_fd_pr__nfet_01v8 ad=0.29 pd=2.58 as=0.29 ps=2.58 w=1 l=0.15
X50 a_216_n1248# inn vdd vss sky130_fd_pr__nfet_01v8_lvt ad=0.33 pd=2.33 as=0.33 ps=2.33 w=2 l=0.15
X51 a_6125_848# a_5663_380# vdd vdd sky130_fd_pr__pfet_01v8 ad=0.2475 pd=1.83 as=0.465 ps=3.62 w=1.5 l=0.15
X52 a_6671_n698# a_6125_848# a_6793_80# vss sky130_fd_pr__nfet_01v8 ad=0.33 pd=2.33 as=0.62 ps=4.62 w=2 l=0.15
X53 a_6671_630# a_6671_n698# vdd vdd sky130_fd_pr__pfet_01v8 ad=0.33 pd=2.33 as=0.62 ps=4.62 w=2 l=0.15
X54 a_6125_n1148# a_5663_n1148# vdd vdd sky130_fd_pr__pfet_01v8 ad=0.2475 pd=1.83 as=0.465 ps=3.62 w=1.5 l=0.15
X55 a_8869_848# a_6671_n698# a_8917_80# vss sky130_fd_pr__nfet_01v8 ad=0.58 pd=4.58 as=0.58 ps=4.58 w=2 l=0.15
X56 a_8559_n1148# a_8153_n1248# vdd vdd sky130_fd_pr__pfet_01v8 ad=0.2475 pd=1.83 as=0.465 ps=3.62 w=1.5 l=0.15
X57 a_8917_n480# a_8559_n1148# vss vss sky130_fd_pr__nfet_01v8 ad=0.58 pd=4.58 as=0.58 ps=4.58 w=2 l=0.15
X58 a_938_n480# vbias vss vss sky130_fd_pr__nfet_01v8 ad=0.29 pd=2.29 as=0.29 ps=2.29 w=2 l=0.5
X59 a_2329_n1274# a_2329_n1274# vdd vdd sky130_fd_pr__pfet_01v8 ad=0.33 pd=2.33 as=0.33 ps=2.33 w=2 l=0.15
X60 a_938_80# a_216_848# a_2329_800# vss sky130_fd_pr__nfet_01v8_lvt ad=0.33 pd=2.33 as=0.33 ps=2.33 w=2 l=0.15
X61 vdd vdd vdd vdd sky130_fd_pr__pfet_01v8 ad=0.62 pd=4.62 as=0 ps=0 w=2 l=0.15
X62 a_8559_n1148# a_8153_n1248# vss vss sky130_fd_pr__nfet_01v8 ad=0.29 pd=2.58 as=0.29 ps=2.58 w=1 l=0.15
X63 vss vbias a_938_80# vss sky130_fd_pr__nfet_01v8 ad=0.29 pd=2.29 as=0.29 ps=2.29 w=2 l=0.5
X64 a_3109_n1248# a_2329_n1274# vdd vdd sky130_fd_pr__pfet_01v8 ad=0.33 pd=2.33 as=0.33 ps=2.33 w=2 l=0.15
X65 a_8153_n1248# a_6671_630# vss vss sky130_fd_pr__nfet_01v8 ad=0.58 pd=4.58 as=0.58 ps=4.58 w=2 l=0.15
X66 a_5457_n1148# a_5251_n1148# vss vss sky130_fd_pr__nfet_01v8 ad=0.145 pd=1.58 as=0.145 ps=1.58 w=0.5 l=0.15
X67 vss vss vss vss sky130_fd_pr__nfet_01v8 ad=0.62 pd=4.62 as=0 ps=0 w=2 l=0.15
X68 a_6793_n480# a_6671_n698# vss vss sky130_fd_pr__nfet_01v8 ad=0.33 pd=2.33 as=0.62 ps=4.62 w=2 l=0.15
X69 vdd vdd vdd vdd sky130_fd_pr__pfet_01v8 ad=0.33 pd=2.33 as=0 ps=0 w=2 l=0.15
X70 a_5251_n1148# a_4465_n1248# vss vss sky130_fd_pr__nfet_01v8 ad=0.145 pd=1.58 as=0.145 ps=1.58 w=0.5 l=0.15
X71 a_6125_n1148# a_4465_n1248# a_6173_n480# vss sky130_fd_pr__nfet_01v8 ad=0.58 pd=4.58 as=0.58 ps=4.58 w=2 l=0.15
X72 vdd a_4465_848# a_6125_848# vdd sky130_fd_pr__pfet_01v8 ad=0.465 pd=3.62 as=0.2475 ps=1.83 w=1.5 l=0.15
X73 vdd inn a_216_n1248# vss sky130_fd_pr__nfet_01v8_lvt ad=0.33 pd=2.33 as=0.33 ps=2.33 w=2 l=0.15
X74 a_6125_848# a_4465_848# vdd vdd sky130_fd_pr__pfet_01v8 ad=0.2475 pd=1.83 as=0.465 ps=3.62 w=1.5 l=0.15
X75 vdd a_8153_n1248# a_8559_n1148# vdd sky130_fd_pr__pfet_01v8 ad=0.465 pd=3.62 as=0.2475 ps=1.83 w=1.5 l=0.15
X76 vdd a_6671_n698# a_6671_630# vdd sky130_fd_pr__pfet_01v8 ad=0.33 pd=2.33 as=0.33 ps=2.33 w=2 l=0.15
X77 vdd a_5663_n1148# a_6125_n1148# vdd sky130_fd_pr__pfet_01v8 ad=0.465 pd=3.62 as=0.2475 ps=1.83 w=1.5 l=0.15
X78 a_6173_n480# a_5663_n1148# vss vss sky130_fd_pr__nfet_01v8 ad=0.58 pd=4.58 as=0.58 ps=4.58 w=2 l=0.15
X79 vdd a_2329_n1274# a_2329_n1274# vdd sky130_fd_pr__pfet_01v8 ad=0.33 pd=2.33 as=0.33 ps=2.33 w=2 l=0.15
X80 vss vss vss vss sky130_fd_pr__nfet_01v8 ad=0.62 pd=4.62 as=0 ps=0 w=2 l=0.15
X81 outn a_8869_n1148# vdd vdd sky130_fd_pr__pfet_01v8 ad=0.33 pd=2.33 as=0.33 ps=2.33 w=2 l=0.15
X82 vss vss vss vss sky130_fd_pr__nfet_01v8 ad=0.33 pd=2.33 as=0 ps=0 w=2 l=0.15
X83 a_2329_800# a_216_848# a_938_80# vss sky130_fd_pr__nfet_01v8_lvt ad=0.33 pd=2.33 as=0.62 ps=4.62 w=2 l=0.15
X84 a_6173_80# a_5663_380# vss vss sky130_fd_pr__nfet_01v8 ad=0.58 pd=4.58 as=0.58 ps=4.58 w=2 l=0.15
X85 vdd a_2329_n1274# a_3109_n1248# vdd sky130_fd_pr__pfet_01v8 ad=0.33 pd=2.33 as=0.33 ps=2.33 w=2 l=0.15
X86 a_938_80# vbias vss vss sky130_fd_pr__nfet_01v8 ad=0.29 pd=2.29 as=0.58 ps=4.58 w=2 l=0.5
X87 vdd vdd vdd vdd sky130_fd_pr__pfet_01v8 ad=0.62 pd=4.62 as=0 ps=0 w=2 l=0.15
X88 a_3109_n1248# a_216_848# a_938_n480# vss sky130_fd_pr__nfet_01v8_lvt ad=0.62 pd=4.62 as=0.33 ps=2.33 w=2 l=0.15
X89 a_5457_380# a_5251_380# vdd vdd sky130_fd_pr__pfet_01v8 ad=0.435 pd=3.58 as=0.435 ps=3.58 w=1.5 l=0.15
X90 vss vss vss vss sky130_fd_pr__nfet_01v8 ad=0.33 pd=2.33 as=0 ps=0 w=2 l=0.15
X91 vdd a_6671_630# a_8153_n1248# vdd sky130_fd_pr__pfet_01v8 ad=0.33 pd=2.33 as=0.33 ps=2.33 w=2 l=0.15
X92 a_2329_n1274# a_2329_n1274# vdd vdd sky130_fd_pr__pfet_01v8 ad=0.33 pd=2.33 as=0.33 ps=2.33 w=2 l=0.15
X93 outp a_8869_848# vss vss sky130_fd_pr__nfet_01v8 ad=0.33 pd=2.33 as=0.33 ps=2.33 w=2 l=0.15
X94 vss vbias a_938_n480# vss sky130_fd_pr__nfet_01v8 ad=0.58 pd=4.58 as=0.29 ps=2.29 w=2 l=0.5
X95 vdd a_8869_n1148# outn vdd sky130_fd_pr__pfet_01v8 ad=0.33 pd=2.33 as=0.33 ps=2.33 w=2 l=0.15
X96 a_3109_n1248# a_2329_n1274# vdd vdd sky130_fd_pr__pfet_01v8 ad=0.33 pd=2.33 as=0.33 ps=2.33 w=2 l=0.15
X97 a_216_n1248# vbias vss vss sky130_fd_pr__nfet_01v8 ad=0.58 pd=4.58 as=0.58 ps=4.58 w=2 l=0.5
X98 a_5663_n1148# a_5457_n1148# vss vss sky130_fd_pr__nfet_01v8 ad=0.145 pd=1.58 as=0.145 ps=1.58 w=0.5 l=0.15
X99 a_2329_n1274# a_216_n1248# a_938_n480# vss sky130_fd_pr__nfet_01v8_lvt ad=0.62 pd=4.62 as=0.33 ps=2.33 w=2 l=0.15
X100 a_4465_n1248# a_4059_n1208# vdd vdd sky130_fd_pr__pfet_01v8 ad=0.33 pd=2.33 as=0.33 ps=2.33 w=2 l=0.15
X101 a_8153_n1248# a_6671_630# vdd vdd sky130_fd_pr__pfet_01v8 ad=0.62 pd=4.62 as=0.33 ps=2.33 w=2 l=0.15
X102 a_8869_n1148# a_6671_630# a_8917_n480# vss sky130_fd_pr__nfet_01v8 ad=0.58 pd=4.58 as=0.58 ps=4.58 w=2 l=0.15
X103 vss a_6671_630# a_6793_80# vss sky130_fd_pr__nfet_01v8 ad=0.62 pd=4.62 as=0.33 ps=2.33 w=2 l=0.15
X104 a_8917_80# a_8559_848# vss vss sky130_fd_pr__nfet_01v8 ad=0.58 pd=4.58 as=0.58 ps=4.58 w=2 l=0.15
X105 vss vss vss vss sky130_fd_pr__nfet_01v8 ad=0.62 pd=4.62 as=0 ps=0 w=2 l=0.15
X106 a_938_n480# vbias vss vss sky130_fd_pr__nfet_01v8 ad=0.29 pd=2.29 as=0.58 ps=4.58 w=2 l=0.5
X107 vdd a_8559_848# a_8869_848# vdd sky130_fd_pr__pfet_01v8 ad=0.465 pd=3.62 as=0.2475 ps=1.83 w=1.5 l=0.15
X108 a_938_80# a_216_n1248# a_3109_848# vss sky130_fd_pr__nfet_01v8_lvt ad=0.33 pd=2.33 as=0.33 ps=2.33 w=2 l=0.15
X109 vss a_8869_n1148# outn vss sky130_fd_pr__nfet_01v8 ad=0.33 pd=2.33 as=0.33 ps=2.33 w=2 l=0.15
X110 a_8869_848# a_8559_848# vdd vdd sky130_fd_pr__pfet_01v8 ad=0.2475 pd=1.83 as=0.465 ps=3.62 w=1.5 l=0.15
X111 a_2329_800# a_216_848# a_938_80# vss sky130_fd_pr__nfet_01v8_lvt ad=0.62 pd=4.62 as=0.33 ps=2.33 w=2 l=0.15
X112 vdd a_4059_n1208# a_4465_n1248# vdd sky130_fd_pr__pfet_01v8 ad=0.33 pd=2.33 as=0.33 ps=2.33 w=2 l=0.15
X113 a_5663_380# a_5457_380# vss vss sky130_fd_pr__nfet_01v8 ad=0.145 pd=1.58 as=0.145 ps=1.58 w=0.5 l=0.15
X114 vdd inn a_216_n1248# vss sky130_fd_pr__nfet_01v8_lvt ad=0.33 pd=2.33 as=0.62 ps=4.62 w=2 l=0.15
X115 vss a_4059_n1208# a_4465_n1248# vss sky130_fd_pr__nfet_01v8 ad=0.33 pd=2.33 as=0.33 ps=2.33 w=2 l=0.15
X116 a_216_n1248# inn vdd vss sky130_fd_pr__nfet_01v8_lvt ad=0.33 pd=2.33 as=0.33 ps=2.33 w=2 l=0.15
X117 a_6671_630# a_6671_n698# vdd vdd sky130_fd_pr__pfet_01v8 ad=0.62 pd=4.62 as=0.33 ps=2.33 w=2 l=0.15
X118 a_3109_848# a_216_n1248# a_938_80# vss sky130_fd_pr__nfet_01v8_lvt ad=0.33 pd=2.33 as=0.62 ps=4.62 w=2 l=0.15
X119 a_4059_n1208# a_3109_n1248# vdd vdd sky130_fd_pr__pfet_01v8 ad=0.297 pd=2.13 as=0.558 ps=4.22 w=1.8 l=0.15
X120 vss vss vss vss sky130_fd_pr__nfet_01v8 ad=0.33 pd=2.33 as=0 ps=0 w=2 l=0.15
X121 a_6671_630# a_6125_n1148# vdd vdd sky130_fd_pr__pfet_01v8 ad=0.33 pd=2.33 as=0.62 ps=4.62 w=2 l=0.15
X122 a_8869_n1148# a_8559_n1148# vdd vdd sky130_fd_pr__pfet_01v8 ad=0.2475 pd=1.83 as=0.465 ps=3.62 w=1.5 l=0.15
X123 vdd a_8153_848# a_8559_848# vdd sky130_fd_pr__pfet_01v8 ad=0.465 pd=3.62 as=0.2475 ps=1.83 w=1.5 l=0.15
X124 a_5251_380# a_4465_848# vss vss sky130_fd_pr__nfet_01v8 ad=0.145 pd=1.58 as=0.145 ps=1.58 w=0.5 l=0.15
X125 a_8559_848# a_8153_848# vdd vdd sky130_fd_pr__pfet_01v8 ad=0.2475 pd=1.83 as=0.465 ps=3.62 w=1.5 l=0.15
X126 a_216_n1248# inn vdd vss sky130_fd_pr__nfet_01v8_lvt ad=0.33 pd=2.33 as=0.33 ps=2.33 w=2 l=0.15
X127 a_5663_n1148# a_5457_n1148# vdd vdd sky130_fd_pr__pfet_01v8 ad=0.435 pd=3.58 as=0.435 ps=3.58 w=1.5 l=0.15
X128 a_6671_n698# a_6125_848# vdd vdd sky130_fd_pr__pfet_01v8 ad=0.33 pd=2.33 as=0.62 ps=4.62 w=2 l=0.15
X129 a_6671_n698# a_6125_848# vdd vdd sky130_fd_pr__pfet_01v8 ad=0.62 pd=4.62 as=0.33 ps=2.33 w=2 l=0.15
X130 vdd vdd vdd vdd sky130_fd_pr__pfet_01v8 ad=0.62 pd=4.62 as=0 ps=0 w=2 l=0.15
X131 a_2329_800# a_2329_800# vdd vdd sky130_fd_pr__pfet_01v8 ad=0.33 pd=2.33 as=0.33 ps=2.33 w=2 l=0.15
X132 a_8153_848# a_6671_n698# vss vss sky130_fd_pr__nfet_01v8 ad=0.58 pd=4.58 as=0.58 ps=4.58 w=2 l=0.15
X133 vdd inn a_216_n1248# vss sky130_fd_pr__nfet_01v8_lvt ad=0.33 pd=2.33 as=0.33 ps=2.33 w=2 l=0.15
X134 vdd a_6125_848# a_6671_n698# vdd sky130_fd_pr__pfet_01v8 ad=0.33 pd=2.33 as=0.33 ps=2.33 w=2 l=0.15
X135 a_6125_848# a_4465_848# a_6173_80# vss sky130_fd_pr__nfet_01v8 ad=0.58 pd=4.58 as=0.58 ps=4.58 w=2 l=0.15
X136 vdd a_2329_800# a_2329_800# vdd sky130_fd_pr__pfet_01v8 ad=0.33 pd=2.33 as=0.33 ps=2.33 w=2 l=0.15
X137 vdd vdd vdd vdd sky130_fd_pr__pfet_01v8 ad=0.33 pd=2.33 as=0 ps=0 w=2 l=0.15
X138 a_2329_800# a_2329_800# vdd vdd sky130_fd_pr__pfet_01v8 ad=0.33 pd=2.33 as=0.33 ps=2.33 w=2 l=0.15
X139 vdd a_2329_800# a_2329_800# vdd sky130_fd_pr__pfet_01v8 ad=0.33 pd=2.33 as=0.33 ps=2.33 w=2 l=0.15
X140 vdd vdd vdd vdd sky130_fd_pr__pfet_01v8 ad=0.33 pd=2.33 as=0 ps=0 w=2 l=0.15
X141 vdd a_3109_n1248# a_4059_n1208# vdd sky130_fd_pr__pfet_01v8 ad=0.558 pd=4.22 as=0.297 ps=2.13 w=1.8 l=0.15
X142 vss a_6671_n698# a_6793_n480# vss sky130_fd_pr__nfet_01v8 ad=0.62 pd=4.62 as=0.33 ps=2.33 w=2 l=0.15
X143 vss a_8869_848# outp vss sky130_fd_pr__nfet_01v8 ad=0.33 pd=2.33 as=0.33 ps=2.33 w=2 l=0.15
X144 vdd a_2329_n1274# a_2329_n1274# vdd sky130_fd_pr__pfet_01v8 ad=0.33 pd=2.33 as=0.33 ps=2.33 w=2 l=0.15
X145 vdd a_8559_n1148# a_8869_n1148# vdd sky130_fd_pr__pfet_01v8 ad=0.465 pd=3.62 as=0.2475 ps=1.83 w=1.5 l=0.15
X146 outn a_8869_n1148# vdd vdd sky130_fd_pr__pfet_01v8 ad=0.33 pd=2.33 as=0.33 ps=2.33 w=2 l=0.15
X147 a_4059_848# a_3109_848# vss vss sky130_fd_pr__nfet_01v8 ad=0.522 pd=4.18 as=0.522 ps=4.18 w=1.8 l=0.15
X148 vdd a_2329_n1274# a_3109_n1248# vdd sky130_fd_pr__pfet_01v8 ad=0.33 pd=2.33 as=0.33 ps=2.33 w=2 l=0.15
X149 a_4059_n1208# a_3109_n1248# vss vss sky130_fd_pr__nfet_01v8 ad=0.522 pd=4.18 as=0.522 ps=4.18 w=1.8 l=0.15
X150 a_5663_380# a_5457_380# vdd vdd sky130_fd_pr__pfet_01v8 ad=0.435 pd=3.58 as=0.435 ps=3.58 w=1.5 l=0.15
X151 vss vss vss vss sky130_fd_pr__nfet_01v8 ad=0.62 pd=4.62 as=0 ps=0 w=2 l=0.15
X152 vdd inn a_216_n1248# vss sky130_fd_pr__nfet_01v8_lvt ad=0.33 pd=2.33 as=0.33 ps=2.33 w=2 l=0.15
X153 vss vbias a_938_80# vss sky130_fd_pr__nfet_01v8 ad=0.58 pd=4.58 as=0.29 ps=2.29 w=2 l=0.5
X154 a_8153_848# a_6671_n698# vdd vdd sky130_fd_pr__pfet_01v8 ad=0.33 pd=2.33 as=0.62 ps=4.62 w=2 l=0.15
X155 vdd inp a_216_848# vss sky130_fd_pr__nfet_01v8_lvt ad=0.33 pd=2.33 as=0.33 ps=2.33 w=2 l=0.15
X156 vdd vdd vdd vdd sky130_fd_pr__pfet_01v8 ad=0.62 pd=4.62 as=0 ps=0 w=2 l=0.15
X157 a_4465_n1248# a_4059_n1208# vss vss sky130_fd_pr__nfet_01v8 ad=0.33 pd=2.33 as=0.33 ps=2.33 w=2 l=0.15
X158 a_938_n480# a_216_848# a_3109_n1248# vss sky130_fd_pr__nfet_01v8_lvt ad=0.33 pd=2.33 as=0.33 ps=2.33 w=2 l=0.15
X159 a_8153_848# a_6671_n698# vdd vdd sky130_fd_pr__pfet_01v8 ad=0.62 pd=4.62 as=0.33 ps=2.33 w=2 l=0.15
X160 a_6793_n480# a_6125_n1148# a_6671_630# vss sky130_fd_pr__nfet_01v8 ad=0.62 pd=4.62 as=0.33 ps=2.33 w=2 l=0.15
X161 a_216_n1248# inn vdd vss sky130_fd_pr__nfet_01v8_lvt ad=0.33 pd=2.33 as=0.33 ps=2.33 w=2 l=0.15
X162 a_216_848# inp vdd vss sky130_fd_pr__nfet_01v8_lvt ad=0.33 pd=2.33 as=0.33 ps=2.33 w=2 l=0.15
X163 vdd inp a_216_848# vss sky130_fd_pr__nfet_01v8_lvt ad=0.33 pd=2.33 as=0.33 ps=2.33 w=2 l=0.15
X164 a_216_848# inp vdd vss sky130_fd_pr__nfet_01v8_lvt ad=0.33 pd=2.33 as=0.33 ps=2.33 w=2 l=0.15
X165 vdd inp a_216_848# vss sky130_fd_pr__nfet_01v8_lvt ad=0.33 pd=2.33 as=0.62 ps=4.62 w=2 l=0.15
X166 vdd a_6671_n698# a_8153_848# vdd sky130_fd_pr__pfet_01v8 ad=0.33 pd=2.33 as=0.33 ps=2.33 w=2 l=0.15
X167 a_216_848# inp vdd vss sky130_fd_pr__nfet_01v8_lvt ad=0.33 pd=2.33 as=0.33 ps=2.33 w=2 l=0.15
X168 vdd inp a_216_848# vss sky130_fd_pr__nfet_01v8_lvt ad=0.33 pd=2.33 as=0.33 ps=2.33 w=2 l=0.15
X169 vdd vdd vdd vdd sky130_fd_pr__pfet_01v8 ad=0.33 pd=2.33 as=0 ps=0 w=2 l=0.15
X170 a_216_848# inp vdd vss sky130_fd_pr__nfet_01v8_lvt ad=0.33 pd=2.33 as=0.33 ps=2.33 w=2 l=0.15
X171 a_3109_848# a_216_n1248# a_938_80# vss sky130_fd_pr__nfet_01v8_lvt ad=0.62 pd=4.62 as=0.33 ps=2.33 w=2 l=0.15
X172 vdd a_8869_n1148# outn vdd sky130_fd_pr__pfet_01v8 ad=0.33 pd=2.33 as=0.33 ps=2.33 w=2 l=0.15
X173 a_5251_380# a_4465_848# vdd vdd sky130_fd_pr__pfet_01v8 ad=0.435 pd=3.58 as=0.435 ps=3.58 w=1.5 l=0.15
X174 vdd vdd vdd vdd sky130_fd_pr__pfet_01v8 ad=0.62 pd=4.62 as=0 ps=0 w=2 l=0.15
X175 vdd vdd vdd vdd sky130_fd_pr__pfet_01v8 ad=0.33 pd=2.33 as=0 ps=0 w=2 l=0.15
X176 a_5251_n1148# a_4465_n1248# vdd vdd sky130_fd_pr__pfet_01v8 ad=0.435 pd=3.58 as=0.435 ps=3.58 w=1.5 l=0.15
X177 a_4465_n1248# a_4059_n1208# vdd vdd sky130_fd_pr__pfet_01v8 ad=0.33 pd=2.33 as=0.33 ps=2.33 w=2 l=0.15
X178 a_216_848# vbias vss vss sky130_fd_pr__nfet_01v8 ad=0.58 pd=4.58 as=0.58 ps=4.58 w=2 l=0.5
X179 a_5457_n1148# a_5251_n1148# vdd vdd sky130_fd_pr__pfet_01v8 ad=0.435 pd=3.58 as=0.435 ps=3.58 w=1.5 l=0.15
X180 a_938_n480# a_216_n1248# a_2329_n1274# vss sky130_fd_pr__nfet_01v8_lvt ad=0.33 pd=2.33 as=0.33 ps=2.33 w=2 l=0.15
X181 a_216_848# inp vdd vss sky130_fd_pr__nfet_01v8_lvt ad=0.62 pd=4.62 as=0.33 ps=2.33 w=2 l=0.15
X182 vdd inp a_216_848# vss sky130_fd_pr__nfet_01v8_lvt ad=0.33 pd=2.33 as=0.33 ps=2.33 w=2 l=0.15
X183 vdd a_8869_848# outp vdd sky130_fd_pr__pfet_01v8 ad=0.33 pd=2.33 as=0.33 ps=2.33 w=2 l=0.15
X184 a_938_80# vbias vss vss sky130_fd_pr__nfet_01v8 ad=0.29 pd=2.29 as=0.29 ps=2.29 w=2 l=0.5
X185 outp a_8869_848# vdd vdd sky130_fd_pr__pfet_01v8 ad=0.33 pd=2.33 as=0.33 ps=2.33 w=2 l=0.15
C0 a_6173_n480# a_5663_n1148# 0.01934f
C1 a_8153_n1248# vdd 0.67745f
C2 vdd a_8869_848# 0.96996f
C3 a_3109_n1248# a_4059_n1208# 0.1434f
C4 a_6173_n480# a_5663_380# 0
C5 a_2329_n1274# a_4059_n1208# 0
C6 a_6173_80# a_4465_848# 0.03084f
C7 a_2329_800# a_938_n480# 0
C8 a_8153_n1248# a_8559_n1148# 0.13843f
C9 a_8559_n1148# a_8869_848# 0
C10 a_2329_800# a_216_848# 0.1409f
C11 vdd a_5457_380# 0.31947f
C12 a_4465_n1248# a_6793_n480# 0
C13 outp a_6671_n698# 0.00186f
C14 a_5457_n1148# a_6671_630# 0
C15 a_8917_n480# a_6671_n698# 0.00262f
C16 a_6125_n1148# a_6125_848# 0.00556f
C17 a_4465_n1248# a_938_n480# 0
C18 vdd a_8559_n1148# 0.50022f
C19 a_216_n1248# a_938_n480# 0.22792f
C20 a_6125_848# a_4465_848# 0.18419f
C21 a_2329_800# vbias 0.00168f
C22 vdd a_5251_n1148# 0.31945f
C23 a_5663_380# a_5663_n1148# 0.00262f
C24 a_216_n1248# a_216_848# 0.68953f
C25 outp a_8559_848# 0
C26 a_6793_80# a_6125_n1148# 0
C27 a_8917_n480# a_8559_848# 0
C28 a_6793_80# a_4465_848# 0
C29 a_4465_n1248# a_6173_80# 0
C30 a_6671_n698# a_6125_n1148# 0.16441f
C31 a_8153_848# a_6671_630# 0.00215f
C32 a_5457_n1148# a_5457_380# 0
C33 a_6671_n698# a_4465_848# 0.00108f
C34 a_6671_n698# a_8869_n1148# 0.00164f
C35 a_216_n1248# vbias 0.41557f
C36 a_6173_n480# a_6125_n1148# 0.07294f
C37 inp a_216_848# 0.38062f
C38 vdd a_5457_n1148# 0.31947f
C39 a_6173_n480# a_4465_848# 0
C40 a_3109_n1248# a_3109_848# 0.00467f
C41 a_8153_n1248# a_8153_848# 0.00103f
C42 a_3109_848# a_2329_n1274# 0
C43 a_5251_n1148# a_5457_n1148# 0.09474f
C44 a_8153_848# a_8869_848# 0.0019f
C45 a_4465_n1248# a_6125_848# 0
C46 a_8559_848# a_8869_n1148# 0
C47 a_5251_380# a_6125_848# 0
C48 a_4465_848# a_938_80# 0
C49 a_3109_848# a_938_80# 0.28923f
C50 a_6793_n480# a_6671_630# 0.21119f
C51 inp vbias 0.12628f
C52 a_3109_n1248# a_2329_800# 0
C53 a_2329_n1274# a_2329_800# 0.00312f
C54 a_6125_n1148# a_5663_n1148# 0.06718f
C55 vdd a_8153_848# 0.67724f
C56 a_6125_n1148# a_4059_n1208# 0
C57 a_4465_848# a_5663_n1148# 0
C58 a_216_n1248# inn 0.38062f
C59 a_6125_n1148# a_5663_380# 0
C60 a_4465_n1248# a_6671_n698# 0.01827f
C61 a_4465_848# a_4059_n1208# 0
C62 a_8559_n1148# a_8153_848# 0
C63 a_2329_800# a_938_80# 0.33259f
C64 a_3109_848# a_4059_n1208# 0
C65 a_8153_n1248# a_6793_n480# 0
C66 a_5663_380# a_4465_848# 0.10734f
C67 a_4465_n1248# a_6173_n480# 0.03084f
C68 a_4465_n1248# a_3109_n1248# 0.00456f
C69 a_6173_80# a_6671_630# 0.00216f
C70 a_216_n1248# a_3109_n1248# 0.00348f
C71 a_216_n1248# a_2329_n1274# 0.14858f
C72 vdd a_6793_n480# 0.00337f
C73 inn inp 0.00332f
C74 a_216_n1248# a_938_80# 0.13958f
C75 outp a_8869_n1148# 0
C76 a_8559_n1148# a_6793_n480# 0
C77 a_8917_n480# a_8869_n1148# 0.07219f
C78 vdd a_938_n480# 0.00863f
C79 vdd a_216_848# 1.32192f
C80 a_4465_n1248# a_5663_n1148# 0.10734f
C81 a_6125_848# a_6671_630# 0.17354f
C82 a_4465_n1248# a_4059_n1208# 0.33857f
C83 a_4465_n1248# a_5663_380# 0
C84 a_6125_848# a_4059_848# 0
C85 inp a_938_80# 0
C86 a_6793_80# a_6671_630# 0.09073f
C87 vdd a_6173_80# 0.01223f
C88 a_8917_80# a_6671_630# 0
C89 a_6125_n1148# a_4465_848# 0
C90 vdd vbias 0.02192f
C91 a_6125_n1148# a_8869_n1148# 0
C92 a_6125_848# a_8869_848# 0
C93 a_6671_n698# a_6671_630# 0.99205f
C94 a_3109_848# a_4465_848# 0.00456f
C95 a_6125_848# a_5457_380# 0.00103f
C96 a_6173_n480# a_6671_630# 0.00216f
C97 a_8917_80# a_8869_848# 0.07219f
C98 vdd a_6125_848# 0.91912f
C99 outp outn 0.00581f
C100 a_8153_n1248# a_6671_n698# 0.00824f
C101 a_8559_848# a_6671_630# 0.0012f
C102 a_6671_n698# a_8869_848# 0.17372f
C103 a_3109_n1248# a_4059_848# 0
C104 a_3109_848# a_2329_800# 0.22442f
C105 a_6793_80# vdd 0.00337f
C106 a_6671_n698# a_5457_380# 0
C107 a_4059_848# a_938_80# 0
C108 vdd a_8917_80# 0.0143f
C109 vdd inn 0.28295f
C110 a_4465_n1248# a_6125_n1148# 0.18419f
C111 a_8153_n1248# a_8559_848# 0
C112 a_8559_n1148# a_8917_80# 0
C113 a_5663_n1148# a_6671_630# 0.00124f
C114 a_8559_848# a_8869_848# 0.07746f
C115 vdd a_6671_n698# 2.16934f
C116 a_4465_n1248# a_4465_848# 0.00348f
C117 a_5251_380# a_4465_848# 0.13368f
C118 a_5663_380# a_6671_630# 0.00127f
C119 a_8559_n1148# a_6671_n698# 0.00431f
C120 a_5251_380# a_3109_848# 0
C121 a_216_n1248# a_3109_848# 0.10349f
C122 vdd a_6173_n480# 0.01223f
C123 a_4059_848# a_4059_n1208# 0.006f
C124 a_8869_n1148# outn 0.25021f
C125 vdd a_3109_n1248# 1.03483f
C126 vdd a_2329_n1274# 1.62762f
C127 vdd a_8559_848# 0.50023f
C128 a_5251_n1148# a_3109_n1248# 0
C129 vdd a_938_80# 0.00863f
C130 a_8559_n1148# a_8559_848# 0.00278f
C131 a_216_n1248# a_2329_800# 0.2971f
C132 a_8917_n480# a_6671_630# 0.041f
C133 a_5663_380# a_5457_380# 0.07828f
C134 vdd a_5663_n1148# 0.49606f
C135 vdd a_4059_n1208# 0.91988f
C136 a_938_n480# a_216_848# 0.13495f
C137 a_6125_848# a_8153_848# 0
C138 vdd a_5663_380# 0.49606f
C139 a_3109_n1248# a_5457_n1148# 0
C140 outp a_8869_848# 0.25021f
C141 a_8153_n1248# a_8917_n480# 0
C142 a_2329_800# inp 0
C143 a_6793_80# a_8153_848# 0
C144 a_6125_n1148# a_6671_630# 0.34672f
C145 a_8917_80# a_8153_848# 0
C146 a_938_n480# vbias 0.28783f
C147 a_4465_848# a_6671_630# 0.01991f
C148 a_8869_n1148# a_6671_630# 0.17273f
C149 a_216_848# vbias 0.4996f
C150 a_6671_n698# a_8153_848# 0.23863f
C151 outp vdd 0.67652f
C152 vdd a_8917_n480# 0.0143f
C153 a_4059_848# a_4465_848# 0.33857f
C154 a_6793_n480# a_6125_848# 0
C155 a_3109_848# a_4059_848# 0.1434f
C156 a_216_n1248# inp 0
C157 a_5663_n1148# a_5457_n1148# 0.07828f
C158 a_8917_n480# a_8559_n1148# 0.01934f
C159 a_8153_n1248# a_6125_n1148# 0
C160 a_8153_n1248# a_8869_n1148# 0.0019f
C161 a_8869_n1148# a_8869_848# 0.00552f
C162 a_8559_848# a_8153_848# 0.13843f
C163 a_2329_800# a_4059_848# 0
C164 a_4465_848# a_5457_380# 0.05409f
C165 a_6671_n698# a_6793_n480# 0.07744f
C166 a_3109_848# a_5457_380# 0
C167 vdd a_6125_n1148# 0.91912f
C168 inn a_938_n480# 0
C169 vdd a_4465_848# 1.27831f
C170 a_6173_80# a_6125_848# 0.07294f
C171 vdd a_8869_n1148# 0.96996f
C172 vdd a_3109_848# 1.03483f
C173 a_8559_n1148# a_6125_n1148# 0
C174 a_4465_n1248# a_6671_630# 0.00246f
C175 a_6173_n480# a_6793_n480# 0.00118f
C176 inn a_216_848# 0
C177 a_5251_n1148# a_6125_n1148# 0
C178 a_8559_n1148# a_8869_n1148# 0.07746f
C179 a_4465_n1248# a_4059_848# 0
C180 a_6671_630# outn 0.00186f
C181 a_6793_80# a_6173_80# 0.00118f
C182 a_216_n1248# a_4059_848# 0
C183 a_3109_n1248# a_938_n480# 0.28923f
C184 a_2329_n1274# a_938_n480# 0.33259f
C185 a_3109_n1248# a_216_848# 0.10139f
C186 a_2329_n1274# a_216_848# 0.28869f
C187 vdd a_2329_800# 1.62732f
C188 inn vbias 0.12517f
C189 a_938_80# a_216_848# 0.2233f
C190 a_8153_n1248# outn 0
C191 a_6793_n480# a_5663_n1148# 0
C192 outp a_8153_848# 0
C193 a_8869_848# outn 0
C194 a_6125_n1148# a_5457_n1148# 0.00103f
C195 a_5251_380# a_5457_380# 0.09474f
C196 a_6793_80# a_6125_848# 0.05936f
C197 a_2329_n1274# vbias 0.00168f
C198 a_4465_n1248# vdd 1.27828f
C199 a_5251_380# vdd 0.31945f
C200 a_4059_n1208# a_938_n480# 0
C201 a_216_n1248# vdd 1.32176f
C202 a_6671_n698# a_6125_848# 0.33783f
C203 a_4059_n1208# a_216_848# 0
C204 a_938_80# vbias 0.28783f
C205 a_4465_n1248# a_5251_n1148# 0.13368f
C206 vdd outn 0.67651f
C207 a_5251_380# a_5251_n1148# 0
C208 a_6793_80# a_8917_80# 0
C209 a_8559_n1148# outn 0
C210 a_6793_80# a_6671_n698# 0.19791f
C211 a_6173_80# a_5663_n1148# 0
C212 a_6671_n698# a_8917_80# 0.04346f
C213 a_8917_n480# a_6793_n480# 0
C214 a_8559_848# a_6125_848# 0
C215 a_6173_80# a_5663_380# 0.01934f
C216 vdd inp 0.28295f
C217 a_4465_n1248# a_5457_n1148# 0.05409f
C218 a_6793_80# a_8559_848# 0
C219 a_2329_n1274# inn 0
C220 a_8917_80# a_8559_848# 0.01934f
C221 a_8153_n1248# a_6671_630# 0.23316f
C222 a_8869_848# a_6671_630# 0
C223 a_6125_848# a_5663_n1148# 0
C224 a_6671_n698# a_8559_848# 0.11054f
C225 a_6793_n480# a_6125_n1148# 0.05936f
C226 a_6125_848# a_5663_380# 0.06718f
C227 a_3109_n1248# a_2329_n1274# 0.22442f
C228 vdd a_6671_630# 2.16427f
C229 a_3109_n1248# a_938_80# 0
C230 a_6793_80# a_5663_380# 0
C231 a_2329_n1274# a_938_80# 0
C232 a_3109_848# a_938_n480# 0
C233 a_8559_n1148# a_6671_630# 0.10771f
C234 a_6671_n698# a_5663_n1148# 0
C235 a_3109_848# a_216_848# 0.0014f
C236 vdd a_4059_848# 0.91988f
C237 a_6671_n698# a_5663_380# 0
C238 outn vss 0.4485f
C239 inn vss 0.99613f
C240 outp vss 0.44849f
C241 vbias vss 3.54796f
C242 inp vss 0.9953f
C243 vdd vss 43.197f
C244 a_8917_n480# vss 0.21199f
C245 a_8153_n1248# vss 0.42645f
C246 a_8869_n1148# vss 0.51628f
C247 a_8559_n1148# vss 0.31711f
C248 a_6793_n480# vss 0.45492f
C249 a_6173_n480# vss 0.21872f
C250 a_6125_n1148# vss 0.40947f
C251 a_5663_n1148# vss 0.36083f
C252 a_5457_n1148# vss 0.2328f
C253 a_5251_n1148# vss 0.23475f
C254 a_4465_n1248# vss 0.84872f
C255 a_4059_n1208# vss 0.65561f
C256 a_3109_n1248# vss 0.55627f
C257 a_2329_n1274# vss 0.35513f
C258 a_938_n480# vss 1.18893f
C259 a_8917_80# vss 0.21193f
C260 a_6793_80# vss 0.45492f
C261 a_6173_80# vss 0.21872f
C262 a_8559_848# vss 0.3171f
C263 a_8153_848# vss 0.42669f
C264 a_8869_848# vss 0.51627f
C265 a_6671_n698# vss 1.85918f
C266 a_6125_848# vss 0.40947f
C267 a_6671_630# vss 1.83345f
C268 a_5663_380# vss 0.36113f
C269 a_5457_380# vss 0.23291f
C270 a_5251_380# vss 0.23479f
C271 a_4465_848# vss 0.84865f
C272 a_4059_848# vss 0.65527f
C273 a_216_n1248# vss 2.22274f
C274 a_3109_848# vss 0.55627f
C275 a_2329_800# vss 0.35543f
C276 a_938_80# vss 1.18893f
C277 a_216_848# vss 2.22888f
.ends
