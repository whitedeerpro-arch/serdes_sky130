* NGSPICE file created from serdes_cml_to_cmos_r4_pdk.ext - technology: sky130A

.subckt serdes_cml_to_cmos_r4_pdk inp inn outp outn vbias vdd vss
X0 vdd a_3264_1394# a_4368_1442# vdd sky130_fd_pr__pfet_01v8 ad=0.66 pd=4.33 as=0.66 ps=4.33 w=4 l=0.15
X1 vss a_4368_1442# a_5766_128# vss sky130_fd_pr__nfet_01v8 ad=0.297 pd=2.13 as=0.297 ps=2.13 w=1.8 l=0.15
X2 vdd inp a_451_230# vss sky130_fd_pr__nfet_01v8_lvt ad=0.66 pd=4.33 as=1.24 ps=8.62 w=4 l=0.15
X3 a_5766_128# a_4368_1442# vss vss sky130_fd_pr__nfet_01v8 ad=0.297 pd=2.13 as=0.558 ps=4.22 w=1.8 l=0.15
X4 a_7114_n1352# a_6900_n1352# vss vss sky130_fd_pr__nfet_01v8 ad=0.232 pd=2.18 as=0.232 ps=2.18 w=0.8 l=0.15
X5 a_7596_n1172# a_6180_n1112# vdd vdd sky130_fd_pr__pfet_01v8 ad=0.2475 pd=1.83 as=0.465 ps=3.62 w=1.5 l=0.15
X6 a_10412_n1172# a_8158_646# a_10460_n488# vss sky130_fd_pr__nfet_01v8 ad=0.58 pd=4.58 as=0.58 ps=4.58 w=2 l=0.15
X7 a_5766_128# a_4368_1442# vss vss sky130_fd_pr__nfet_01v8 ad=0.558 pd=4.22 as=0.297 ps=2.13 w=1.8 l=0.15
X8 a_6686_n1352# a_6180_n1112# vss vss sky130_fd_pr__nfet_01v8 ad=0.232 pd=2.18 as=0.232 ps=2.18 w=0.8 l=0.15
X9 a_10412_872# a_10094_872# vdd vdd sky130_fd_pr__pfet_01v8 ad=0.2475 pd=1.83 as=0.465 ps=3.62 w=1.5 l=0.15
X10 outn a_10412_n1172# vdd vdd sky130_fd_pr__pfet_01v8 ad=0.33 pd=2.33 as=0.62 ps=4.62 w=2 l=0.15
X11 vdd a_3264_1394# a_3264_1394# vdd sky130_fd_pr__pfet_01v8 ad=0.66 pd=4.33 as=0.66 ps=4.33 w=4 l=0.15
X12 a_6180_872# a_5766_128# vdd vdd sky130_fd_pr__pfet_01v8 ad=0.198 pd=1.53 as=0.372 ps=3.02 w=1.2 l=0.15
X13 a_7114_328# a_6900_328# vdd vdd sky130_fd_pr__pfet_01v8 ad=0.696 pd=5.38 as=0.696 ps=5.38 w=2.4 l=0.15
X14 a_8158_646# a_7596_n1172# a_8280_n488# vss sky130_fd_pr__nfet_01v8 ad=0.33 pd=2.33 as=0.62 ps=4.62 w=2 l=0.15
X15 a_945_n870# vbias vss vss sky130_fd_pr__nfet_01v8 ad=0.464 pd=3.49 as=0.928 ps=6.98 w=3.2 l=0.5
X16 a_7596_n1172# a_6180_n1112# a_7596_n488# vss sky130_fd_pr__nfet_01v8 ad=0.2475 pd=1.83 as=0.465 ps=3.62 w=1.5 l=0.15
X17 vdd a_4368_1442# a_5766_128# vdd sky130_fd_pr__pfet_01v8 ad=0.198 pd=1.53 as=0.198 ps=1.53 w=1.2 l=0.15
X18 a_6180_872# a_5766_128# vdd vdd sky130_fd_pr__pfet_01v8 ad=0.198 pd=1.53 as=0.198 ps=1.53 w=1.2 l=0.15
X19 vdd a_10094_872# a_10412_872# vdd sky130_fd_pr__pfet_01v8 ad=0.465 pd=3.62 as=0.2475 ps=1.83 w=1.5 l=0.15
X20 vss a_5766_128# a_6180_872# vss sky130_fd_pr__nfet_01v8 ad=0.372 pd=3.02 as=0.198 ps=1.53 w=1.2 l=0.15
X21 outp a_10412_872# vss vss sky130_fd_pr__nfet_01v8 ad=0.33 pd=2.33 as=0.62 ps=4.62 w=2 l=0.15
X22 a_5766_n1112# a_4368_n2242# vdd vdd sky130_fd_pr__pfet_01v8 ad=0.372 pd=3.02 as=0.198 ps=1.53 w=1.2 l=0.15
X23 a_4368_1442# a_3264_1394# vdd vdd sky130_fd_pr__pfet_01v8 ad=0.66 pd=4.33 as=0.66 ps=4.33 w=4 l=0.15
X24 vdd a_7596_n1172# a_8158_646# vdd sky130_fd_pr__pfet_01v8 ad=0.33 pd=2.33 as=0.33 ps=2.33 w=2 l=0.15
X25 vss a_5766_n1112# a_6180_n1112# vss sky130_fd_pr__nfet_01v8 ad=0.372 pd=3.02 as=0.198 ps=1.53 w=1.2 l=0.15
X26 a_5766_128# a_4368_1442# vdd vdd sky130_fd_pr__pfet_01v8 ad=0.198 pd=1.53 as=0.372 ps=3.02 w=1.2 l=0.15
X27 vdd a_5766_128# a_6180_872# vdd sky130_fd_pr__pfet_01v8 ad=0.198 pd=1.53 as=0.198 ps=1.53 w=1.2 l=0.15
X28 a_6180_872# a_5766_128# vss vss sky130_fd_pr__nfet_01v8 ad=0.198 pd=1.53 as=0.372 ps=3.02 w=1.2 l=0.15
X29 vss a_10412_n1172# outn vss sky130_fd_pr__nfet_01v8 ad=0.62 pd=4.62 as=0.33 ps=2.33 w=2 l=0.15
X30 vss vbias a_945_n870# vss sky130_fd_pr__nfet_01v8 ad=0.464 pd=3.49 as=0.464 ps=3.49 w=3.2 l=0.5
X31 a_451_230# inp vdd vss sky130_fd_pr__nfet_01v8_lvt ad=0.66 pd=4.33 as=0.66 ps=4.33 w=4 l=0.15
X32 vdd a_5766_128# a_6180_872# vdd sky130_fd_pr__pfet_01v8 ad=0.372 pd=3.02 as=0.198 ps=1.53 w=1.2 l=0.15
X33 a_10460_n488# a_10094_n1172# vss vss sky130_fd_pr__nfet_01v8 ad=0.58 pd=4.58 as=0.58 ps=4.58 w=2 l=0.15
X34 a_5766_128# a_4368_1442# vdd vdd sky130_fd_pr__pfet_01v8 ad=0.372 pd=3.02 as=0.198 ps=1.53 w=1.2 l=0.15
X35 a_10460_88# a_10094_872# vss vss sky130_fd_pr__nfet_01v8 ad=0.58 pd=4.58 as=0.58 ps=4.58 w=2 l=0.15
X36 vdd a_6180_n1112# a_7596_n1172# vdd sky130_fd_pr__pfet_01v8 ad=0.465 pd=3.62 as=0.2475 ps=1.83 w=1.5 l=0.15
X37 vdd a_8158_646# a_9680_n1272# vdd sky130_fd_pr__pfet_01v8 ad=0.33 pd=2.33 as=0.33 ps=2.33 w=2 l=0.15
X38 a_4368_n2242# a_3264_n2290# vdd vdd sky130_fd_pr__pfet_01v8 ad=0.66 pd=4.33 as=1.24 ps=8.62 w=4 l=0.15
X39 vdd a_10412_n1172# outn vdd sky130_fd_pr__pfet_01v8 ad=0.33 pd=2.33 as=0.33 ps=2.33 w=2 l=0.15
X40 vdd a_7596_872# a_8158_n714# vdd sky130_fd_pr__pfet_01v8 ad=0.33 pd=2.33 as=0.33 ps=2.33 w=2 l=0.15
X41 a_8158_n714# a_7596_872# vdd vdd sky130_fd_pr__pfet_01v8 ad=0.33 pd=2.33 as=0.62 ps=4.62 w=2 l=0.15
X42 vdd a_3264_n2290# a_4368_n2242# vdd sky130_fd_pr__pfet_01v8 ad=0.66 pd=4.33 as=0.66 ps=4.33 w=4 l=0.15
X43 vdd inp a_451_230# vss sky130_fd_pr__nfet_01v8_lvt ad=0.66 pd=4.33 as=0.66 ps=4.33 w=4 l=0.15
X44 a_7596_n1172# a_7114_n1352# vdd vdd sky130_fd_pr__pfet_01v8 ad=0.2475 pd=1.83 as=0.465 ps=3.62 w=1.5 l=0.15
X45 a_3264_n2290# a_3264_n2290# vdd vdd sky130_fd_pr__pfet_01v8 ad=0.66 pd=4.33 as=0.66 ps=4.33 w=4 l=0.15
X46 a_945_n870# vbias vss vss sky130_fd_pr__nfet_01v8 ad=0.464 pd=3.49 as=0.464 ps=3.49 w=3.2 l=0.5
X47 a_8158_n714# a_7596_872# vdd vdd sky130_fd_pr__pfet_01v8 ad=0.62 pd=4.62 as=0.33 ps=2.33 w=2 l=0.15
X48 a_10412_n1172# a_10094_n1172# vdd vdd sky130_fd_pr__pfet_01v8 ad=0.2475 pd=1.83 as=0.465 ps=3.62 w=1.5 l=0.15
X49 vdd a_3264_n2290# a_3264_n2290# vdd sky130_fd_pr__pfet_01v8 ad=1.24 pd=8.62 as=0.66 ps=4.33 w=4 l=0.15
X50 a_4368_1442# a_3264_1394# vdd vdd sky130_fd_pr__pfet_01v8 ad=0.66 pd=4.33 as=1.24 ps=8.62 w=4 l=0.15
X51 a_10094_872# a_9680_872# vss vss sky130_fd_pr__nfet_01v8 ad=0.29 pd=2.58 as=0.29 ps=2.58 w=1 l=0.15
X52 a_10412_872# a_8158_n714# a_10460_88# vss sky130_fd_pr__nfet_01v8 ad=0.58 pd=4.58 as=0.58 ps=4.58 w=2 l=0.15
X53 a_451_n830# vbias vss vss sky130_fd_pr__nfet_01v8 ad=0.87 pd=6.58 as=0.87 ps=6.58 w=3 l=0.5
X54 a_9680_n1272# a_8158_646# vdd vdd sky130_fd_pr__pfet_01v8 ad=0.62 pd=4.62 as=0.33 ps=2.33 w=2 l=0.15
X55 vdd a_3264_n2290# a_4368_n2242# vdd sky130_fd_pr__pfet_01v8 ad=0.66 pd=4.33 as=0.66 ps=4.33 w=4 l=0.15
X56 vss a_4368_n2242# a_5766_n1112# vss sky130_fd_pr__nfet_01v8 ad=0.297 pd=2.13 as=0.297 ps=2.13 w=1.8 l=0.15
X57 outn a_10412_n1172# vdd vdd sky130_fd_pr__pfet_01v8 ad=0.33 pd=2.33 as=0.33 ps=2.33 w=2 l=0.15
X58 vdd a_5766_n1112# a_6180_n1112# vdd sky130_fd_pr__pfet_01v8 ad=0.372 pd=3.02 as=0.198 ps=1.53 w=1.2 l=0.15
X59 a_945_n870# a_451_230# a_4368_n2242# vss sky130_fd_pr__nfet_01v8_lvt ad=1.24 pd=8.62 as=0.66 ps=4.33 w=4 l=0.15
X60 vss vbias a_945_n870# vss sky130_fd_pr__nfet_01v8 ad=0.464 pd=3.49 as=0.464 ps=3.49 w=3.2 l=0.5
X61 vdd a_3264_n2290# a_4368_n2242# vdd sky130_fd_pr__pfet_01v8 ad=1.24 pd=8.62 as=0.66 ps=4.33 w=4 l=0.15
X62 a_4368_n2242# a_3264_n2290# vdd vdd sky130_fd_pr__pfet_01v8 ad=0.66 pd=4.33 as=0.66 ps=4.33 w=4 l=0.15
X63 a_3264_n2290# a_451_n830# a_945_n870# vss sky130_fd_pr__nfet_01v8_lvt ad=0.66 pd=4.33 as=1.24 ps=8.62 w=4 l=0.15
X64 vdd inn a_451_n830# vss sky130_fd_pr__nfet_01v8_lvt ad=0.66 pd=4.33 as=0.66 ps=4.33 w=4 l=0.15
X65 a_3264_1394# a_3264_1394# vdd vdd sky130_fd_pr__pfet_01v8 ad=0.66 pd=4.33 as=0.66 ps=4.33 w=4 l=0.15
X66 vdd a_7114_n1352# a_7596_n1172# vdd sky130_fd_pr__pfet_01v8 ad=0.465 pd=3.62 as=0.2475 ps=1.83 w=1.5 l=0.15
X67 vdd a_3264_n2290# a_3264_n2290# vdd sky130_fd_pr__pfet_01v8 ad=0.66 pd=4.33 as=0.66 ps=4.33 w=4 l=0.15
X68 vdd a_3264_1394# a_4368_1442# vdd sky130_fd_pr__pfet_01v8 ad=0.66 pd=4.33 as=0.66 ps=4.33 w=4 l=0.15
X69 a_6180_n1112# a_5766_n1112# vss vss sky130_fd_pr__nfet_01v8 ad=0.198 pd=1.53 as=0.372 ps=3.02 w=1.2 l=0.15
X70 vdd a_8158_n714# a_10412_872# vdd sky130_fd_pr__pfet_01v8 ad=0.465 pd=3.62 as=0.2475 ps=1.83 w=1.5 l=0.15
X71 outn a_10412_n1172# vss vss sky130_fd_pr__nfet_01v8 ad=0.33 pd=2.33 as=0.62 ps=4.62 w=2 l=0.15
X72 a_451_n830# inn vdd vss sky130_fd_pr__nfet_01v8_lvt ad=1.24 pd=8.62 as=0.66 ps=4.33 w=4 l=0.15
X73 vdd inp a_451_230# vss sky130_fd_pr__nfet_01v8_lvt ad=0.66 pd=4.33 as=0.66 ps=4.33 w=4 l=0.15
X74 vss vbias a_945_230# vss sky130_fd_pr__nfet_01v8 ad=0.928 pd=6.98 as=0.464 ps=3.49 w=3.2 l=0.5
X75 a_6686_n1352# a_6180_n1112# vdd vdd sky130_fd_pr__pfet_01v8 ad=0.696 pd=5.38 as=0.696 ps=5.38 w=2.4 l=0.15
X76 a_4368_n2242# a_3264_n2290# vdd vdd sky130_fd_pr__pfet_01v8 ad=0.66 pd=4.33 as=0.66 ps=4.33 w=4 l=0.15
X77 a_451_230# vbias vss vss sky130_fd_pr__nfet_01v8 ad=0.87 pd=6.58 as=0.87 ps=6.58 w=3 l=0.5
X78 a_8280_n488# a_8158_n714# vss vss sky130_fd_pr__nfet_01v8 ad=0.33 pd=2.33 as=0.62 ps=4.62 w=2 l=0.15
X79 vdd a_3264_1394# a_3264_1394# vdd sky130_fd_pr__pfet_01v8 ad=1.24 pd=8.62 as=0.66 ps=4.33 w=4 l=0.15
X80 a_10094_n1172# a_9680_n1272# vdd vdd sky130_fd_pr__pfet_01v8 ad=0.2475 pd=1.83 as=0.465 ps=3.62 w=1.5 l=0.15
X81 a_4368_1442# a_451_n830# a_945_230# vss sky130_fd_pr__nfet_01v8_lvt ad=0.66 pd=4.33 as=1.24 ps=8.62 w=4 l=0.15
X82 a_7114_328# a_6900_328# vss vss sky130_fd_pr__nfet_01v8 ad=0.232 pd=2.18 as=0.232 ps=2.18 w=0.8 l=0.15
X83 a_4368_1442# a_3264_1394# vdd vdd sky130_fd_pr__pfet_01v8 ad=0.66 pd=4.33 as=0.66 ps=4.33 w=4 l=0.15
X84 a_10412_n1172# a_8158_646# vdd vdd sky130_fd_pr__pfet_01v8 ad=0.2475 pd=1.83 as=0.465 ps=3.62 w=1.5 l=0.15
X85 a_945_n870# a_451_n830# a_3264_n2290# vss sky130_fd_pr__nfet_01v8_lvt ad=0.66 pd=4.33 as=0.66 ps=4.33 w=4 l=0.15
X86 a_4368_1442# a_451_n830# a_945_230# vss sky130_fd_pr__nfet_01v8_lvt ad=0.66 pd=4.33 as=0.66 ps=4.33 w=4 l=0.15
X87 a_8280_88# a_7596_872# a_8158_n714# vss sky130_fd_pr__nfet_01v8 ad=0.62 pd=4.62 as=0.33 ps=2.33 w=2 l=0.15
X88 a_451_n830# inn vdd vss sky130_fd_pr__nfet_01v8_lvt ad=0.66 pd=4.33 as=0.66 ps=4.33 w=4 l=0.15
X89 a_451_230# inp vdd vss sky130_fd_pr__nfet_01v8_lvt ad=0.66 pd=4.33 as=0.66 ps=4.33 w=4 l=0.15
X90 a_945_230# a_451_n830# a_4368_1442# vss sky130_fd_pr__nfet_01v8_lvt ad=0.66 pd=4.33 as=0.66 ps=4.33 w=4 l=0.15
X91 vdd a_8158_646# a_10412_n1172# vdd sky130_fd_pr__pfet_01v8 ad=0.465 pd=3.62 as=0.2475 ps=1.83 w=1.5 l=0.15
X92 a_945_n870# vbias vss vss sky130_fd_pr__nfet_01v8 ad=0.464 pd=3.49 as=0.464 ps=3.49 w=3.2 l=0.5
X93 vss vbias a_945_n870# vss sky130_fd_pr__nfet_01v8 ad=0.464 pd=3.49 as=0.464 ps=3.49 w=3.2 l=0.5
X94 a_945_230# a_451_n830# a_4368_1442# vss sky130_fd_pr__nfet_01v8_lvt ad=1.24 pd=8.62 as=0.66 ps=4.33 w=4 l=0.15
X95 vdd a_7114_328# a_7596_872# vdd sky130_fd_pr__pfet_01v8 ad=0.465 pd=3.62 as=0.2475 ps=1.83 w=1.5 l=0.15
X96 a_7596_872# a_7114_328# vdd vdd sky130_fd_pr__pfet_01v8 ad=0.2475 pd=1.83 as=0.465 ps=3.62 w=1.5 l=0.15
X97 a_8158_646# a_7596_n1172# vdd vdd sky130_fd_pr__pfet_01v8 ad=0.62 pd=4.62 as=0.33 ps=2.33 w=2 l=0.15
X98 a_6180_n1112# a_5766_n1112# vdd vdd sky130_fd_pr__pfet_01v8 ad=0.198 pd=1.53 as=0.372 ps=3.02 w=1.2 l=0.15
X99 a_4368_n2242# a_451_230# a_945_n870# vss sky130_fd_pr__nfet_01v8_lvt ad=0.66 pd=4.33 as=1.24 ps=8.62 w=4 l=0.15
X100 vdd a_3264_1394# a_3264_1394# vdd sky130_fd_pr__pfet_01v8 ad=0.66 pd=4.33 as=0.66 ps=4.33 w=4 l=0.15
X101 a_945_230# a_451_230# a_3264_1394# vss sky130_fd_pr__nfet_01v8_lvt ad=0.66 pd=4.33 as=0.66 ps=4.33 w=4 l=0.15
X102 a_6900_328# a_6686_328# vdd vdd sky130_fd_pr__pfet_01v8 ad=0.696 pd=5.38 as=0.696 ps=5.38 w=2.4 l=0.15
X103 vdd a_9680_n1272# a_10094_n1172# vdd sky130_fd_pr__pfet_01v8 ad=0.465 pd=3.62 as=0.2475 ps=1.83 w=1.5 l=0.15
X104 a_3264_1394# a_451_230# a_945_230# vss sky130_fd_pr__nfet_01v8_lvt ad=0.66 pd=4.33 as=1.24 ps=8.62 w=4 l=0.15
X105 a_945_230# a_451_230# a_3264_1394# vss sky130_fd_pr__nfet_01v8_lvt ad=1.24 pd=8.62 as=0.66 ps=4.33 w=4 l=0.15
X106 a_5766_n1112# a_4368_n2242# vss vss sky130_fd_pr__nfet_01v8 ad=0.297 pd=2.13 as=0.558 ps=4.22 w=1.8 l=0.15
X107 a_6900_n1352# a_6686_n1352# vdd vdd sky130_fd_pr__pfet_01v8 ad=0.696 pd=5.38 as=0.696 ps=5.38 w=2.4 l=0.15
X108 a_6900_n1352# a_6686_n1352# vss vss sky130_fd_pr__nfet_01v8 ad=0.232 pd=2.18 as=0.232 ps=2.18 w=0.8 l=0.15
X109 a_3264_1394# a_451_230# a_945_230# vss sky130_fd_pr__nfet_01v8_lvt ad=0.66 pd=4.33 as=0.66 ps=4.33 w=4 l=0.15
X110 a_8280_88# a_8158_646# vss vss sky130_fd_pr__nfet_01v8 ad=0.33 pd=2.33 as=0.62 ps=4.62 w=2 l=0.15
X111 a_8158_n714# a_7596_872# a_8280_88# vss sky130_fd_pr__nfet_01v8 ad=0.33 pd=2.33 as=0.62 ps=4.62 w=2 l=0.15
X112 vdd a_3264_1394# a_4368_1442# vdd sky130_fd_pr__pfet_01v8 ad=1.24 pd=8.62 as=0.66 ps=4.33 w=4 l=0.15
X113 vss a_7114_328# a_7596_188# vss sky130_fd_pr__nfet_01v8 ad=0.465 pd=3.62 as=0.2475 ps=1.83 w=1.5 l=0.15
X114 a_945_230# vbias vss vss sky130_fd_pr__nfet_01v8 ad=0.464 pd=3.49 as=0.464 ps=3.49 w=3.2 l=0.5
X115 a_9680_872# a_8158_n714# vss vss sky130_fd_pr__nfet_01v8 ad=0.58 pd=4.58 as=0.58 ps=4.58 w=2 l=0.15
X116 a_7596_188# a_7114_328# vss vss sky130_fd_pr__nfet_01v8 ad=0.2475 pd=1.83 as=0.465 ps=3.62 w=1.5 l=0.15
X117 a_10412_872# a_8158_n714# vdd vdd sky130_fd_pr__pfet_01v8 ad=0.2475 pd=1.83 as=0.465 ps=3.62 w=1.5 l=0.15
X118 outp a_10412_872# vdd vdd sky130_fd_pr__pfet_01v8 ad=0.33 pd=2.33 as=0.33 ps=2.33 w=2 l=0.15
X119 vdd a_10412_872# outp vdd sky130_fd_pr__pfet_01v8 ad=0.33 pd=2.33 as=0.33 ps=2.33 w=2 l=0.15
X120 vdd a_10094_n1172# a_10412_n1172# vdd sky130_fd_pr__pfet_01v8 ad=0.465 pd=3.62 as=0.2475 ps=1.83 w=1.5 l=0.15
X121 outp a_10412_872# vdd vdd sky130_fd_pr__pfet_01v8 ad=0.33 pd=2.33 as=0.62 ps=4.62 w=2 l=0.15
X122 vdd a_10412_872# outp vdd sky130_fd_pr__pfet_01v8 ad=0.62 pd=4.62 as=0.33 ps=2.33 w=2 l=0.15
X123 a_945_230# vbias vss vss sky130_fd_pr__nfet_01v8 ad=0.464 pd=3.49 as=0.464 ps=3.49 w=3.2 l=0.5
X124 vdd a_3264_1394# a_4368_1442# vdd sky130_fd_pr__pfet_01v8 ad=0.66 pd=4.33 as=0.66 ps=4.33 w=4 l=0.15
X125 vdd a_10412_n1172# outn vdd sky130_fd_pr__pfet_01v8 ad=0.62 pd=4.62 as=0.33 ps=2.33 w=2 l=0.15
X126 a_5766_n1112# a_4368_n2242# vdd vdd sky130_fd_pr__pfet_01v8 ad=0.198 pd=1.53 as=0.372 ps=3.02 w=1.2 l=0.15
X127 vdd inp a_451_230# vss sky130_fd_pr__nfet_01v8_lvt ad=0.66 pd=4.33 as=0.66 ps=4.33 w=4 l=0.15
X128 a_6686_328# a_6180_872# vdd vdd sky130_fd_pr__pfet_01v8 ad=0.696 pd=5.38 as=0.696 ps=5.38 w=2.4 l=0.15
X129 a_3264_n2290# a_3264_n2290# vdd vdd sky130_fd_pr__pfet_01v8 ad=0.66 pd=4.33 as=0.66 ps=4.33 w=4 l=0.15
X130 vss vbias a_945_230# vss sky130_fd_pr__nfet_01v8 ad=0.464 pd=3.49 as=0.464 ps=3.49 w=3.2 l=0.5
X131 vdd a_6180_872# a_7596_872# vdd sky130_fd_pr__pfet_01v8 ad=0.465 pd=3.62 as=0.2475 ps=1.83 w=1.5 l=0.15
X132 vss a_7114_n1352# a_7596_n488# vss sky130_fd_pr__nfet_01v8 ad=0.465 pd=3.62 as=0.2475 ps=1.83 w=1.5 l=0.15
X133 a_7596_872# a_6180_872# vdd vdd sky130_fd_pr__pfet_01v8 ad=0.2475 pd=1.83 as=0.465 ps=3.62 w=1.5 l=0.15
X134 a_8158_n714# a_8158_646# vdd vdd sky130_fd_pr__pfet_01v8 ad=0.62 pd=4.62 as=0.33 ps=2.33 w=2 l=0.15
X135 a_3264_1394# a_3264_1394# vdd vdd sky130_fd_pr__pfet_01v8 ad=0.66 pd=4.33 as=1.24 ps=8.62 w=4 l=0.15
X136 vdd a_8158_646# a_8158_n714# vdd sky130_fd_pr__pfet_01v8 ad=0.33 pd=2.33 as=0.33 ps=2.33 w=2 l=0.15
X137 a_451_230# inp vdd vss sky130_fd_pr__nfet_01v8_lvt ad=1.24 pd=8.62 as=0.66 ps=4.33 w=4 l=0.15
X138 vss vbias a_945_n870# vss sky130_fd_pr__nfet_01v8 ad=0.464 pd=3.49 as=0.464 ps=3.49 w=3.2 l=0.5
X139 a_945_230# vbias vss vss sky130_fd_pr__nfet_01v8 ad=0.464 pd=3.49 as=0.464 ps=3.49 w=3.2 l=0.5
X140 vdd a_3264_n2290# a_4368_n2242# vdd sky130_fd_pr__pfet_01v8 ad=0.66 pd=4.33 as=0.66 ps=4.33 w=4 l=0.15
X141 vdd a_4368_n2242# a_5766_n1112# vdd sky130_fd_pr__pfet_01v8 ad=0.198 pd=1.53 as=0.198 ps=1.53 w=1.2 l=0.15
X142 a_3264_n2290# a_3264_n2290# vdd vdd sky130_fd_pr__pfet_01v8 ad=0.66 pd=4.33 as=1.24 ps=8.62 w=4 l=0.15
X143 a_7596_188# a_6180_872# a_7596_872# vss sky130_fd_pr__nfet_01v8 ad=0.465 pd=3.62 as=0.2475 ps=1.83 w=1.5 l=0.15
X144 a_3264_n2290# a_451_n830# a_945_n870# vss sky130_fd_pr__nfet_01v8_lvt ad=0.66 pd=4.33 as=0.66 ps=4.33 w=4 l=0.15
X145 vdd inn a_451_n830# vss sky130_fd_pr__nfet_01v8_lvt ad=0.66 pd=4.33 as=0.66 ps=4.33 w=4 l=0.15
X146 a_945_n870# vbias vss vss sky130_fd_pr__nfet_01v8 ad=0.464 pd=3.49 as=0.464 ps=3.49 w=3.2 l=0.5
X147 a_7114_n1352# a_6900_n1352# vdd vdd sky130_fd_pr__pfet_01v8 ad=0.696 pd=5.38 as=0.696 ps=5.38 w=2.4 l=0.15
X148 vdd a_3264_n2290# a_3264_n2290# vdd sky130_fd_pr__pfet_01v8 ad=0.66 pd=4.33 as=0.66 ps=4.33 w=4 l=0.15
X149 a_7596_872# a_6180_872# a_7596_188# vss sky130_fd_pr__nfet_01v8 ad=0.2475 pd=1.83 as=0.465 ps=3.62 w=1.5 l=0.15
X150 vdd a_3264_1394# a_3264_1394# vdd sky130_fd_pr__pfet_01v8 ad=0.66 pd=4.33 as=0.66 ps=4.33 w=4 l=0.15
X151 a_6900_328# a_6686_328# vss vss sky130_fd_pr__nfet_01v8 ad=0.232 pd=2.18 as=0.232 ps=2.18 w=0.8 l=0.15
X152 a_9680_n1272# a_8158_646# vdd vdd sky130_fd_pr__pfet_01v8 ad=0.33 pd=2.33 as=0.62 ps=4.62 w=2 l=0.15
X153 vss vbias a_945_230# vss sky130_fd_pr__nfet_01v8 ad=0.464 pd=3.49 as=0.464 ps=3.49 w=3.2 l=0.5
X154 a_4368_1442# a_3264_1394# vdd vdd sky130_fd_pr__pfet_01v8 ad=0.66 pd=4.33 as=0.66 ps=4.33 w=4 l=0.15
X155 a_8158_646# a_8158_n714# vdd vdd sky130_fd_pr__pfet_01v8 ad=0.33 pd=2.33 as=0.62 ps=4.62 w=2 l=0.15
X156 a_5766_n1112# a_4368_n2242# vss vss sky130_fd_pr__nfet_01v8 ad=0.558 pd=4.22 as=0.297 ps=2.13 w=1.8 l=0.15
X157 a_451_230# inp vdd vss sky130_fd_pr__nfet_01v8_lvt ad=0.66 pd=4.33 as=0.66 ps=4.33 w=4 l=0.15
X158 a_945_230# vbias vss vss sky130_fd_pr__nfet_01v8 ad=0.464 pd=3.49 as=0.464 ps=3.49 w=3.2 l=0.5
X159 vdd a_8158_n714# a_8158_646# vdd sky130_fd_pr__pfet_01v8 ad=0.33 pd=2.33 as=0.33 ps=2.33 w=2 l=0.15
X160 vdd a_9680_872# a_10094_872# vdd sky130_fd_pr__pfet_01v8 ad=0.465 pd=3.62 as=0.2475 ps=1.83 w=1.5 l=0.15
X161 vdd a_5766_n1112# a_6180_n1112# vdd sky130_fd_pr__pfet_01v8 ad=0.198 pd=1.53 as=0.198 ps=1.53 w=1.2 l=0.15
X162 a_945_n870# a_451_230# a_4368_n2242# vss sky130_fd_pr__nfet_01v8_lvt ad=0.66 pd=4.33 as=0.66 ps=4.33 w=4 l=0.15
X163 a_4368_n2242# a_3264_n2290# vdd vdd sky130_fd_pr__pfet_01v8 ad=0.66 pd=4.33 as=0.66 ps=4.33 w=4 l=0.15
X164 a_9680_n1272# a_8158_646# vss vss sky130_fd_pr__nfet_01v8 ad=0.58 pd=4.58 as=0.58 ps=4.58 w=2 l=0.15
X165 a_10094_872# a_9680_872# vdd vdd sky130_fd_pr__pfet_01v8 ad=0.2475 pd=1.83 as=0.465 ps=3.62 w=1.5 l=0.15
X166 vdd inn a_451_n830# vss sky130_fd_pr__nfet_01v8_lvt ad=0.66 pd=4.33 as=1.24 ps=8.62 w=4 l=0.15
X167 a_945_230# vbias vss vss sky130_fd_pr__nfet_01v8 ad=0.464 pd=3.49 as=0.928 ps=6.98 w=3.2 l=0.5
X168 vdd a_3264_n2290# a_3264_n2290# vdd sky130_fd_pr__pfet_01v8 ad=0.66 pd=4.33 as=0.66 ps=4.33 w=4 l=0.15
X169 a_9680_872# a_8158_n714# vdd vdd sky130_fd_pr__pfet_01v8 ad=0.33 pd=2.33 as=0.62 ps=4.62 w=2 l=0.15
X170 a_3264_1394# a_3264_1394# vdd vdd sky130_fd_pr__pfet_01v8 ad=0.66 pd=4.33 as=0.66 ps=4.33 w=4 l=0.15
X171 vss a_8158_646# a_8280_88# vss sky130_fd_pr__nfet_01v8 ad=0.62 pd=4.62 as=0.33 ps=2.33 w=2 l=0.15
X172 a_8280_n488# a_7596_n1172# a_8158_646# vss sky130_fd_pr__nfet_01v8 ad=0.62 pd=4.62 as=0.33 ps=2.33 w=2 l=0.15
X173 a_945_n870# a_451_n830# a_3264_n2290# vss sky130_fd_pr__nfet_01v8_lvt ad=1.24 pd=8.62 as=0.66 ps=4.33 w=4 l=0.15
X174 a_9680_872# a_8158_n714# vdd vdd sky130_fd_pr__pfet_01v8 ad=0.62 pd=4.62 as=0.33 ps=2.33 w=2 l=0.15
X175 a_7596_n488# a_6180_n1112# a_7596_n1172# vss sky130_fd_pr__nfet_01v8 ad=0.465 pd=3.62 as=0.2475 ps=1.83 w=1.5 l=0.15
X176 a_451_n830# inn vdd vss sky130_fd_pr__nfet_01v8_lvt ad=0.66 pd=4.33 as=0.66 ps=4.33 w=4 l=0.15
X177 a_3264_n2290# a_3264_n2290# vdd vdd sky130_fd_pr__pfet_01v8 ad=0.66 pd=4.33 as=0.66 ps=4.33 w=4 l=0.15
X178 vdd a_8158_n714# a_9680_872# vdd sky130_fd_pr__pfet_01v8 ad=0.33 pd=2.33 as=0.33 ps=2.33 w=2 l=0.15
X179 vss a_8158_n714# a_8280_n488# vss sky130_fd_pr__nfet_01v8 ad=0.62 pd=4.62 as=0.33 ps=2.33 w=2 l=0.15
X180 vss vbias a_945_n870# vss sky130_fd_pr__nfet_01v8 ad=0.928 pd=6.98 as=0.464 ps=3.49 w=3.2 l=0.5
X181 a_945_n870# vbias vss vss sky130_fd_pr__nfet_01v8 ad=0.464 pd=3.49 as=0.464 ps=3.49 w=3.2 l=0.5
X182 a_7596_n488# a_7114_n1352# vss vss sky130_fd_pr__nfet_01v8 ad=0.2475 pd=1.83 as=0.465 ps=3.62 w=1.5 l=0.15
X183 vss vbias a_945_230# vss sky130_fd_pr__nfet_01v8 ad=0.464 pd=3.49 as=0.464 ps=3.49 w=3.2 l=0.5
X184 a_8158_646# a_8158_n714# vdd vdd sky130_fd_pr__pfet_01v8 ad=0.62 pd=4.62 as=0.33 ps=2.33 w=2 l=0.15
X185 a_4368_n2242# a_451_230# a_945_n870# vss sky130_fd_pr__nfet_01v8_lvt ad=0.66 pd=4.33 as=0.66 ps=4.33 w=4 l=0.15
X186 a_8158_n714# a_8158_646# vdd vdd sky130_fd_pr__pfet_01v8 ad=0.33 pd=2.33 as=0.62 ps=4.62 w=2 l=0.15
X187 a_6180_n1112# a_5766_n1112# vdd vdd sky130_fd_pr__pfet_01v8 ad=0.198 pd=1.53 as=0.198 ps=1.53 w=1.2 l=0.15
X188 a_10094_n1172# a_9680_n1272# vss vss sky130_fd_pr__nfet_01v8 ad=0.29 pd=2.58 as=0.29 ps=2.58 w=1 l=0.15
X189 a_451_n830# inn vdd vss sky130_fd_pr__nfet_01v8_lvt ad=0.66 pd=4.33 as=0.66 ps=4.33 w=4 l=0.15
X190 a_6686_328# a_6180_872# vss vss sky130_fd_pr__nfet_01v8 ad=0.232 pd=2.18 as=0.232 ps=2.18 w=0.8 l=0.15
X191 vss a_10412_872# outp vss sky130_fd_pr__nfet_01v8 ad=0.62 pd=4.62 as=0.33 ps=2.33 w=2 l=0.15
X192 vdd inn a_451_n830# vss sky130_fd_pr__nfet_01v8_lvt ad=0.66 pd=4.33 as=0.66 ps=4.33 w=4 l=0.15
X193 a_8158_646# a_7596_n1172# vdd vdd sky130_fd_pr__pfet_01v8 ad=0.33 pd=2.33 as=0.62 ps=4.62 w=2 l=0.15
X194 vss vbias a_945_230# vss sky130_fd_pr__nfet_01v8 ad=0.464 pd=3.49 as=0.464 ps=3.49 w=3.2 l=0.5
X195 a_3264_1394# a_3264_1394# vdd vdd sky130_fd_pr__pfet_01v8 ad=0.66 pd=4.33 as=0.66 ps=4.33 w=4 l=0.15
C0 outp outn 0.00563f
C1 vdd a_7596_872# 1.06897f
C2 a_7596_n488# a_6180_872# 0
C3 a_9680_n1272# a_8158_n714# 0.00225f
C4 a_10094_872# a_8158_646# 0.00416f
C5 a_8158_n714# a_10412_872# 0.18884f
C6 a_4368_1442# a_3264_1394# 0.72152f
C7 a_8280_88# vdd 0.01539f
C8 a_6180_872# a_945_230# 0
C9 vdd a_10460_88# 0.02966f
C10 vdd inn 0.98136f
C11 a_6180_n1112# a_7596_n1172# 0.18595f
C12 a_9680_n1272# a_10094_872# 0
C13 a_10094_n1172# a_10460_88# 0
C14 a_7114_n1352# a_8158_646# 0
C15 vdd a_8158_n714# 2.50767f
C16 a_10094_872# a_10412_872# 0.07852f
C17 a_4368_n2242# a_5766_128# 0
C18 a_6900_328# a_6686_328# 0.12204f
C19 a_10094_n1172# a_8158_n714# 0.00114f
C20 a_6900_328# a_4368_1442# 0
C21 a_451_n830# a_4368_1442# 0.49312f
C22 vdd a_7596_n488# 0.0203f
C23 a_6180_872# a_5766_n1112# 0
C24 vdd a_4368_n2242# 3.11578f
C25 a_10412_n1172# outn 0.26648f
C26 a_945_230# a_5766_128# 0
C27 vdd a_3264_n2290# 7.37745f
C28 a_7114_328# a_6180_872# 0.17107f
C29 vdd a_10094_872# 0.59023f
C30 a_6686_n1352# a_4368_n2242# 0.00135f
C31 vdd a_945_230# 0.06772f
C32 a_10094_n1172# a_10094_872# 0.00248f
C33 a_451_n830# a_3264_1394# 0.39422f
C34 a_10460_n488# a_8158_646# 0.04187f
C35 a_5766_n1112# a_5766_128# 0.00227f
C36 a_7114_328# a_5766_128# 0
C37 vdd a_7114_n1352# 0.68957f
C38 vdd a_5766_n1112# 0.88624f
C39 a_945_n870# a_451_230# 0.53165f
C40 a_7596_872# a_9680_872# 0
C41 vdd a_7114_328# 0.68957f
C42 outp a_10412_872# 0.26648f
C43 a_4368_n2242# a_6900_n1352# 0
C44 a_6686_n1352# a_5766_n1112# 0
C45 a_9680_n1272# a_10460_n488# 0
C46 a_3264_1394# inp 0.00302f
C47 a_7596_n1172# a_8158_646# 0.33909f
C48 a_10460_88# a_9680_872# 0
C49 a_945_n870# vbias 1.11145f
C50 a_10412_n1172# a_8158_646# 0.18981f
C51 a_451_230# vbias 0.81285f
C52 a_8158_n714# a_9680_872# 0.26345f
C53 a_7596_n1172# a_6180_872# 0
C54 outp vdd 0.79728f
C55 vdd a_10460_n488# 0.02966f
C56 a_6180_872# a_6686_328# 0.19026f
C57 a_8280_n488# a_7596_872# 0
C58 a_4368_1442# a_6180_872# 0.00583f
C59 a_7114_n1352# a_6900_n1352# 0.10591f
C60 a_10460_n488# a_10094_n1172# 0.01925f
C61 a_9680_n1272# a_7596_n1172# 0
C62 a_6900_n1352# a_5766_n1112# 0
C63 a_9680_n1272# a_10412_n1172# 0.00387f
C64 a_10412_n1172# a_10412_872# 0.00496f
C65 a_10094_872# a_9680_872# 0.14059f
C66 a_6686_328# a_5766_128# 0
C67 a_8158_n714# a_8280_n488# 0.09038f
C68 a_4368_1442# a_5766_128# 0.25268f
C69 vdd a_7596_n1172# 1.06814f
C70 inn a_945_n870# 0.00108f
C71 vdd a_6686_328# 0.50273f
C72 a_7596_188# a_7596_872# 0.15532f
C73 vdd a_10412_n1172# 1.14508f
C74 a_6180_n1112# a_8158_646# 0.00134f
C75 vdd a_4368_1442# 3.11578f
C76 a_10094_n1172# a_7596_n1172# 0
C77 a_6686_n1352# a_7596_n1172# 0
C78 a_10094_n1172# a_10412_n1172# 0.07852f
C79 a_6686_n1352# a_6686_328# 0
C80 a_6180_n1112# a_6180_872# 0.00299f
C81 a_8158_646# outn 0.00109f
C82 a_6900_328# a_6180_872# 0.07397f
C83 a_451_n830# a_6180_872# 0
C84 a_4368_n2242# a_945_n870# 0.71094f
C85 a_3264_n2290# a_945_n870# 0.73751f
C86 a_4368_n2242# a_451_230# 0.49312f
C87 a_3264_n2290# a_451_230# 0.38517f
C88 vdd a_3264_1394# 7.37729f
C89 inn vbias 0.2752f
C90 a_7596_188# a_8158_n714# 0.00257f
C91 a_945_230# a_451_230# 0.69912f
C92 a_9680_n1272# outn 0
C93 a_6180_n1112# a_5766_128# 0
C94 outp a_9680_872# 0
C95 a_10412_872# outn 0
C96 a_7596_n1172# a_6900_n1352# 0
C97 a_6900_328# a_5766_128# 0
C98 a_451_n830# a_5766_128# 0.00295f
C99 a_8280_88# a_7596_872# 0.05841f
C100 a_3264_n2290# vbias 0
C101 a_6180_n1112# vdd 1.06349f
C102 a_6900_328# vdd 0.50136f
C103 a_5766_n1112# a_945_n870# 0
C104 a_451_n830# vdd 1.87651f
C105 a_8158_n714# a_7596_872# 0.34733f
C106 a_5766_n1112# a_451_230# 0.00295f
C107 a_945_230# vbias 1.11145f
C108 a_6180_n1112# a_6686_n1352# 0.19026f
C109 vdd outn 0.79728f
C110 a_10094_n1172# outn 0
C111 a_8280_88# a_8158_n714# 0.20925f
C112 a_7596_188# a_7114_n1352# 0
C113 a_8158_n714# a_10460_88# 0.03949f
C114 a_10094_872# a_7596_872# 0
C115 a_7596_188# a_7114_328# 0.0413f
C116 vdd inp 0.98136f
C117 a_6180_872# a_8158_646# 0.01954f
C118 a_6180_n1112# a_6900_n1352# 0.07397f
C119 a_7596_n488# a_8158_n714# 0.00259f
C120 a_3264_n2290# inn 0.00302f
C121 a_10460_88# a_10094_872# 0.01925f
C122 a_6900_328# a_6900_n1352# 0
C123 a_9680_n1272# a_8158_646# 0.26892f
C124 a_10412_872# a_8158_646# 0.00143f
C125 a_8158_n714# a_10094_872# 0.10046f
C126 a_8280_n488# a_7596_n1172# 0.05841f
C127 a_7596_872# a_7114_328# 0.0611f
C128 a_4368_n2242# a_3264_n2290# 0.72152f
C129 vdd a_8158_646# 2.55678f
C130 a_6180_872# a_5766_128# 0.22017f
C131 a_3264_n2290# a_945_230# 0
C132 a_8158_n714# a_7114_n1352# 0.00151f
C133 a_10094_n1172# a_8158_646# 0.10321f
C134 a_4368_1442# a_451_230# 0
C135 vdd a_6180_872# 1.06366f
C136 a_8158_n714# a_7114_328# 0.00171f
C137 a_7596_n488# a_7114_n1352# 0.0413f
C138 a_9680_n1272# vdd 0.82692f
C139 vdd a_10412_872# 1.14508f
C140 a_4368_n2242# a_5766_n1112# 0.25268f
C141 a_7596_n488# a_7114_328# 0
C142 a_3264_1394# a_945_n870# 0
C143 a_9680_n1272# a_10094_n1172# 0.14059f
C144 a_3264_1394# a_451_230# 0.49802f
C145 vdd a_5766_128# 0.88638f
C146 a_6180_n1112# a_8280_n488# 0
C147 outp a_8158_n714# 0.00109f
C148 a_6900_n1352# a_8158_646# 0
C149 a_10460_n488# a_8158_n714# 0
C150 a_7596_n1172# a_7596_872# 0.00496f
C151 a_6180_n1112# a_945_n870# 0
C152 vdd a_10094_n1172# 0.59023f
C153 a_451_n830# a_945_n870# 0.70081f
C154 a_7114_n1352# a_5766_n1112# 0
C155 a_7596_872# a_6686_328# 0
C156 a_3264_1394# vbias 0
C157 vdd a_6686_n1352# 0.50273f
C158 a_6180_n1112# a_451_230# 0
C159 a_451_n830# a_451_230# 1.09996f
C160 a_7114_328# a_7114_n1352# 0.00225f
C161 outp a_10094_872# 0
C162 a_8280_88# a_7596_n1172# 0
C163 a_10460_n488# a_10094_872# 0
C164 a_6180_n1112# a_7596_188# 0
C165 a_8158_n714# a_7596_n1172# 0.16826f
C166 a_9680_872# a_8158_646# 0.00844f
C167 a_8158_n714# a_10412_n1172# 0
C168 a_451_n830# vbias 0.63267f
C169 a_7596_n488# a_7596_n1172# 0.15532f
C170 inp a_451_230# 0.90528f
C171 vdd a_6900_n1352# 0.50136f
C172 a_4368_n2242# a_4368_1442# 0.00465f
C173 a_9680_n1272# a_9680_872# 0.001f
C174 a_6686_n1352# a_6900_n1352# 0.12204f
C175 a_9680_872# a_10412_872# 0.00387f
C176 a_6180_n1112# a_7596_872# 0
C177 a_6900_328# a_7596_872# 0
C178 a_4368_1442# a_945_230# 0.71094f
C179 a_8280_n488# a_8158_646# 0.19651f
C180 inp vbias 0.2752f
C181 a_7596_n1172# a_7114_n1352# 0.0611f
C182 vdd a_9680_872# 0.82671f
C183 a_7596_n1172# a_5766_n1112# 0
C184 a_451_n830# inn 0.90528f
C185 a_6180_n1112# a_8158_n714# 0.02174f
C186 a_10094_n1172# a_9680_872# 0
C187 a_3264_1394# a_945_230# 0.73751f
C188 a_4368_1442# a_5766_n1112# 0
C189 a_6900_328# a_8158_n714# 0
C190 a_6180_n1112# a_7596_n488# 0.06486f
C191 a_6180_n1112# a_4368_n2242# 0.00583f
C192 a_7596_188# a_8158_646# 0
C193 a_451_n830# a_4368_n2242# 0
C194 a_451_n830# a_3264_n2290# 0.50683f
C195 vdd a_8280_n488# 0.01539f
C196 a_7596_188# a_6180_872# 0.06486f
C197 a_451_n830# a_945_230# 0.53334f
C198 outp a_10412_n1172# 0
C199 a_10460_n488# a_10412_n1172# 0.07261f
C200 vdd a_945_n870# 0.06772f
C201 vdd a_451_230# 1.92361f
C202 a_6180_n1112# a_7114_n1352# 0.17107f
C203 a_7596_872# a_8158_646# 0.15991f
C204 a_6180_n1112# a_5766_n1112# 0.22017f
C205 a_6900_328# a_7114_328# 0.10591f
C206 a_7596_872# a_6180_872# 0.18595f
C207 inp a_945_230# 0.00108f
C208 a_8280_88# a_8158_646# 0.07764f
C209 vdd a_7596_188# 0.0203f
C210 a_10460_88# a_8158_646# 0.00254f
C211 vdd vbias 0.04644f
C212 a_7596_n1172# a_10412_n1172# 0
C213 a_7596_872# a_10412_872# 0
C214 a_8280_88# a_6180_872# 0
C215 a_8158_n714# a_8158_646# 0.94953f
C216 a_4368_1442# a_6686_328# 0.00135f
C217 a_7596_872# a_5766_128# 0
C218 a_8158_n714# a_6180_872# 0.0033f
C219 a_10460_88# a_10412_872# 0.07261f
C220 outn vss 0.49839f
C221 inn vss 1.89695f
C222 outp vss 0.49839f
C223 vbias vss 10.7011f
C224 inp vss 1.89695f
C225 vdd vss 84.819f
C226 a_10460_n488# vss 0.27146f
C227 a_9680_n1272# vss 0.46874f
C228 a_10412_n1172# vss 0.54061f
C229 a_10094_n1172# vss 0.35446f
C230 a_8280_n488# vss 0.54773f
C231 a_7596_n488# vss 0.41962f
C232 a_7596_n1172# vss 0.41873f
C233 a_7114_n1352# vss 0.52211f
C234 a_6900_n1352# vss 0.30691f
C235 a_6686_n1352# vss 0.30392f
C236 a_6180_n1112# vss 0.87376f
C237 a_5766_n1112# vss 0.84574f
C238 a_4368_n2242# vss 0.89638f
C239 a_3264_n2290# vss 0.45998f
C240 a_945_n870# vss 2.5549f
C241 a_10460_88# vss 0.2714f
C242 a_8280_88# vss 0.54773f
C243 a_7596_188# vss 0.41962f
C244 a_10094_872# vss 0.35445f
C245 a_9680_872# vss 0.46888f
C246 a_10412_872# vss 0.54061f
C247 a_8158_n714# vss 2.05268f
C248 a_7596_872# vss 0.41874f
C249 a_8158_646# vss 2.07361f
C250 a_7114_328# vss 0.52262f
C251 a_5766_128# vss 0.84585f
C252 a_6900_328# vss 0.30709f
C253 a_6686_328# vss 0.30402f
C254 a_6180_872# vss 0.87387f
C255 a_451_n830# vss 5.09681f
C256 a_4368_1442# vss 0.89643f
C257 a_3264_1394# vss 0.45988f
C258 a_945_230# vss 2.5549f
C259 a_451_230# vss 5.10827f
.ends
