* NGSPICE file created from serdes_cml_to_cmos_r5_pdk.ext - technology: sky130A

.subckt serdes_cml_to_cmos_r5_pdk inp inn outp outn vbias vdd vss
X0 vdd a_3264_1394# a_4368_1442# vdd sky130_fd_pr__pfet_01v8 ad=0.66 pd=4.33 as=0.66 ps=4.33 w=4 l=0.15
X1 vdd inp a_451_230# vss sky130_fd_pr__nfet_01v8_lvt ad=0.66 pd=4.33 as=1.24 ps=8.62 w=4 l=0.15
X2 a_11696_n1172# a_9722_n1192# vdd vdd sky130_fd_pr__pfet_01v8 ad=0.2475 pd=1.83 as=0.465 ps=3.62 w=1.5 l=0.15
X3 a_14196_n1352# a_12482_646# vdd vdd sky130_fd_pr__pfet_01v8 ad=0.744 pd=5.42 as=0.396 ps=2.73 w=2.4 l=0.15
X4 vdd a_10796_872# a_11114_872# vdd sky130_fd_pr__pfet_01v8 ad=0.496 pd=3.82 as=0.264 ps=1.93 w=1.6 l=0.15
X5 a_12572_n488# a_11696_n1172# a_12482_646# vss sky130_fd_pr__nfet_01v8 ad=0.33 pd=2.33 as=0.33 ps=2.33 w=2 l=0.15
X6 vdd a_3264_1394# a_3264_1394# vdd sky130_fd_pr__pfet_01v8 ad=0.66 pd=4.33 as=0.66 ps=4.33 w=4 l=0.15
X7 a_11114_872# a_10796_872# vdd vdd sky130_fd_pr__pfet_01v8 ad=0.264 pd=1.93 as=0.496 ps=3.82 w=1.6 l=0.15
X8 vdd a_10478_872# a_10796_872# vdd sky130_fd_pr__pfet_01v8 ad=0.496 pd=3.82 as=0.264 ps=1.93 w=1.6 l=0.15
X9 a_945_n870# vbias vss vss sky130_fd_pr__nfet_01v8 ad=0.464 pd=3.49 as=0.928 ps=6.98 w=3.2 l=0.5
X10 a_4368_1442# a_3264_1394# vdd vdd sky130_fd_pr__pfet_01v8 ad=0.66 pd=4.33 as=0.66 ps=4.33 w=4 l=0.15
X11 a_10796_872# a_10478_872# vdd vdd sky130_fd_pr__pfet_01v8 ad=0.264 pd=1.93 as=0.496 ps=3.82 w=1.6 l=0.15
X12 a_11696_n488# a_11114_n1192# vss vss sky130_fd_pr__nfet_01v8 ad=0.2475 pd=1.83 as=0.465 ps=3.62 w=1.5 l=0.15
X13 a_7025_284# a_6693_1884# vss vss sky130_fd_pr__nfet_01v8 ad=0.33 pd=2.33 as=0.62 ps=4.62 w=2 l=0.15
X14 vss vbias a_945_n870# vss sky130_fd_pr__nfet_01v8 ad=0.464 pd=3.49 as=0.464 ps=3.49 w=3.2 l=0.5
X15 a_451_230# inp vdd vss sky130_fd_pr__nfet_01v8_lvt ad=0.66 pd=4.33 as=0.66 ps=4.33 w=4 l=0.15
X16 outp a_14928_872# vss vss sky130_fd_pr__nfet_01v8 ad=0.33 pd=2.33 as=0.62 ps=4.62 w=2 l=0.15
X17 a_11696_872# a_9722_872# vdd vdd sky130_fd_pr__pfet_01v8 ad=0.2475 pd=1.83 as=0.465 ps=3.62 w=1.5 l=0.15
X18 vss a_7025_284# a_9722_872# vss sky130_fd_pr__nfet_01v8 ad=0.558 pd=4.22 as=0.297 ps=2.13 w=1.8 l=0.15
X19 a_9722_n1192# a_7025_n716# vss vss sky130_fd_pr__nfet_01v8 ad=0.297 pd=2.13 as=0.558 ps=4.22 w=1.8 l=0.15
X20 vdd a_11114_872# a_11696_872# vdd sky130_fd_pr__pfet_01v8 ad=0.2475 pd=1.83 as=0.2475 ps=1.83 w=1.5 l=0.15
X21 a_11696_872# a_9722_872# vdd vdd sky130_fd_pr__pfet_01v8 ad=0.465 pd=3.62 as=0.2475 ps=1.83 w=1.5 l=0.15
X22 a_14610_872# a_14196_872# vdd vdd sky130_fd_pr__pfet_01v8 ad=0.37125 pd=2.58 as=0.6975 ps=5.12 w=2.25 l=0.15
X23 a_9722_872# a_7025_284# vss vss sky130_fd_pr__nfet_01v8 ad=0.297 pd=2.13 as=0.558 ps=4.22 w=1.8 l=0.15
X24 vdd a_9722_872# a_11696_872# vdd sky130_fd_pr__pfet_01v8 ad=0.2475 pd=1.83 as=0.2475 ps=1.83 w=1.5 l=0.15
X25 a_6859_1884# a_6693_284# vss sky130_fd_pr__res_high_po_0p35 l=6
X26 a_11696_872# a_11114_872# vdd vdd sky130_fd_pr__pfet_01v8 ad=0.2475 pd=1.83 as=0.465 ps=3.62 w=1.5 l=0.15
X27 a_4368_n2242# a_3264_n2290# vdd vdd sky130_fd_pr__pfet_01v8 ad=0.66 pd=4.33 as=1.24 ps=8.62 w=4 l=0.15
X28 a_12482_646# a_12482_n714# vdd vdd sky130_fd_pr__pfet_01v8 ad=0.37125 pd=2.58 as=0.6975 ps=5.12 w=2.25 l=0.15
X29 a_11696_872# a_11114_872# vdd vdd sky130_fd_pr__pfet_01v8 ad=0.465 pd=3.62 as=0.2475 ps=1.83 w=1.5 l=0.15
X30 vdd a_14196_872# a_14610_872# vdd sky130_fd_pr__pfet_01v8 ad=0.6975 pd=5.12 as=0.37125 ps=2.58 w=2.25 l=0.15
X31 outn a_14928_n1232# vss vss sky130_fd_pr__nfet_01v8 ad=0.33 pd=2.33 as=0.62 ps=4.62 w=2 l=0.15
X32 a_9722_n1192# a_9722_872# vss vss sky130_fd_pr__nfet_01v8 ad=0.174 pd=1.78 as=0.174 ps=1.78 w=0.6 l=0.15
X33 a_12572_n488# a_12482_n714# vss vss sky130_fd_pr__nfet_01v8 ad=0.62 pd=4.62 as=0.33 ps=2.33 w=2 l=0.15
X34 a_9722_872# a_7025_284# vdd vdd sky130_fd_pr__pfet_01v8 ad=0.264 pd=1.93 as=0.496 ps=3.82 w=1.6 l=0.15
X35 vdd a_7025_284# a_9722_872# vdd sky130_fd_pr__pfet_01v8 ad=0.496 pd=3.82 as=0.264 ps=1.93 w=1.6 l=0.15
X36 vdd a_3264_n2290# a_4368_n2242# vdd sky130_fd_pr__pfet_01v8 ad=0.66 pd=4.33 as=0.66 ps=4.33 w=4 l=0.15
X37 vdd inp a_451_230# vss sky130_fd_pr__nfet_01v8_lvt ad=0.66 pd=4.33 as=0.66 ps=4.33 w=4 l=0.15
X38 a_945_n870# vbias vss vss sky130_fd_pr__nfet_01v8 ad=0.464 pd=3.49 as=0.464 ps=3.49 w=3.2 l=0.5
X39 a_7025_n716# a_6859_n2316# vss sky130_fd_pr__res_high_po_0p35 l=6
X40 a_3264_n2290# a_3264_n2290# vdd vdd sky130_fd_pr__pfet_01v8 ad=0.66 pd=4.33 as=0.66 ps=4.33 w=4 l=0.15
X41 a_9722_872# a_7025_284# vdd vdd sky130_fd_pr__pfet_01v8 ad=0.264 pd=1.93 as=0.264 ps=1.93 w=1.6 l=0.15
X42 vdd a_7025_284# a_9722_872# vdd sky130_fd_pr__pfet_01v8 ad=0.264 pd=1.93 as=0.264 ps=1.93 w=1.6 l=0.15
X43 a_11696_872# a_9722_872# a_11696_188# vss sky130_fd_pr__nfet_01v8 ad=0.2475 pd=1.83 as=0.465 ps=3.62 w=1.5 l=0.15
X44 a_11696_n1172# a_11114_n1192# vdd vdd sky130_fd_pr__pfet_01v8 ad=0.2475 pd=1.83 as=0.465 ps=3.62 w=1.5 l=0.15
X45 a_14928_n1232# a_12482_646# a_14928_n488# vss sky130_fd_pr__nfet_01v8 ad=0.198 pd=1.53 as=0.372 ps=3.02 w=1.2 l=0.15
X46 vdd a_11696_872# a_12482_n714# vdd sky130_fd_pr__pfet_01v8 ad=0.37125 pd=2.58 as=0.37125 ps=2.58 w=2.25 l=0.15
X47 vss a_11114_872# a_11696_188# vss sky130_fd_pr__nfet_01v8 ad=0.2475 pd=1.83 as=0.2475 ps=1.83 w=1.5 l=0.15
X48 a_11696_872# a_9722_872# a_11696_188# vss sky130_fd_pr__nfet_01v8 ad=0.465 pd=3.62 as=0.2475 ps=1.83 w=1.5 l=0.15
X49 vdd a_3264_n2290# a_3264_n2290# vdd sky130_fd_pr__pfet_01v8 ad=1.24 pd=8.62 as=0.66 ps=4.33 w=4 l=0.15
X50 a_4368_1442# a_3264_1394# vdd vdd sky130_fd_pr__pfet_01v8 ad=0.66 pd=4.33 as=1.24 ps=8.62 w=4 l=0.15
X51 a_12482_n714# a_11696_872# vdd vdd sky130_fd_pr__pfet_01v8 ad=0.37125 pd=2.58 as=0.6975 ps=5.12 w=2.25 l=0.15
X52 vdd a_11696_872# a_12482_n714# vdd sky130_fd_pr__pfet_01v8 ad=0.6975 pd=5.12 as=0.37125 ps=2.58 w=2.25 l=0.15
X53 a_10478_872# a_9722_872# vss vss sky130_fd_pr__nfet_01v8 ad=0.348 pd=2.98 as=0.348 ps=2.98 w=1.2 l=0.15
X54 a_11696_188# a_9722_872# a_11696_872# vss sky130_fd_pr__nfet_01v8 ad=0.2475 pd=1.83 as=0.2475 ps=1.83 w=1.5 l=0.15
X55 a_12482_n714# a_11696_872# a_12572_88# vss sky130_fd_pr__nfet_01v8 ad=0.62 pd=4.62 as=0.33 ps=2.33 w=2 l=0.15
X56 outn a_14928_n1232# vdd vdd sky130_fd_pr__pfet_01v8 ad=0.33 pd=2.33 as=0.62 ps=4.62 w=2 l=0.15
X57 a_11696_188# a_11114_872# vss vss sky130_fd_pr__nfet_01v8 ad=0.2475 pd=1.83 as=0.465 ps=3.62 w=1.5 l=0.15
X58 a_11114_n1192# a_10796_n1192# vss vss sky130_fd_pr__nfet_01v8 ad=0.348 pd=2.98 as=0.348 ps=2.98 w=1.2 l=0.15
X59 a_12482_n714# a_11696_872# vdd vdd sky130_fd_pr__pfet_01v8 ad=0.37125 pd=2.58 as=0.37125 ps=2.58 w=2.25 l=0.15
X60 vss a_6693_1884# a_7025_284# vss sky130_fd_pr__nfet_01v8 ad=0.33 pd=2.33 as=0.33 ps=2.33 w=2 l=0.15
X61 a_11696_188# a_11114_872# vss vss sky130_fd_pr__nfet_01v8 ad=0.465 pd=3.62 as=0.2475 ps=1.83 w=1.5 l=0.15
X62 a_451_n830# vbias vss vss sky130_fd_pr__nfet_01v8 ad=0.87 pd=6.58 as=0.87 ps=6.58 w=3 l=0.5
X63 a_11114_n1192# a_10796_n1192# vdd vdd sky130_fd_pr__pfet_01v8 ad=0.264 pd=1.93 as=0.496 ps=3.82 w=1.6 l=0.15
X64 a_9722_n1192# a_9722_872# vdd vdd sky130_fd_pr__pfet_01v8 ad=0.348 pd=2.98 as=0.348 ps=2.98 w=1.2 l=0.15
X65 vdd a_3264_n2290# a_4368_n2242# vdd sky130_fd_pr__pfet_01v8 ad=0.66 pd=4.33 as=0.66 ps=4.33 w=4 l=0.15
X66 vdd a_12482_n714# a_12482_646# vdd sky130_fd_pr__pfet_01v8 ad=0.37125 pd=2.58 as=0.37125 ps=2.58 w=2.25 l=0.15
X67 vdd a_7025_n716# a_9722_n1192# vdd sky130_fd_pr__pfet_01v8 ad=0.264 pd=1.93 as=0.264 ps=1.93 w=1.6 l=0.15
X68 vss vbias a_945_n870# vss sky130_fd_pr__nfet_01v8 ad=0.464 pd=3.49 as=0.464 ps=3.49 w=3.2 l=0.5
X69 a_945_n870# a_451_230# a_4368_n2242# vss sky130_fd_pr__nfet_01v8_lvt ad=1.24 pd=8.62 as=0.66 ps=4.33 w=4 l=0.15
X70 a_3264_n2290# a_451_n830# a_945_n870# vss sky130_fd_pr__nfet_01v8_lvt ad=0.66 pd=4.33 as=1.24 ps=8.62 w=4 l=0.15
X71 vdd a_3264_n2290# a_4368_n2242# vdd sky130_fd_pr__pfet_01v8 ad=1.24 pd=8.62 as=0.66 ps=4.33 w=4 l=0.15
X72 a_4368_n2242# a_3264_n2290# vdd vdd sky130_fd_pr__pfet_01v8 ad=0.66 pd=4.33 as=0.66 ps=4.33 w=4 l=0.15
X73 vdd inn a_451_n830# vss sky130_fd_pr__nfet_01v8_lvt ad=0.66 pd=4.33 as=0.66 ps=4.33 w=4 l=0.15
X74 a_12482_646# a_11696_n1172# a_12572_n488# vss sky130_fd_pr__nfet_01v8 ad=0.33 pd=2.33 as=0.62 ps=4.62 w=2 l=0.15
X75 a_3264_1394# a_3264_1394# vdd vdd sky130_fd_pr__pfet_01v8 ad=0.66 pd=4.33 as=0.66 ps=4.33 w=4 l=0.15
X76 vdd a_3264_n2290# a_3264_n2290# vdd sky130_fd_pr__pfet_01v8 ad=0.66 pd=4.33 as=0.66 ps=4.33 w=4 l=0.15
X77 vdd a_3264_1394# a_4368_1442# vdd sky130_fd_pr__pfet_01v8 ad=0.66 pd=4.33 as=0.66 ps=4.33 w=4 l=0.15
X78 vdd a_11114_n1192# a_11696_n1172# vdd sky130_fd_pr__pfet_01v8 ad=0.2475 pd=1.83 as=0.2475 ps=1.83 w=1.5 l=0.15
X79 a_451_n830# inn vdd vss sky130_fd_pr__nfet_01v8_lvt ad=1.24 pd=8.62 as=0.66 ps=4.33 w=4 l=0.15
X80 vdd inp a_451_230# vss sky130_fd_pr__nfet_01v8_lvt ad=0.66 pd=4.33 as=0.66 ps=4.33 w=4 l=0.15
X81 vss vbias a_945_230# vss sky130_fd_pr__nfet_01v8 ad=0.928 pd=6.98 as=0.464 ps=3.49 w=3.2 l=0.5
X82 vdd a_14928_n1232# outn vdd sky130_fd_pr__pfet_01v8 ad=0.33 pd=2.33 as=0.33 ps=2.33 w=2 l=0.15
X83 a_6859_1884# a_7025_284# vss sky130_fd_pr__res_high_po_0p35 l=6
X84 a_12482_646# a_11696_n1172# vdd vdd sky130_fd_pr__pfet_01v8 ad=0.37125 pd=2.58 as=0.6975 ps=5.12 w=2.25 l=0.15
X85 vdd a_10796_n1192# a_11114_n1192# vdd sky130_fd_pr__pfet_01v8 ad=0.496 pd=3.82 as=0.264 ps=1.93 w=1.6 l=0.15
X86 a_4368_n2242# a_3264_n2290# vdd vdd sky130_fd_pr__pfet_01v8 ad=0.66 pd=4.33 as=0.66 ps=4.33 w=4 l=0.15
X87 a_451_230# vbias vss vss sky130_fd_pr__nfet_01v8 ad=0.87 pd=6.58 as=0.87 ps=6.58 w=3 l=0.5
X88 vdd a_12482_646# a_12482_n714# vdd sky130_fd_pr__pfet_01v8 ad=0.37125 pd=2.58 as=0.37125 ps=2.58 w=2.25 l=0.15
X89 a_12572_88# a_12482_646# vss vss sky130_fd_pr__nfet_01v8 ad=0.33 pd=2.33 as=0.62 ps=4.62 w=2 l=0.15
X90 vdd a_3264_1394# a_3264_1394# vdd sky130_fd_pr__pfet_01v8 ad=1.24 pd=8.62 as=0.66 ps=4.33 w=4 l=0.15
X91 a_12482_n714# a_12482_646# vdd vdd sky130_fd_pr__pfet_01v8 ad=0.37125 pd=2.58 as=0.6975 ps=5.12 w=2.25 l=0.15
X92 a_9722_n1192# a_7025_n716# vdd vdd sky130_fd_pr__pfet_01v8 ad=0.264 pd=1.93 as=0.264 ps=1.93 w=1.6 l=0.15
X93 a_4368_1442# a_451_n830# a_945_230# vss sky130_fd_pr__nfet_01v8_lvt ad=0.66 pd=4.33 as=1.24 ps=8.62 w=4 l=0.15
X94 vdd a_12482_646# a_12482_n714# vdd sky130_fd_pr__pfet_01v8 ad=0.6975 pd=5.12 as=0.37125 ps=2.58 w=2.25 l=0.15
X95 a_7025_n716# a_6693_n2316# vss vss sky130_fd_pr__nfet_01v8 ad=0.62 pd=4.62 as=0.33 ps=2.33 w=2 l=0.15
X96 a_4368_1442# a_3264_1394# vdd vdd sky130_fd_pr__pfet_01v8 ad=0.66 pd=4.33 as=0.66 ps=4.33 w=4 l=0.15
X97 a_12482_n714# a_12482_646# vdd vdd sky130_fd_pr__pfet_01v8 ad=0.37125 pd=2.58 as=0.37125 ps=2.58 w=2.25 l=0.15
X98 a_945_n870# a_451_n830# a_3264_n2290# vss sky130_fd_pr__nfet_01v8_lvt ad=0.66 pd=4.33 as=0.66 ps=4.33 w=4 l=0.15
X99 vss a_12482_n714# a_12572_n488# vss sky130_fd_pr__nfet_01v8 ad=0.33 pd=2.33 as=0.33 ps=2.33 w=2 l=0.15
X100 a_4368_1442# a_451_n830# a_945_230# vss sky130_fd_pr__nfet_01v8_lvt ad=0.66 pd=4.33 as=0.66 ps=4.33 w=4 l=0.15
X101 vdd a_14610_872# a_14928_872# vdd sky130_fd_pr__pfet_01v8 ad=0.558 pd=4.22 as=0.297 ps=2.13 w=1.8 l=0.15
X102 vss a_14610_872# a_14928_248# vss sky130_fd_pr__nfet_01v8 ad=0.372 pd=3.02 as=0.198 ps=1.53 w=1.2 l=0.15
X103 a_451_n830# inn vdd vss sky130_fd_pr__nfet_01v8_lvt ad=0.66 pd=4.33 as=0.66 ps=4.33 w=4 l=0.15
X104 vdd a_9722_n1192# a_11696_n1172# vdd sky130_fd_pr__pfet_01v8 ad=0.2475 pd=1.83 as=0.2475 ps=1.83 w=1.5 l=0.15
X105 a_11696_n1172# a_9722_n1192# a_11696_n488# vss sky130_fd_pr__nfet_01v8 ad=0.2475 pd=1.83 as=0.465 ps=3.62 w=1.5 l=0.15
X106 a_11696_n488# a_11114_n1192# vss vss sky130_fd_pr__nfet_01v8 ad=0.465 pd=3.62 as=0.2475 ps=1.83 w=1.5 l=0.15
X107 a_451_230# inp vdd vss sky130_fd_pr__nfet_01v8_lvt ad=0.66 pd=4.33 as=0.66 ps=4.33 w=4 l=0.15
X108 a_945_230# a_451_n830# a_4368_1442# vss sky130_fd_pr__nfet_01v8_lvt ad=0.66 pd=4.33 as=0.66 ps=4.33 w=4 l=0.15
X109 a_14928_872# a_14610_872# vdd vdd sky130_fd_pr__pfet_01v8 ad=0.297 pd=2.13 as=0.558 ps=4.22 w=1.8 l=0.15
X110 vss vbias a_945_n870# vss sky130_fd_pr__nfet_01v8 ad=0.464 pd=3.49 as=0.464 ps=3.49 w=3.2 l=0.5
X111 a_945_n870# vbias vss vss sky130_fd_pr__nfet_01v8 ad=0.464 pd=3.49 as=0.464 ps=3.49 w=3.2 l=0.5
X112 a_14928_248# a_14610_872# vss vss sky130_fd_pr__nfet_01v8 ad=0.198 pd=1.53 as=0.372 ps=3.02 w=1.2 l=0.15
X113 a_945_230# a_451_n830# a_4368_1442# vss sky130_fd_pr__nfet_01v8_lvt ad=1.24 pd=8.62 as=0.66 ps=4.33 w=4 l=0.15
X114 vdd a_6693_n2316# a_7025_n716# vdd sky130_fd_pr__pfet_01v8 ad=0.297 pd=2.13 as=0.297 ps=2.13 w=1.8 l=0.15
X115 a_4368_n2242# a_451_230# a_945_n870# vss sky130_fd_pr__nfet_01v8_lvt ad=0.66 pd=4.33 as=1.24 ps=8.62 w=4 l=0.15
X116 a_14610_n1322# a_14196_n1352# vdd vdd sky130_fd_pr__pfet_01v8 ad=0.37125 pd=2.58 as=0.6975 ps=5.12 w=2.25 l=0.15
X117 a_7025_n716# a_6693_n2316# vdd vdd sky130_fd_pr__pfet_01v8 ad=0.297 pd=2.13 as=0.558 ps=4.22 w=1.8 l=0.15
X118 vss a_14928_872# outp vss sky130_fd_pr__nfet_01v8 ad=0.62 pd=4.62 as=0.33 ps=2.33 w=2 l=0.15
X119 vdd a_11696_n1172# a_12482_646# vdd sky130_fd_pr__pfet_01v8 ad=0.37125 pd=2.58 as=0.37125 ps=2.58 w=2.25 l=0.15
X120 vdd a_3264_1394# a_3264_1394# vdd sky130_fd_pr__pfet_01v8 ad=0.66 pd=4.33 as=0.66 ps=4.33 w=4 l=0.15
X121 a_945_230# a_451_230# a_3264_1394# vss sky130_fd_pr__nfet_01v8_lvt ad=0.66 pd=4.33 as=0.66 ps=4.33 w=4 l=0.15
X122 vdd a_7025_n716# a_9722_n1192# vdd sky130_fd_pr__pfet_01v8 ad=0.496 pd=3.82 as=0.264 ps=1.93 w=1.6 l=0.15
X123 a_3264_1394# a_451_230# a_945_230# vss sky130_fd_pr__nfet_01v8_lvt ad=0.66 pd=4.33 as=1.24 ps=8.62 w=4 l=0.15
X124 a_945_230# a_451_230# a_3264_1394# vss sky130_fd_pr__nfet_01v8_lvt ad=1.24 pd=8.62 as=0.66 ps=4.33 w=4 l=0.15
X125 a_3264_1394# a_451_230# a_945_230# vss sky130_fd_pr__nfet_01v8_lvt ad=0.66 pd=4.33 as=0.66 ps=4.33 w=4 l=0.15
X126 a_11696_n1172# a_9722_n1192# vdd vdd sky130_fd_pr__pfet_01v8 ad=0.465 pd=3.62 as=0.2475 ps=1.83 w=1.5 l=0.15
X127 vdd a_6693_1884# a_7025_284# vdd sky130_fd_pr__pfet_01v8 ad=0.297 pd=2.13 as=0.297 ps=2.13 w=1.8 l=0.15
X128 a_9722_872# a_9722_n1192# vdd vdd sky130_fd_pr__pfet_01v8 ad=0.348 pd=2.98 as=0.348 ps=2.98 w=1.2 l=0.15
X129 a_14610_n1322# a_14196_n1352# vss vss sky130_fd_pr__nfet_01v8 ad=0.435 pd=3.58 as=0.435 ps=3.58 w=1.5 l=0.15
X130 vdd a_3264_1394# a_4368_1442# vdd sky130_fd_pr__pfet_01v8 ad=1.24 pd=8.62 as=0.66 ps=4.33 w=4 l=0.15
X131 a_945_230# vbias vss vss sky130_fd_pr__nfet_01v8 ad=0.464 pd=3.49 as=0.464 ps=3.49 w=3.2 l=0.5
X132 vdd a_6693_1884# a_7025_284# vdd sky130_fd_pr__pfet_01v8 ad=0.558 pd=4.22 as=0.297 ps=2.13 w=1.8 l=0.15
X133 a_10796_n1192# a_10478_n1192# vdd vdd sky130_fd_pr__pfet_01v8 ad=0.264 pd=1.93 as=0.496 ps=3.82 w=1.6 l=0.15
X134 vss a_12482_n714# a_14196_872# vss sky130_fd_pr__nfet_01v8 ad=0.372 pd=3.02 as=0.198 ps=1.53 w=1.2 l=0.15
X135 a_6693_n2316# a_4368_n2242# sky130_fd_pr__cap_mim_m3_1 l=5.5 w=9
X136 a_7025_284# a_6693_1884# vdd vdd sky130_fd_pr__pfet_01v8 ad=0.297 pd=2.13 as=0.297 ps=2.13 w=1.8 l=0.15
X137 a_14196_872# a_12482_n714# vss vss sky130_fd_pr__nfet_01v8 ad=0.198 pd=1.53 as=0.372 ps=3.02 w=1.2 l=0.15
X138 a_14928_n1232# a_14610_n1322# vdd vdd sky130_fd_pr__pfet_01v8 ad=0.297 pd=2.13 as=0.558 ps=4.22 w=1.8 l=0.15
X139 a_6693_n716# a_6859_n2316# vss sky130_fd_pr__res_high_po_0p35 l=6
X140 a_6693_n716# a_6693_n2316# vss sky130_fd_pr__res_high_po_0p35 l=6
X141 vss a_12482_646# a_14196_n1352# vss sky130_fd_pr__nfet_01v8 ad=0.372 pd=3.02 as=0.198 ps=1.53 w=1.2 l=0.15
X142 a_12482_646# a_11696_n1172# a_12572_n488# vss sky130_fd_pr__nfet_01v8 ad=0.62 pd=4.62 as=0.33 ps=2.33 w=2 l=0.15
X143 a_945_230# vbias vss vss sky130_fd_pr__nfet_01v8 ad=0.464 pd=3.49 as=0.464 ps=3.49 w=3.2 l=0.5
X144 a_7025_284# a_6693_1884# vss vss sky130_fd_pr__nfet_01v8 ad=0.62 pd=4.62 as=0.33 ps=2.33 w=2 l=0.15
X145 a_9722_872# a_9722_n1192# vss vss sky130_fd_pr__nfet_01v8 ad=0.174 pd=1.78 as=0.174 ps=1.78 w=0.6 l=0.15
X146 a_14196_n1352# a_12482_646# vdd vdd sky130_fd_pr__pfet_01v8 ad=0.396 pd=2.73 as=0.744 ps=5.42 w=2.4 l=0.15
X147 a_12572_88# a_12482_646# vss vss sky130_fd_pr__nfet_01v8 ad=0.62 pd=4.62 as=0.33 ps=2.33 w=2 l=0.15
X148 vdd a_3264_1394# a_4368_1442# vdd sky130_fd_pr__pfet_01v8 ad=0.66 pd=4.33 as=0.66 ps=4.33 w=4 l=0.15
X149 a_14928_n1232# a_12482_646# vdd vdd sky130_fd_pr__pfet_01v8 ad=0.297 pd=2.13 as=0.558 ps=4.22 w=1.8 l=0.15
X150 a_12482_646# a_12482_n714# vdd vdd sky130_fd_pr__pfet_01v8 ad=0.37125 pd=2.58 as=0.37125 ps=2.58 w=2.25 l=0.15
X151 vdd inp a_451_230# vss sky130_fd_pr__nfet_01v8_lvt ad=0.66 pd=4.33 as=0.66 ps=4.33 w=4 l=0.15
X152 vdd a_10478_n1192# a_10796_n1192# vdd sky130_fd_pr__pfet_01v8 ad=0.496 pd=3.82 as=0.264 ps=1.93 w=1.6 l=0.15
X153 vdd a_12482_n714# a_14928_872# vdd sky130_fd_pr__pfet_01v8 ad=0.558 pd=4.22 as=0.297 ps=2.13 w=1.8 l=0.15
X154 a_14928_248# a_12482_n714# a_14928_872# vss sky130_fd_pr__nfet_01v8 ad=0.372 pd=3.02 as=0.198 ps=1.53 w=1.2 l=0.15
X155 a_6693_1884# a_6693_284# vss sky130_fd_pr__res_high_po_0p35 l=6
X156 a_14928_872# a_12482_n714# vdd vdd sky130_fd_pr__pfet_01v8 ad=0.297 pd=2.13 as=0.558 ps=4.22 w=1.8 l=0.15
X157 a_14928_872# a_12482_n714# a_14928_248# vss sky130_fd_pr__nfet_01v8 ad=0.198 pd=1.53 as=0.372 ps=3.02 w=1.2 l=0.15
X158 vdd a_14610_n1322# a_14928_n1232# vdd sky130_fd_pr__pfet_01v8 ad=0.558 pd=4.22 as=0.297 ps=2.13 w=1.8 l=0.15
X159 a_3264_n2290# a_3264_n2290# vdd vdd sky130_fd_pr__pfet_01v8 ad=0.66 pd=4.33 as=0.66 ps=4.33 w=4 l=0.15
X160 vss vbias a_945_230# vss sky130_fd_pr__nfet_01v8 ad=0.464 pd=3.49 as=0.464 ps=3.49 w=3.2 l=0.5
X161 a_11696_n1172# a_11114_n1192# vdd vdd sky130_fd_pr__pfet_01v8 ad=0.465 pd=3.62 as=0.2475 ps=1.83 w=1.5 l=0.15
X162 a_3264_1394# a_3264_1394# vdd vdd sky130_fd_pr__pfet_01v8 ad=0.66 pd=4.33 as=1.24 ps=8.62 w=4 l=0.15
X163 outn a_14928_n1232# vdd vdd sky130_fd_pr__pfet_01v8 ad=0.33 pd=2.33 as=0.33 ps=2.33 w=2 l=0.15
X164 a_10478_n1192# a_9722_n1192# vdd vdd sky130_fd_pr__pfet_01v8 ad=0.264 pd=1.93 as=0.496 ps=3.82 w=1.6 l=0.15
X165 vss a_14928_n1232# outn vss sky130_fd_pr__nfet_01v8 ad=0.62 pd=4.62 as=0.33 ps=2.33 w=2 l=0.15
X166 vdd a_12482_646# a_14196_n1352# vdd sky130_fd_pr__pfet_01v8 ad=0.396 pd=2.73 as=0.396 ps=2.73 w=2.4 l=0.15
X167 a_11114_872# a_10796_872# vss vss sky130_fd_pr__nfet_01v8 ad=0.348 pd=2.98 as=0.348 ps=2.98 w=1.2 l=0.15
X168 a_11696_n1172# a_9722_n1192# a_11696_n488# vss sky130_fd_pr__nfet_01v8 ad=0.465 pd=3.62 as=0.2475 ps=1.83 w=1.5 l=0.15
X169 a_451_230# inp vdd vss sky130_fd_pr__nfet_01v8_lvt ad=1.24 pd=8.62 as=0.66 ps=4.33 w=4 l=0.15
X170 vss vbias a_945_n870# vss sky130_fd_pr__nfet_01v8 ad=0.464 pd=3.49 as=0.464 ps=3.49 w=3.2 l=0.5
X171 vss a_14610_n1322# a_14928_n488# vss sky130_fd_pr__nfet_01v8 ad=0.372 pd=3.02 as=0.198 ps=1.53 w=1.2 l=0.15
X172 a_10796_n1192# a_10478_n1192# vss vss sky130_fd_pr__nfet_01v8 ad=0.348 pd=2.98 as=0.348 ps=2.98 w=1.2 l=0.15
X173 a_945_230# vbias vss vss sky130_fd_pr__nfet_01v8 ad=0.464 pd=3.49 as=0.464 ps=3.49 w=3.2 l=0.5
X174 a_10796_872# a_10478_872# vss vss sky130_fd_pr__nfet_01v8 ad=0.348 pd=2.98 as=0.348 ps=2.98 w=1.2 l=0.15
X175 vss a_12482_646# a_12572_88# vss sky130_fd_pr__nfet_01v8 ad=0.33 pd=2.33 as=0.33 ps=2.33 w=2 l=0.15
X176 vdd a_12482_646# a_14928_n1232# vdd sky130_fd_pr__pfet_01v8 ad=0.558 pd=4.22 as=0.297 ps=2.13 w=1.8 l=0.15
X177 vdd a_12482_n714# a_12482_646# vdd sky130_fd_pr__pfet_01v8 ad=0.6975 pd=5.12 as=0.37125 ps=2.58 w=2.25 l=0.15
X178 vdd a_3264_n2290# a_4368_n2242# vdd sky130_fd_pr__pfet_01v8 ad=0.66 pd=4.33 as=0.66 ps=4.33 w=4 l=0.15
X179 a_7025_n716# a_7025_284# vdd vdd sky130_fd_pr__pfet_01v8 ad=0.348 pd=2.98 as=0.348 ps=2.98 w=1.2 l=0.15
X180 a_3264_n2290# a_3264_n2290# vdd vdd sky130_fd_pr__pfet_01v8 ad=0.66 pd=4.33 as=1.24 ps=8.62 w=4 l=0.15
X181 a_7025_n716# a_7025_284# vss vss sky130_fd_pr__nfet_01v8 ad=0.174 pd=1.78 as=0.174 ps=1.78 w=0.6 l=0.15
X182 a_7025_n716# a_6693_n2316# vss vss sky130_fd_pr__nfet_01v8 ad=0.33 pd=2.33 as=0.62 ps=4.62 w=2 l=0.15
X183 a_945_n870# vbias vss vss sky130_fd_pr__nfet_01v8 ad=0.464 pd=3.49 as=0.464 ps=3.49 w=3.2 l=0.5
X184 vdd inn a_451_n830# vss sky130_fd_pr__nfet_01v8_lvt ad=0.66 pd=4.33 as=0.66 ps=4.33 w=4 l=0.15
X185 a_3264_n2290# a_451_n830# a_945_n870# vss sky130_fd_pr__nfet_01v8_lvt ad=0.66 pd=4.33 as=0.66 ps=4.33 w=4 l=0.15
X186 vdd a_3264_n2290# a_3264_n2290# vdd sky130_fd_pr__pfet_01v8 ad=0.66 pd=4.33 as=0.66 ps=4.33 w=4 l=0.15
X187 vdd a_3264_1394# a_3264_1394# vdd sky130_fd_pr__pfet_01v8 ad=0.66 pd=4.33 as=0.66 ps=4.33 w=4 l=0.15
X188 a_7025_284# a_6693_1884# vdd vdd sky130_fd_pr__pfet_01v8 ad=0.297 pd=2.13 as=0.558 ps=4.22 w=1.8 l=0.15
X189 a_10478_n1192# a_9722_n1192# vss vss sky130_fd_pr__nfet_01v8 ad=0.348 pd=2.98 as=0.348 ps=2.98 w=1.2 l=0.15
X190 vss vbias a_945_230# vss sky130_fd_pr__nfet_01v8 ad=0.464 pd=3.49 as=0.464 ps=3.49 w=3.2 l=0.5
X191 a_4368_1442# a_3264_1394# vdd vdd sky130_fd_pr__pfet_01v8 ad=0.66 pd=4.33 as=0.66 ps=4.33 w=4 l=0.15
X192 vdd a_9722_n1192# a_10478_n1192# vdd sky130_fd_pr__pfet_01v8 ad=0.496 pd=3.82 as=0.264 ps=1.93 w=1.6 l=0.15
X193 vdd a_14928_n1232# outn vdd sky130_fd_pr__pfet_01v8 ad=0.62 pd=4.62 as=0.33 ps=2.33 w=2 l=0.15
X194 a_451_230# inp vdd vss sky130_fd_pr__nfet_01v8_lvt ad=0.66 pd=4.33 as=0.66 ps=4.33 w=4 l=0.15
X195 a_945_230# vbias vss vss sky130_fd_pr__nfet_01v8 ad=0.464 pd=3.49 as=0.464 ps=3.49 w=3.2 l=0.5
X196 a_7025_n716# a_6693_n2316# vdd vdd sky130_fd_pr__pfet_01v8 ad=0.297 pd=2.13 as=0.297 ps=2.13 w=1.8 l=0.15
X197 a_14196_n1352# a_12482_646# vss vss sky130_fd_pr__nfet_01v8 ad=0.198 pd=1.53 as=0.372 ps=3.02 w=1.2 l=0.15
X198 a_945_n870# a_451_230# a_4368_n2242# vss sky130_fd_pr__nfet_01v8_lvt ad=0.66 pd=4.33 as=0.66 ps=4.33 w=4 l=0.15
X199 vdd a_14196_n1352# a_14610_n1322# vdd sky130_fd_pr__pfet_01v8 ad=0.6975 pd=5.12 as=0.37125 ps=2.58 w=2.25 l=0.15
X200 a_12482_646# a_11696_n1172# vdd vdd sky130_fd_pr__pfet_01v8 ad=0.37125 pd=2.58 as=0.37125 ps=2.58 w=2.25 l=0.15
X201 a_4368_n2242# a_3264_n2290# vdd vdd sky130_fd_pr__pfet_01v8 ad=0.66 pd=4.33 as=0.66 ps=4.33 w=4 l=0.15
X202 vdd inn a_451_n830# vss sky130_fd_pr__nfet_01v8_lvt ad=0.66 pd=4.33 as=1.24 ps=8.62 w=4 l=0.15
X203 a_945_230# vbias vss vss sky130_fd_pr__nfet_01v8 ad=0.464 pd=3.49 as=0.928 ps=6.98 w=3.2 l=0.5
X204 vdd a_3264_n2290# a_3264_n2290# vdd sky130_fd_pr__pfet_01v8 ad=0.66 pd=4.33 as=0.66 ps=4.33 w=4 l=0.15
X205 vdd a_9722_872# a_10478_872# vdd sky130_fd_pr__pfet_01v8 ad=0.496 pd=3.82 as=0.264 ps=1.93 w=1.6 l=0.15
X206 a_3264_1394# a_3264_1394# vdd vdd sky130_fd_pr__pfet_01v8 ad=0.66 pd=4.33 as=0.66 ps=4.33 w=4 l=0.15
X207 a_945_n870# a_451_n830# a_3264_n2290# vss sky130_fd_pr__nfet_01v8_lvt ad=1.24 pd=8.62 as=0.66 ps=4.33 w=4 l=0.15
X208 a_10478_872# a_9722_872# vdd vdd sky130_fd_pr__pfet_01v8 ad=0.264 pd=1.93 as=0.496 ps=3.82 w=1.6 l=0.15
X209 a_451_n830# inn vdd vss sky130_fd_pr__nfet_01v8_lvt ad=0.66 pd=4.33 as=0.66 ps=4.33 w=4 l=0.15
X210 vss a_6693_n2316# a_7025_n716# vss sky130_fd_pr__nfet_01v8 ad=0.33 pd=2.33 as=0.33 ps=2.33 w=2 l=0.15
X211 a_12572_n488# a_12482_n714# vss vss sky130_fd_pr__nfet_01v8 ad=0.33 pd=2.33 as=0.62 ps=4.62 w=2 l=0.15
X212 a_3264_n2290# a_3264_n2290# vdd vdd sky130_fd_pr__pfet_01v8 ad=0.66 pd=4.33 as=0.66 ps=4.33 w=4 l=0.15
X213 a_7025_284# a_7025_n716# vdd vdd sky130_fd_pr__pfet_01v8 ad=0.348 pd=2.98 as=0.348 ps=2.98 w=1.2 l=0.15
X214 vdd a_14928_872# outp vdd sky130_fd_pr__pfet_01v8 ad=0.33 pd=2.33 as=0.33 ps=2.33 w=2 l=0.15
X215 a_12572_88# a_11696_872# a_12482_n714# vss sky130_fd_pr__nfet_01v8 ad=0.33 pd=2.33 as=0.33 ps=2.33 w=2 l=0.15
X216 vss a_11114_n1192# a_11696_n488# vss sky130_fd_pr__nfet_01v8 ad=0.2475 pd=1.83 as=0.2475 ps=1.83 w=1.5 l=0.15
X217 outp a_14928_872# vdd vdd sky130_fd_pr__pfet_01v8 ad=0.33 pd=2.33 as=0.62 ps=4.62 w=2 l=0.15
X218 a_14610_872# a_14196_872# vss vss sky130_fd_pr__nfet_01v8 ad=0.435 pd=3.58 as=0.435 ps=3.58 w=1.5 l=0.15
X219 a_945_n870# vbias vss vss sky130_fd_pr__nfet_01v8 ad=0.464 pd=3.49 as=0.464 ps=3.49 w=3.2 l=0.5
X220 vss vbias a_945_n870# vss sky130_fd_pr__nfet_01v8 ad=0.928 pd=6.98 as=0.464 ps=3.49 w=3.2 l=0.5
X221 vdd a_14928_872# outp vdd sky130_fd_pr__pfet_01v8 ad=0.62 pd=4.62 as=0.33 ps=2.33 w=2 l=0.15
X222 vdd a_12482_n714# a_14196_872# vdd sky130_fd_pr__pfet_01v8 ad=0.396 pd=2.73 as=0.396 ps=2.73 w=2.4 l=0.15
X223 outp a_14928_872# vdd vdd sky130_fd_pr__pfet_01v8 ad=0.33 pd=2.33 as=0.33 ps=2.33 w=2 l=0.15
X224 vss a_7025_n716# a_9722_n1192# vss sky130_fd_pr__nfet_01v8 ad=0.558 pd=4.22 as=0.297 ps=2.13 w=1.8 l=0.15
X225 a_9722_n1192# a_7025_n716# vdd vdd sky130_fd_pr__pfet_01v8 ad=0.264 pd=1.93 as=0.496 ps=3.82 w=1.6 l=0.15
X226 vdd a_6693_n2316# a_7025_n716# vdd sky130_fd_pr__pfet_01v8 ad=0.558 pd=4.22 as=0.297 ps=2.13 w=1.8 l=0.15
X227 vss vbias a_945_230# vss sky130_fd_pr__nfet_01v8 ad=0.464 pd=3.49 as=0.464 ps=3.49 w=3.2 l=0.5
X228 a_14196_872# a_12482_n714# vdd vdd sky130_fd_pr__pfet_01v8 ad=0.396 pd=2.73 as=0.744 ps=5.42 w=2.4 l=0.15
X229 a_4368_n2242# a_451_230# a_945_n870# vss sky130_fd_pr__nfet_01v8_lvt ad=0.66 pd=4.33 as=0.66 ps=4.33 w=4 l=0.15
X230 vdd a_11696_n1172# a_12482_646# vdd sky130_fd_pr__pfet_01v8 ad=0.6975 pd=5.12 as=0.37125 ps=2.58 w=2.25 l=0.15
X231 a_11696_n488# a_9722_n1192# a_11696_n1172# vss sky130_fd_pr__nfet_01v8 ad=0.2475 pd=1.83 as=0.2475 ps=1.83 w=1.5 l=0.15
X232 a_14196_872# a_12482_n714# vdd vdd sky130_fd_pr__pfet_01v8 ad=0.744 pd=5.42 as=0.396 ps=2.73 w=2.4 l=0.15
X233 a_14928_n488# a_14610_n1322# vss vss sky130_fd_pr__nfet_01v8 ad=0.198 pd=1.53 as=0.372 ps=3.02 w=1.2 l=0.15
X234 a_451_n830# inn vdd vss sky130_fd_pr__nfet_01v8_lvt ad=0.66 pd=4.33 as=0.66 ps=4.33 w=4 l=0.15
X235 a_7025_284# a_7025_n716# vss vss sky130_fd_pr__nfet_01v8 ad=0.174 pd=1.78 as=0.174 ps=1.78 w=0.6 l=0.15
X236 a_6693_1884# a_4368_1442# sky130_fd_pr__cap_mim_m3_1 l=5.5 w=9
X237 vdd inn a_451_n830# vss sky130_fd_pr__nfet_01v8_lvt ad=0.66 pd=4.33 as=0.66 ps=4.33 w=4 l=0.15
X238 a_14928_n488# a_12482_646# a_14928_n1232# vss sky130_fd_pr__nfet_01v8 ad=0.372 pd=3.02 as=0.198 ps=1.53 w=1.2 l=0.15
X239 vss vbias a_945_230# vss sky130_fd_pr__nfet_01v8 ad=0.464 pd=3.49 as=0.464 ps=3.49 w=3.2 l=0.5
X240 a_3264_1394# a_3264_1394# vdd vdd sky130_fd_pr__pfet_01v8 ad=0.66 pd=4.33 as=0.66 ps=4.33 w=4 l=0.15
X241 a_12482_n714# a_11696_872# a_12572_88# vss sky130_fd_pr__nfet_01v8 ad=0.33 pd=2.33 as=0.62 ps=4.62 w=2 l=0.15
.ends
