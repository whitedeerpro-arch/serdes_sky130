* NGSPICE file created from serdes_cml_to_cmos_r5_pdk.ext - technology: sky130A

.subckt serdes_cml_to_cmos_r5_pdk inp inn outp outn vbias vdd vss
X0 vdd a_3264_1394# a_4368_1442# vdd sky130_fd_pr__pfet_01v8 ad=0.66 pd=4.33 as=0.66 ps=4.33 w=4 l=0.15
X1 a_6505_284# a_6173_1884# vdd vdd sky130_fd_pr__pfet_01v8 ad=0.4125 pd=2.83 as=0.775 ps=5.62 w=2.5 l=0.15
X2 vdd inp a_451_230# vss sky130_fd_pr__nfet_01v8_lvt ad=0.66 pd=4.33 as=1.24 ps=8.62 w=4 l=0.15
X3 outn a_9264_n1172# vss vss sky130_fd_pr__nfet_01v8 ad=0.264 pd=1.93 as=0.496 ps=3.82 w=1.6 l=0.15
X4 vdd a_3264_1394# a_3264_1394# vdd sky130_fd_pr__pfet_01v8 ad=0.66 pd=4.33 as=0.66 ps=4.33 w=4 l=0.15
X5 a_945_n870# vbias vss vss sky130_fd_pr__nfet_01v8 ad=0.464 pd=3.49 as=0.928 ps=6.98 w=3.2 l=0.5
X6 outn a_9264_n1172# vdd vdd sky130_fd_pr__pfet_01v8 ad=0.33 pd=2.33 as=0.33 ps=2.33 w=2 l=0.15
X7 a_4368_1442# a_3264_1394# vdd vdd sky130_fd_pr__pfet_01v8 ad=0.66 pd=4.33 as=0.66 ps=4.33 w=4 l=0.15
X8 vss vbias a_945_n870# vss sky130_fd_pr__nfet_01v8 ad=0.464 pd=3.49 as=0.464 ps=3.49 w=3.2 l=0.5
X9 a_451_230# inp vdd vss sky130_fd_pr__nfet_01v8_lvt ad=0.66 pd=4.33 as=0.66 ps=4.33 w=4 l=0.15
X10 vss a_6173_1884# a_6505_284# vss sky130_fd_pr__nfet_01v8_lvt ad=0.2475 pd=1.83 as=0.2475 ps=1.83 w=1.5 l=0.15
X11 a_6173_n2316# a_4368_n2242# sky130_fd_pr__cap_mim_m3_1 l=9.9 w=5
X12 a_4368_n2242# a_3264_n2290# vdd vdd sky130_fd_pr__pfet_01v8 ad=0.66 pd=4.33 as=1.24 ps=8.62 w=4 l=0.15
X13 a_6505_284# a_6173_1884# vss vss sky130_fd_pr__nfet_01v8_lvt ad=0.465 pd=3.62 as=0.2475 ps=1.83 w=1.5 l=0.15
X14 a_6339_1884# a_6173_284# vss sky130_fd_pr__res_high_po_0p35 l=6
X15 vss a_6505_n716# a_8738_n1192# vss sky130_fd_pr__nfet_01v8 ad=0.558 pd=4.22 as=0.297 ps=2.13 w=1.8 l=0.15
X16 vdd a_3264_n2290# a_4368_n2242# vdd sky130_fd_pr__pfet_01v8 ad=0.66 pd=4.33 as=0.66 ps=4.33 w=4 l=0.15
X17 vdd inp a_451_230# vss sky130_fd_pr__nfet_01v8_lvt ad=0.66 pd=4.33 as=0.66 ps=4.33 w=4 l=0.15
X18 a_3264_n2290# a_3264_n2290# vdd vdd sky130_fd_pr__pfet_01v8 ad=0.66 pd=4.33 as=0.66 ps=4.33 w=4 l=0.15
X19 a_945_n870# vbias vss vss sky130_fd_pr__nfet_01v8 ad=0.464 pd=3.49 as=0.464 ps=3.49 w=3.2 l=0.5
X20 a_9264_n1172# a_8738_n1192# vdd vdd sky130_fd_pr__pfet_01v8 ad=0.2475 pd=1.83 as=0.2475 ps=1.83 w=1.5 l=0.15
X21 vdd a_3264_n2290# a_3264_n2290# vdd sky130_fd_pr__pfet_01v8 ad=1.24 pd=8.62 as=0.66 ps=4.33 w=4 l=0.15
X22 a_4368_1442# a_3264_1394# vdd vdd sky130_fd_pr__pfet_01v8 ad=0.66 pd=4.33 as=1.24 ps=8.62 w=4 l=0.15
X23 a_8738_n1192# a_6505_n716# vdd vdd sky130_fd_pr__pfet_01v8 ad=0.264 pd=1.93 as=0.496 ps=3.82 w=1.6 l=0.15
X24 a_6505_n716# a_6339_n2316# vss sky130_fd_pr__res_high_po_0p35 l=6
X25 a_451_n830# vbias vss vss sky130_fd_pr__nfet_01v8 ad=0.87 pd=6.58 as=0.87 ps=6.58 w=3 l=0.5
X26 vdd a_6505_284# a_8738_872# vdd sky130_fd_pr__pfet_01v8 ad=0.496 pd=3.82 as=0.264 ps=1.93 w=1.6 l=0.15
X27 vdd a_3264_n2290# a_4368_n2242# vdd sky130_fd_pr__pfet_01v8 ad=0.66 pd=4.33 as=0.66 ps=4.33 w=4 l=0.15
X28 a_6505_n716# a_6505_284# vss vss sky130_fd_pr__nfet_01v8 ad=0.174 pd=1.78 as=0.174 ps=1.78 w=0.6 l=0.15
X29 vdd a_8738_872# a_9264_872# vdd sky130_fd_pr__pfet_01v8 ad=0.2475 pd=1.83 as=0.2475 ps=1.83 w=1.5 l=0.15
X30 vdd a_8738_872# a_9264_872# vdd sky130_fd_pr__pfet_01v8 ad=0.465 pd=3.62 as=0.2475 ps=1.83 w=1.5 l=0.15
X31 a_9264_872# a_8738_872# vdd vdd sky130_fd_pr__pfet_01v8 ad=0.2475 pd=1.83 as=0.465 ps=3.62 w=1.5 l=0.15
X32 a_945_n870# a_451_230# a_4368_n2242# vss sky130_fd_pr__nfet_01v8_lvt ad=1.24 pd=8.62 as=0.66 ps=4.33 w=4 l=0.15
X33 vss vbias a_945_n870# vss sky130_fd_pr__nfet_01v8 ad=0.464 pd=3.49 as=0.464 ps=3.49 w=3.2 l=0.5
X34 vdd a_3264_n2290# a_4368_n2242# vdd sky130_fd_pr__pfet_01v8 ad=1.24 pd=8.62 as=0.66 ps=4.33 w=4 l=0.15
X35 a_4368_n2242# a_3264_n2290# vdd vdd sky130_fd_pr__pfet_01v8 ad=0.66 pd=4.33 as=0.66 ps=4.33 w=4 l=0.15
X36 a_3264_n2290# a_451_n830# a_945_n870# vss sky130_fd_pr__nfet_01v8_lvt ad=0.66 pd=4.33 as=1.24 ps=8.62 w=4 l=0.15
X37 a_9264_872# a_8738_872# vdd vdd sky130_fd_pr__pfet_01v8 ad=0.2475 pd=1.83 as=0.2475 ps=1.83 w=1.5 l=0.15
X38 a_6505_n716# a_6173_n2316# vdd vdd sky130_fd_pr__pfet_01v8 ad=0.4125 pd=2.83 as=0.4125 ps=2.83 w=2.5 l=0.15
X39 vdd inn a_451_n830# vss sky130_fd_pr__nfet_01v8_lvt ad=0.66 pd=4.33 as=0.66 ps=4.33 w=4 l=0.15
X40 a_3264_1394# a_3264_1394# vdd vdd sky130_fd_pr__pfet_01v8 ad=0.66 pd=4.33 as=0.66 ps=4.33 w=4 l=0.15
X41 vdd a_3264_n2290# a_3264_n2290# vdd sky130_fd_pr__pfet_01v8 ad=0.66 pd=4.33 as=0.66 ps=4.33 w=4 l=0.15
X42 vdd a_3264_1394# a_4368_1442# vdd sky130_fd_pr__pfet_01v8 ad=0.66 pd=4.33 as=0.66 ps=4.33 w=4 l=0.15
X43 vdd a_8738_n1192# a_9264_n1172# vdd sky130_fd_pr__pfet_01v8 ad=0.465 pd=3.62 as=0.2475 ps=1.83 w=1.5 l=0.15
X44 a_451_n830# inn vdd vss sky130_fd_pr__nfet_01v8_lvt ad=1.24 pd=8.62 as=0.66 ps=4.33 w=4 l=0.15
X45 vdd inp a_451_230# vss sky130_fd_pr__nfet_01v8_lvt ad=0.66 pd=4.33 as=0.66 ps=4.33 w=4 l=0.15
X46 vss vbias a_945_230# vss sky130_fd_pr__nfet_01v8 ad=0.928 pd=6.98 as=0.464 ps=3.49 w=3.2 l=0.5
X47 vdd a_6505_n716# a_8738_n1192# vdd sky130_fd_pr__pfet_01v8 ad=0.264 pd=1.93 as=0.264 ps=1.93 w=1.6 l=0.15
X48 a_4368_n2242# a_3264_n2290# vdd vdd sky130_fd_pr__pfet_01v8 ad=0.66 pd=4.33 as=0.66 ps=4.33 w=4 l=0.15
X49 vss a_9264_872# outp vss sky130_fd_pr__nfet_01v8 ad=0.496 pd=3.82 as=0.264 ps=1.93 w=1.6 l=0.15
X50 a_451_230# vbias vss vss sky130_fd_pr__nfet_01v8 ad=0.87 pd=6.58 as=0.87 ps=6.58 w=3 l=0.5
X51 vdd a_3264_1394# a_3264_1394# vdd sky130_fd_pr__pfet_01v8 ad=1.24 pd=8.62 as=0.66 ps=4.33 w=4 l=0.15
X52 a_6173_1884# a_4368_1442# sky130_fd_pr__cap_mim_m3_1 l=9.9 w=5
X53 outp a_9264_872# vss vss sky130_fd_pr__nfet_01v8 ad=0.264 pd=1.93 as=0.496 ps=3.82 w=1.6 l=0.15
X54 a_4368_1442# a_451_n830# a_945_230# vss sky130_fd_pr__nfet_01v8_lvt ad=0.66 pd=4.33 as=1.24 ps=8.62 w=4 l=0.15
X55 a_9264_n1172# a_8738_n1192# vss vss sky130_fd_pr__nfet_01v8 ad=0.522 pd=4.18 as=0.522 ps=4.18 w=1.8 l=0.15
X56 a_8738_n1192# a_6505_n716# vss vss sky130_fd_pr__nfet_01v8 ad=0.297 pd=2.13 as=0.558 ps=4.22 w=1.8 l=0.15
X57 a_6505_284# a_6173_1884# vss vss sky130_fd_pr__nfet_01v8_lvt ad=0.2475 pd=1.83 as=0.465 ps=3.62 w=1.5 l=0.15
X58 a_4368_1442# a_3264_1394# vdd vdd sky130_fd_pr__pfet_01v8 ad=0.66 pd=4.33 as=0.66 ps=4.33 w=4 l=0.15
X59 a_6505_n716# a_6173_n2316# vss vss sky130_fd_pr__nfet_01v8_lvt ad=0.465 pd=3.62 as=0.2475 ps=1.83 w=1.5 l=0.15
X60 a_945_n870# a_451_n830# a_3264_n2290# vss sky130_fd_pr__nfet_01v8_lvt ad=0.66 pd=4.33 as=0.66 ps=4.33 w=4 l=0.15
X61 a_4368_1442# a_451_n830# a_945_230# vss sky130_fd_pr__nfet_01v8_lvt ad=0.66 pd=4.33 as=0.66 ps=4.33 w=4 l=0.15
X62 vdd a_6173_n2316# a_6505_n716# vdd sky130_fd_pr__pfet_01v8 ad=0.775 pd=5.62 as=0.4125 ps=2.83 w=2.5 l=0.15
X63 a_451_n830# inn vdd vss sky130_fd_pr__nfet_01v8_lvt ad=0.66 pd=4.33 as=0.66 ps=4.33 w=4 l=0.15
X64 vss a_6505_284# a_8738_872# vss sky130_fd_pr__nfet_01v8 ad=0.558 pd=4.22 as=0.297 ps=2.13 w=1.8 l=0.15
X65 a_451_230# inp vdd vss sky130_fd_pr__nfet_01v8_lvt ad=0.66 pd=4.33 as=0.66 ps=4.33 w=4 l=0.15
X66 a_945_230# a_451_n830# a_4368_1442# vss sky130_fd_pr__nfet_01v8_lvt ad=0.66 pd=4.33 as=0.66 ps=4.33 w=4 l=0.15
X67 a_945_n870# vbias vss vss sky130_fd_pr__nfet_01v8 ad=0.464 pd=3.49 as=0.464 ps=3.49 w=3.2 l=0.5
X68 vss vbias a_945_n870# vss sky130_fd_pr__nfet_01v8 ad=0.464 pd=3.49 as=0.464 ps=3.49 w=3.2 l=0.5
X69 a_8738_872# a_6505_284# vss vss sky130_fd_pr__nfet_01v8 ad=0.297 pd=2.13 as=0.558 ps=4.22 w=1.8 l=0.15
X70 a_945_230# a_451_n830# a_4368_1442# vss sky130_fd_pr__nfet_01v8_lvt ad=1.24 pd=8.62 as=0.66 ps=4.33 w=4 l=0.15
X71 vdd a_9264_n1172# outn vdd sky130_fd_pr__pfet_01v8 ad=0.62 pd=4.62 as=0.33 ps=2.33 w=2 l=0.15
X72 a_8738_n1192# a_6505_n716# vdd vdd sky130_fd_pr__pfet_01v8 ad=0.264 pd=1.93 as=0.264 ps=1.93 w=1.6 l=0.15
X73 a_6505_n716# a_6505_284# vdd vdd sky130_fd_pr__pfet_01v8 ad=0.348 pd=2.98 as=0.348 ps=2.98 w=1.2 l=0.15
X74 a_4368_n2242# a_451_230# a_945_n870# vss sky130_fd_pr__nfet_01v8_lvt ad=0.66 pd=4.33 as=1.24 ps=8.62 w=4 l=0.15
X75 vdd a_6505_n716# a_8738_n1192# vdd sky130_fd_pr__pfet_01v8 ad=0.496 pd=3.82 as=0.264 ps=1.93 w=1.6 l=0.15
X76 vdd a_3264_1394# a_3264_1394# vdd sky130_fd_pr__pfet_01v8 ad=0.66 pd=4.33 as=0.66 ps=4.33 w=4 l=0.15
X77 a_945_230# a_451_230# a_3264_1394# vss sky130_fd_pr__nfet_01v8_lvt ad=0.66 pd=4.33 as=0.66 ps=4.33 w=4 l=0.15
X78 a_8738_872# a_6505_284# vdd vdd sky130_fd_pr__pfet_01v8 ad=0.264 pd=1.93 as=0.264 ps=1.93 w=1.6 l=0.15
X79 a_3264_1394# a_451_230# a_945_230# vss sky130_fd_pr__nfet_01v8_lvt ad=0.66 pd=4.33 as=1.24 ps=8.62 w=4 l=0.15
X80 a_945_230# a_451_230# a_3264_1394# vss sky130_fd_pr__nfet_01v8_lvt ad=1.24 pd=8.62 as=0.66 ps=4.33 w=4 l=0.15
X81 vdd a_6505_284# a_8738_872# vdd sky130_fd_pr__pfet_01v8 ad=0.264 pd=1.93 as=0.264 ps=1.93 w=1.6 l=0.15
X82 a_6173_n716# a_6339_n2316# vss sky130_fd_pr__res_high_po_0p35 l=6
X83 a_3264_1394# a_451_230# a_945_230# vss sky130_fd_pr__nfet_01v8_lvt ad=0.66 pd=4.33 as=0.66 ps=4.33 w=4 l=0.15
X84 a_8738_872# a_6505_284# vdd vdd sky130_fd_pr__pfet_01v8 ad=0.264 pd=1.93 as=0.496 ps=3.82 w=1.6 l=0.15
X85 a_6173_n716# a_6173_n2316# vss sky130_fd_pr__res_high_po_0p35 l=6
X86 vdd a_3264_1394# a_4368_1442# vdd sky130_fd_pr__pfet_01v8 ad=1.24 pd=8.62 as=0.66 ps=4.33 w=4 l=0.15
X87 a_9264_n1172# a_9264_872# vdd vdd sky130_fd_pr__pfet_01v8 ad=0.29 pd=2.58 as=0.29 ps=2.58 w=1 l=0.15
X88 a_945_230# vbias vss vss sky130_fd_pr__nfet_01v8 ad=0.464 pd=3.49 as=0.464 ps=3.49 w=3.2 l=0.5
X89 a_9264_n1172# a_9264_872# vss vss sky130_fd_pr__nfet_01v8 ad=0.1218 pd=1.42 as=0.1218 ps=1.42 w=0.42 l=0.15
X90 outn a_9264_n1172# vdd vdd sky130_fd_pr__pfet_01v8 ad=0.33 pd=2.33 as=0.62 ps=4.62 w=2 l=0.15
X91 a_9264_872# a_8738_872# vss vss sky130_fd_pr__nfet_01v8 ad=0.522 pd=4.18 as=0.522 ps=4.18 w=1.8 l=0.15
X92 a_945_230# vbias vss vss sky130_fd_pr__nfet_01v8 ad=0.464 pd=3.49 as=0.464 ps=3.49 w=3.2 l=0.5
X93 a_6339_1884# a_6505_284# vss sky130_fd_pr__res_high_po_0p35 l=6
X94 vdd a_3264_1394# a_4368_1442# vdd sky130_fd_pr__pfet_01v8 ad=0.66 pd=4.33 as=0.66 ps=4.33 w=4 l=0.15
X95 a_9264_872# a_9264_n1172# vdd vdd sky130_fd_pr__pfet_01v8 ad=0.29 pd=2.58 as=0.29 ps=2.58 w=1 l=0.15
X96 vdd inp a_451_230# vss sky130_fd_pr__nfet_01v8_lvt ad=0.66 pd=4.33 as=0.66 ps=4.33 w=4 l=0.15
X97 a_6173_1884# a_6173_284# vss sky130_fd_pr__res_high_po_0p35 l=6
X98 a_3264_n2290# a_3264_n2290# vdd vdd sky130_fd_pr__pfet_01v8 ad=0.66 pd=4.33 as=0.66 ps=4.33 w=4 l=0.15
X99 vss vbias a_945_230# vss sky130_fd_pr__nfet_01v8 ad=0.464 pd=3.49 as=0.464 ps=3.49 w=3.2 l=0.5
X100 outp a_9264_872# vdd vdd sky130_fd_pr__pfet_01v8 ad=0.33 pd=2.33 as=0.33 ps=2.33 w=2 l=0.15
X101 vdd a_9264_872# outp vdd sky130_fd_pr__pfet_01v8 ad=0.33 pd=2.33 as=0.33 ps=2.33 w=2 l=0.15
X102 a_3264_1394# a_3264_1394# vdd vdd sky130_fd_pr__pfet_01v8 ad=0.66 pd=4.33 as=1.24 ps=8.62 w=4 l=0.15
X103 vdd a_9264_872# outp vdd sky130_fd_pr__pfet_01v8 ad=0.62 pd=4.62 as=0.33 ps=2.33 w=2 l=0.15
X104 a_451_230# inp vdd vss sky130_fd_pr__nfet_01v8_lvt ad=1.24 pd=8.62 as=0.66 ps=4.33 w=4 l=0.15
X105 vss vbias a_945_n870# vss sky130_fd_pr__nfet_01v8 ad=0.464 pd=3.49 as=0.464 ps=3.49 w=3.2 l=0.5
X106 a_945_230# vbias vss vss sky130_fd_pr__nfet_01v8 ad=0.464 pd=3.49 as=0.464 ps=3.49 w=3.2 l=0.5
X107 vdd a_3264_n2290# a_4368_n2242# vdd sky130_fd_pr__pfet_01v8 ad=0.66 pd=4.33 as=0.66 ps=4.33 w=4 l=0.15
X108 a_3264_n2290# a_3264_n2290# vdd vdd sky130_fd_pr__pfet_01v8 ad=0.66 pd=4.33 as=1.24 ps=8.62 w=4 l=0.15
X109 vdd a_6173_1884# a_6505_284# vdd sky130_fd_pr__pfet_01v8 ad=0.4125 pd=2.83 as=0.4125 ps=2.83 w=2.5 l=0.15
X110 a_9264_n1172# a_8738_n1192# vdd vdd sky130_fd_pr__pfet_01v8 ad=0.2475 pd=1.83 as=0.465 ps=3.62 w=1.5 l=0.15
X111 a_6505_n716# a_6173_n2316# vss vss sky130_fd_pr__nfet_01v8_lvt ad=0.2475 pd=1.83 as=0.465 ps=3.62 w=1.5 l=0.15
X112 a_3264_n2290# a_451_n830# a_945_n870# vss sky130_fd_pr__nfet_01v8_lvt ad=0.66 pd=4.33 as=0.66 ps=4.33 w=4 l=0.15
X113 vdd inn a_451_n830# vss sky130_fd_pr__nfet_01v8_lvt ad=0.66 pd=4.33 as=0.66 ps=4.33 w=4 l=0.15
X114 a_945_n870# vbias vss vss sky130_fd_pr__nfet_01v8 ad=0.464 pd=3.49 as=0.464 ps=3.49 w=3.2 l=0.5
X115 vdd a_3264_n2290# a_3264_n2290# vdd sky130_fd_pr__pfet_01v8 ad=0.66 pd=4.33 as=0.66 ps=4.33 w=4 l=0.15
X116 vdd a_6173_1884# a_6505_284# vdd sky130_fd_pr__pfet_01v8 ad=0.775 pd=5.62 as=0.4125 ps=2.83 w=2.5 l=0.15
X117 vdd a_3264_1394# a_3264_1394# vdd sky130_fd_pr__pfet_01v8 ad=0.66 pd=4.33 as=0.66 ps=4.33 w=4 l=0.15
X118 a_6505_284# a_6173_1884# vdd vdd sky130_fd_pr__pfet_01v8 ad=0.4125 pd=2.83 as=0.4125 ps=2.83 w=2.5 l=0.15
X119 vss vbias a_945_230# vss sky130_fd_pr__nfet_01v8 ad=0.464 pd=3.49 as=0.464 ps=3.49 w=3.2 l=0.5
X120 a_4368_1442# a_3264_1394# vdd vdd sky130_fd_pr__pfet_01v8 ad=0.66 pd=4.33 as=0.66 ps=4.33 w=4 l=0.15
X121 a_451_230# inp vdd vss sky130_fd_pr__nfet_01v8_lvt ad=0.66 pd=4.33 as=0.66 ps=4.33 w=4 l=0.15
X122 a_945_230# vbias vss vss sky130_fd_pr__nfet_01v8 ad=0.464 pd=3.49 as=0.464 ps=3.49 w=3.2 l=0.5
X123 a_945_n870# a_451_230# a_4368_n2242# vss sky130_fd_pr__nfet_01v8_lvt ad=0.66 pd=4.33 as=0.66 ps=4.33 w=4 l=0.15
X124 a_4368_n2242# a_3264_n2290# vdd vdd sky130_fd_pr__pfet_01v8 ad=0.66 pd=4.33 as=0.66 ps=4.33 w=4 l=0.15
X125 vss a_9264_n1172# outn vss sky130_fd_pr__nfet_01v8 ad=0.496 pd=3.82 as=0.264 ps=1.93 w=1.6 l=0.15
X126 vdd inn a_451_n830# vss sky130_fd_pr__nfet_01v8_lvt ad=0.66 pd=4.33 as=1.24 ps=8.62 w=4 l=0.15
X127 a_945_230# vbias vss vss sky130_fd_pr__nfet_01v8 ad=0.464 pd=3.49 as=0.928 ps=6.98 w=3.2 l=0.5
X128 vdd a_3264_n2290# a_3264_n2290# vdd sky130_fd_pr__pfet_01v8 ad=0.66 pd=4.33 as=0.66 ps=4.33 w=4 l=0.15
X129 a_3264_1394# a_3264_1394# vdd vdd sky130_fd_pr__pfet_01v8 ad=0.66 pd=4.33 as=0.66 ps=4.33 w=4 l=0.15
X130 vdd a_8738_n1192# a_9264_n1172# vdd sky130_fd_pr__pfet_01v8 ad=0.2475 pd=1.83 as=0.2475 ps=1.83 w=1.5 l=0.15
X131 a_945_n870# a_451_n830# a_3264_n2290# vss sky130_fd_pr__nfet_01v8_lvt ad=1.24 pd=8.62 as=0.66 ps=4.33 w=4 l=0.15
X132 a_451_n830# inn vdd vss sky130_fd_pr__nfet_01v8_lvt ad=0.66 pd=4.33 as=0.66 ps=4.33 w=4 l=0.15
X133 vss a_6173_n2316# a_6505_n716# vss sky130_fd_pr__nfet_01v8_lvt ad=0.2475 pd=1.83 as=0.2475 ps=1.83 w=1.5 l=0.15
X134 a_3264_n2290# a_3264_n2290# vdd vdd sky130_fd_pr__pfet_01v8 ad=0.66 pd=4.33 as=0.66 ps=4.33 w=4 l=0.15
X135 a_9264_872# a_9264_n1172# vss vss sky130_fd_pr__nfet_01v8 ad=0.1218 pd=1.42 as=0.1218 ps=1.42 w=0.42 l=0.15
X136 vss vbias a_945_n870# vss sky130_fd_pr__nfet_01v8 ad=0.928 pd=6.98 as=0.464 ps=3.49 w=3.2 l=0.5
X137 a_945_n870# vbias vss vss sky130_fd_pr__nfet_01v8 ad=0.464 pd=3.49 as=0.464 ps=3.49 w=3.2 l=0.5
X138 a_6505_284# a_6505_n716# vdd vdd sky130_fd_pr__pfet_01v8 ad=0.348 pd=2.98 as=0.348 ps=2.98 w=1.2 l=0.15
X139 vss vbias a_945_230# vss sky130_fd_pr__nfet_01v8 ad=0.464 pd=3.49 as=0.464 ps=3.49 w=3.2 l=0.5
X140 a_4368_n2242# a_451_230# a_945_n870# vss sky130_fd_pr__nfet_01v8_lvt ad=0.66 pd=4.33 as=0.66 ps=4.33 w=4 l=0.15
X141 outp a_9264_872# vdd vdd sky130_fd_pr__pfet_01v8 ad=0.33 pd=2.33 as=0.62 ps=4.62 w=2 l=0.15
X142 vdd a_6173_n2316# a_6505_n716# vdd sky130_fd_pr__pfet_01v8 ad=0.4125 pd=2.83 as=0.4125 ps=2.83 w=2.5 l=0.15
X143 a_6505_n716# a_6173_n2316# vdd vdd sky130_fd_pr__pfet_01v8 ad=0.4125 pd=2.83 as=0.775 ps=5.62 w=2.5 l=0.15
X144 a_451_n830# inn vdd vss sky130_fd_pr__nfet_01v8_lvt ad=0.66 pd=4.33 as=0.66 ps=4.33 w=4 l=0.15
X145 vdd inn a_451_n830# vss sky130_fd_pr__nfet_01v8_lvt ad=0.66 pd=4.33 as=0.66 ps=4.33 w=4 l=0.15
X146 a_6505_284# a_6505_n716# vss vss sky130_fd_pr__nfet_01v8 ad=0.174 pd=1.78 as=0.174 ps=1.78 w=0.6 l=0.15
X147 vdd a_9264_n1172# outn vdd sky130_fd_pr__pfet_01v8 ad=0.33 pd=2.33 as=0.33 ps=2.33 w=2 l=0.15
X148 vss vbias a_945_230# vss sky130_fd_pr__nfet_01v8 ad=0.464 pd=3.49 as=0.464 ps=3.49 w=3.2 l=0.5
X149 a_3264_1394# a_3264_1394# vdd vdd sky130_fd_pr__pfet_01v8 ad=0.66 pd=4.33 as=0.66 ps=4.33 w=4 l=0.15
.ends
