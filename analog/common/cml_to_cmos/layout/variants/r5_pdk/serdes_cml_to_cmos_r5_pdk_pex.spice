* NGSPICE file created from serdes_cml_to_cmos_r5_pdk.ext - technology: sky130A

.subckt serdes_cml_to_cmos_r5_pdk inp inn outp outn vbias vdd vss
X0 vdd a_3264_1394# a_4368_1442# vdd sky130_fd_pr__pfet_01v8 ad=0.66 pd=4.33 as=0.66 ps=4.33 w=4 l=0.15
X1 vdd inp a_451_230# vss sky130_fd_pr__nfet_01v8_lvt ad=0.66 pd=4.33 as=1.24 ps=8.62 w=4 l=0.15
X2 a_11696_n1172# a_9722_n1192# vdd vdd sky130_fd_pr__pfet_01v8 ad=0.2475 pd=1.83 as=0.465 ps=3.62 w=1.5 l=0.15
X3 a_14196_n1352# a_12482_646# vdd vdd sky130_fd_pr__pfet_01v8 ad=0.744 pd=5.42 as=0.396 ps=2.73 w=2.4 l=0.15
X4 vdd a_10796_872# a_11114_872# vdd sky130_fd_pr__pfet_01v8 ad=0.496 pd=3.82 as=0.264 ps=1.93 w=1.6 l=0.15
X5 a_12572_n488# a_11696_n1172# a_12482_646# vss sky130_fd_pr__nfet_01v8 ad=0.33 pd=2.33 as=0.33 ps=2.33 w=2 l=0.15
X6 vdd a_3264_1394# a_3264_1394# vdd sky130_fd_pr__pfet_01v8 ad=0.66 pd=4.33 as=0.66 ps=4.33 w=4 l=0.15
X7 a_11114_872# a_10796_872# vdd vdd sky130_fd_pr__pfet_01v8 ad=0.264 pd=1.93 as=0.496 ps=3.82 w=1.6 l=0.15
X8 vdd a_10478_872# a_10796_872# vdd sky130_fd_pr__pfet_01v8 ad=0.496 pd=3.82 as=0.264 ps=1.93 w=1.6 l=0.15
X9 a_945_n870# vbias vss vss sky130_fd_pr__nfet_01v8 ad=0.464 pd=3.49 as=0.928 ps=6.98 w=3.2 l=0.5
X10 a_4368_1442# a_3264_1394# vdd vdd sky130_fd_pr__pfet_01v8 ad=0.66 pd=4.33 as=0.66 ps=4.33 w=4 l=0.15
X11 a_10796_872# a_10478_872# vdd vdd sky130_fd_pr__pfet_01v8 ad=0.264 pd=1.93 as=0.496 ps=3.82 w=1.6 l=0.15
X12 a_11696_n488# a_11114_n1192# vss vss sky130_fd_pr__nfet_01v8 ad=0.2475 pd=1.83 as=0.465 ps=3.62 w=1.5 l=0.15
X13 a_7025_284# a_6693_1884# vss vss sky130_fd_pr__nfet_01v8 ad=0.33 pd=2.33 as=0.62 ps=4.62 w=2 l=0.15
X14 vss vbias a_945_n870# vss sky130_fd_pr__nfet_01v8 ad=0.464 pd=3.49 as=0.464 ps=3.49 w=3.2 l=0.5
X15 a_451_230# inp vdd vss sky130_fd_pr__nfet_01v8_lvt ad=0.66 pd=4.33 as=0.66 ps=4.33 w=4 l=0.15
X16 outp a_14928_872# vss vss sky130_fd_pr__nfet_01v8 ad=0.33 pd=2.33 as=0.62 ps=4.62 w=2 l=0.15
X17 a_11696_872# a_9722_872# vdd vdd sky130_fd_pr__pfet_01v8 ad=0.2475 pd=1.83 as=0.465 ps=3.62 w=1.5 l=0.15
X18 vss a_7025_284# a_9722_872# vss sky130_fd_pr__nfet_01v8 ad=0.558 pd=4.22 as=0.297 ps=2.13 w=1.8 l=0.15
X19 a_9722_n1192# a_7025_n716# vss vss sky130_fd_pr__nfet_01v8 ad=0.297 pd=2.13 as=0.558 ps=4.22 w=1.8 l=0.15
X20 vdd a_11114_872# a_11696_872# vdd sky130_fd_pr__pfet_01v8 ad=0.2475 pd=1.83 as=0.2475 ps=1.83 w=1.5 l=0.15
X21 a_11696_872# a_9722_872# vdd vdd sky130_fd_pr__pfet_01v8 ad=0.465 pd=3.62 as=0.2475 ps=1.83 w=1.5 l=0.15
X22 a_14610_872# a_14196_872# vdd vdd sky130_fd_pr__pfet_01v8 ad=0.37125 pd=2.58 as=0.6975 ps=5.12 w=2.25 l=0.15
X23 a_9722_872# a_7025_284# vss vss sky130_fd_pr__nfet_01v8 ad=0.297 pd=2.13 as=0.558 ps=4.22 w=1.8 l=0.15
X24 vdd a_9722_872# a_11696_872# vdd sky130_fd_pr__pfet_01v8 ad=0.2475 pd=1.83 as=0.2475 ps=1.83 w=1.5 l=0.15
X25 a_6859_1884# a_6693_284# vss sky130_fd_pr__res_high_po_0p35 l=6
X26 a_11696_872# a_11114_872# vdd vdd sky130_fd_pr__pfet_01v8 ad=0.2475 pd=1.83 as=0.465 ps=3.62 w=1.5 l=0.15
X27 a_4368_n2242# a_3264_n2290# vdd vdd sky130_fd_pr__pfet_01v8 ad=0.66 pd=4.33 as=1.24 ps=8.62 w=4 l=0.15
X28 a_12482_646# a_12482_n714# vdd vdd sky130_fd_pr__pfet_01v8 ad=0.37125 pd=2.58 as=0.6975 ps=5.12 w=2.25 l=0.15
X29 a_11696_872# a_11114_872# vdd vdd sky130_fd_pr__pfet_01v8 ad=0.465 pd=3.62 as=0.2475 ps=1.83 w=1.5 l=0.15
X30 vdd a_14196_872# a_14610_872# vdd sky130_fd_pr__pfet_01v8 ad=0.6975 pd=5.12 as=0.37125 ps=2.58 w=2.25 l=0.15
X31 outn a_14928_n1232# vss vss sky130_fd_pr__nfet_01v8 ad=0.33 pd=2.33 as=0.62 ps=4.62 w=2 l=0.15
X32 a_9722_n1192# a_9722_872# vss vss sky130_fd_pr__nfet_01v8 ad=0.174 pd=1.78 as=0.174 ps=1.78 w=0.6 l=0.15
X33 a_12572_n488# a_12482_n714# vss vss sky130_fd_pr__nfet_01v8 ad=0.62 pd=4.62 as=0.33 ps=2.33 w=2 l=0.15
X34 a_9722_872# a_7025_284# vdd vdd sky130_fd_pr__pfet_01v8 ad=0.264 pd=1.93 as=0.496 ps=3.82 w=1.6 l=0.15
X35 vdd a_7025_284# a_9722_872# vdd sky130_fd_pr__pfet_01v8 ad=0.496 pd=3.82 as=0.264 ps=1.93 w=1.6 l=0.15
X36 vdd a_3264_n2290# a_4368_n2242# vdd sky130_fd_pr__pfet_01v8 ad=0.66 pd=4.33 as=0.66 ps=4.33 w=4 l=0.15
X37 vdd inp a_451_230# vss sky130_fd_pr__nfet_01v8_lvt ad=0.66 pd=4.33 as=0.66 ps=4.33 w=4 l=0.15
X38 a_945_n870# vbias vss vss sky130_fd_pr__nfet_01v8 ad=0.464 pd=3.49 as=0.464 ps=3.49 w=3.2 l=0.5
X39 a_7025_n716# a_6859_n2316# vss sky130_fd_pr__res_high_po_0p35 l=6
X40 a_3264_n2290# a_3264_n2290# vdd vdd sky130_fd_pr__pfet_01v8 ad=0.66 pd=4.33 as=0.66 ps=4.33 w=4 l=0.15
X41 a_9722_872# a_7025_284# vdd vdd sky130_fd_pr__pfet_01v8 ad=0.264 pd=1.93 as=0.264 ps=1.93 w=1.6 l=0.15
X42 vdd a_7025_284# a_9722_872# vdd sky130_fd_pr__pfet_01v8 ad=0.264 pd=1.93 as=0.264 ps=1.93 w=1.6 l=0.15
X43 a_11696_872# a_9722_872# a_11696_188# vss sky130_fd_pr__nfet_01v8 ad=0.2475 pd=1.83 as=0.465 ps=3.62 w=1.5 l=0.15
X44 a_11696_n1172# a_11114_n1192# vdd vdd sky130_fd_pr__pfet_01v8 ad=0.2475 pd=1.83 as=0.465 ps=3.62 w=1.5 l=0.15
X45 a_14928_n1232# a_12482_646# a_14928_n488# vss sky130_fd_pr__nfet_01v8 ad=0.198 pd=1.53 as=0.372 ps=3.02 w=1.2 l=0.15
X46 vdd a_11696_872# a_12482_n714# vdd sky130_fd_pr__pfet_01v8 ad=0.37125 pd=2.58 as=0.37125 ps=2.58 w=2.25 l=0.15
X47 vss a_11114_872# a_11696_188# vss sky130_fd_pr__nfet_01v8 ad=0.2475 pd=1.83 as=0.2475 ps=1.83 w=1.5 l=0.15
X48 a_11696_872# a_9722_872# a_11696_188# vss sky130_fd_pr__nfet_01v8 ad=0.465 pd=3.62 as=0.2475 ps=1.83 w=1.5 l=0.15
X49 vdd a_3264_n2290# a_3264_n2290# vdd sky130_fd_pr__pfet_01v8 ad=1.24 pd=8.62 as=0.66 ps=4.33 w=4 l=0.15
X50 a_4368_1442# a_3264_1394# vdd vdd sky130_fd_pr__pfet_01v8 ad=0.66 pd=4.33 as=1.24 ps=8.62 w=4 l=0.15
X51 a_12482_n714# a_11696_872# vdd vdd sky130_fd_pr__pfet_01v8 ad=0.37125 pd=2.58 as=0.6975 ps=5.12 w=2.25 l=0.15
X52 vdd a_11696_872# a_12482_n714# vdd sky130_fd_pr__pfet_01v8 ad=0.6975 pd=5.12 as=0.37125 ps=2.58 w=2.25 l=0.15
X53 a_10478_872# a_9722_872# vss vss sky130_fd_pr__nfet_01v8 ad=0.348 pd=2.98 as=0.348 ps=2.98 w=1.2 l=0.15
X54 a_11696_188# a_9722_872# a_11696_872# vss sky130_fd_pr__nfet_01v8 ad=0.2475 pd=1.83 as=0.2475 ps=1.83 w=1.5 l=0.15
X55 a_12482_n714# a_11696_872# a_12572_88# vss sky130_fd_pr__nfet_01v8 ad=0.62 pd=4.62 as=0.33 ps=2.33 w=2 l=0.15
X56 outn a_14928_n1232# vdd vdd sky130_fd_pr__pfet_01v8 ad=0.33 pd=2.33 as=0.62 ps=4.62 w=2 l=0.15
X57 a_11696_188# a_11114_872# vss vss sky130_fd_pr__nfet_01v8 ad=0.2475 pd=1.83 as=0.465 ps=3.62 w=1.5 l=0.15
X58 a_11114_n1192# a_10796_n1192# vss vss sky130_fd_pr__nfet_01v8 ad=0.348 pd=2.98 as=0.348 ps=2.98 w=1.2 l=0.15
X59 a_12482_n714# a_11696_872# vdd vdd sky130_fd_pr__pfet_01v8 ad=0.37125 pd=2.58 as=0.37125 ps=2.58 w=2.25 l=0.15
X60 vss a_6693_1884# a_7025_284# vss sky130_fd_pr__nfet_01v8 ad=0.33 pd=2.33 as=0.33 ps=2.33 w=2 l=0.15
X61 a_11696_188# a_11114_872# vss vss sky130_fd_pr__nfet_01v8 ad=0.465 pd=3.62 as=0.2475 ps=1.83 w=1.5 l=0.15
X62 a_451_n830# vbias vss vss sky130_fd_pr__nfet_01v8 ad=0.87 pd=6.58 as=0.87 ps=6.58 w=3 l=0.5
X63 a_11114_n1192# a_10796_n1192# vdd vdd sky130_fd_pr__pfet_01v8 ad=0.264 pd=1.93 as=0.496 ps=3.82 w=1.6 l=0.15
X64 a_9722_n1192# a_9722_872# vdd vdd sky130_fd_pr__pfet_01v8 ad=0.348 pd=2.98 as=0.348 ps=2.98 w=1.2 l=0.15
X65 vdd a_3264_n2290# a_4368_n2242# vdd sky130_fd_pr__pfet_01v8 ad=0.66 pd=4.33 as=0.66 ps=4.33 w=4 l=0.15
X66 vdd a_12482_n714# a_12482_646# vdd sky130_fd_pr__pfet_01v8 ad=0.37125 pd=2.58 as=0.37125 ps=2.58 w=2.25 l=0.15
X67 vdd a_7025_n716# a_9722_n1192# vdd sky130_fd_pr__pfet_01v8 ad=0.264 pd=1.93 as=0.264 ps=1.93 w=1.6 l=0.15
X68 vss vbias a_945_n870# vss sky130_fd_pr__nfet_01v8 ad=0.464 pd=3.49 as=0.464 ps=3.49 w=3.2 l=0.5
X69 a_945_n870# a_451_230# a_4368_n2242# vss sky130_fd_pr__nfet_01v8_lvt ad=1.24 pd=8.62 as=0.66 ps=4.33 w=4 l=0.15
X70 a_3264_n2290# a_451_n830# a_945_n870# vss sky130_fd_pr__nfet_01v8_lvt ad=0.66 pd=4.33 as=1.24 ps=8.62 w=4 l=0.15
X71 vdd a_3264_n2290# a_4368_n2242# vdd sky130_fd_pr__pfet_01v8 ad=1.24 pd=8.62 as=0.66 ps=4.33 w=4 l=0.15
X72 a_4368_n2242# a_3264_n2290# vdd vdd sky130_fd_pr__pfet_01v8 ad=0.66 pd=4.33 as=0.66 ps=4.33 w=4 l=0.15
X73 vdd inn a_451_n830# vss sky130_fd_pr__nfet_01v8_lvt ad=0.66 pd=4.33 as=0.66 ps=4.33 w=4 l=0.15
X74 a_12482_646# a_11696_n1172# a_12572_n488# vss sky130_fd_pr__nfet_01v8 ad=0.33 pd=2.33 as=0.62 ps=4.62 w=2 l=0.15
X75 a_3264_1394# a_3264_1394# vdd vdd sky130_fd_pr__pfet_01v8 ad=0.66 pd=4.33 as=0.66 ps=4.33 w=4 l=0.15
X76 vdd a_3264_n2290# a_3264_n2290# vdd sky130_fd_pr__pfet_01v8 ad=0.66 pd=4.33 as=0.66 ps=4.33 w=4 l=0.15
X77 vdd a_3264_1394# a_4368_1442# vdd sky130_fd_pr__pfet_01v8 ad=0.66 pd=4.33 as=0.66 ps=4.33 w=4 l=0.15
X78 vdd a_11114_n1192# a_11696_n1172# vdd sky130_fd_pr__pfet_01v8 ad=0.2475 pd=1.83 as=0.2475 ps=1.83 w=1.5 l=0.15
X79 a_451_n830# inn vdd vss sky130_fd_pr__nfet_01v8_lvt ad=1.24 pd=8.62 as=0.66 ps=4.33 w=4 l=0.15
X80 vdd inp a_451_230# vss sky130_fd_pr__nfet_01v8_lvt ad=0.66 pd=4.33 as=0.66 ps=4.33 w=4 l=0.15
X81 vss vbias a_945_230# vss sky130_fd_pr__nfet_01v8 ad=0.928 pd=6.98 as=0.464 ps=3.49 w=3.2 l=0.5
X82 vdd a_14928_n1232# outn vdd sky130_fd_pr__pfet_01v8 ad=0.33 pd=2.33 as=0.33 ps=2.33 w=2 l=0.15
X83 a_6859_1884# a_7025_284# vss sky130_fd_pr__res_high_po_0p35 l=6
X84 a_12482_646# a_11696_n1172# vdd vdd sky130_fd_pr__pfet_01v8 ad=0.37125 pd=2.58 as=0.6975 ps=5.12 w=2.25 l=0.15
X85 vdd a_10796_n1192# a_11114_n1192# vdd sky130_fd_pr__pfet_01v8 ad=0.496 pd=3.82 as=0.264 ps=1.93 w=1.6 l=0.15
X86 a_4368_n2242# a_3264_n2290# vdd vdd sky130_fd_pr__pfet_01v8 ad=0.66 pd=4.33 as=0.66 ps=4.33 w=4 l=0.15
X87 a_451_230# vbias vss vss sky130_fd_pr__nfet_01v8 ad=0.87 pd=6.58 as=0.87 ps=6.58 w=3 l=0.5
X88 vdd a_12482_646# a_12482_n714# vdd sky130_fd_pr__pfet_01v8 ad=0.37125 pd=2.58 as=0.37125 ps=2.58 w=2.25 l=0.15
X89 a_12572_88# a_12482_646# vss vss sky130_fd_pr__nfet_01v8 ad=0.33 pd=2.33 as=0.62 ps=4.62 w=2 l=0.15
X90 vdd a_3264_1394# a_3264_1394# vdd sky130_fd_pr__pfet_01v8 ad=1.24 pd=8.62 as=0.66 ps=4.33 w=4 l=0.15
X91 a_12482_n714# a_12482_646# vdd vdd sky130_fd_pr__pfet_01v8 ad=0.37125 pd=2.58 as=0.6975 ps=5.12 w=2.25 l=0.15
X92 a_9722_n1192# a_7025_n716# vdd vdd sky130_fd_pr__pfet_01v8 ad=0.264 pd=1.93 as=0.264 ps=1.93 w=1.6 l=0.15
X93 a_4368_1442# a_451_n830# a_945_230# vss sky130_fd_pr__nfet_01v8_lvt ad=0.66 pd=4.33 as=1.24 ps=8.62 w=4 l=0.15
X94 vdd a_12482_646# a_12482_n714# vdd sky130_fd_pr__pfet_01v8 ad=0.6975 pd=5.12 as=0.37125 ps=2.58 w=2.25 l=0.15
X95 a_7025_n716# a_6693_n2316# vss vss sky130_fd_pr__nfet_01v8 ad=0.62 pd=4.62 as=0.33 ps=2.33 w=2 l=0.15
X96 a_4368_1442# a_3264_1394# vdd vdd sky130_fd_pr__pfet_01v8 ad=0.66 pd=4.33 as=0.66 ps=4.33 w=4 l=0.15
X97 a_12482_n714# a_12482_646# vdd vdd sky130_fd_pr__pfet_01v8 ad=0.37125 pd=2.58 as=0.37125 ps=2.58 w=2.25 l=0.15
X98 a_945_n870# a_451_n830# a_3264_n2290# vss sky130_fd_pr__nfet_01v8_lvt ad=0.66 pd=4.33 as=0.66 ps=4.33 w=4 l=0.15
X99 vss a_12482_n714# a_12572_n488# vss sky130_fd_pr__nfet_01v8 ad=0.33 pd=2.33 as=0.33 ps=2.33 w=2 l=0.15
X100 a_4368_1442# a_451_n830# a_945_230# vss sky130_fd_pr__nfet_01v8_lvt ad=0.66 pd=4.33 as=0.66 ps=4.33 w=4 l=0.15
X101 vdd a_14610_872# a_14928_872# vdd sky130_fd_pr__pfet_01v8 ad=0.558 pd=4.22 as=0.297 ps=2.13 w=1.8 l=0.15
X102 vss a_14610_872# a_14928_248# vss sky130_fd_pr__nfet_01v8 ad=0.372 pd=3.02 as=0.198 ps=1.53 w=1.2 l=0.15
X103 a_451_n830# inn vdd vss sky130_fd_pr__nfet_01v8_lvt ad=0.66 pd=4.33 as=0.66 ps=4.33 w=4 l=0.15
X104 vdd a_9722_n1192# a_11696_n1172# vdd sky130_fd_pr__pfet_01v8 ad=0.2475 pd=1.83 as=0.2475 ps=1.83 w=1.5 l=0.15
X105 a_11696_n1172# a_9722_n1192# a_11696_n488# vss sky130_fd_pr__nfet_01v8 ad=0.2475 pd=1.83 as=0.465 ps=3.62 w=1.5 l=0.15
X106 a_11696_n488# a_11114_n1192# vss vss sky130_fd_pr__nfet_01v8 ad=0.465 pd=3.62 as=0.2475 ps=1.83 w=1.5 l=0.15
X107 a_451_230# inp vdd vss sky130_fd_pr__nfet_01v8_lvt ad=0.66 pd=4.33 as=0.66 ps=4.33 w=4 l=0.15
X108 a_945_230# a_451_n830# a_4368_1442# vss sky130_fd_pr__nfet_01v8_lvt ad=0.66 pd=4.33 as=0.66 ps=4.33 w=4 l=0.15
X109 a_14928_872# a_14610_872# vdd vdd sky130_fd_pr__pfet_01v8 ad=0.297 pd=2.13 as=0.558 ps=4.22 w=1.8 l=0.15
X110 vss vbias a_945_n870# vss sky130_fd_pr__nfet_01v8 ad=0.464 pd=3.49 as=0.464 ps=3.49 w=3.2 l=0.5
X111 a_945_n870# vbias vss vss sky130_fd_pr__nfet_01v8 ad=0.464 pd=3.49 as=0.464 ps=3.49 w=3.2 l=0.5
X112 a_14928_248# a_14610_872# vss vss sky130_fd_pr__nfet_01v8 ad=0.198 pd=1.53 as=0.372 ps=3.02 w=1.2 l=0.15
X113 a_945_230# a_451_n830# a_4368_1442# vss sky130_fd_pr__nfet_01v8_lvt ad=1.24 pd=8.62 as=0.66 ps=4.33 w=4 l=0.15
X114 vdd a_6693_n2316# a_7025_n716# vdd sky130_fd_pr__pfet_01v8 ad=0.297 pd=2.13 as=0.297 ps=2.13 w=1.8 l=0.15
X115 a_4368_n2242# a_451_230# a_945_n870# vss sky130_fd_pr__nfet_01v8_lvt ad=0.66 pd=4.33 as=1.24 ps=8.62 w=4 l=0.15
X116 a_14610_n1322# a_14196_n1352# vdd vdd sky130_fd_pr__pfet_01v8 ad=0.37125 pd=2.58 as=0.6975 ps=5.12 w=2.25 l=0.15
X117 a_7025_n716# a_6693_n2316# vdd vdd sky130_fd_pr__pfet_01v8 ad=0.297 pd=2.13 as=0.558 ps=4.22 w=1.8 l=0.15
X118 vss a_14928_872# outp vss sky130_fd_pr__nfet_01v8 ad=0.62 pd=4.62 as=0.33 ps=2.33 w=2 l=0.15
X119 vdd a_11696_n1172# a_12482_646# vdd sky130_fd_pr__pfet_01v8 ad=0.37125 pd=2.58 as=0.37125 ps=2.58 w=2.25 l=0.15
X120 vdd a_3264_1394# a_3264_1394# vdd sky130_fd_pr__pfet_01v8 ad=0.66 pd=4.33 as=0.66 ps=4.33 w=4 l=0.15
X121 a_945_230# a_451_230# a_3264_1394# vss sky130_fd_pr__nfet_01v8_lvt ad=0.66 pd=4.33 as=0.66 ps=4.33 w=4 l=0.15
X122 vdd a_7025_n716# a_9722_n1192# vdd sky130_fd_pr__pfet_01v8 ad=0.496 pd=3.82 as=0.264 ps=1.93 w=1.6 l=0.15
X123 a_3264_1394# a_451_230# a_945_230# vss sky130_fd_pr__nfet_01v8_lvt ad=0.66 pd=4.33 as=1.24 ps=8.62 w=4 l=0.15
X124 a_945_230# a_451_230# a_3264_1394# vss sky130_fd_pr__nfet_01v8_lvt ad=1.24 pd=8.62 as=0.66 ps=4.33 w=4 l=0.15
X125 a_3264_1394# a_451_230# a_945_230# vss sky130_fd_pr__nfet_01v8_lvt ad=0.66 pd=4.33 as=0.66 ps=4.33 w=4 l=0.15
X126 a_11696_n1172# a_9722_n1192# vdd vdd sky130_fd_pr__pfet_01v8 ad=0.465 pd=3.62 as=0.2475 ps=1.83 w=1.5 l=0.15
X127 vdd a_6693_1884# a_7025_284# vdd sky130_fd_pr__pfet_01v8 ad=0.297 pd=2.13 as=0.297 ps=2.13 w=1.8 l=0.15
X128 a_9722_872# a_9722_n1192# vdd vdd sky130_fd_pr__pfet_01v8 ad=0.348 pd=2.98 as=0.348 ps=2.98 w=1.2 l=0.15
X129 a_14610_n1322# a_14196_n1352# vss vss sky130_fd_pr__nfet_01v8 ad=0.435 pd=3.58 as=0.435 ps=3.58 w=1.5 l=0.15
X130 vdd a_3264_1394# a_4368_1442# vdd sky130_fd_pr__pfet_01v8 ad=1.24 pd=8.62 as=0.66 ps=4.33 w=4 l=0.15
X131 a_945_230# vbias vss vss sky130_fd_pr__nfet_01v8 ad=0.464 pd=3.49 as=0.464 ps=3.49 w=3.2 l=0.5
X132 vdd a_6693_1884# a_7025_284# vdd sky130_fd_pr__pfet_01v8 ad=0.558 pd=4.22 as=0.297 ps=2.13 w=1.8 l=0.15
X133 a_10796_n1192# a_10478_n1192# vdd vdd sky130_fd_pr__pfet_01v8 ad=0.264 pd=1.93 as=0.496 ps=3.82 w=1.6 l=0.15
X134 vss a_12482_n714# a_14196_872# vss sky130_fd_pr__nfet_01v8 ad=0.372 pd=3.02 as=0.198 ps=1.53 w=1.2 l=0.15
X135 a_6693_n2316# a_4368_n2242# sky130_fd_pr__cap_mim_m3_1 l=5.5 w=9
X136 a_7025_284# a_6693_1884# vdd vdd sky130_fd_pr__pfet_01v8 ad=0.297 pd=2.13 as=0.297 ps=2.13 w=1.8 l=0.15
X137 a_14196_872# a_12482_n714# vss vss sky130_fd_pr__nfet_01v8 ad=0.198 pd=1.53 as=0.372 ps=3.02 w=1.2 l=0.15
X138 a_14928_n1232# a_14610_n1322# vdd vdd sky130_fd_pr__pfet_01v8 ad=0.297 pd=2.13 as=0.558 ps=4.22 w=1.8 l=0.15
X139 a_6693_n716# a_6859_n2316# vss sky130_fd_pr__res_high_po_0p35 l=6
X140 a_6693_n716# a_6693_n2316# vss sky130_fd_pr__res_high_po_0p35 l=6
X141 vss a_12482_646# a_14196_n1352# vss sky130_fd_pr__nfet_01v8 ad=0.372 pd=3.02 as=0.198 ps=1.53 w=1.2 l=0.15
X142 a_12482_646# a_11696_n1172# a_12572_n488# vss sky130_fd_pr__nfet_01v8 ad=0.62 pd=4.62 as=0.33 ps=2.33 w=2 l=0.15
X143 a_945_230# vbias vss vss sky130_fd_pr__nfet_01v8 ad=0.464 pd=3.49 as=0.464 ps=3.49 w=3.2 l=0.5
X144 a_7025_284# a_6693_1884# vss vss sky130_fd_pr__nfet_01v8 ad=0.62 pd=4.62 as=0.33 ps=2.33 w=2 l=0.15
X145 a_9722_872# a_9722_n1192# vss vss sky130_fd_pr__nfet_01v8 ad=0.174 pd=1.78 as=0.174 ps=1.78 w=0.6 l=0.15
X146 a_14196_n1352# a_12482_646# vdd vdd sky130_fd_pr__pfet_01v8 ad=0.396 pd=2.73 as=0.744 ps=5.42 w=2.4 l=0.15
X147 a_12572_88# a_12482_646# vss vss sky130_fd_pr__nfet_01v8 ad=0.62 pd=4.62 as=0.33 ps=2.33 w=2 l=0.15
X148 vdd a_3264_1394# a_4368_1442# vdd sky130_fd_pr__pfet_01v8 ad=0.66 pd=4.33 as=0.66 ps=4.33 w=4 l=0.15
X149 a_14928_n1232# a_12482_646# vdd vdd sky130_fd_pr__pfet_01v8 ad=0.297 pd=2.13 as=0.558 ps=4.22 w=1.8 l=0.15
X150 a_12482_646# a_12482_n714# vdd vdd sky130_fd_pr__pfet_01v8 ad=0.37125 pd=2.58 as=0.37125 ps=2.58 w=2.25 l=0.15
X151 vdd inp a_451_230# vss sky130_fd_pr__nfet_01v8_lvt ad=0.66 pd=4.33 as=0.66 ps=4.33 w=4 l=0.15
X152 vdd a_10478_n1192# a_10796_n1192# vdd sky130_fd_pr__pfet_01v8 ad=0.496 pd=3.82 as=0.264 ps=1.93 w=1.6 l=0.15
X153 vdd a_12482_n714# a_14928_872# vdd sky130_fd_pr__pfet_01v8 ad=0.558 pd=4.22 as=0.297 ps=2.13 w=1.8 l=0.15
X154 a_14928_248# a_12482_n714# a_14928_872# vss sky130_fd_pr__nfet_01v8 ad=0.372 pd=3.02 as=0.198 ps=1.53 w=1.2 l=0.15
X155 a_6693_1884# a_6693_284# vss sky130_fd_pr__res_high_po_0p35 l=6
X156 a_14928_872# a_12482_n714# vdd vdd sky130_fd_pr__pfet_01v8 ad=0.297 pd=2.13 as=0.558 ps=4.22 w=1.8 l=0.15
X157 a_14928_872# a_12482_n714# a_14928_248# vss sky130_fd_pr__nfet_01v8 ad=0.198 pd=1.53 as=0.372 ps=3.02 w=1.2 l=0.15
X158 vdd a_14610_n1322# a_14928_n1232# vdd sky130_fd_pr__pfet_01v8 ad=0.558 pd=4.22 as=0.297 ps=2.13 w=1.8 l=0.15
X159 a_3264_n2290# a_3264_n2290# vdd vdd sky130_fd_pr__pfet_01v8 ad=0.66 pd=4.33 as=0.66 ps=4.33 w=4 l=0.15
X160 vss vbias a_945_230# vss sky130_fd_pr__nfet_01v8 ad=0.464 pd=3.49 as=0.464 ps=3.49 w=3.2 l=0.5
X161 a_11696_n1172# a_11114_n1192# vdd vdd sky130_fd_pr__pfet_01v8 ad=0.465 pd=3.62 as=0.2475 ps=1.83 w=1.5 l=0.15
X162 a_3264_1394# a_3264_1394# vdd vdd sky130_fd_pr__pfet_01v8 ad=0.66 pd=4.33 as=1.24 ps=8.62 w=4 l=0.15
X163 outn a_14928_n1232# vdd vdd sky130_fd_pr__pfet_01v8 ad=0.33 pd=2.33 as=0.33 ps=2.33 w=2 l=0.15
X164 a_10478_n1192# a_9722_n1192# vdd vdd sky130_fd_pr__pfet_01v8 ad=0.264 pd=1.93 as=0.496 ps=3.82 w=1.6 l=0.15
X165 vss a_14928_n1232# outn vss sky130_fd_pr__nfet_01v8 ad=0.62 pd=4.62 as=0.33 ps=2.33 w=2 l=0.15
X166 vdd a_12482_646# a_14196_n1352# vdd sky130_fd_pr__pfet_01v8 ad=0.396 pd=2.73 as=0.396 ps=2.73 w=2.4 l=0.15
X167 a_11114_872# a_10796_872# vss vss sky130_fd_pr__nfet_01v8 ad=0.348 pd=2.98 as=0.348 ps=2.98 w=1.2 l=0.15
X168 a_11696_n1172# a_9722_n1192# a_11696_n488# vss sky130_fd_pr__nfet_01v8 ad=0.465 pd=3.62 as=0.2475 ps=1.83 w=1.5 l=0.15
X169 a_451_230# inp vdd vss sky130_fd_pr__nfet_01v8_lvt ad=1.24 pd=8.62 as=0.66 ps=4.33 w=4 l=0.15
X170 vss vbias a_945_n870# vss sky130_fd_pr__nfet_01v8 ad=0.464 pd=3.49 as=0.464 ps=3.49 w=3.2 l=0.5
X171 vss a_14610_n1322# a_14928_n488# vss sky130_fd_pr__nfet_01v8 ad=0.372 pd=3.02 as=0.198 ps=1.53 w=1.2 l=0.15
X172 a_10796_n1192# a_10478_n1192# vss vss sky130_fd_pr__nfet_01v8 ad=0.348 pd=2.98 as=0.348 ps=2.98 w=1.2 l=0.15
X173 a_945_230# vbias vss vss sky130_fd_pr__nfet_01v8 ad=0.464 pd=3.49 as=0.464 ps=3.49 w=3.2 l=0.5
X174 a_10796_872# a_10478_872# vss vss sky130_fd_pr__nfet_01v8 ad=0.348 pd=2.98 as=0.348 ps=2.98 w=1.2 l=0.15
X175 vss a_12482_646# a_12572_88# vss sky130_fd_pr__nfet_01v8 ad=0.33 pd=2.33 as=0.33 ps=2.33 w=2 l=0.15
X176 vdd a_12482_646# a_14928_n1232# vdd sky130_fd_pr__pfet_01v8 ad=0.558 pd=4.22 as=0.297 ps=2.13 w=1.8 l=0.15
X177 vdd a_12482_n714# a_12482_646# vdd sky130_fd_pr__pfet_01v8 ad=0.6975 pd=5.12 as=0.37125 ps=2.58 w=2.25 l=0.15
X178 vdd a_3264_n2290# a_4368_n2242# vdd sky130_fd_pr__pfet_01v8 ad=0.66 pd=4.33 as=0.66 ps=4.33 w=4 l=0.15
X179 a_7025_n716# a_7025_284# vdd vdd sky130_fd_pr__pfet_01v8 ad=0.348 pd=2.98 as=0.348 ps=2.98 w=1.2 l=0.15
X180 a_3264_n2290# a_3264_n2290# vdd vdd sky130_fd_pr__pfet_01v8 ad=0.66 pd=4.33 as=1.24 ps=8.62 w=4 l=0.15
X181 a_7025_n716# a_7025_284# vss vss sky130_fd_pr__nfet_01v8 ad=0.174 pd=1.78 as=0.174 ps=1.78 w=0.6 l=0.15
X182 a_7025_n716# a_6693_n2316# vss vss sky130_fd_pr__nfet_01v8 ad=0.33 pd=2.33 as=0.62 ps=4.62 w=2 l=0.15
X183 a_945_n870# vbias vss vss sky130_fd_pr__nfet_01v8 ad=0.464 pd=3.49 as=0.464 ps=3.49 w=3.2 l=0.5
X184 vdd inn a_451_n830# vss sky130_fd_pr__nfet_01v8_lvt ad=0.66 pd=4.33 as=0.66 ps=4.33 w=4 l=0.15
X185 a_3264_n2290# a_451_n830# a_945_n870# vss sky130_fd_pr__nfet_01v8_lvt ad=0.66 pd=4.33 as=0.66 ps=4.33 w=4 l=0.15
X186 vdd a_3264_n2290# a_3264_n2290# vdd sky130_fd_pr__pfet_01v8 ad=0.66 pd=4.33 as=0.66 ps=4.33 w=4 l=0.15
X187 vdd a_3264_1394# a_3264_1394# vdd sky130_fd_pr__pfet_01v8 ad=0.66 pd=4.33 as=0.66 ps=4.33 w=4 l=0.15
X188 a_7025_284# a_6693_1884# vdd vdd sky130_fd_pr__pfet_01v8 ad=0.297 pd=2.13 as=0.558 ps=4.22 w=1.8 l=0.15
X189 a_10478_n1192# a_9722_n1192# vss vss sky130_fd_pr__nfet_01v8 ad=0.348 pd=2.98 as=0.348 ps=2.98 w=1.2 l=0.15
X190 vss vbias a_945_230# vss sky130_fd_pr__nfet_01v8 ad=0.464 pd=3.49 as=0.464 ps=3.49 w=3.2 l=0.5
X191 a_4368_1442# a_3264_1394# vdd vdd sky130_fd_pr__pfet_01v8 ad=0.66 pd=4.33 as=0.66 ps=4.33 w=4 l=0.15
X192 vdd a_9722_n1192# a_10478_n1192# vdd sky130_fd_pr__pfet_01v8 ad=0.496 pd=3.82 as=0.264 ps=1.93 w=1.6 l=0.15
X193 vdd a_14928_n1232# outn vdd sky130_fd_pr__pfet_01v8 ad=0.62 pd=4.62 as=0.33 ps=2.33 w=2 l=0.15
X194 a_451_230# inp vdd vss sky130_fd_pr__nfet_01v8_lvt ad=0.66 pd=4.33 as=0.66 ps=4.33 w=4 l=0.15
X195 a_945_230# vbias vss vss sky130_fd_pr__nfet_01v8 ad=0.464 pd=3.49 as=0.464 ps=3.49 w=3.2 l=0.5
X196 a_7025_n716# a_6693_n2316# vdd vdd sky130_fd_pr__pfet_01v8 ad=0.297 pd=2.13 as=0.297 ps=2.13 w=1.8 l=0.15
X197 a_14196_n1352# a_12482_646# vss vss sky130_fd_pr__nfet_01v8 ad=0.198 pd=1.53 as=0.372 ps=3.02 w=1.2 l=0.15
X198 a_945_n870# a_451_230# a_4368_n2242# vss sky130_fd_pr__nfet_01v8_lvt ad=0.66 pd=4.33 as=0.66 ps=4.33 w=4 l=0.15
X199 vdd a_14196_n1352# a_14610_n1322# vdd sky130_fd_pr__pfet_01v8 ad=0.6975 pd=5.12 as=0.37125 ps=2.58 w=2.25 l=0.15
X200 a_12482_646# a_11696_n1172# vdd vdd sky130_fd_pr__pfet_01v8 ad=0.37125 pd=2.58 as=0.37125 ps=2.58 w=2.25 l=0.15
X201 a_4368_n2242# a_3264_n2290# vdd vdd sky130_fd_pr__pfet_01v8 ad=0.66 pd=4.33 as=0.66 ps=4.33 w=4 l=0.15
X202 vdd inn a_451_n830# vss sky130_fd_pr__nfet_01v8_lvt ad=0.66 pd=4.33 as=1.24 ps=8.62 w=4 l=0.15
X203 a_945_230# vbias vss vss sky130_fd_pr__nfet_01v8 ad=0.464 pd=3.49 as=0.928 ps=6.98 w=3.2 l=0.5
X204 vdd a_3264_n2290# a_3264_n2290# vdd sky130_fd_pr__pfet_01v8 ad=0.66 pd=4.33 as=0.66 ps=4.33 w=4 l=0.15
X205 vdd a_9722_872# a_10478_872# vdd sky130_fd_pr__pfet_01v8 ad=0.496 pd=3.82 as=0.264 ps=1.93 w=1.6 l=0.15
X206 a_3264_1394# a_3264_1394# vdd vdd sky130_fd_pr__pfet_01v8 ad=0.66 pd=4.33 as=0.66 ps=4.33 w=4 l=0.15
X207 a_945_n870# a_451_n830# a_3264_n2290# vss sky130_fd_pr__nfet_01v8_lvt ad=1.24 pd=8.62 as=0.66 ps=4.33 w=4 l=0.15
X208 a_10478_872# a_9722_872# vdd vdd sky130_fd_pr__pfet_01v8 ad=0.264 pd=1.93 as=0.496 ps=3.82 w=1.6 l=0.15
X209 a_451_n830# inn vdd vss sky130_fd_pr__nfet_01v8_lvt ad=0.66 pd=4.33 as=0.66 ps=4.33 w=4 l=0.15
X210 vss a_6693_n2316# a_7025_n716# vss sky130_fd_pr__nfet_01v8 ad=0.33 pd=2.33 as=0.33 ps=2.33 w=2 l=0.15
X211 a_12572_n488# a_12482_n714# vss vss sky130_fd_pr__nfet_01v8 ad=0.33 pd=2.33 as=0.62 ps=4.62 w=2 l=0.15
X212 a_3264_n2290# a_3264_n2290# vdd vdd sky130_fd_pr__pfet_01v8 ad=0.66 pd=4.33 as=0.66 ps=4.33 w=4 l=0.15
X213 a_7025_284# a_7025_n716# vdd vdd sky130_fd_pr__pfet_01v8 ad=0.348 pd=2.98 as=0.348 ps=2.98 w=1.2 l=0.15
X214 vdd a_14928_872# outp vdd sky130_fd_pr__pfet_01v8 ad=0.33 pd=2.33 as=0.33 ps=2.33 w=2 l=0.15
X215 a_12572_88# a_11696_872# a_12482_n714# vss sky130_fd_pr__nfet_01v8 ad=0.33 pd=2.33 as=0.33 ps=2.33 w=2 l=0.15
X216 vss a_11114_n1192# a_11696_n488# vss sky130_fd_pr__nfet_01v8 ad=0.2475 pd=1.83 as=0.2475 ps=1.83 w=1.5 l=0.15
X217 outp a_14928_872# vdd vdd sky130_fd_pr__pfet_01v8 ad=0.33 pd=2.33 as=0.62 ps=4.62 w=2 l=0.15
X218 a_14610_872# a_14196_872# vss vss sky130_fd_pr__nfet_01v8 ad=0.435 pd=3.58 as=0.435 ps=3.58 w=1.5 l=0.15
X219 a_945_n870# vbias vss vss sky130_fd_pr__nfet_01v8 ad=0.464 pd=3.49 as=0.464 ps=3.49 w=3.2 l=0.5
X220 vss vbias a_945_n870# vss sky130_fd_pr__nfet_01v8 ad=0.928 pd=6.98 as=0.464 ps=3.49 w=3.2 l=0.5
X221 vdd a_14928_872# outp vdd sky130_fd_pr__pfet_01v8 ad=0.62 pd=4.62 as=0.33 ps=2.33 w=2 l=0.15
X222 vdd a_12482_n714# a_14196_872# vdd sky130_fd_pr__pfet_01v8 ad=0.396 pd=2.73 as=0.396 ps=2.73 w=2.4 l=0.15
X223 outp a_14928_872# vdd vdd sky130_fd_pr__pfet_01v8 ad=0.33 pd=2.33 as=0.33 ps=2.33 w=2 l=0.15
X224 vss a_7025_n716# a_9722_n1192# vss sky130_fd_pr__nfet_01v8 ad=0.558 pd=4.22 as=0.297 ps=2.13 w=1.8 l=0.15
X225 a_9722_n1192# a_7025_n716# vdd vdd sky130_fd_pr__pfet_01v8 ad=0.264 pd=1.93 as=0.496 ps=3.82 w=1.6 l=0.15
X226 vdd a_6693_n2316# a_7025_n716# vdd sky130_fd_pr__pfet_01v8 ad=0.558 pd=4.22 as=0.297 ps=2.13 w=1.8 l=0.15
X227 vss vbias a_945_230# vss sky130_fd_pr__nfet_01v8 ad=0.464 pd=3.49 as=0.464 ps=3.49 w=3.2 l=0.5
X228 a_14196_872# a_12482_n714# vdd vdd sky130_fd_pr__pfet_01v8 ad=0.396 pd=2.73 as=0.744 ps=5.42 w=2.4 l=0.15
X229 a_4368_n2242# a_451_230# a_945_n870# vss sky130_fd_pr__nfet_01v8_lvt ad=0.66 pd=4.33 as=0.66 ps=4.33 w=4 l=0.15
X230 vdd a_11696_n1172# a_12482_646# vdd sky130_fd_pr__pfet_01v8 ad=0.6975 pd=5.12 as=0.37125 ps=2.58 w=2.25 l=0.15
X231 a_11696_n488# a_9722_n1192# a_11696_n1172# vss sky130_fd_pr__nfet_01v8 ad=0.2475 pd=1.83 as=0.2475 ps=1.83 w=1.5 l=0.15
X232 a_14196_872# a_12482_n714# vdd vdd sky130_fd_pr__pfet_01v8 ad=0.744 pd=5.42 as=0.396 ps=2.73 w=2.4 l=0.15
X233 a_14928_n488# a_14610_n1322# vss vss sky130_fd_pr__nfet_01v8 ad=0.198 pd=1.53 as=0.372 ps=3.02 w=1.2 l=0.15
X234 a_451_n830# inn vdd vss sky130_fd_pr__nfet_01v8_lvt ad=0.66 pd=4.33 as=0.66 ps=4.33 w=4 l=0.15
X235 a_7025_284# a_7025_n716# vss vss sky130_fd_pr__nfet_01v8 ad=0.174 pd=1.78 as=0.174 ps=1.78 w=0.6 l=0.15
X236 a_6693_1884# a_4368_1442# sky130_fd_pr__cap_mim_m3_1 l=5.5 w=9
X237 vdd inn a_451_n830# vss sky130_fd_pr__nfet_01v8_lvt ad=0.66 pd=4.33 as=0.66 ps=4.33 w=4 l=0.15
X238 a_14928_n488# a_12482_646# a_14928_n1232# vss sky130_fd_pr__nfet_01v8 ad=0.372 pd=3.02 as=0.198 ps=1.53 w=1.2 l=0.15
X239 vss vbias a_945_230# vss sky130_fd_pr__nfet_01v8 ad=0.464 pd=3.49 as=0.464 ps=3.49 w=3.2 l=0.5
X240 a_3264_1394# a_3264_1394# vdd vdd sky130_fd_pr__pfet_01v8 ad=0.66 pd=4.33 as=0.66 ps=4.33 w=4 l=0.15
X241 a_12482_n714# a_11696_872# a_12572_88# vss sky130_fd_pr__nfet_01v8 ad=0.33 pd=2.33 as=0.62 ps=4.62 w=2 l=0.15
C0 vdd a_6693_n2316# 1.09497f
C1 a_12482_n714# a_11696_188# 0
C2 a_9722_n1192# a_11696_n488# 0.08634f
C3 a_6693_1884# a_6693_284# 0.01689f
C4 a_12482_n714# a_11696_n1172# 0.23381f
C5 vdd a_945_n870# 0.01713f
C6 vdd a_12572_88# 0.02406f
C7 a_3264_n2290# a_945_230# 0
C8 a_7025_n716# a_4368_n2242# 0.77492f
C9 vbias a_3264_1394# 0
C10 a_14928_n488# a_14610_872# 0
C11 a_12482_n714# a_14928_n1232# 0
C12 a_11696_872# a_11114_872# 0.10077f
C13 a_11114_n1192# a_10796_n1192# 0.13869f
C14 a_11696_n1172# a_10478_n1192# 0
C15 a_12482_n714# a_9722_872# 0.00314f
C16 a_14610_n1322# a_14196_n1352# 0.16131f
C17 vdd a_9722_n1192# 1.94418f
C18 a_11696_n488# a_11114_n1192# 0.06647f
C19 a_6693_n2316# a_6693_n716# 0.01689f
C20 a_14928_248# a_14610_872# 0.03527f
C21 a_10478_n1192# a_9722_872# 0.01136f
C22 a_4368_1442# a_7025_n716# 0.0128f
C23 a_4368_n2242# a_451_n830# 0
C24 vdd a_14610_872# 0.71172f
C25 a_14928_n1232# a_11696_n1172# 0
C26 a_12482_n714# a_12482_646# 1.0292f
C27 a_11696_188# a_9722_872# 0.0877f
C28 a_451_230# a_3264_1394# 0.49802f
C29 a_12482_n714# a_14928_872# 0.19354f
C30 vdd a_6859_1884# 0.04713f
C31 a_12572_n488# a_9722_n1192# 0
C32 a_11696_n1172# a_9722_872# 0
C33 a_14610_n1322# a_14928_n488# 0.03527f
C34 a_12482_n714# a_14196_872# 0.28973f
C35 vdd a_11114_n1192# 0.72252f
C36 vdd a_3264_1394# 7.23511f
C37 a_10478_872# a_10796_872# 0.14978f
C38 a_7025_n716# a_10478_n1192# 0
C39 a_3264_n2290# inn 0.00302f
C40 a_3264_n2290# vbias 0
C41 a_12482_646# a_11696_n1172# 0.41872f
C42 a_4368_1442# a_451_n830# 0.50679f
C43 a_14610_n1322# a_14928_248# 0
C44 a_14610_n1322# outn 0
C45 a_14610_n1322# vdd 0.71185f
C46 a_12482_646# a_14928_n1232# 0.19416f
C47 a_14928_n1232# a_14928_872# 0.00506f
C48 a_12482_646# a_9722_872# 0.01665f
C49 a_7025_n716# a_9722_872# 0.01275f
C50 a_4368_1442# a_945_230# 0.72397f
C51 a_4368_1442# a_6693_284# 0.20733f
C52 a_451_230# a_3264_n2290# 0.38517f
C53 a_10796_872# a_9722_n1192# 0
C54 vdd a_7025_284# 1.60999f
C55 a_10478_872# a_9722_n1192# 0.00155f
C56 a_12482_646# a_14928_872# 0.00106f
C57 a_11696_872# vdd 1.57409f
C58 vdd a_6693_1884# 1.0953f
C59 outp outn 0.00563f
C60 vdd outp 0.78448f
C61 vdd a_3264_n2290# 7.23527f
C62 a_6693_n2316# a_9722_n1192# 0
C63 a_12482_n714# a_11114_872# 0
C64 a_12482_646# a_14196_872# 0.00815f
C65 a_14196_872# a_14928_872# 0.00388f
C66 a_10796_872# a_11114_n1192# 0
C67 a_11696_872# a_12572_n488# 0
C68 a_11696_188# a_11114_872# 0.06647f
C69 a_6859_n2316# a_4368_n2242# 0.00941f
C70 a_945_n870# a_3264_1394# 0
C71 a_451_230# a_4368_n2242# 0.50679f
C72 a_12482_n714# a_14196_n1352# 0.00236f
C73 a_11114_872# a_9722_872# 0.19996f
C74 vdd a_4368_n2242# 2.16698f
C75 a_9722_n1192# a_11114_n1192# 0.19566f
C76 a_11696_872# a_10796_872# 0
C77 a_10478_872# a_7025_284# 0
C78 a_12482_n714# a_14928_n488# 0
C79 a_14196_n1352# a_11696_n1172# 0
C80 a_12482_n714# a_11696_n488# 0
C81 a_4368_1442# a_451_230# 0
C82 a_7025_284# a_6693_n2316# 0.01208f
C83 a_10478_872# a_11696_872# 0
C84 a_10796_n1192# a_10478_n1192# 0.14978f
C85 a_14196_n1352# a_14928_n1232# 0.00388f
C86 a_6693_n2316# a_6693_1884# 0.17729f
C87 a_11696_n1172# a_10796_n1192# 0
C88 a_945_230# a_451_n830# 0.53334f
C89 a_11696_872# a_12572_88# 0.11317f
C90 vdd a_4368_1442# 2.16699f
C91 a_14610_n1322# a_14610_872# 0.00192f
C92 a_6693_n716# a_4368_n2242# 0.20733f
C93 a_12482_n714# a_14928_248# 0.08819f
C94 a_3264_n2290# a_945_n870# 0.73751f
C95 a_12482_n714# vdd 3.0533f
C96 a_11696_n488# a_11696_n1172# 0.22047f
C97 a_7025_284# a_9722_n1192# 0.10882f
C98 a_10796_n1192# a_9722_872# 0.00507f
C99 a_14928_n488# a_14928_n1232# 0.1257f
C100 a_12482_646# a_14196_n1352# 0.2948f
C101 a_11696_872# a_9722_n1192# 0
C102 a_6693_1884# a_9722_n1192# 0
C103 vdd a_10478_n1192# 0.55719f
C104 a_11696_n488# a_9722_872# 0.00154f
C105 a_12482_n714# a_12572_n488# 0.1171f
C106 a_11696_188# vdd 0.03218f
C107 a_7025_284# a_6859_1884# 0.00187f
C108 a_11696_872# a_14610_872# 0
C109 a_14196_n1352# a_14196_872# 0.00136f
C110 vdd a_11696_n1172# 1.57308f
C111 a_14610_872# outp 0
C112 inp a_945_230# 0.00108f
C113 a_6693_1884# a_6859_1884# 0.27608f
C114 outn a_14928_n1232# 0.24157f
C115 vdd a_14928_n1232# 1.21528f
C116 a_12482_646# a_14928_n488# 0.09032f
C117 a_7025_n716# a_6859_n2316# 0.00187f
C118 vdd a_9722_872# 1.96828f
C119 a_12572_n488# a_11696_n1172# 0.11317f
C120 a_6693_n2316# a_4368_n2242# 4.81879f
C121 inn a_451_n830# 0.90528f
C122 vbias a_451_n830# 0.63267f
C123 a_945_n870# a_4368_n2242# 0.72397f
C124 a_12482_646# a_14928_248# 0.00223f
C125 a_12482_646# outn 0.00152f
C126 a_14928_248# a_14928_872# 0.1257f
C127 a_12482_646# vdd 3.10543f
C128 outn a_14928_872# 0
C129 vdd a_14928_872# 1.21521f
C130 vdd a_7025_n716# 1.58629f
C131 vbias a_945_230# 1.11145f
C132 vdd a_14196_872# 0.98555f
C133 a_4368_1442# a_6693_n2316# 0.02434f
C134 a_451_230# a_451_n830# 1.09996f
C135 a_12482_646# a_12572_n488# 0.26191f
C136 a_10796_872# a_10478_n1192# 0
C137 a_7025_284# a_6693_1884# 0.52197f
C138 a_12482_n714# a_12572_88# 0.27423f
C139 inp vbias 0.2752f
C140 a_10478_872# a_10478_n1192# 0.00116f
C141 vdd a_451_n830# 1.77378f
C142 a_11114_872# a_10796_n1192# 0
C143 a_7025_n716# a_6693_n716# 0.17154f
C144 a_451_230# a_945_230# 0.69912f
C145 a_11114_872# a_11696_n488# 0
C146 a_10796_872# a_9722_872# 0.10919f
C147 a_12482_n714# a_9722_n1192# 0.01899f
C148 a_12572_88# a_11696_n1172# 0
C149 a_10478_872# a_9722_872# 0.27096f
C150 vdd a_945_230# 0.01713f
C151 inp a_451_230# 0.90528f
C152 a_4368_1442# a_6859_1884# 0.00941f
C153 a_12482_n714# a_14610_872# 0.10611f
C154 a_6693_n2316# a_9722_872# 0
C155 a_9722_n1192# a_10478_n1192# 0.25808f
C156 inn vbias 0.2752f
C157 a_11696_188# a_9722_n1192# 0
C158 a_12572_88# a_9722_872# 0
C159 a_4368_1442# a_3264_1394# 0.72243f
C160 vdd a_11114_872# 0.72252f
C161 inp vdd 0.98175f
C162 a_9722_n1192# a_11696_n1172# 0.26286f
C163 a_7025_284# a_4368_n2242# 0
C164 a_7025_n716# a_6693_n2316# 0.53855f
C165 a_12482_646# a_12572_88# 0.10478f
C166 a_4368_n2242# a_6693_1884# 0.02434f
C167 a_9722_n1192# a_9722_872# 0.69666f
C168 a_11114_n1192# a_10478_n1192# 0
C169 a_3264_n2290# a_4368_n2242# 0.72243f
C170 a_12482_n714# a_14610_n1322# 0
C171 a_11696_188# a_11114_n1192# 0
C172 a_451_230# vbias 0.81285f
C173 a_11696_n1172# a_11114_n1192# 0.10077f
C174 a_14196_n1352# outn 0
C175 vdd a_14196_n1352# 0.98576f
C176 a_12482_646# a_9722_n1192# 0
C177 a_7025_284# a_4368_1442# 0.76265f
C178 vdd inn 0.98175f
C179 a_7025_n716# a_9722_n1192# 0.30136f
C180 vdd vbias 0.04654f
C181 a_11114_n1192# a_9722_872# 0.00425f
C182 a_4368_1442# a_6693_1884# 4.81879f
C183 a_14610_n1322# a_11696_n1172# 0
C184 a_12482_646# a_14610_872# 0.00479f
C185 a_14610_872# a_14928_872# 0.07584f
C186 a_945_n870# a_451_n830# 0.70081f
C187 a_12482_n714# a_11696_872# 0.43157f
C188 vdd a_10796_n1192# 0.56532f
C189 a_12482_n714# outp 0.00152f
C190 a_14610_n1322# a_14928_n1232# 0.07584f
C191 vdd a_6859_n2316# 0.04713f
C192 a_14610_872# a_14196_872# 0.16131f
C193 vdd a_14928_n488# 0.02122f
C194 vdd a_11696_n488# 0.03218f
C195 a_12482_646# a_11114_n1192# 0
C196 a_10796_872# a_11114_872# 0.13869f
C197 vdd a_451_230# 1.82087f
C198 a_11696_188# a_11696_872# 0.22047f
C199 a_10478_872# a_11114_872# 0
C200 a_11696_872# a_11696_n1172# 0.00722f
C201 a_12482_646# a_14610_n1322# 0.10976f
C202 vdd a_14928_248# 0.02122f
C203 vdd outn 0.78447f
C204 a_7025_284# a_9722_872# 0.30932f
C205 outp a_14928_n1232# 0
C206 a_6859_n2316# a_6693_n716# 0.00166f
C207 a_11696_872# a_9722_872# 0.26384f
C208 a_14610_n1322# a_14196_872# 0
C209 a_6693_1884# a_9722_872# 0
C210 a_451_n830# a_3264_1394# 0.39422f
C211 a_4368_1442# a_4368_n2242# 0.24837f
C212 vdd a_12572_n488# 0.02406f
C213 a_11114_872# a_9722_n1192# 0
C214 a_7025_284# a_7025_n716# 0.72446f
C215 a_6693_284# a_6859_1884# 0.00166f
C216 a_12482_646# a_11696_872# 0.22122f
C217 a_11696_872# a_14928_872# 0
C218 a_7025_n716# a_6693_1884# 0.02661f
C219 outp a_14928_872# 0.24157f
C220 a_10796_872# a_10796_n1192# 0.00116f
C221 a_945_230# a_3264_1394# 0.73751f
C222 a_11696_872# a_14196_872# 0
C223 a_10478_872# a_10796_n1192# 0
C224 a_945_n870# inn 0.00108f
C225 a_945_n870# vbias 1.11145f
C226 outp a_14196_872# 0
C227 a_11114_872# a_11114_n1192# 0.00334f
C228 inp a_3264_1394# 0.00302f
C229 a_6859_n2316# a_6693_n2316# 0.27608f
C230 a_6693_1884# a_451_n830# 0
C231 a_3264_n2290# a_451_n830# 0.50683f
C232 a_451_230# a_6693_n2316# 0
C233 vdd a_10796_872# 0.56532f
C234 a_14196_n1352# a_14610_872# 0
C235 a_451_230# a_945_n870# 0.53165f
C236 a_10478_872# vdd 0.55719f
C237 a_9722_n1192# a_10796_n1192# 0.1041f
C238 a_7025_284# a_6693_284# 0.17154f
C239 outn vss 0.51842f
C240 inn vss 1.89695f
C241 outp vss 0.51842f
C242 vbias vss 10.7011f
C243 inp vss 1.89695f
C244 vdd vss 0.10718p
C245 a_14928_n488# vss 0.32581f
C246 a_14610_n1322# vss 0.45055f
C247 a_14196_n1352# vss 0.42982f
C248 a_14928_n1232# vss 0.46124f
C249 a_12572_n488# vss 0.61094f
C250 a_11696_n488# vss 0.42989f
C251 a_11696_n1172# vss 0.68451f
C252 a_11114_n1192# vss 0.67362f
C253 a_10796_n1192# vss 0.39507f
C254 a_10478_n1192# vss 0.39141f
C255 a_6859_n2316# vss 0.53648f
C256 a_6693_n2316# vss 2.3778f
C257 a_6693_n716# vss 0.55329f
C258 a_4368_n2242# vss 2.89527f
C259 a_3264_n2290# vss 0.466f
C260 a_945_n870# vss 2.55685f
C261 a_14928_248# vss 0.32577f
C262 a_12572_88# vss 0.61094f
C263 a_11696_188# vss 0.42989f
C264 a_14928_872# vss 0.46125f
C265 a_14610_872# vss 0.4505f
C266 a_14196_872# vss 0.42971f
C267 a_12482_n714# vss 2.4057f
C268 a_11696_872# vss 0.68298f
C269 a_12482_646# vss 2.44368f
C270 a_11114_872# vss 0.67423f
C271 a_9722_n1192# vss 1.89476f
C272 a_7025_n716# vss 2.88802f
C273 a_10796_872# vss 0.39525f
C274 a_10478_872# vss 0.39149f
C275 a_9722_872# vss 2.09383f
C276 a_7025_284# vss 2.88509f
C277 a_6859_1884# vss 0.53648f
C278 a_6693_284# vss 0.55329f
C279 a_451_n830# vss 5.14626f
C280 a_6693_1884# vss 2.37793f
C281 a_4368_1442# vss 2.89541f
C282 a_3264_1394# vss 0.46589f
C283 a_945_230# vss 2.55685f
C284 a_451_230# vss 5.15767f
.ends
