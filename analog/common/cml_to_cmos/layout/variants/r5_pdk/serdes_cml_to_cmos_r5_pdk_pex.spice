* NGSPICE file created from serdes_cml_to_cmos_r5_pdk.ext - technology: sky130A

.subckt serdes_cml_to_cmos_r5_pdk inp inn outp outn vbias vdd vss
X0 vdd a_3264_1394# a_4368_1442# vdd sky130_fd_pr__pfet_01v8 ad=0.66 pd=4.33 as=0.66 ps=4.33 w=4 l=0.15
X1 a_6505_284# a_6173_1884# vdd vdd sky130_fd_pr__pfet_01v8 ad=0.4125 pd=2.83 as=0.775 ps=5.62 w=2.5 l=0.15
X2 vdd inp a_451_230# vss sky130_fd_pr__nfet_01v8_lvt ad=0.66 pd=4.33 as=1.24 ps=8.62 w=4 l=0.15
X3 outn a_9264_n1172# vss vss sky130_fd_pr__nfet_01v8 ad=0.264 pd=1.93 as=0.496 ps=3.82 w=1.6 l=0.15
X4 vdd a_3264_1394# a_3264_1394# vdd sky130_fd_pr__pfet_01v8 ad=0.66 pd=4.33 as=0.66 ps=4.33 w=4 l=0.15
X5 a_945_n870# vbias vss vss sky130_fd_pr__nfet_01v8 ad=0.464 pd=3.49 as=0.928 ps=6.98 w=3.2 l=0.5
X6 outn a_9264_n1172# vdd vdd sky130_fd_pr__pfet_01v8 ad=0.33 pd=2.33 as=0.33 ps=2.33 w=2 l=0.15
X7 a_4368_1442# a_3264_1394# vdd vdd sky130_fd_pr__pfet_01v8 ad=0.66 pd=4.33 as=0.66 ps=4.33 w=4 l=0.15
X8 vss vbias a_945_n870# vss sky130_fd_pr__nfet_01v8 ad=0.464 pd=3.49 as=0.464 ps=3.49 w=3.2 l=0.5
X9 a_451_230# inp vdd vss sky130_fd_pr__nfet_01v8_lvt ad=0.66 pd=4.33 as=0.66 ps=4.33 w=4 l=0.15
X10 vss a_6173_1884# a_6505_284# vss sky130_fd_pr__nfet_01v8_lvt ad=0.2475 pd=1.83 as=0.2475 ps=1.83 w=1.5 l=0.15
X11 a_6173_n2316# a_4368_n2242# sky130_fd_pr__cap_mim_m3_1 l=9.9 w=5
X12 a_4368_n2242# a_3264_n2290# vdd vdd sky130_fd_pr__pfet_01v8 ad=0.66 pd=4.33 as=1.24 ps=8.62 w=4 l=0.15
X13 a_6505_284# a_6173_1884# vss vss sky130_fd_pr__nfet_01v8_lvt ad=0.465 pd=3.62 as=0.2475 ps=1.83 w=1.5 l=0.15
X14 a_6339_1884# a_6173_284# vss sky130_fd_pr__res_high_po_0p35 l=6
X15 vss a_6505_n716# a_8738_n1192# vss sky130_fd_pr__nfet_01v8 ad=0.558 pd=4.22 as=0.297 ps=2.13 w=1.8 l=0.15
X16 vdd a_3264_n2290# a_4368_n2242# vdd sky130_fd_pr__pfet_01v8 ad=0.66 pd=4.33 as=0.66 ps=4.33 w=4 l=0.15
X17 vdd inp a_451_230# vss sky130_fd_pr__nfet_01v8_lvt ad=0.66 pd=4.33 as=0.66 ps=4.33 w=4 l=0.15
X18 a_3264_n2290# a_3264_n2290# vdd vdd sky130_fd_pr__pfet_01v8 ad=0.66 pd=4.33 as=0.66 ps=4.33 w=4 l=0.15
X19 a_945_n870# vbias vss vss sky130_fd_pr__nfet_01v8 ad=0.464 pd=3.49 as=0.464 ps=3.49 w=3.2 l=0.5
X20 a_9264_n1172# a_8738_n1192# vdd vdd sky130_fd_pr__pfet_01v8 ad=0.2475 pd=1.83 as=0.2475 ps=1.83 w=1.5 l=0.15
X21 vdd a_3264_n2290# a_3264_n2290# vdd sky130_fd_pr__pfet_01v8 ad=1.24 pd=8.62 as=0.66 ps=4.33 w=4 l=0.15
X22 a_4368_1442# a_3264_1394# vdd vdd sky130_fd_pr__pfet_01v8 ad=0.66 pd=4.33 as=1.24 ps=8.62 w=4 l=0.15
X23 a_8738_n1192# a_6505_n716# vdd vdd sky130_fd_pr__pfet_01v8 ad=0.264 pd=1.93 as=0.496 ps=3.82 w=1.6 l=0.15
X24 a_6505_n716# a_6339_n2316# vss sky130_fd_pr__res_high_po_0p35 l=6
X25 a_451_n830# vbias vss vss sky130_fd_pr__nfet_01v8 ad=0.87 pd=6.58 as=0.87 ps=6.58 w=3 l=0.5
X26 vdd a_6505_284# a_8738_872# vdd sky130_fd_pr__pfet_01v8 ad=0.496 pd=3.82 as=0.264 ps=1.93 w=1.6 l=0.15
X27 vdd a_3264_n2290# a_4368_n2242# vdd sky130_fd_pr__pfet_01v8 ad=0.66 pd=4.33 as=0.66 ps=4.33 w=4 l=0.15
X28 a_6505_n716# a_6505_284# vss vss sky130_fd_pr__nfet_01v8 ad=0.174 pd=1.78 as=0.174 ps=1.78 w=0.6 l=0.15
X29 vdd a_8738_872# a_9264_872# vdd sky130_fd_pr__pfet_01v8 ad=0.2475 pd=1.83 as=0.2475 ps=1.83 w=1.5 l=0.15
X30 vdd a_8738_872# a_9264_872# vdd sky130_fd_pr__pfet_01v8 ad=0.465 pd=3.62 as=0.2475 ps=1.83 w=1.5 l=0.15
X31 a_9264_872# a_8738_872# vdd vdd sky130_fd_pr__pfet_01v8 ad=0.2475 pd=1.83 as=0.465 ps=3.62 w=1.5 l=0.15
X32 a_945_n870# a_451_230# a_4368_n2242# vss sky130_fd_pr__nfet_01v8_lvt ad=1.24 pd=8.62 as=0.66 ps=4.33 w=4 l=0.15
X33 vss vbias a_945_n870# vss sky130_fd_pr__nfet_01v8 ad=0.464 pd=3.49 as=0.464 ps=3.49 w=3.2 l=0.5
X34 vdd a_3264_n2290# a_4368_n2242# vdd sky130_fd_pr__pfet_01v8 ad=1.24 pd=8.62 as=0.66 ps=4.33 w=4 l=0.15
X35 a_4368_n2242# a_3264_n2290# vdd vdd sky130_fd_pr__pfet_01v8 ad=0.66 pd=4.33 as=0.66 ps=4.33 w=4 l=0.15
X36 a_3264_n2290# a_451_n830# a_945_n870# vss sky130_fd_pr__nfet_01v8_lvt ad=0.66 pd=4.33 as=1.24 ps=8.62 w=4 l=0.15
X37 a_9264_872# a_8738_872# vdd vdd sky130_fd_pr__pfet_01v8 ad=0.2475 pd=1.83 as=0.2475 ps=1.83 w=1.5 l=0.15
X38 a_6505_n716# a_6173_n2316# vdd vdd sky130_fd_pr__pfet_01v8 ad=0.4125 pd=2.83 as=0.4125 ps=2.83 w=2.5 l=0.15
X39 vdd inn a_451_n830# vss sky130_fd_pr__nfet_01v8_lvt ad=0.66 pd=4.33 as=0.66 ps=4.33 w=4 l=0.15
X40 a_3264_1394# a_3264_1394# vdd vdd sky130_fd_pr__pfet_01v8 ad=0.66 pd=4.33 as=0.66 ps=4.33 w=4 l=0.15
X41 vdd a_3264_n2290# a_3264_n2290# vdd sky130_fd_pr__pfet_01v8 ad=0.66 pd=4.33 as=0.66 ps=4.33 w=4 l=0.15
X42 vdd a_3264_1394# a_4368_1442# vdd sky130_fd_pr__pfet_01v8 ad=0.66 pd=4.33 as=0.66 ps=4.33 w=4 l=0.15
X43 vdd a_8738_n1192# a_9264_n1172# vdd sky130_fd_pr__pfet_01v8 ad=0.465 pd=3.62 as=0.2475 ps=1.83 w=1.5 l=0.15
X44 a_451_n830# inn vdd vss sky130_fd_pr__nfet_01v8_lvt ad=1.24 pd=8.62 as=0.66 ps=4.33 w=4 l=0.15
X45 vdd inp a_451_230# vss sky130_fd_pr__nfet_01v8_lvt ad=0.66 pd=4.33 as=0.66 ps=4.33 w=4 l=0.15
X46 vss vbias a_945_230# vss sky130_fd_pr__nfet_01v8 ad=0.928 pd=6.98 as=0.464 ps=3.49 w=3.2 l=0.5
X47 vdd a_6505_n716# a_8738_n1192# vdd sky130_fd_pr__pfet_01v8 ad=0.264 pd=1.93 as=0.264 ps=1.93 w=1.6 l=0.15
X48 a_4368_n2242# a_3264_n2290# vdd vdd sky130_fd_pr__pfet_01v8 ad=0.66 pd=4.33 as=0.66 ps=4.33 w=4 l=0.15
X49 vss a_9264_872# outp vss sky130_fd_pr__nfet_01v8 ad=0.496 pd=3.82 as=0.264 ps=1.93 w=1.6 l=0.15
X50 a_451_230# vbias vss vss sky130_fd_pr__nfet_01v8 ad=0.87 pd=6.58 as=0.87 ps=6.58 w=3 l=0.5
X51 vdd a_3264_1394# a_3264_1394# vdd sky130_fd_pr__pfet_01v8 ad=1.24 pd=8.62 as=0.66 ps=4.33 w=4 l=0.15
X52 a_6173_1884# a_4368_1442# sky130_fd_pr__cap_mim_m3_1 l=9.9 w=5
X53 outp a_9264_872# vss vss sky130_fd_pr__nfet_01v8 ad=0.264 pd=1.93 as=0.496 ps=3.82 w=1.6 l=0.15
X54 a_4368_1442# a_451_n830# a_945_230# vss sky130_fd_pr__nfet_01v8_lvt ad=0.66 pd=4.33 as=1.24 ps=8.62 w=4 l=0.15
X55 a_9264_n1172# a_8738_n1192# vss vss sky130_fd_pr__nfet_01v8 ad=0.522 pd=4.18 as=0.522 ps=4.18 w=1.8 l=0.15
X56 a_8738_n1192# a_6505_n716# vss vss sky130_fd_pr__nfet_01v8 ad=0.297 pd=2.13 as=0.558 ps=4.22 w=1.8 l=0.15
X57 a_6505_284# a_6173_1884# vss vss sky130_fd_pr__nfet_01v8_lvt ad=0.2475 pd=1.83 as=0.465 ps=3.62 w=1.5 l=0.15
X58 a_4368_1442# a_3264_1394# vdd vdd sky130_fd_pr__pfet_01v8 ad=0.66 pd=4.33 as=0.66 ps=4.33 w=4 l=0.15
X59 a_6505_n716# a_6173_n2316# vss vss sky130_fd_pr__nfet_01v8_lvt ad=0.465 pd=3.62 as=0.2475 ps=1.83 w=1.5 l=0.15
X60 a_945_n870# a_451_n830# a_3264_n2290# vss sky130_fd_pr__nfet_01v8_lvt ad=0.66 pd=4.33 as=0.66 ps=4.33 w=4 l=0.15
X61 a_4368_1442# a_451_n830# a_945_230# vss sky130_fd_pr__nfet_01v8_lvt ad=0.66 pd=4.33 as=0.66 ps=4.33 w=4 l=0.15
X62 vdd a_6173_n2316# a_6505_n716# vdd sky130_fd_pr__pfet_01v8 ad=0.775 pd=5.62 as=0.4125 ps=2.83 w=2.5 l=0.15
X63 a_451_n830# inn vdd vss sky130_fd_pr__nfet_01v8_lvt ad=0.66 pd=4.33 as=0.66 ps=4.33 w=4 l=0.15
X64 vss a_6505_284# a_8738_872# vss sky130_fd_pr__nfet_01v8 ad=0.558 pd=4.22 as=0.297 ps=2.13 w=1.8 l=0.15
X65 a_451_230# inp vdd vss sky130_fd_pr__nfet_01v8_lvt ad=0.66 pd=4.33 as=0.66 ps=4.33 w=4 l=0.15
X66 a_945_230# a_451_n830# a_4368_1442# vss sky130_fd_pr__nfet_01v8_lvt ad=0.66 pd=4.33 as=0.66 ps=4.33 w=4 l=0.15
X67 a_945_n870# vbias vss vss sky130_fd_pr__nfet_01v8 ad=0.464 pd=3.49 as=0.464 ps=3.49 w=3.2 l=0.5
X68 vss vbias a_945_n870# vss sky130_fd_pr__nfet_01v8 ad=0.464 pd=3.49 as=0.464 ps=3.49 w=3.2 l=0.5
X69 a_8738_872# a_6505_284# vss vss sky130_fd_pr__nfet_01v8 ad=0.297 pd=2.13 as=0.558 ps=4.22 w=1.8 l=0.15
X70 a_945_230# a_451_n830# a_4368_1442# vss sky130_fd_pr__nfet_01v8_lvt ad=1.24 pd=8.62 as=0.66 ps=4.33 w=4 l=0.15
X71 vdd a_9264_n1172# outn vdd sky130_fd_pr__pfet_01v8 ad=0.62 pd=4.62 as=0.33 ps=2.33 w=2 l=0.15
X72 a_8738_n1192# a_6505_n716# vdd vdd sky130_fd_pr__pfet_01v8 ad=0.264 pd=1.93 as=0.264 ps=1.93 w=1.6 l=0.15
X73 a_6505_n716# a_6505_284# vdd vdd sky130_fd_pr__pfet_01v8 ad=0.348 pd=2.98 as=0.348 ps=2.98 w=1.2 l=0.15
X74 a_4368_n2242# a_451_230# a_945_n870# vss sky130_fd_pr__nfet_01v8_lvt ad=0.66 pd=4.33 as=1.24 ps=8.62 w=4 l=0.15
X75 vdd a_6505_n716# a_8738_n1192# vdd sky130_fd_pr__pfet_01v8 ad=0.496 pd=3.82 as=0.264 ps=1.93 w=1.6 l=0.15
X76 vdd a_3264_1394# a_3264_1394# vdd sky130_fd_pr__pfet_01v8 ad=0.66 pd=4.33 as=0.66 ps=4.33 w=4 l=0.15
X77 a_945_230# a_451_230# a_3264_1394# vss sky130_fd_pr__nfet_01v8_lvt ad=0.66 pd=4.33 as=0.66 ps=4.33 w=4 l=0.15
X78 a_8738_872# a_6505_284# vdd vdd sky130_fd_pr__pfet_01v8 ad=0.264 pd=1.93 as=0.264 ps=1.93 w=1.6 l=0.15
X79 a_3264_1394# a_451_230# a_945_230# vss sky130_fd_pr__nfet_01v8_lvt ad=0.66 pd=4.33 as=1.24 ps=8.62 w=4 l=0.15
X80 a_945_230# a_451_230# a_3264_1394# vss sky130_fd_pr__nfet_01v8_lvt ad=1.24 pd=8.62 as=0.66 ps=4.33 w=4 l=0.15
X81 vdd a_6505_284# a_8738_872# vdd sky130_fd_pr__pfet_01v8 ad=0.264 pd=1.93 as=0.264 ps=1.93 w=1.6 l=0.15
X82 a_6173_n716# a_6339_n2316# vss sky130_fd_pr__res_high_po_0p35 l=6
X83 a_3264_1394# a_451_230# a_945_230# vss sky130_fd_pr__nfet_01v8_lvt ad=0.66 pd=4.33 as=0.66 ps=4.33 w=4 l=0.15
X84 a_8738_872# a_6505_284# vdd vdd sky130_fd_pr__pfet_01v8 ad=0.264 pd=1.93 as=0.496 ps=3.82 w=1.6 l=0.15
X85 a_6173_n716# a_6173_n2316# vss sky130_fd_pr__res_high_po_0p35 l=6
X86 vdd a_3264_1394# a_4368_1442# vdd sky130_fd_pr__pfet_01v8 ad=1.24 pd=8.62 as=0.66 ps=4.33 w=4 l=0.15
X87 a_9264_n1172# a_9264_872# vdd vdd sky130_fd_pr__pfet_01v8 ad=0.29 pd=2.58 as=0.29 ps=2.58 w=1 l=0.15
X88 a_945_230# vbias vss vss sky130_fd_pr__nfet_01v8 ad=0.464 pd=3.49 as=0.464 ps=3.49 w=3.2 l=0.5
X89 a_9264_n1172# a_9264_872# vss vss sky130_fd_pr__nfet_01v8 ad=0.1218 pd=1.42 as=0.1218 ps=1.42 w=0.42 l=0.15
X90 outn a_9264_n1172# vdd vdd sky130_fd_pr__pfet_01v8 ad=0.33 pd=2.33 as=0.62 ps=4.62 w=2 l=0.15
X91 a_9264_872# a_8738_872# vss vss sky130_fd_pr__nfet_01v8 ad=0.522 pd=4.18 as=0.522 ps=4.18 w=1.8 l=0.15
X92 a_945_230# vbias vss vss sky130_fd_pr__nfet_01v8 ad=0.464 pd=3.49 as=0.464 ps=3.49 w=3.2 l=0.5
X93 a_6339_1884# a_6505_284# vss sky130_fd_pr__res_high_po_0p35 l=6
X94 vdd a_3264_1394# a_4368_1442# vdd sky130_fd_pr__pfet_01v8 ad=0.66 pd=4.33 as=0.66 ps=4.33 w=4 l=0.15
X95 a_9264_872# a_9264_n1172# vdd vdd sky130_fd_pr__pfet_01v8 ad=0.29 pd=2.58 as=0.29 ps=2.58 w=1 l=0.15
X96 vdd inp a_451_230# vss sky130_fd_pr__nfet_01v8_lvt ad=0.66 pd=4.33 as=0.66 ps=4.33 w=4 l=0.15
X97 a_6173_1884# a_6173_284# vss sky130_fd_pr__res_high_po_0p35 l=6
X98 a_3264_n2290# a_3264_n2290# vdd vdd sky130_fd_pr__pfet_01v8 ad=0.66 pd=4.33 as=0.66 ps=4.33 w=4 l=0.15
X99 vss vbias a_945_230# vss sky130_fd_pr__nfet_01v8 ad=0.464 pd=3.49 as=0.464 ps=3.49 w=3.2 l=0.5
X100 outp a_9264_872# vdd vdd sky130_fd_pr__pfet_01v8 ad=0.33 pd=2.33 as=0.33 ps=2.33 w=2 l=0.15
X101 vdd a_9264_872# outp vdd sky130_fd_pr__pfet_01v8 ad=0.33 pd=2.33 as=0.33 ps=2.33 w=2 l=0.15
X102 a_3264_1394# a_3264_1394# vdd vdd sky130_fd_pr__pfet_01v8 ad=0.66 pd=4.33 as=1.24 ps=8.62 w=4 l=0.15
X103 vdd a_9264_872# outp vdd sky130_fd_pr__pfet_01v8 ad=0.62 pd=4.62 as=0.33 ps=2.33 w=2 l=0.15
X104 a_451_230# inp vdd vss sky130_fd_pr__nfet_01v8_lvt ad=1.24 pd=8.62 as=0.66 ps=4.33 w=4 l=0.15
X105 vss vbias a_945_n870# vss sky130_fd_pr__nfet_01v8 ad=0.464 pd=3.49 as=0.464 ps=3.49 w=3.2 l=0.5
X106 a_945_230# vbias vss vss sky130_fd_pr__nfet_01v8 ad=0.464 pd=3.49 as=0.464 ps=3.49 w=3.2 l=0.5
X107 vdd a_3264_n2290# a_4368_n2242# vdd sky130_fd_pr__pfet_01v8 ad=0.66 pd=4.33 as=0.66 ps=4.33 w=4 l=0.15
X108 a_3264_n2290# a_3264_n2290# vdd vdd sky130_fd_pr__pfet_01v8 ad=0.66 pd=4.33 as=1.24 ps=8.62 w=4 l=0.15
X109 vdd a_6173_1884# a_6505_284# vdd sky130_fd_pr__pfet_01v8 ad=0.4125 pd=2.83 as=0.4125 ps=2.83 w=2.5 l=0.15
X110 a_9264_n1172# a_8738_n1192# vdd vdd sky130_fd_pr__pfet_01v8 ad=0.2475 pd=1.83 as=0.465 ps=3.62 w=1.5 l=0.15
X111 a_6505_n716# a_6173_n2316# vss vss sky130_fd_pr__nfet_01v8_lvt ad=0.2475 pd=1.83 as=0.465 ps=3.62 w=1.5 l=0.15
X112 a_3264_n2290# a_451_n830# a_945_n870# vss sky130_fd_pr__nfet_01v8_lvt ad=0.66 pd=4.33 as=0.66 ps=4.33 w=4 l=0.15
X113 vdd inn a_451_n830# vss sky130_fd_pr__nfet_01v8_lvt ad=0.66 pd=4.33 as=0.66 ps=4.33 w=4 l=0.15
X114 a_945_n870# vbias vss vss sky130_fd_pr__nfet_01v8 ad=0.464 pd=3.49 as=0.464 ps=3.49 w=3.2 l=0.5
X115 vdd a_3264_n2290# a_3264_n2290# vdd sky130_fd_pr__pfet_01v8 ad=0.66 pd=4.33 as=0.66 ps=4.33 w=4 l=0.15
X116 vdd a_6173_1884# a_6505_284# vdd sky130_fd_pr__pfet_01v8 ad=0.775 pd=5.62 as=0.4125 ps=2.83 w=2.5 l=0.15
X117 vdd a_3264_1394# a_3264_1394# vdd sky130_fd_pr__pfet_01v8 ad=0.66 pd=4.33 as=0.66 ps=4.33 w=4 l=0.15
X118 a_6505_284# a_6173_1884# vdd vdd sky130_fd_pr__pfet_01v8 ad=0.4125 pd=2.83 as=0.4125 ps=2.83 w=2.5 l=0.15
X119 vss vbias a_945_230# vss sky130_fd_pr__nfet_01v8 ad=0.464 pd=3.49 as=0.464 ps=3.49 w=3.2 l=0.5
X120 a_4368_1442# a_3264_1394# vdd vdd sky130_fd_pr__pfet_01v8 ad=0.66 pd=4.33 as=0.66 ps=4.33 w=4 l=0.15
X121 a_451_230# inp vdd vss sky130_fd_pr__nfet_01v8_lvt ad=0.66 pd=4.33 as=0.66 ps=4.33 w=4 l=0.15
X122 a_945_230# vbias vss vss sky130_fd_pr__nfet_01v8 ad=0.464 pd=3.49 as=0.464 ps=3.49 w=3.2 l=0.5
X123 a_945_n870# a_451_230# a_4368_n2242# vss sky130_fd_pr__nfet_01v8_lvt ad=0.66 pd=4.33 as=0.66 ps=4.33 w=4 l=0.15
X124 a_4368_n2242# a_3264_n2290# vdd vdd sky130_fd_pr__pfet_01v8 ad=0.66 pd=4.33 as=0.66 ps=4.33 w=4 l=0.15
X125 vss a_9264_n1172# outn vss sky130_fd_pr__nfet_01v8 ad=0.496 pd=3.82 as=0.264 ps=1.93 w=1.6 l=0.15
X126 vdd inn a_451_n830# vss sky130_fd_pr__nfet_01v8_lvt ad=0.66 pd=4.33 as=1.24 ps=8.62 w=4 l=0.15
X127 a_945_230# vbias vss vss sky130_fd_pr__nfet_01v8 ad=0.464 pd=3.49 as=0.928 ps=6.98 w=3.2 l=0.5
X128 vdd a_3264_n2290# a_3264_n2290# vdd sky130_fd_pr__pfet_01v8 ad=0.66 pd=4.33 as=0.66 ps=4.33 w=4 l=0.15
X129 a_3264_1394# a_3264_1394# vdd vdd sky130_fd_pr__pfet_01v8 ad=0.66 pd=4.33 as=0.66 ps=4.33 w=4 l=0.15
X130 vdd a_8738_n1192# a_9264_n1172# vdd sky130_fd_pr__pfet_01v8 ad=0.2475 pd=1.83 as=0.2475 ps=1.83 w=1.5 l=0.15
X131 a_945_n870# a_451_n830# a_3264_n2290# vss sky130_fd_pr__nfet_01v8_lvt ad=1.24 pd=8.62 as=0.66 ps=4.33 w=4 l=0.15
X132 a_451_n830# inn vdd vss sky130_fd_pr__nfet_01v8_lvt ad=0.66 pd=4.33 as=0.66 ps=4.33 w=4 l=0.15
X133 vss a_6173_n2316# a_6505_n716# vss sky130_fd_pr__nfet_01v8_lvt ad=0.2475 pd=1.83 as=0.2475 ps=1.83 w=1.5 l=0.15
X134 a_3264_n2290# a_3264_n2290# vdd vdd sky130_fd_pr__pfet_01v8 ad=0.66 pd=4.33 as=0.66 ps=4.33 w=4 l=0.15
X135 a_9264_872# a_9264_n1172# vss vss sky130_fd_pr__nfet_01v8 ad=0.1218 pd=1.42 as=0.1218 ps=1.42 w=0.42 l=0.15
X136 vss vbias a_945_n870# vss sky130_fd_pr__nfet_01v8 ad=0.928 pd=6.98 as=0.464 ps=3.49 w=3.2 l=0.5
X137 a_945_n870# vbias vss vss sky130_fd_pr__nfet_01v8 ad=0.464 pd=3.49 as=0.464 ps=3.49 w=3.2 l=0.5
X138 a_6505_284# a_6505_n716# vdd vdd sky130_fd_pr__pfet_01v8 ad=0.348 pd=2.98 as=0.348 ps=2.98 w=1.2 l=0.15
X139 vss vbias a_945_230# vss sky130_fd_pr__nfet_01v8 ad=0.464 pd=3.49 as=0.464 ps=3.49 w=3.2 l=0.5
X140 a_4368_n2242# a_451_230# a_945_n870# vss sky130_fd_pr__nfet_01v8_lvt ad=0.66 pd=4.33 as=0.66 ps=4.33 w=4 l=0.15
X141 outp a_9264_872# vdd vdd sky130_fd_pr__pfet_01v8 ad=0.33 pd=2.33 as=0.62 ps=4.62 w=2 l=0.15
X142 vdd a_6173_n2316# a_6505_n716# vdd sky130_fd_pr__pfet_01v8 ad=0.4125 pd=2.83 as=0.4125 ps=2.83 w=2.5 l=0.15
X143 a_6505_n716# a_6173_n2316# vdd vdd sky130_fd_pr__pfet_01v8 ad=0.4125 pd=2.83 as=0.775 ps=5.62 w=2.5 l=0.15
X144 a_451_n830# inn vdd vss sky130_fd_pr__nfet_01v8_lvt ad=0.66 pd=4.33 as=0.66 ps=4.33 w=4 l=0.15
X145 vdd inn a_451_n830# vss sky130_fd_pr__nfet_01v8_lvt ad=0.66 pd=4.33 as=0.66 ps=4.33 w=4 l=0.15
X146 a_6505_284# a_6505_n716# vss vss sky130_fd_pr__nfet_01v8 ad=0.174 pd=1.78 as=0.174 ps=1.78 w=0.6 l=0.15
X147 vdd a_9264_n1172# outn vdd sky130_fd_pr__pfet_01v8 ad=0.33 pd=2.33 as=0.33 ps=2.33 w=2 l=0.15
X148 vss vbias a_945_230# vss sky130_fd_pr__nfet_01v8 ad=0.464 pd=3.49 as=0.464 ps=3.49 w=3.2 l=0.5
X149 a_3264_1394# a_3264_1394# vdd vdd sky130_fd_pr__pfet_01v8 ad=0.66 pd=4.33 as=0.66 ps=4.33 w=4 l=0.15
C0 a_945_n870# a_6173_n716# 0
C1 outn outp 0.00563f
C2 a_6173_1884# a_3264_1394# 0
C3 a_945_n870# a_4368_n2242# 0.72696f
C4 a_6173_1884# a_4368_1442# 5.50076f
C5 vdd a_6505_n716# 1.77415f
C6 a_6505_284# a_945_230# 0
C7 outp a_9264_n1172# 0.00194f
C8 a_8738_872# vdd 0.99914f
C9 outn a_6505_n716# 0
C10 inp a_945_230# 0.00108f
C11 a_6173_n2316# a_8738_n1192# 0.00104f
C12 a_6173_n2316# a_6173_n716# 0.01264f
C13 a_451_n830# inn 0.90528f
C14 a_6505_284# a_8738_n1192# 0.01349f
C15 a_6173_n2316# a_4368_n2242# 5.50076f
C16 a_6505_284# a_4368_n2242# 0
C17 a_945_230# a_3264_n2290# 0
C18 a_451_n830# a_3264_n2290# 0.50683f
C19 a_945_n870# a_451_230# 0.53165f
C20 vdd a_945_230# 0.01713f
C21 a_9264_n1172# a_6505_n716# 0.02518f
C22 a_451_n830# vdd 1.77378f
C23 a_6173_284# a_4368_1442# 0.19421f
C24 a_6173_1884# a_6173_284# 0.01264f
C25 a_4368_1442# a_6505_n716# 0.01142f
C26 a_8738_872# a_9264_n1172# 0.01924f
C27 a_3264_n2290# a_4368_n2242# 0.7681f
C28 a_6173_1884# a_6505_n716# 0.02175f
C29 vdd a_8738_n1192# 0.99907f
C30 vbias a_945_230# 1.11145f
C31 vbias a_451_n830# 0.63267f
C32 vdd a_4368_n2242# 2.62898f
C33 a_9264_872# a_6505_284# 0.02419f
C34 a_6173_1884# a_8738_872# 0.00104f
C35 a_451_230# a_6173_n2316# 0
C36 outn a_8738_n1192# 0
C37 outp a_6505_n716# 0
C38 a_3264_1394# a_945_230# 0.73751f
C39 a_451_n830# a_3264_1394# 0.39422f
C40 a_4368_1442# a_945_230# 0.72696f
C41 a_8738_872# outp 0
C42 a_451_n830# a_4368_1442# 0.51024f
C43 inp a_451_230# 0.90528f
C44 a_9264_872# vdd 1.69657f
C45 a_6173_1884# a_451_n830# 0
C46 a_8738_n1192# a_9264_n1172# 0.2368f
C47 a_6505_284# a_6339_1884# 0.00187f
C48 a_451_230# a_3264_n2290# 0.38517f
C49 a_451_230# vdd 1.82087f
C50 a_4368_1442# a_4368_n2242# 0.10991f
C51 outn a_9264_872# 0.01035f
C52 a_6173_1884# a_4368_n2242# 0.00662f
C53 a_8738_872# a_6505_n716# 0.0021f
C54 vbias a_451_230# 0.81285f
C55 vdd a_6339_1884# 0.03446f
C56 a_6173_n2316# a_6339_n2316# 0.28335f
C57 a_9264_872# a_9264_n1172# 0.68169f
C58 a_6173_284# a_945_230# 0
C59 a_451_n830# a_6173_284# 0.00147f
C60 a_6173_1884# a_9264_872# 0
C61 a_451_230# a_3264_1394# 0.49802f
C62 a_4368_1442# a_451_230# 0
C63 a_6339_n2316# a_3264_n2290# 0
C64 a_945_n870# inn 0.00108f
C65 a_8738_n1192# a_6505_n716# 0.25222f
C66 a_6173_n716# a_6505_n716# 0.17154f
C67 vdd a_6339_n2316# 0.03446f
C68 a_945_n870# a_3264_n2290# 0.73751f
C69 a_6505_n716# a_4368_n2242# 0.5502f
C70 a_9264_872# outp 0.27013f
C71 a_3264_1394# a_6339_1884# 0
C72 a_8738_872# a_8738_n1192# 0.00214f
C73 a_4368_1442# a_6339_1884# 0.16413f
C74 a_945_n870# vdd 0.01713f
C75 a_6505_284# a_6173_n2316# 0.01066f
C76 a_6173_1884# a_6339_1884# 0.28335f
C77 a_451_n830# a_945_230# 0.53334f
C78 vbias a_945_n870# 1.11145f
C79 a_9264_872# a_6505_n716# 0
C80 a_6173_n2316# a_3264_n2290# 0
C81 a_451_n830# a_4368_n2242# 0
C82 vdd a_6173_n2316# 1.27723f
C83 a_9264_872# a_8738_872# 0.22703f
C84 a_6505_284# vdd 1.79892f
C85 inn a_3264_n2290# 0.00302f
C86 a_945_n870# a_3264_1394# 0
C87 a_6173_n716# a_4368_n2242# 0.19421f
C88 a_6173_284# a_6339_1884# 0.00166f
C89 vdd inn 0.98175f
C90 inp vdd 0.98175f
C91 outn a_6505_284# 0
C92 vdd a_3264_n2290# 7.23527f
C93 vbias inn 0.2752f
C94 a_6173_n2316# a_9264_n1172# 0
C95 vbias inp 0.2752f
C96 a_6505_284# a_9264_n1172# 0.0448f
C97 a_451_230# a_945_230# 0.69912f
C98 a_451_n830# a_451_230# 1.09996f
C99 vbias a_3264_n2290# 0
C100 a_9264_872# a_8738_n1192# 0.01177f
C101 a_4368_1442# a_6173_n2316# 0.00662f
C102 a_4368_1442# a_6505_284# 0.53937f
C103 a_6173_1884# a_6173_n2316# 0.06626f
C104 outn vdd 0.77814f
C105 vbias vdd 0.04654f
C106 a_6173_1884# a_6505_284# 0.51466f
C107 a_451_230# a_6173_n716# 0.00147f
C108 a_6339_n2316# a_6505_n716# 0.00187f
C109 inp a_3264_1394# 0.00302f
C110 a_451_230# a_4368_n2242# 0.51024f
C111 vdd a_9264_n1172# 1.59515f
C112 a_945_n870# a_6505_n716# 0
C113 a_6505_284# outp 0
C114 vdd a_3264_1394# 7.23511f
C115 a_4368_1442# vdd 2.62924f
C116 a_6173_1884# vdd 1.27727f
C117 outn a_9264_n1172# 0.25666f
C118 vbias a_3264_1394# 0
C119 a_6173_284# a_6505_284# 0.17154f
C120 a_6173_n2316# a_6505_n716# 0.52769f
C121 a_6505_284# a_6505_n716# 0.71815f
C122 vdd outp 0.77814f
C123 a_451_n830# a_945_n870# 0.70081f
C124 a_6339_n2316# a_6173_n716# 0.00166f
C125 a_8738_872# a_6505_284# 0.26918f
C126 a_6339_n2316# a_4368_n2242# 0.16413f
C127 a_6173_1884# a_9264_n1172# 0
C128 a_4368_1442# a_3264_1394# 0.7681f
C129 outn vss 0.46578f
C130 inn vss 1.89695f
C131 outp vss 0.46578f
C132 vbias vss 10.7011f
C133 inp vss 1.89695f
C134 vdd vss 71.1618f
C135 a_8738_n1192# vss 0.63921f
C136 a_6339_n2316# vss 0.53648f
C137 a_6173_n2316# vss 1.99597f
C138 a_6173_n716# vss 0.54015f
C139 a_4368_n2242# vss 2.36636f
C140 a_3264_n2290# vss 0.466f
C141 a_945_n870# vss 2.55685f
C142 a_9264_n1172# vss 1.36906f
C143 a_8738_872# vss 0.63921f
C144 a_6505_n716# vss 2.64723f
C145 a_9264_872# vss 1.38577f
C146 a_6505_284# vss 2.67508f
C147 a_6339_1884# vss 0.53648f
C148 a_6173_284# vss 0.54015f
C149 a_451_n830# vss 5.14434f
C150 a_6173_1884# vss 1.99608f
C151 a_4368_1442# vss 2.36652f
C152 a_3264_1394# vss 0.46589f
C153 a_945_230# vss 2.55685f
C154 a_451_230# vss 5.15576f
.ends
