* Physical LVS reference for serdes_cml_to_cmos_r5_pdk
.subckt serdes_cml_to_cmos_r5_pdk inp inn outp outn vbias vdd vss
Xfp vdd inp fp vss sky130_fd_pr__nfet_01v8_lvt w=32 l=0.15
Xfn vdd inn fn vss sky130_fd_pr__nfet_01v8_lvt w=32 l=0.15
Xsp fp vbias vss vss sky130_fd_pr__nfet_01v8 w=3 l=0.5
Xsn fn vbias vss vss sky130_fd_pr__nfet_01v8 w=3 l=0.5
Xap_ip ap_mir fp ap_tail vss sky130_fd_pr__nfet_01v8_lvt w=16 l=0.15
Xap_in ap fn ap_tail vss sky130_fd_pr__nfet_01v8_lvt w=16 l=0.15
Xap_lp ap_mir ap_mir vdd vdd sky130_fd_pr__pfet_01v8 w=32 l=0.15
Xap_ln ap ap_mir vdd vdd sky130_fd_pr__pfet_01v8 w=32 l=0.15
Xap_t ap_tail vbias vss vss sky130_fd_pr__nfet_01v8 w=32 l=0.5
Xan_ip an_mir fn an_tail vss sky130_fd_pr__nfet_01v8_lvt w=16 l=0.15
Xan_in an fp an_tail vss sky130_fd_pr__nfet_01v8_lvt w=16 l=0.15
Xan_lp an_mir an_mir vdd vdd sky130_fd_pr__pfet_01v8 w=32 l=0.15
Xan_ln an an_mir vdd vdd sky130_fd_pr__pfet_01v8 w=32 l=0.15
Xan_t an_tail vbias vss vss sky130_fd_pr__nfet_01v8 w=32 l=0.5
XCac_p ap_ac ap sky130_fd_pr__cap_mim_m3_1 w=9 l=5.5
XCac_n an_ac an sky130_fd_pr__cap_mim_m3_1 w=9 l=5.5
XRfb_p0 ap_ac rfp1 vss sky130_fd_pr__res_high_po_0p35 l=6
XRfb_p1 rfp1  rfp2 vss sky130_fd_pr__res_high_po_0p35 l=6
XRfb_p2 rfp2  bp   vss sky130_fd_pr__res_high_po_0p35 l=6
XRfb_n0 an_ac rfn1 vss sky130_fd_pr__res_high_po_0p35 l=6
XRfb_n1 rfn1  rfn2 vss sky130_fd_pr__res_high_po_0p35 l=6
XRfb_n2 rfn2  bn   vss sky130_fd_pr__res_high_po_0p35 l=6
Xbp_n bp ap_ac vss vss sky130_fd_pr__nfet_01v8 w=6.0 l=0.15
Xbp_p bp ap_ac vdd vdd sky130_fd_pr__pfet_01v8 w=7.2 l=0.15
Xbn_n bn an_ac vss vss sky130_fd_pr__nfet_01v8 w=6.0 l=0.15
Xbn_p bn an_ac vdd vdd sky130_fd_pr__pfet_01v8 w=7.2 l=0.15
Xkbp_n bp bn vss vss sky130_fd_pr__nfet_01v8 w=0.6 l=0.15
Xkbp_p bp bn vdd vdd sky130_fd_pr__pfet_01v8 w=1.2 l=0.15
Xkbn_n bn bp vss vss sky130_fd_pr__nfet_01v8 w=0.6 l=0.15
Xkbn_p bn bp vdd vdd sky130_fd_pr__pfet_01v8 w=1.2 l=0.15
Xop_n rawp bp vss vss sky130_fd_pr__nfet_01v8 w=3.6 l=0.15
Xop_p rawp bp vdd vdd sky130_fd_pr__pfet_01v8 w=6.4 l=0.15
Xon_n rawn bn vss vss sky130_fd_pr__nfet_01v8 w=3.6 l=0.15
Xon_p rawn bn vdd vdd sky130_fd_pr__pfet_01v8 w=6.4 l=0.15
Xkrp_n rawp rawn vss vss sky130_fd_pr__nfet_01v8 w=0.6 l=0.15
Xkrp_p rawp rawn vdd vdd sky130_fd_pr__pfet_01v8 w=1.2 l=0.15
Xkrn_n rawn rawp vss vss sky130_fd_pr__nfet_01v8 w=0.6 l=0.15
Xkrn_p rawn rawp vdd vdd sky130_fd_pr__pfet_01v8 w=1.2 l=0.15
Xdp1_n dp1 rawp vss vss sky130_fd_pr__nfet_01v8 w=1.2 l=0.15
Xdp1_p dp1 rawp vdd vdd sky130_fd_pr__pfet_01v8 w=3.2 l=0.15
Xdp2_n dp2 dp1 vss vss sky130_fd_pr__nfet_01v8 w=1.2 l=0.15
Xdp2_p dp2 dp1 vdd vdd sky130_fd_pr__pfet_01v8 w=3.2 l=0.15
Xdp3_n dp3 dp2 vss vss sky130_fd_pr__nfet_01v8 w=1.2 l=0.15
Xdp3_p dp3 dp2 vdd vdd sky130_fd_pr__pfet_01v8 w=3.2 l=0.15
Xdn1_n dn1 rawn vss vss sky130_fd_pr__nfet_01v8 w=1.2 l=0.15
Xdn1_p dn1 rawn vdd vdd sky130_fd_pr__pfet_01v8 w=3.2 l=0.15
Xdn2_n dn2 dn1 vss vss sky130_fd_pr__nfet_01v8 w=1.2 l=0.15
Xdn2_p dn2 dn1 vdd vdd sky130_fd_pr__pfet_01v8 w=3.2 l=0.15
Xdn3_n dn3 dn2 vss vss sky130_fd_pr__nfet_01v8 w=1.2 l=0.15
Xdn3_p dn3 dn2 vdd vdd sky130_fd_pr__pfet_01v8 w=3.2 l=0.15
Xset_nt set_b rawp set_mid vss sky130_fd_pr__nfet_01v8 w=4.5 l=0.15
Xset_nb set_mid dp3 vss vss sky130_fd_pr__nfet_01v8 w=4.5 l=0.15
Xset_pa set_b rawp vdd vdd sky130_fd_pr__pfet_01v8 w=4.5 l=0.15
Xset_pb set_b dp3 vdd vdd sky130_fd_pr__pfet_01v8 w=4.5 l=0.15
Xrst_nt reset_b rawn rst_mid vss sky130_fd_pr__nfet_01v8 w=4.5 l=0.15
Xrst_nb rst_mid dn3 vss vss sky130_fd_pr__nfet_01v8 w=4.5 l=0.15
Xrst_pa reset_b rawn vdd vdd sky130_fd_pr__pfet_01v8 w=4.5 l=0.15
Xrst_pb reset_b dn3 vdd vdd sky130_fd_pr__pfet_01v8 w=4.5 l=0.15
Xqp_nt qp set_b qp_mid vss sky130_fd_pr__nfet_01v8 w=6.0 l=0.15
Xqp_nb qp_mid qn vss vss sky130_fd_pr__nfet_01v8 w=6.0 l=0.15
Xqp_pa qp set_b vdd vdd sky130_fd_pr__pfet_01v8 w=9.0 l=0.15
Xqp_pb qp qn vdd vdd sky130_fd_pr__pfet_01v8 w=9.0 l=0.15
Xqn_nt qn reset_b qn_mid vss sky130_fd_pr__nfet_01v8 w=6.0 l=0.15
Xqn_nb qn_mid qp vss vss sky130_fd_pr__nfet_01v8 w=6.0 l=0.15
Xqn_pa qn reset_b vdd vdd sky130_fd_pr__pfet_01v8 w=9.0 l=0.15
Xqn_pb qn qp vdd vdd sky130_fd_pr__pfet_01v8 w=9.0 l=0.15
Xrp1_n rp1 qp vss vss sky130_fd_pr__nfet_01v8 w=2.4 l=0.15
Xrp1_p rp1 qp vdd vdd sky130_fd_pr__pfet_01v8 w=7.2 l=0.15
Xrp2_n rp2 rp1 vss vss sky130_fd_pr__nfet_01v8 w=1.5 l=0.15
Xrp2_p rp2 rp1 vdd vdd sky130_fd_pr__pfet_01v8 w=4.5 l=0.15
Xrn1_n rn1 qn vss vss sky130_fd_pr__nfet_01v8 w=2.4 l=0.15
Xrn1_p rn1 qn vdd vdd sky130_fd_pr__pfet_01v8 w=7.2 l=0.15
Xrn2_n rn2 rn1 vss vss sky130_fd_pr__nfet_01v8 w=1.5 l=0.15
Xrn2_p rn2 rn1 vdd vdd sky130_fd_pr__pfet_01v8 w=4.5 l=0.15
Xbpr_nt bp_r qp bpr_mid vss sky130_fd_pr__nfet_01v8 w=2.4 l=0.15
Xbpr_nb bpr_mid rp2 vss vss sky130_fd_pr__nfet_01v8 w=2.4 l=0.15
Xbpr_pa bp_r qp vdd vdd sky130_fd_pr__pfet_01v8 w=3.6 l=0.15
Xbpr_pb bp_r rp2 vdd vdd sky130_fd_pr__pfet_01v8 w=3.6 l=0.15
Xbnr_nt bn_r qn bnr_mid vss sky130_fd_pr__nfet_01v8 w=2.4 l=0.15
Xbnr_nb bnr_mid rn2 vss vss sky130_fd_pr__nfet_01v8 w=2.4 l=0.15
Xbnr_pa bn_r qn vdd vdd sky130_fd_pr__pfet_01v8 w=3.6 l=0.15
Xbnr_pb bn_r rn2 vdd vdd sky130_fd_pr__pfet_01v8 w=3.6 l=0.15
Xopr_n outp bp_r vss vss sky130_fd_pr__nfet_01v8 w=4.0 l=0.15
Xopr_p outp bp_r vdd vdd sky130_fd_pr__pfet_01v8 w=8.0 l=0.15
Xonr_n outn bn_r vss vss sky130_fd_pr__nfet_01v8 w=4.0 l=0.15
Xonr_p outn bn_r vdd vdd sky130_fd_pr__pfet_01v8 w=8.0 l=0.15
.ends serdes_cml_to_cmos_r5_pdk
