* Differential CML-to-CMOS CLOCK receiver prototype.
* Includes LVT source-follower input isolation/level shifting, two mirrored
* differential-to-single-ended paths, and an edge-driven clock restorer.
* Output state is meaningful after clock edges; this is not a static-data receiver.
* No ideal gain blocks, switches or behavioral comparators in the DUT.
* Dependencies: common/devices/spice/sky130_primitives.spice.

.subckt serdes_rx_diff_to_se inp inn out vbias vdd vss
+ params: win=6 nfin=1 wload=8 nfload=2 wtail=6
Xip mirror inp tail vss serdes_nfet_lvt w={win} nf={nfin}
Xin out inn tail vss serdes_nfet_lvt w={win} nf={nfin}
Xlp mirror mirror vdd vdd serdes_pfet w={wload} nf={nfload}
Xln out mirror vdd vdd serdes_pfet w={wload} nf={nfload}
Xtail tail vbias vss vss serdes_nfet w={wtail} l=0.5
.ends serdes_rx_diff_to_se

.subckt serdes_rx_inverter in out vdd vss
+ params: wn=1 wp=3 nfn=1 nfp=1
Xn out in vss vss serdes_nfet w={wn} nf={nfn}
Xp out in vdd vdd serdes_pfet w={wp} nf={nfp}
.ends serdes_rx_inverter

.subckt serdes_cml_to_cmos inp inn outp outn vbias vdd vss
+ params: wsf=20 wsf_sink=2 win=6 wload=8 wtail=6
+ pre_wn=1 pre_wp=3.6 out_wn=4 out_wp=8

* Source followers: gates face the VCO, sources drive the gain stages.
* High input common mode is shifted down before differential gain.
Xfp vdd inp fp vss serdes_nfet_lvt w={wsf}
Xfn vdd inn fn vss serdes_nfet_lvt w={wsf}
Xsp fp vbias vss vss serdes_nfet w={wsf_sink} l=0.5
Xsn fn vbias vss vss serdes_nfet w={wsf_sink} l=0.5

* Identical reversed-input paths preserve symmetry of complementary outputs.
Xap fp fn ap vbias vdd vss serdes_rx_diff_to_se
+ win={win} wload={wload} wtail={wtail}
Xan fn fp an vbias vdd vss serdes_rx_diff_to_se
+ win={win} wload={wload} wtail={wtail}
Xbp ap bp vdd vss serdes_rx_inverter wn={pre_wn} wp={pre_wp}
Xbn an bn vdd vss serdes_rx_inverter wn={pre_wn} wp={pre_wp}
Xop bp rawp vdd vss serdes_rx_inverter wn=4 wp=12 nfp=4
Xon bn rawn vdd vss serdes_rx_inverter wn=4 wp=12 nfp=4
Xrestore rawp rawn outp outn vdd vss serdes_rx_clock_restorer
+ out_wn={out_wn} out_wp={out_wp}
.ends serdes_cml_to_cmos

.subckt serdes_rx_nand2 a b out vdd vss params: wn=2 wp=3
Xnt out a mid vss serdes_nfet w={wn}
Xnb mid b vss vss serdes_nfet w={wn}
Xpa out a vdd vdd serdes_pfet w={wp}
Xpb out b vdd vdd serdes_pfet w={wp}
.ends serdes_rx_nand2

.subckt serdes_rx_clock_restorer rawp rawn outp outn vdd vss
+ params: out_wn=4 out_wp=8
* Three inverters generate a delayed complement for each rising-edge detector.
Xdp1 rawp dp1 vdd vss serdes_rx_inverter wn=0.5 wp=1.5
Xdp2 dp1 dp2 vdd vss serdes_rx_inverter wn=0.5 wp=1.5
Xdp3 dp2 dp3 vdd vss serdes_rx_inverter wn=0.5 wp=1.5
Xdn1 rawn dn1 vdd vss serdes_rx_inverter wn=0.5 wp=1.5
Xdn2 dn1 dn2 vdd vss serdes_rx_inverter wn=0.5 wp=1.5
Xdn3 dn2 dn3 vdd vss serdes_rx_inverter wn=0.5 wp=1.5
Xset rawp dp3 set_b vdd vss serdes_rx_nand2
Xreset rawn dn3 reset_b vdd vss serdes_rx_nand2
* Active-low set/reset latch. Pulses must remain mutually exclusive.
Xqp set_b qn qp vdd vss serdes_rx_nand2 wn=4 wp=6
Xqn reset_b qp qn vdd vss serdes_rx_nand2 wn=4 wp=6
* Delay each rising transition to compensate the latch's unequal set/reset depth.
* Falling transitions use the undelayed NAND input; delay cells track PVT.
Xrp1 qp rp1 vdd vss serdes_rx_inverter wn=2 wp=6
Xrp2 rp1 rp2 vdd vss serdes_rx_inverter wn=1 wp=3
Xrn1 qn rn1 vdd vss serdes_rx_inverter wn=2 wp=6
Xrn2 rn1 rn2 vdd vss serdes_rx_inverter wn=1 wp=3
Xbp qp rp2 bp vdd vss serdes_rx_nand2
Xbn qn rn2 bn vdd vss serdes_rx_nand2
Xop bp outp vdd vss serdes_rx_inverter wn={out_wn} wp={out_wp} nfp=4
Xon bn outn vdd vss serdes_rx_inverter wn={out_wn} wp={out_wp} nfp=4
.ends serdes_rx_clock_restorer
