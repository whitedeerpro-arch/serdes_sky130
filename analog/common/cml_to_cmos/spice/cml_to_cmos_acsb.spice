* AC-coupled self-biased CML-to-CMOS clock receiver (exploration, I-04).
* The coupling capacitor removes the CML common mode; each first inverter is
* biased at its own switching threshold by a feedback resistor, so the
* operating point tracks process and temperature instead of depending on a
* gain stage's output level. A second inverter restores full swing; weak
* cross-coupled inverters keep the two outputs complementary and the duty
* cycle symmetric. Clock only: the input must toggle (no DC path).
* Pin-compatible with serdes_cml_to_cmos_pvt_candidate (vbias unused).
* rf is an ideal nominal resistor here (see open issue I-02).
* Dependencies: sky130_primitives.spice, cml_to_cmos.spice (inverter helper).
.subckt serdes_cml_to_cmos_acsb inp inn outp outn vbias vdd vss
+ params: cc=60f rf=40k wn1=2 wp1=4 wn2=3 wp2=6 wnx=0.5 wpx=1 wno=4 wpo=8
Ccp inp xp {cc}
Ccn inn xn {cc}
X1p xp yp vdd vss serdes_rx_inverter wn={wn1} wp={wp1}
X1n xn yn vdd vss serdes_rx_inverter wn={wn1} wp={wp1}
Rfp xp yp {rf}
Rfn xn yn {rf}
X2p yp zn vdd vss serdes_rx_inverter wn={wn2} wp={wp2}
X2n yn zp vdd vss serdes_rx_inverter wn={wn2} wp={wp2}
* Weak cross-coupling between the complementary nodes.
Xxp zp zn vdd vss serdes_rx_inverter wn={wnx} wp={wpx}
Xxn zn zp vdd vss serdes_rx_inverter wn={wnx} wp={wpx}
Xop zn outp vdd vss serdes_rx_inverter wn={wno} wp={wpo}
Xon zp outn vdd vss serdes_rx_inverter wn={wno} wp={wpo}
.ends serdes_cml_to_cmos_acsb
