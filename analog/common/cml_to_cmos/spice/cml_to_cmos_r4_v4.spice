* Full-rate 2 GHz CML-to-CMOS clock receiver, schematic equivalent of layout revision v4
* (1D straight-through M1-first physical cell `serdes_cml_to_cmos_r4_pdk`).
* Uses exact multi-finger SKY130 device widths/finger counts matched to the physical cell:
*   SF: Xfp/Xfn = 32/0.15 LVT (4.0x8), Xsp/Xsn = 3/0.5 (3.0x1)
*   Gain: Xip/Xin = 16/0.15 LVT (4.0x4), Xlp/Xln = 32/0.15 (4.0x8), Xtail = 32/0.5 (3.2x10)
*   Pre-driver: bp/bn = 5.4/3.6 (1.8x3 / 1.2x3), op/on = 2.4/4.8 (1.2x2 / 1.2x4, balanced across PVT/RCX)
*   Restorer: 1.6x delay chain (0.8/2.4), symmetric SR NAND latch + rising-edge balance
* Dependencies: sky130_primitives.spice, cml_to_cmos.spice.

.subckt serdes_rx_nand2_v4 a b out vdd vss params: wn=2 wp=3 nfn=1 nfp=1
Xnt out a mid vss serdes_nfet w={wn} nf={nfn}
Xnb mid b vss vss serdes_nfet w={wn} nf={nfn}
Xpa out a vdd vdd serdes_pfet w={wp} nf={nfp}
Xpb out b vdd vdd serdes_pfet w={wp} nf={nfp}
.ends serdes_rx_nand2_v4

.subckt serdes_rx_diff_to_se_v4 inp inn out vbias vdd vss
+ params: win=16 nfin=4 wload=32 nfload=8 wtail=32 nftail=10
Xip mirror inp tail vss serdes_nfet_lvt w={win} nf={nfin}
Xin out inn tail vss serdes_nfet_lvt w={win} nf={nfin}
Xlp mirror mirror vdd vdd serdes_pfet w={wload} nf={nfload}
Xln out mirror vdd vdd serdes_pfet w={wload} nf={nfload}
Xtail tail vbias vss vss serdes_nfet w={wtail} l=0.5 nf={nftail}
.ends serdes_rx_diff_to_se_v4

.subckt serdes_rx_clock_restorer_v4 rawp rawn outp outn vdd vss
+ params: out_wn=4 out_wp=8
Xdp1 rawp dp1 vdd vss serdes_rx_inverter wn=0.8 wp=2.4 nfn=1 nfp=1
Xdp2 dp1 dp2 vdd vss serdes_rx_inverter wn=0.8 wp=2.4 nfn=1 nfp=1
Xdp3 dp2 dp3 vdd vss serdes_rx_inverter wn=0.8 wp=2.4 nfn=1 nfp=1
Xdn1 rawn dn1 vdd vss serdes_rx_inverter wn=0.8 wp=2.4 nfn=1 nfp=1
Xdn2 dn1 dn2 vdd vss serdes_rx_inverter wn=0.8 wp=2.4 nfn=1 nfp=1
Xdn3 dn2 dn3 vdd vss serdes_rx_inverter wn=0.8 wp=2.4 nfn=1 nfp=1
Xset rawp dp3 set_b vdd vss serdes_rx_nand2_v4 wn=3 wp=3 nfn=2 nfp=2
Xreset rawn dn3 reset_b vdd vss serdes_rx_nand2_v4 wn=3 wp=3 nfn=2 nfp=2
Xqp set_b qn qp vdd vss serdes_rx_nand2_v4 wn=4 wp=6 nfn=2 nfp=3
Xqn reset_b qp qn vdd vss serdes_rx_nand2_v4 wn=4 wp=6 nfn=2 nfp=3
Xrp1 qp rp1 vdd vss serdes_rx_inverter wn=2 wp=6 nfn=1 nfp=3
Xrp2 rp1 rp2 vdd vss serdes_rx_inverter wn=1 wp=3 nfn=1 nfp=2
Xrn1 qn rn1 vdd vss serdes_rx_inverter wn=2 wp=6 nfn=1 nfp=3
Xrn2 rn1 rn2 vdd vss serdes_rx_inverter wn=1 wp=3 nfn=1 nfp=2
Xbp qp rp2 bp vdd vss serdes_rx_nand2_v4 wn=2 wp=3 nfn=1 nfp=2
Xbn qn rn2 bn vdd vss serdes_rx_nand2_v4 wn=2 wp=3 nfn=1 nfp=2
Xop bp outp vdd vss serdes_rx_inverter wn={out_wn} wp={out_wp} nfn=2 nfp=4
Xon bn outn vdd vss serdes_rx_inverter wn={out_wn} wp={out_wp} nfn=2 nfp=4
.ends serdes_rx_clock_restorer_v4

.subckt serdes_cml_to_cmos_r4_v4 inp inn outp outn vbias vdd vss
+ params: wsf=32 wsf_sink=3 win=16 wload=32 wtail=32
+ pre_wn=5.4 pre_wp=3.6 op_wn=2.4 op_wp=4.8 out_wn=4 out_wp=8
Xfp vdd inp fp vss serdes_nfet_lvt w={wsf} nf=8
Xfn vdd inn fn vss serdes_nfet_lvt w={wsf} nf=8
Xsp fp vbias vss vss serdes_nfet w={wsf_sink} l=0.5 nf=1
Xsn fn vbias vss vss serdes_nfet w={wsf_sink} l=0.5 nf=1
Xap fp fn ap vbias vdd vss serdes_rx_diff_to_se_v4
+ win={win} nfin=4 wload={wload} nfload=8 wtail={wtail} nftail=10
Xan fn fp an vbias vdd vss serdes_rx_diff_to_se_v4
+ win={win} nfin=4 wload={wload} nfload=8 wtail={wtail} nftail=10
Xbp ap bp vdd vss serdes_rx_inverter wn={pre_wn} wp={pre_wp} nfn=3 nfp=3
Xbn an bn vdd vss serdes_rx_inverter wn={pre_wn} wp={pre_wp} nfn=3 nfp=3
Xop bp rawp vdd vss serdes_rx_inverter wn={op_wn} wp={op_wp} nfn=2 nfp=4
Xon bn rawn vdd vss serdes_rx_inverter wn={op_wn} wp={op_wp} nfn=2 nfp=4
Xrestore rawp rawn outp outn vdd vss serdes_rx_clock_restorer_v4
+ out_wn={out_wn} out_wp={out_wp}
.ends serdes_cml_to_cmos_r4_v4
