* Static CMOS data to high-CM CML; unlike the clock-only receiver, preserves DC data.
* Input intended for 250 Mb/s parallel word lanes in the first serializer prototype.
* Outp-outn has the same polarity as input. External bias, ideal load resistors.
.subckt serdes_cmos_to_cml_data din outp outn vbias vdd vss
+ params: wdata=12 wtail=12 rload=400
Xinv din din_b vdd vss serdes_cmos_inv wn=2 wp=4
Rp vdd outp {rload}
Rn vdd outn {rload}
Xp outn din tail vss serdes_nfet_lvt w={wdata} nf=4
Xn outp din_b tail vss serdes_nfet_lvt w={wdata} nf=4
Xt tail vbias vss vss serdes_nfet w={wtail} l=0.5 nf=4
.ends serdes_cmos_to_cml_data
