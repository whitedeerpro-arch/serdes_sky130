* Static CMOS helpers, SKY130 MOS adapters required. Widths in micrometres.
.subckt serdes_cmos_inv a y vdd vss params: wn=1 wp=2
Xn y a vss vss serdes_nfet w={wn}
Xp y a vdd vdd serdes_pfet w={wp}
.ends serdes_cmos_inv

.subckt serdes_cmos_nand2 a b y vdd vss params: wn=2 wp=2
Xna y a mid vss serdes_nfet w={wn}
Xnb mid b vss vss serdes_nfet w={wn}
Xpa y a vdd vdd serdes_pfet w={wp}
Xpb y b vdd vdd serdes_pfet w={wp}
.ends serdes_cmos_nand2

.subckt serdes_cmos_nor2 a b y vdd vss params: wn=1 wp=4
Xna y a vss vss serdes_nfet w={wn}
Xnb y b vss vss serdes_nfet w={wn}
Xpa y a mid vdd serdes_pfet w={wp}
Xpb mid b vdd vdd serdes_pfet w={wp}
.ends serdes_cmos_nor2

.subckt serdes_cmos_and2 a b y vdd vss
Xn a b yn vdd vss serdes_cmos_nand2
Xi yn y vdd vss serdes_cmos_inv
.ends serdes_cmos_and2

.subckt serdes_cmos_tgate a b en en_b vdd vss params: wn=1 wp=2
Xn a en b vss serdes_nfet w={wn}
Xp a en_b b vdd serdes_pfet w={wp}
.ends serdes_cmos_tgate

.subckt serdes_cmos_or2 a b y vdd vss
Xn a b yn vdd vss serdes_cmos_nor2
Xi yn y vdd vss serdes_cmos_inv
.ends serdes_cmos_or2

.subckt serdes_cmos_mux2 a b sel y vdd vss
Xsi sel sel_b vdd vss serdes_cmos_inv
Xa a sel_b an vdd vss serdes_cmos_nand2
Xb b sel bn vdd vss serdes_cmos_nand2
Xo an bn y vdd vss serdes_cmos_nand2
.ends serdes_cmos_mux2

.subckt serdes_cmos_xor a b y vdd vss
Xi a a_b vdd vss serdes_cmos_inv
Xm a a_b b y vdd vss serdes_cmos_mux2
.ends serdes_cmos_xor

.subckt serdes_cmos_xnor a b y vdd vss
Xx a b yn vdd vss serdes_cmos_xor
Xi yn y vdd vss serdes_cmos_inv
.ends serdes_cmos_xnor

* Carry recurrence for an unsigned comparator: greater OR (equal AND ge_lower).
.subckt serdes_cmos_ge_bit a b ge_lower ge vdd vss
Xbi b b_b vdd vss serdes_cmos_inv
Xgt a b_b gt vdd vss serdes_cmos_and2
Xeq a b eq vdd vss serdes_cmos_xnor
Xe eq ge_lower eg vdd vss serdes_cmos_and2
Xo gt eg ge vdd vss serdes_cmos_or2
.ends serdes_cmos_ge_bit

.subckt serdes_cmos_ge4 a0 a1 a2 a3 b0 b1 b2 b3 ge vdd vss
X0 a0 b0 vdd ge0 vdd vss serdes_cmos_ge_bit
X1 a1 b1 ge0 ge1 vdd vss serdes_cmos_ge_bit
X2 a2 b2 ge1 ge2 vdd vss serdes_cmos_ge_bit
X3 a3 b3 ge2 ge vdd vss serdes_cmos_ge_bit
.ends serdes_cmos_ge4
