* Separate optional LVT PMOS adapter. Minimum drawn L uses0.35um model family.
* Total W convention matches existing project adapters.
.subckt serdes_pfet_lvt d g s b params: w=4 l=.35 nf=1
Xmos d g s b sky130_fd_pr__pfet_01v8_lvt w={w} l={l} nf={nf}
+ ad={floor((nf+1)/2)*(w/nf)*0.29}
+ as={floor((nf+2)/2)*(w/nf)*0.29}
+ pd={2*floor((nf+1)/2)*(w/nf+0.29)}
+ ps={2*floor((nf+2)/2)*(w/nf+0.29)}
.ends serdes_pfet_lvt
