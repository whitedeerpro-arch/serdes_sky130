* NGSPICE file created from serdes_ldo_ref_res_pdk.ext - technology: sky130A

.subckt serdes_ldo_ref_res_pdk a b sub
X0 b a_4192_n10155# sub sky130_fd_pr__res_high_po w=1 l=97.39
X1 a_3896_9723# a_3600_n10155# sub sky130_fd_pr__res_high_po w=1 l=97.39
X2 a_n4392_9723# a_n4688_n10155# sub sky130_fd_pr__res_high_po w=1 l=97.39
X3 a_n4392_9723# a_n4096_n10155# sub sky130_fd_pr__res_high_po w=1 l=97.39
X4 a_2120_9723# a_1824_n10155# sub sky130_fd_pr__res_high_po w=1 l=97.39
X5 a_3304_9723# a_3600_n10155# sub sky130_fd_pr__res_high_po w=1 l=97.39
X6 a a_n4688_n10155# sub sky130_fd_pr__res_high_po w=1 l=97.39
X7 a_936_9723# a_1232_n10155# sub sky130_fd_pr__res_high_po w=1 l=97.39
X8 a_2712_9723# a_2416_n10155# sub sky130_fd_pr__res_high_po w=1 l=97.39
X9 a_3304_9723# a_3008_n10155# sub sky130_fd_pr__res_high_po w=1 l=97.39
X10 a_2712_9723# a_3008_n10155# sub sky130_fd_pr__res_high_po w=1 l=97.39
X11 a_n3800_9723# a_n4096_n10155# sub sky130_fd_pr__res_high_po w=1 l=97.39
X12 a_344_9723# a_640_n10155# sub sky130_fd_pr__res_high_po w=1 l=97.39
X13 a_1528_9723# a_1824_n10155# sub sky130_fd_pr__res_high_po w=1 l=97.39
X14 a_2120_9723# a_2416_n10155# sub sky130_fd_pr__res_high_po w=1 l=97.39
X15 a_344_9723# a_48_n10155# sub sky130_fd_pr__res_high_po w=1 l=97.39
X16 a_1528_9723# a_1232_n10155# sub sky130_fd_pr__res_high_po w=1 l=97.39
X17 a_n3800_9723# a_n3504_n10155# sub sky130_fd_pr__res_high_po w=1 l=97.39
X18 a_n2024_9723# a_n2320_n10155# sub sky130_fd_pr__res_high_po w=1 l=97.39
X19 a_936_9723# a_640_n10155# sub sky130_fd_pr__res_high_po w=1 l=97.39
X20 a_n3208_9723# a_n2912_n10155# sub sky130_fd_pr__res_high_po w=1 l=97.39
X21 a_n1432_9723# a_n1728_n10155# sub sky130_fd_pr__res_high_po w=1 l=97.39
X22 a_n840_9723# a_n544_n10155# sub sky130_fd_pr__res_high_po w=1 l=97.39
X23 a_n3208_9723# a_n3504_n10155# sub sky130_fd_pr__res_high_po w=1 l=97.39
X24 a_n2616_9723# a_n2912_n10155# sub sky130_fd_pr__res_high_po w=1 l=97.39
X25 a_n1432_9723# a_n1136_n10155# sub sky130_fd_pr__res_high_po w=1 l=97.39
X26 a_n248_9723# a_n544_n10155# sub sky130_fd_pr__res_high_po w=1 l=97.39
X27 a_n2616_9723# a_n2320_n10155# sub sky130_fd_pr__res_high_po w=1 l=97.39
X28 a_n2024_9723# a_n1728_n10155# sub sky130_fd_pr__res_high_po w=1 l=97.39
X29 a_n840_9723# a_n1136_n10155# sub sky130_fd_pr__res_high_po w=1 l=97.39
X30 a_3896_9723# a_4192_n10155# sub sky130_fd_pr__res_high_po w=1 l=97.39
X31 a_n248_9723# a_48_n10155# sub sky130_fd_pr__res_high_po w=1 l=97.39
.ends
