* NGSPICE file created from serdes_pll_bias_lowpass_r4_pdk.ext - technology: sky130A

.subckt serdes_pll_bias_lowpass_r4_pdk original filtered vss
X0 original a_n544_n8273# vss sky130_fd_pr__res_high_po w=1 l=78.57
X1 filtered vss sky130_fd_pr__cap_mim_m3_1 l=22.2 w=22.2
X2 filtered vss sky130_fd_pr__cap_mim_m3_1 l=22.2 w=22.2
X3 filtered vss sky130_fd_pr__cap_mim_m3_1 l=22.2 w=22.2
X4 a_n248_7841# a_n544_n8273# vss sky130_fd_pr__res_high_po w=1 l=78.57
X5 filtered vss sky130_fd_pr__cap_mim_m3_1 l=22.2 w=22.2
X6 filtered vss sky130_fd_pr__cap_mim_m3_1 l=22.2 w=22.2
X7 filtered vss sky130_fd_pr__cap_mim_m3_1 l=22.2 w=22.2
X8 filtered vss sky130_fd_pr__cap_mim_m3_1 l=22.2 w=22.2
X9 a_n248_7841# a_48_n8273# vss sky130_fd_pr__res_high_po w=1 l=78.57
X10 filtered vss sky130_fd_pr__cap_mim_m3_1 l=22.2 w=22.2
X11 filtered vss sky130_fd_pr__cap_mim_m3_1 l=22.2 w=22.2
X12 filtered vss sky130_fd_pr__cap_mim_m3_1 l=22.2 w=22.2
X13 filtered vss sky130_fd_pr__cap_mim_m3_1 l=22.2 w=22.2
X14 filtered vss sky130_fd_pr__cap_mim_m3_1 l=22.2 w=22.2
X15 filtered vss sky130_fd_pr__cap_mim_m3_1 l=22.2 w=22.2
X16 filtered vss sky130_fd_pr__cap_mim_m3_1 l=22.2 w=22.2
X17 filtered vss sky130_fd_pr__cap_mim_m3_1 l=22.2 w=22.2
X18 filtered a_48_n8273# vss sky130_fd_pr__res_high_po w=1 l=78.57
X19 filtered vss sky130_fd_pr__cap_mim_m3_1 l=22.2 w=22.2
.ends
