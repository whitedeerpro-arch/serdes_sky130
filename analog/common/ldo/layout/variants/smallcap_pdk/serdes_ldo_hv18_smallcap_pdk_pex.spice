* NGSPICE file created from serdes_ldo_hv18_smallcap_pdk.ext - technology: sky130A

.subckt serdes_ldo_hv18_smallcap_pdk vss out vin off ibias fb ref
X0 w_n8809_8685# a_n8609_2082# a_n8609_14110# w_n8809_8685# sky130_fd_pr__pfet_g5v0d10v5 ad=0.2175 pd=1.79 as=0.2175 ps=1.79 w=1.5 l=4
X1 a_n8609_4082# a_n8609_4082# vss vss sky130_fd_pr__nfet_g5v0d10v5 ad=0.145 pd=1.29 as=0.145 ps=1.29 w=1 l=4
X2 vss ibias a_n8609_2082# vss sky130_fd_pr__nfet_g5v0d10v5 ad=0.145 pd=1.29 as=0.145 ps=1.29 w=1 l=4
X3 out a_n8609_14110# a_n8639_n20509# vss sky130_fd_pr__nfet_05v0_nvt ad=1.45 pd=10.29 as=2.9 ps=20.58 w=10 l=0.9
X4 vin a_n8581_n15597# a_n8639_n20509# vss sky130_fd_pr__nfet_05v0_nvt ad=1.45 pd=10.29 as=1.45 ps=10.29 w=10 l=0.9
X5 w_n8809_8685# a_n8609_2082# a_n8609_14110# w_n8809_8685# sky130_fd_pr__pfet_g5v0d10v5 ad=0.2175 pd=1.79 as=0.2175 ps=1.79 w=1.5 l=4
X6 w_n8809_8685# a_n8609_2082# a_n8609_14110# w_n8809_8685# sky130_fd_pr__pfet_g5v0d10v5 ad=0.2175 pd=1.79 as=0.2175 ps=1.79 w=1.5 l=4
X7 a_n8609_14110# a_n8609_2082# w_n8809_8685# w_n8809_8685# sky130_fd_pr__pfet_g5v0d10v5 ad=0.2175 pd=1.79 as=0.2175 ps=1.79 w=1.5 l=4
X8 w_n8809_8685# a_n8609_2082# a_n8609_2082# w_n8809_8685# sky130_fd_pr__pfet_g5v0d10v5 ad=0.2175 pd=1.79 as=0.2175 ps=1.79 w=1.5 l=4
X9 vin a_n8581_n15597# a_n8639_n20509# vss sky130_fd_pr__nfet_05v0_nvt ad=1.45 pd=10.29 as=1.45 ps=10.29 w=10 l=0.9
X10 vin a_n8581_n15597# a_n8639_n20509# vss sky130_fd_pr__nfet_05v0_nvt ad=1.45 pd=10.29 as=1.45 ps=10.29 w=10 l=0.9
X11 vss ibias ibias vss sky130_fd_pr__nfet_g5v0d10v5 ad=0.145 pd=1.29 as=0.145 ps=1.29 w=1 l=4
X12 a_n8609_2082# a_n8609_2082# w_n8809_8685# w_n8809_8685# sky130_fd_pr__pfet_g5v0d10v5 ad=0.2175 pd=1.79 as=0.2175 ps=1.79 w=1.5 l=4
X13 a_n8609_14110# a_n8609_2082# w_n8809_8685# w_n8809_8685# sky130_fd_pr__pfet_g5v0d10v5 ad=0.435 pd=3.58 as=0.2175 ps=1.79 w=1.5 l=4
X14 w_n8809_8685# a_n8609_2082# a_n8609_14110# w_n8809_8685# sky130_fd_pr__pfet_g5v0d10v5 ad=0.2175 pd=1.79 as=0.2175 ps=1.79 w=1.5 l=4
X15 vss a_n8609_4082# a_n8609_4082# vss sky130_fd_pr__nfet_g5v0d10v5 ad=0.145 pd=1.29 as=0.145 ps=1.29 w=1 l=4
X16 a_n8639_n20509# a_n8609_14110# out vss sky130_fd_pr__nfet_05v0_nvt ad=1.45 pd=10.29 as=1.45 ps=10.29 w=10 l=0.9
X17 w_n8809_8685# vss sky130_fd_pr__cap_mim_m3_1 l=22.2 w=22.2
X18 w_n8809_8685# a_n8609_2082# a_n8609_11046# w_n8809_8685# sky130_fd_pr__pfet_g5v0d10v5 ad=0.2175 pd=1.79 as=0.2175 ps=1.79 w=1.5 l=4
X19 w_n8809_8685# a_n8609_2082# a_n8609_11046# w_n8809_8685# sky130_fd_pr__pfet_g5v0d10v5 ad=0.2175 pd=1.79 as=0.435 ps=3.58 w=1.5 l=4
X20 out a_n8609_14110# a_n8639_n20509# vss sky130_fd_pr__nfet_05v0_nvt ad=1.45 pd=10.29 as=2.9 ps=20.58 w=10 l=0.9
X21 a_n8609_11046# a_n8609_2082# w_n8809_8685# w_n8809_8685# sky130_fd_pr__pfet_g5v0d10v5 ad=0.2175 pd=1.79 as=0.2175 ps=1.79 w=1.5 l=4
X22 a_n8609_14110# a_n8609_2082# w_n8809_8685# w_n8809_8685# sky130_fd_pr__pfet_g5v0d10v5 ad=0.2175 pd=1.79 as=0.2175 ps=1.79 w=1.5 l=4
X23 vss a_n8609_4082# a_n8609_6082# vss sky130_fd_pr__nfet_g5v0d10v5 ad=0.145 pd=1.29 as=0.145 ps=1.29 w=1 l=4
X24 a_n8639_n20509# a_n8581_n15597# vin vss sky130_fd_pr__nfet_05v0_nvt ad=1.45 pd=10.29 as=1.45 ps=10.29 w=10 l=0.9
X25 w_n8809_8685# a_n8609_2082# a_n8609_11046# w_n8809_8685# sky130_fd_pr__pfet_g5v0d10v5 ad=0.2175 pd=1.79 as=0.2175 ps=1.79 w=1.5 l=4
X26 vss a_n8609_4082# a_n8609_4082# vss sky130_fd_pr__nfet_g5v0d10v5 ad=0.145 pd=1.29 as=0.145 ps=1.29 w=1 l=4
X27 w_n8809_8685# a_n8609_2082# a_n8609_14110# w_n8809_8685# sky130_fd_pr__pfet_g5v0d10v5 ad=0.2175 pd=1.79 as=0.2175 ps=1.79 w=1.5 l=4
X28 w_n8809_8685# vss sky130_fd_pr__cap_mim_m3_1 l=22.2 w=22.2
X29 vin a_n8581_n15597# a_n8639_n20509# vss sky130_fd_pr__nfet_05v0_nvt ad=1.45 pd=10.29 as=1.45 ps=10.29 w=10 l=0.9
X30 vss a_n8609_4082# a_n8609_6082# vss sky130_fd_pr__nfet_g5v0d10v5 ad=0.145 pd=1.29 as=0.145 ps=1.29 w=1 l=4
X31 a_n8609_6082# a_n8609_4082# vss vss sky130_fd_pr__nfet_g5v0d10v5 ad=0.145 pd=1.29 as=0.145 ps=1.29 w=1 l=4
X32 a_n8609_4082# a_n8609_4082# vss vss sky130_fd_pr__nfet_g5v0d10v5 ad=0.145 pd=1.29 as=0.145 ps=1.29 w=1 l=4
X33 vin a_n8581_n15597# a_n8639_n20509# vss sky130_fd_pr__nfet_05v0_nvt ad=1.45 pd=10.29 as=1.45 ps=10.29 w=10 l=0.9
X34 w_n8809_8685# a_n8609_2082# a_n8609_14110# w_n8809_8685# sky130_fd_pr__pfet_g5v0d10v5 ad=0.2175 pd=1.79 as=0.2175 ps=1.79 w=1.5 l=4
X35 a_n8609_14110# a_n8609_2082# w_n8809_8685# w_n8809_8685# sky130_fd_pr__pfet_g5v0d10v5 ad=0.2175 pd=1.79 as=0.2175 ps=1.79 w=1.5 l=4
X36 a_n8609_2082# ibias vss vss sky130_fd_pr__nfet_g5v0d10v5 ad=0.145 pd=1.29 as=0.145 ps=1.29 w=1 l=4
X37 a_n8639_n20509# a_n8581_n15597# vin vss sky130_fd_pr__nfet_05v0_nvt ad=1.45 pd=10.29 as=1.45 ps=10.29 w=10 l=0.9
X38 a_n8609_2082# ibias vss vss sky130_fd_pr__nfet_g5v0d10v5 ad=0.145 pd=1.29 as=0.145 ps=1.29 w=1 l=4
X39 vss off ibias vss sky130_fd_pr__nfet_g5v0d10v5 ad=2.9 pd=20.58 as=2.9 ps=20.58 w=10 l=0.5
X40 ibias ibias vss vss sky130_fd_pr__nfet_g5v0d10v5 ad=0.145 pd=1.29 as=0.145 ps=1.29 w=1 l=4
X41 a_n8609_11046# fb a_n8609_4082# w_n8809_8685# sky130_fd_pr__pfet_g5v0d10v5 ad=4.35 pd=30.58 as=4.35 ps=30.58 w=15 l=1
X42 a_n8639_n20509# a_n8581_n15597# vin vss sky130_fd_pr__nfet_05v0_nvt ad=1.45 pd=10.29 as=1.45 ps=10.29 w=10 l=0.9
X43 vss a_n8609_6082# a_n8609_14110# vss sky130_fd_pr__nfet_g5v0d10v5 ad=1.45 pd=10.29 as=1.45 ps=10.29 w=10 l=0.5
X44 a_n8609_2082# ibias vss vss sky130_fd_pr__nfet_g5v0d10v5 ad=0.145 pd=1.29 as=0.145 ps=1.29 w=1 l=4
X45 ibias ibias vss vss sky130_fd_pr__nfet_g5v0d10v5 ad=0.145 pd=1.29 as=0.145 ps=1.29 w=1 l=4
X46 w_n8809_8685# a_n8609_2082# a_n8609_14110# w_n8809_8685# sky130_fd_pr__pfet_g5v0d10v5 ad=0.2175 pd=1.79 as=0.2175 ps=1.79 w=1.5 l=4
X47 w_n8809_8685# a_n8609_2082# a_n8609_14110# w_n8809_8685# sky130_fd_pr__pfet_g5v0d10v5 ad=0.2175 pd=1.79 as=0.435 ps=3.58 w=1.5 l=4
X48 a_n8609_14110# a_n8609_2082# w_n8809_8685# w_n8809_8685# sky130_fd_pr__pfet_g5v0d10v5 ad=0.2175 pd=1.79 as=0.2175 ps=1.79 w=1.5 l=4
X49 a_n8639_n20509# a_n8581_n15597# vin vss sky130_fd_pr__nfet_05v0_nvt ad=1.45 pd=10.29 as=1.45 ps=10.29 w=10 l=0.9
X50 a_n8609_14110# a_n8609_2082# w_n8809_8685# w_n8809_8685# sky130_fd_pr__pfet_g5v0d10v5 ad=0.2175 pd=1.79 as=0.2175 ps=1.79 w=1.5 l=4
X51 a_n8609_2082# a_n8609_2082# w_n8809_8685# w_n8809_8685# sky130_fd_pr__pfet_g5v0d10v5 ad=0.2175 pd=1.79 as=0.2175 ps=1.79 w=1.5 l=4
X52 vin a_n8581_n15597# a_n8639_n20509# vss sky130_fd_pr__nfet_05v0_nvt ad=1.45 pd=10.29 as=1.45 ps=10.29 w=10 l=0.9
X53 vss ibias ibias vss sky130_fd_pr__nfet_g5v0d10v5 ad=0.145 pd=1.29 as=0.145 ps=1.29 w=1 l=4
X54 w_n8809_8685# a_n8609_2082# a_n8609_14110# w_n8809_8685# sky130_fd_pr__pfet_g5v0d10v5 ad=0.2175 pd=1.79 as=0.2175 ps=1.79 w=1.5 l=4
X55 w_n8809_8685# a_n8609_2082# a_n8609_14110# w_n8809_8685# sky130_fd_pr__pfet_g5v0d10v5 ad=0.2175 pd=1.79 as=0.2175 ps=1.79 w=1.5 l=4
X56 vss ibias a_n8609_2082# vss sky130_fd_pr__nfet_g5v0d10v5 ad=0.145 pd=1.29 as=0.145 ps=1.29 w=1 l=4
X57 a_n8639_n20509# a_n8581_n15597# vin vss sky130_fd_pr__nfet_05v0_nvt ad=1.45 pd=10.29 as=1.45 ps=10.29 w=10 l=0.9
X58 vss a_n8609_6082# a_n8609_14110# vss sky130_fd_pr__nfet_g5v0d10v5 ad=1.45 pd=10.29 as=2.9 ps=20.58 w=10 l=0.5
X59 w_n8809_8685# a_n8609_2082# a_n8609_14110# w_n8809_8685# sky130_fd_pr__pfet_g5v0d10v5 ad=0.2175 pd=1.79 as=0.2175 ps=1.79 w=1.5 l=4
X60 a_n8581_n15597# vss sky130_fd_pr__cap_mim_m3_1 l=22.2 w=22.2
X61 w_n8809_8685# a_n8609_2082# a_n8609_14110# w_n8809_8685# sky130_fd_pr__pfet_g5v0d10v5 ad=0.2175 pd=1.79 as=0.2175 ps=1.79 w=1.5 l=4
X62 a_n8609_4082# a_n8609_4082# vss vss sky130_fd_pr__nfet_g5v0d10v5 ad=0.145 pd=1.29 as=0.145 ps=1.29 w=1 l=4
X63 vin a_n8581_n15597# a_n8639_n20509# vss sky130_fd_pr__nfet_05v0_nvt ad=1.45 pd=10.29 as=1.45 ps=10.29 w=10 l=0.9
X64 vss a_n8609_4082# a_n8609_4082# vss sky130_fd_pr__nfet_g5v0d10v5 ad=0.145 pd=1.29 as=0.29 ps=2.58 w=1 l=4
X65 a_n8609_2082# ibias vss vss sky130_fd_pr__nfet_g5v0d10v5 ad=0.145 pd=1.29 as=0.145 ps=1.29 w=1 l=4
X66 ibias ibias vss vss sky130_fd_pr__nfet_g5v0d10v5 ad=0.145 pd=1.29 as=0.145 ps=1.29 w=1 l=4
X67 vin a_n8581_n15597# a_n8639_n20509# vss sky130_fd_pr__nfet_05v0_nvt ad=1.45 pd=10.29 as=1.45 ps=10.29 w=10 l=0.9
X68 a_n8609_2082# ibias vss vss sky130_fd_pr__nfet_g5v0d10v5 ad=0.145 pd=1.29 as=0.145 ps=1.29 w=1 l=4
X69 a_n8639_n20509# a_n8581_n15597# vin vss sky130_fd_pr__nfet_05v0_nvt ad=1.45 pd=10.29 as=1.45 ps=10.29 w=10 l=0.9
X70 a_n8639_n20509# a_n8581_n15597# vin vss sky130_fd_pr__nfet_05v0_nvt ad=1.45 pd=10.29 as=1.45 ps=10.29 w=10 l=0.9
X71 a_n8639_n20509# a_n8581_n15597# vin vss sky130_fd_pr__nfet_05v0_nvt ad=1.45 pd=10.29 as=1.45 ps=10.29 w=10 l=0.9
X72 vss ibias ibias vss sky130_fd_pr__nfet_g5v0d10v5 ad=0.145 pd=1.29 as=0.145 ps=1.29 w=1 l=4
X73 a_n8609_2082# a_n8609_2082# w_n8809_8685# w_n8809_8685# sky130_fd_pr__pfet_g5v0d10v5 ad=0.2175 pd=1.79 as=0.2175 ps=1.79 w=1.5 l=4
X74 a_n8609_2082# a_n8609_2082# w_n8809_8685# w_n8809_8685# sky130_fd_pr__pfet_g5v0d10v5 ad=0.2175 pd=1.79 as=0.2175 ps=1.79 w=1.5 l=4
X75 vin a_n8581_n15597# a_n8639_n20509# vss sky130_fd_pr__nfet_05v0_nvt ad=1.45 pd=10.29 as=1.45 ps=10.29 w=10 l=0.9
X76 w_n8809_8685# a_n8609_2082# a_n8609_11046# w_n8809_8685# sky130_fd_pr__pfet_g5v0d10v5 ad=0.2175 pd=1.79 as=0.2175 ps=1.79 w=1.5 l=4
X77 ibias ibias vss vss sky130_fd_pr__nfet_g5v0d10v5 ad=0.145 pd=1.29 as=0.145 ps=1.29 w=1 l=4
X78 a_n8639_n20509# a_n8581_n15597# vin vss sky130_fd_pr__nfet_05v0_nvt ad=1.45 pd=10.29 as=1.45 ps=10.29 w=10 l=0.9
X79 a_n8639_n20509# a_n8581_n15597# vin vss sky130_fd_pr__nfet_05v0_nvt ad=1.45 pd=10.29 as=1.45 ps=10.29 w=10 l=0.9
X80 a_n8609_2082# a_n8609_2082# w_n8809_8685# w_n8809_8685# sky130_fd_pr__pfet_g5v0d10v5 ad=0.2175 pd=1.79 as=0.2175 ps=1.79 w=1.5 l=4
X81 a_n8581_n15597# vss sky130_fd_pr__cap_mim_m3_1 l=22.2 w=22.2
X82 vss ibias a_n8609_2082# vss sky130_fd_pr__nfet_g5v0d10v5 ad=0.145 pd=1.29 as=0.145 ps=1.29 w=1 l=4
X83 a_n8639_n20509# a_n8581_n15597# vin vss sky130_fd_pr__nfet_05v0_nvt ad=1.45 pd=10.29 as=1.45 ps=10.29 w=10 l=0.9
X84 a_n8609_14110# a_n8609_2082# w_n8809_8685# w_n8809_8685# sky130_fd_pr__pfet_g5v0d10v5 ad=0.2175 pd=1.79 as=0.2175 ps=1.79 w=1.5 l=4
X85 ibias ibias vss vss sky130_fd_pr__nfet_g5v0d10v5 ad=0.145 pd=1.29 as=0.145 ps=1.29 w=1 l=4
X86 a_n8581_n15597# vss sky130_fd_pr__cap_mim_m3_1 l=22.2 w=22.2
X87 a_n8609_14110# a_n8609_2082# w_n8809_8685# w_n8809_8685# sky130_fd_pr__pfet_g5v0d10v5 ad=0.2175 pd=1.79 as=0.2175 ps=1.79 w=1.5 l=4
X88 w_n8809_8685# a_n8609_2082# a_n8609_11046# w_n8809_8685# sky130_fd_pr__pfet_g5v0d10v5 ad=0.2175 pd=1.79 as=0.2175 ps=1.79 w=1.5 l=4
X89 w_n8809_8685# a_n8609_2082# a_n8609_2082# w_n8809_8685# sky130_fd_pr__pfet_g5v0d10v5 ad=0.2175 pd=1.79 as=0.2175 ps=1.79 w=1.5 l=4
X90 vin a_n8581_n15597# a_n8639_n20509# vss sky130_fd_pr__nfet_05v0_nvt ad=1.45 pd=10.29 as=1.45 ps=10.29 w=10 l=0.9
X91 a_n8609_14110# a_n8609_6082# vss vss sky130_fd_pr__nfet_g5v0d10v5 ad=1.45 pd=10.29 as=1.45 ps=10.29 w=10 l=0.5
X92 w_n8809_8685# a_n8609_2082# a_n8609_11046# w_n8809_8685# sky130_fd_pr__pfet_g5v0d10v5 ad=0.2175 pd=1.79 as=0.2175 ps=1.79 w=1.5 l=4
X93 vss a_n8609_4082# a_n8609_4082# vss sky130_fd_pr__nfet_g5v0d10v5 ad=0.145 pd=1.29 as=0.145 ps=1.29 w=1 l=4
X94 ibias ibias vss vss sky130_fd_pr__nfet_g5v0d10v5 ad=0.145 pd=1.29 as=0.145 ps=1.29 w=1 l=4
X95 a_n8639_n20509# a_n8581_n15597# vin vss sky130_fd_pr__nfet_05v0_nvt ad=1.45 pd=10.29 as=1.45 ps=10.29 w=10 l=0.9
X96 vss ibias a_n8609_2082# vss sky130_fd_pr__nfet_g5v0d10v5 ad=0.145 pd=1.29 as=0.145 ps=1.29 w=1 l=4
X97 w_n8809_8685# a_n8609_2082# a_n8609_11046# w_n8809_8685# sky130_fd_pr__pfet_g5v0d10v5 ad=0.2175 pd=1.79 as=0.2175 ps=1.79 w=1.5 l=4
X98 vin a_n8581_n15597# a_n8639_n20509# vss sky130_fd_pr__nfet_05v0_nvt ad=1.45 pd=10.29 as=1.45 ps=10.29 w=10 l=0.9
X99 w_n8809_8685# vss sky130_fd_pr__cap_mim_m3_1 l=22.2 w=22.2
X100 w_n8809_8685# a_n8609_2082# a_n8609_14110# w_n8809_8685# sky130_fd_pr__pfet_g5v0d10v5 ad=0.2175 pd=1.79 as=0.2175 ps=1.79 w=1.5 l=4
X101 vss a_n8609_4082# a_n8609_4082# vss sky130_fd_pr__nfet_g5v0d10v5 ad=0.145 pd=1.29 as=0.145 ps=1.29 w=1 l=4
X102 a_n8609_4082# a_n8609_4082# vss vss sky130_fd_pr__nfet_g5v0d10v5 ad=0.145 pd=1.29 as=0.145 ps=1.29 w=1 l=4
X103 a_n8609_2082# ibias vss vss sky130_fd_pr__nfet_g5v0d10v5 ad=0.145 pd=1.29 as=0.145 ps=1.29 w=1 l=4
X104 w_n8809_8685# a_n8609_2082# a_n8609_14110# w_n8809_8685# sky130_fd_pr__pfet_g5v0d10v5 ad=0.2175 pd=1.79 as=0.435 ps=3.58 w=1.5 l=4
X105 a_n8609_2082# a_n8609_2082# w_n8809_8685# w_n8809_8685# sky130_fd_pr__pfet_g5v0d10v5 ad=0.2175 pd=1.79 as=0.2175 ps=1.79 w=1.5 l=4
X106 w_n8809_8685# vss sky130_fd_pr__cap_mim_m3_1 l=22.2 w=22.2
X107 w_n8809_8685# a_n8609_2082# a_n8609_14110# w_n8809_8685# sky130_fd_pr__pfet_g5v0d10v5 ad=0.2175 pd=1.79 as=0.2175 ps=1.79 w=1.5 l=4
X108 a_n8609_14110# a_n8609_2082# w_n8809_8685# w_n8809_8685# sky130_fd_pr__pfet_g5v0d10v5 ad=0.2175 pd=1.79 as=0.2175 ps=1.79 w=1.5 l=4
X109 a_n8639_n20509# a_n8581_n15597# vin vss sky130_fd_pr__nfet_05v0_nvt ad=1.45 pd=10.29 as=1.45 ps=10.29 w=10 l=0.9
X110 w_n8809_8685# vss sky130_fd_pr__cap_mim_m3_1 l=22.2 w=22.2
X111 vin a_n8581_n15597# a_n8639_n20509# vss sky130_fd_pr__nfet_05v0_nvt ad=1.45 pd=10.29 as=1.45 ps=10.29 w=10 l=0.9
X112 w_n8809_8685# a_n8609_2082# a_n8609_14110# w_n8809_8685# sky130_fd_pr__pfet_g5v0d10v5 ad=0.2175 pd=1.79 as=0.2175 ps=1.79 w=1.5 l=4
X113 a_n8609_14110# a_n8609_2082# w_n8809_8685# w_n8809_8685# sky130_fd_pr__pfet_g5v0d10v5 ad=0.2175 pd=1.79 as=0.2175 ps=1.79 w=1.5 l=4
X114 a_n8609_14110# a_n8609_2082# w_n8809_8685# w_n8809_8685# sky130_fd_pr__pfet_g5v0d10v5 ad=0.2175 pd=1.79 as=0.2175 ps=1.79 w=1.5 l=4
X115 w_n8809_8685# a_n8609_2082# a_n8609_14110# w_n8809_8685# sky130_fd_pr__pfet_g5v0d10v5 ad=0.2175 pd=1.79 as=0.2175 ps=1.79 w=1.5 l=4
X116 a_n8609_2082# a_n8609_2082# w_n8809_8685# w_n8809_8685# sky130_fd_pr__pfet_g5v0d10v5 ad=0.2175 pd=1.79 as=0.2175 ps=1.79 w=1.5 l=4
X117 w_n8809_8685# a_n8609_2082# a_n8609_14110# w_n8809_8685# sky130_fd_pr__pfet_g5v0d10v5 ad=0.2175 pd=1.79 as=0.2175 ps=1.79 w=1.5 l=4
X118 w_n8809_8685# a_n8609_2082# a_n8609_2082# w_n8809_8685# sky130_fd_pr__pfet_g5v0d10v5 ad=0.2175 pd=1.79 as=0.2175 ps=1.79 w=1.5 l=4
X119 a_n8609_6082# a_n8609_4082# vss vss sky130_fd_pr__nfet_g5v0d10v5 ad=0.29 pd=2.58 as=0.145 ps=1.29 w=1 l=4
X120 a_n8639_n20509# a_n8581_n15597# vin vss sky130_fd_pr__nfet_05v0_nvt ad=1.45 pd=10.29 as=1.45 ps=10.29 w=10 l=0.9
X121 a_n8609_6082# a_n8609_4082# vss vss sky130_fd_pr__nfet_g5v0d10v5 ad=0.145 pd=1.29 as=0.145 ps=1.29 w=1 l=4
X122 vss ibias ibias vss sky130_fd_pr__nfet_g5v0d10v5 ad=0.145 pd=1.29 as=0.145 ps=1.29 w=1 l=4
X123 a_n8639_n20509# a_n8609_14110# out vss sky130_fd_pr__nfet_05v0_nvt ad=1.45 pd=10.29 as=1.45 ps=10.29 w=10 l=0.9
X124 a_n8639_n20509# a_n8581_n15597# vin vss sky130_fd_pr__nfet_05v0_nvt ad=1.45 pd=10.29 as=1.45 ps=10.29 w=10 l=0.9
X125 a_n8639_n20509# a_n8581_n15597# vin vss sky130_fd_pr__nfet_05v0_nvt ad=1.45 pd=10.29 as=1.45 ps=10.29 w=10 l=0.9
X126 w_n8809_8685# a_n8609_2082# a_n8609_14110# w_n8809_8685# sky130_fd_pr__pfet_g5v0d10v5 ad=0.2175 pd=1.79 as=0.2175 ps=1.79 w=1.5 l=4
X127 vss a_n8609_4082# a_n8609_6082# vss sky130_fd_pr__nfet_g5v0d10v5 ad=0.145 pd=1.29 as=0.145 ps=1.29 w=1 l=4
X128 a_n8609_6082# a_n8609_4082# vss vss sky130_fd_pr__nfet_g5v0d10v5 ad=0.145 pd=1.29 as=0.145 ps=1.29 w=1 l=4
X129 a_n8609_2082# ibias vss vss sky130_fd_pr__nfet_g5v0d10v5 ad=0.145 pd=1.29 as=0.145 ps=1.29 w=1 l=4
X130 vin a_n8581_n15597# a_n8639_n20509# vss sky130_fd_pr__nfet_05v0_nvt ad=1.45 pd=10.29 as=1.45 ps=10.29 w=10 l=0.9
X131 w_n8809_8685# a_n8609_2082# a_n8609_14110# w_n8809_8685# sky130_fd_pr__pfet_g5v0d10v5 ad=0.2175 pd=1.79 as=0.2175 ps=1.79 w=1.5 l=4
X132 a_n8609_11046# a_n8609_2082# w_n8809_8685# w_n8809_8685# sky130_fd_pr__pfet_g5v0d10v5 ad=0.2175 pd=1.79 as=0.2175 ps=1.79 w=1.5 l=4
X133 vss ibias a_n8609_2082# vss sky130_fd_pr__nfet_g5v0d10v5 ad=0.145 pd=1.29 as=0.29 ps=2.58 w=1 l=4
X134 a_n8609_14110# a_n8609_2082# w_n8809_8685# w_n8809_8685# sky130_fd_pr__pfet_g5v0d10v5 ad=0.435 pd=3.58 as=0.2175 ps=1.79 w=1.5 l=4
X135 a_n8639_n20509# a_n8609_14110# out vss sky130_fd_pr__nfet_05v0_nvt ad=1.45 pd=10.29 as=1.45 ps=10.29 w=10 l=0.9
X136 vin a_n8581_n15597# a_n8639_n20509# vss sky130_fd_pr__nfet_05v0_nvt ad=2.9 pd=20.58 as=1.45 ps=10.29 w=10 l=0.9
X137 a_n8639_n20509# a_n8581_n15597# vin vss sky130_fd_pr__nfet_05v0_nvt ad=1.45 pd=10.29 as=1.45 ps=10.29 w=10 l=0.9
X138 w_n8809_8685# a_n8609_2082# a_n8609_14110# w_n8809_8685# sky130_fd_pr__pfet_g5v0d10v5 ad=0.2175 pd=1.79 as=0.2175 ps=1.79 w=1.5 l=4
X139 a_n8639_n20509# a_n8609_14110# out vss sky130_fd_pr__nfet_05v0_nvt ad=1.45 pd=10.29 as=1.45 ps=10.29 w=10 l=0.9
X140 w_n8809_8685# a_n8609_2082# a_n8609_11046# w_n8809_8685# sky130_fd_pr__pfet_g5v0d10v5 ad=0.2175 pd=1.79 as=0.2175 ps=1.79 w=1.5 l=4
X141 w_n8809_8685# a_n8609_2082# a_n8609_11046# w_n8809_8685# sky130_fd_pr__pfet_g5v0d10v5 ad=0.2175 pd=1.79 as=0.435 ps=3.58 w=1.5 l=4
X142 vss a_n8609_4082# a_n8609_6082# vss sky130_fd_pr__nfet_g5v0d10v5 ad=0.145 pd=1.29 as=0.145 ps=1.29 w=1 l=4
X143 vss ibias ibias vss sky130_fd_pr__nfet_g5v0d10v5 ad=0.145 pd=1.29 as=0.145 ps=1.29 w=1 l=4
X144 a_n8609_14110# a_n8609_2082# w_n8809_8685# w_n8809_8685# sky130_fd_pr__pfet_g5v0d10v5 ad=0.2175 pd=1.79 as=0.2175 ps=1.79 w=1.5 l=4
X145 a_n8609_11046# a_n8609_2082# w_n8809_8685# w_n8809_8685# sky130_fd_pr__pfet_g5v0d10v5 ad=0.2175 pd=1.79 as=0.2175 ps=1.79 w=1.5 l=4
X146 a_n8609_2082# a_n8609_2082# w_n8809_8685# w_n8809_8685# sky130_fd_pr__pfet_g5v0d10v5 ad=0.2175 pd=1.79 as=0.2175 ps=1.79 w=1.5 l=4
X147 a_n8609_14110# a_n8609_2082# w_n8809_8685# w_n8809_8685# sky130_fd_pr__pfet_g5v0d10v5 ad=0.2175 pd=1.79 as=0.2175 ps=1.79 w=1.5 l=4
X148 ibias ibias vss vss sky130_fd_pr__nfet_g5v0d10v5 ad=0.145 pd=1.29 as=0.145 ps=1.29 w=1 l=4
X149 ibias ibias vss vss sky130_fd_pr__nfet_g5v0d10v5 ad=0.145 pd=1.29 as=0.145 ps=1.29 w=1 l=4
X150 a_n8639_n20509# a_n8581_n15597# vin vss sky130_fd_pr__nfet_05v0_nvt ad=1.45 pd=10.29 as=1.45 ps=10.29 w=10 l=0.9
X151 w_n8809_8685# a_n8609_2082# a_n8609_14110# w_n8809_8685# sky130_fd_pr__pfet_g5v0d10v5 ad=0.2175 pd=1.79 as=0.2175 ps=1.79 w=1.5 l=4
X152 w_n8809_8685# a_n8609_2082# a_n8609_11046# w_n8809_8685# sky130_fd_pr__pfet_g5v0d10v5 ad=0.2175 pd=1.79 as=0.2175 ps=1.79 w=1.5 l=4
X153 a_n8639_n20509# a_n8609_14110# out vss sky130_fd_pr__nfet_05v0_nvt ad=1.45 pd=10.29 as=1.45 ps=10.29 w=10 l=0.9
X154 vss a_n8609_4082# a_n8609_6082# vss sky130_fd_pr__nfet_g5v0d10v5 ad=0.145 pd=1.29 as=0.145 ps=1.29 w=1 l=4
X155 vin a_n8581_n15597# a_n8639_n20509# vss sky130_fd_pr__nfet_05v0_nvt ad=1.45 pd=10.29 as=1.45 ps=10.29 w=10 l=0.9
X156 a_n8609_6082# a_n8609_4082# vss vss sky130_fd_pr__nfet_g5v0d10v5 ad=0.145 pd=1.29 as=0.145 ps=1.29 w=1 l=4
X157 a_n8609_14110# a_n8609_2082# w_n8809_8685# w_n8809_8685# sky130_fd_pr__pfet_g5v0d10v5 ad=0.2175 pd=1.79 as=0.2175 ps=1.79 w=1.5 l=4
X158 w_n8809_8685# a_n8609_2082# a_n8609_14110# w_n8809_8685# sky130_fd_pr__pfet_g5v0d10v5 ad=0.2175 pd=1.79 as=0.2175 ps=1.79 w=1.5 l=4
X159 vss ibias a_n8609_2082# vss sky130_fd_pr__nfet_g5v0d10v5 ad=0.145 pd=1.29 as=0.145 ps=1.29 w=1 l=4
X160 a_n8609_11046# a_n8609_2082# w_n8809_8685# w_n8809_8685# sky130_fd_pr__pfet_g5v0d10v5 ad=0.2175 pd=1.79 as=0.2175 ps=1.79 w=1.5 l=4
X161 a_n8639_n20509# a_n8609_14110# out vss sky130_fd_pr__nfet_05v0_nvt ad=1.45 pd=10.29 as=1.45 ps=10.29 w=10 l=0.9
X162 w_n8809_8685# a_n8609_2082# a_n8609_14110# w_n8809_8685# sky130_fd_pr__pfet_g5v0d10v5 ad=0.2175 pd=1.79 as=0.2175 ps=1.79 w=1.5 l=4
X163 a_n8609_14110# a_n8609_2082# w_n8809_8685# w_n8809_8685# sky130_fd_pr__pfet_g5v0d10v5 ad=0.2175 pd=1.79 as=0.2175 ps=1.79 w=1.5 l=4
X164 w_n8809_8685# a_n8609_2082# a_n8609_14110# w_n8809_8685# sky130_fd_pr__pfet_g5v0d10v5 ad=0.2175 pd=1.79 as=0.2175 ps=1.79 w=1.5 l=4
X165 vss a_n8609_4082# a_n8609_6082# vss sky130_fd_pr__nfet_g5v0d10v5 ad=0.145 pd=1.29 as=0.29 ps=2.58 w=1 l=4
X166 vss ibias ibias vss sky130_fd_pr__nfet_g5v0d10v5 ad=0.145 pd=1.29 as=0.145 ps=1.29 w=1 l=4
X167 a_n8639_n20509# a_n8609_14110# out vss sky130_fd_pr__nfet_05v0_nvt ad=1.45 pd=10.29 as=1.45 ps=10.29 w=10 l=0.9
X168 a_n8639_n20509# a_n8581_n15597# vin vss sky130_fd_pr__nfet_05v0_nvt ad=1.45 pd=10.29 as=1.45 ps=10.29 w=10 l=0.9
X169 vin a_n8581_n15597# a_n8639_n20509# vss sky130_fd_pr__nfet_05v0_nvt ad=1.45 pd=10.29 as=1.45 ps=10.29 w=10 l=0.9
X170 vss a_n8609_4082# a_n8609_6082# vss sky130_fd_pr__nfet_g5v0d10v5 ad=0.145 pd=1.29 as=0.145 ps=1.29 w=1 l=4
X171 vin a_n8581_n15597# a_n8639_n20509# vss sky130_fd_pr__nfet_05v0_nvt ad=1.45 pd=10.29 as=1.45 ps=10.29 w=10 l=0.9
X172 vss ibias a_n8609_2082# vss sky130_fd_pr__nfet_g5v0d10v5 ad=0.145 pd=1.29 as=0.145 ps=1.29 w=1 l=4
X173 a_n8609_2082# ibias vss vss sky130_fd_pr__nfet_g5v0d10v5 ad=0.145 pd=1.29 as=0.145 ps=1.29 w=1 l=4
X174 w_n8809_8685# vss sky130_fd_pr__cap_mim_m3_1 l=22.2 w=22.2
X175 a_n8609_14110# a_n8609_2082# w_n8809_8685# w_n8809_8685# sky130_fd_pr__pfet_g5v0d10v5 ad=0.2175 pd=1.79 as=0.2175 ps=1.79 w=1.5 l=4
X176 w_n8809_8685# a_n8609_2082# a_n8609_14110# w_n8809_8685# sky130_fd_pr__pfet_g5v0d10v5 ad=0.2175 pd=1.79 as=0.2175 ps=1.79 w=1.5 l=4
X177 vss ibias ibias vss sky130_fd_pr__nfet_g5v0d10v5 ad=0.145 pd=1.29 as=0.145 ps=1.29 w=1 l=4
X178 a_n8639_n20509# a_n8581_n15597# vin vss sky130_fd_pr__nfet_05v0_nvt ad=1.45 pd=10.29 as=2.9 ps=20.58 w=10 l=0.9
X179 vin a_n8581_n15597# a_n8639_n20509# vss sky130_fd_pr__nfet_05v0_nvt ad=1.45 pd=10.29 as=1.45 ps=10.29 w=10 l=0.9
X180 w_n8809_8685# a_n8609_2082# a_n8609_14110# w_n8809_8685# sky130_fd_pr__pfet_g5v0d10v5 ad=0.2175 pd=1.79 as=0.2175 ps=1.79 w=1.5 l=4
X181 a_n8639_n20509# a_n8609_14110# out vss sky130_fd_pr__nfet_05v0_nvt ad=1.45 pd=10.29 as=1.45 ps=10.29 w=10 l=0.9
X182 a_n8639_n20509# a_n8609_14110# out vss sky130_fd_pr__nfet_05v0_nvt ad=1.45 pd=10.29 as=1.45 ps=10.29 w=10 l=0.9
X183 w_n8809_8685# a_n8609_2082# a_n8609_14110# w_n8809_8685# sky130_fd_pr__pfet_g5v0d10v5 ad=0.2175 pd=1.79 as=0.2175 ps=1.79 w=1.5 l=4
X184 w_n8809_8685# a_n8609_2082# a_n8609_14110# w_n8809_8685# sky130_fd_pr__pfet_g5v0d10v5 ad=0.2175 pd=1.79 as=0.435 ps=3.58 w=1.5 l=4
X185 a_n8609_14110# a_n8609_2082# w_n8809_8685# w_n8809_8685# sky130_fd_pr__pfet_g5v0d10v5 ad=0.2175 pd=1.79 as=0.2175 ps=1.79 w=1.5 l=4
X186 w_n8809_8685# vss sky130_fd_pr__cap_mim_m3_1 l=22.2 w=22.2
X187 w_n8809_8685# a_n8609_2082# a_n8609_2082# w_n8809_8685# sky130_fd_pr__pfet_g5v0d10v5 ad=0.2175 pd=1.79 as=0.2175 ps=1.79 w=1.5 l=4
X188 a_n8609_4082# a_n8609_4082# vss vss sky130_fd_pr__nfet_g5v0d10v5 ad=0.29 pd=2.58 as=0.145 ps=1.29 w=1 l=4
X189 w_n8809_8685# a_n8609_2082# a_n8609_14110# w_n8809_8685# sky130_fd_pr__pfet_g5v0d10v5 ad=0.2175 pd=1.79 as=0.2175 ps=1.79 w=1.5 l=4
X190 w_n8809_8685# a_n8609_2082# a_n8609_14110# w_n8809_8685# sky130_fd_pr__pfet_g5v0d10v5 ad=0.2175 pd=1.79 as=0.2175 ps=1.79 w=1.5 l=4
X191 a_n8609_11046# ref a_n8609_6082# w_n8809_8685# sky130_fd_pr__pfet_g5v0d10v5 ad=4.35 pd=30.58 as=4.35 ps=30.58 w=15 l=1
X192 a_n8609_14110# a_n8609_2082# w_n8809_8685# w_n8809_8685# sky130_fd_pr__pfet_g5v0d10v5 ad=0.2175 pd=1.79 as=0.2175 ps=1.79 w=1.5 l=4
X193 w_n8809_8685# a_n8609_2082# a_n8609_14110# w_n8809_8685# sky130_fd_pr__pfet_g5v0d10v5 ad=0.2175 pd=1.79 as=0.2175 ps=1.79 w=1.5 l=4
X194 a_n8609_4082# a_n8609_4082# vss vss sky130_fd_pr__nfet_g5v0d10v5 ad=0.145 pd=1.29 as=0.145 ps=1.29 w=1 l=4
X195 a_n8609_11046# a_n8609_2082# w_n8809_8685# w_n8809_8685# sky130_fd_pr__pfet_g5v0d10v5 ad=0.2175 pd=1.79 as=0.2175 ps=1.79 w=1.5 l=4
X196 vss a_n8609_4082# a_n8609_6082# vss sky130_fd_pr__nfet_g5v0d10v5 ad=0.145 pd=1.29 as=0.145 ps=1.29 w=1 l=4
X197 vss a_n8609_4082# a_n8609_4082# vss sky130_fd_pr__nfet_g5v0d10v5 ad=0.145 pd=1.29 as=0.145 ps=1.29 w=1 l=4
X198 a_n8581_n15597# vss sky130_fd_pr__cap_mim_m3_1 l=22.2 w=22.2
X199 out a_n8609_14110# a_n8639_n20509# vss sky130_fd_pr__nfet_05v0_nvt ad=1.45 pd=10.29 as=1.45 ps=10.29 w=10 l=0.9
X200 w_n8809_8685# a_n8609_2082# a_n8609_11046# w_n8809_8685# sky130_fd_pr__pfet_g5v0d10v5 ad=0.2175 pd=1.79 as=0.2175 ps=1.79 w=1.5 l=4
X201 a_n8609_4082# a_n8609_4082# vss vss sky130_fd_pr__nfet_g5v0d10v5 ad=0.145 pd=1.29 as=0.145 ps=1.29 w=1 l=4
X202 vin a_n8581_n15597# a_n8639_n20509# vss sky130_fd_pr__nfet_05v0_nvt ad=1.45 pd=10.29 as=1.45 ps=10.29 w=10 l=0.9
X203 a_n8609_6082# a_n8609_4082# vss vss sky130_fd_pr__nfet_g5v0d10v5 ad=0.145 pd=1.29 as=0.145 ps=1.29 w=1 l=4
X204 a_n8639_n20509# a_n8609_14110# out vss sky130_fd_pr__nfet_05v0_nvt ad=1.45 pd=10.29 as=1.45 ps=10.29 w=10 l=0.9
X205 a_n8639_n20509# a_n8581_n15597# vin vss sky130_fd_pr__nfet_05v0_nvt ad=1.45 pd=10.29 as=1.45 ps=10.29 w=10 l=0.9
X206 a_n8639_n20509# a_n8581_n15597# vin vss sky130_fd_pr__nfet_05v0_nvt ad=1.45 pd=10.29 as=1.45 ps=10.29 w=10 l=0.9
X207 w_n8809_8685# a_n8609_2082# a_n8609_14110# w_n8809_8685# sky130_fd_pr__pfet_g5v0d10v5 ad=0.2175 pd=1.79 as=0.2175 ps=1.79 w=1.5 l=4
X208 vss a_n8609_4082# a_n8609_4082# vss sky130_fd_pr__nfet_g5v0d10v5 ad=0.145 pd=1.29 as=0.145 ps=1.29 w=1 l=4
X209 a_n8609_11046# a_n8609_2082# w_n8809_8685# w_n8809_8685# sky130_fd_pr__pfet_g5v0d10v5 ad=0.2175 pd=1.79 as=0.2175 ps=1.79 w=1.5 l=4
X210 out a_n8609_14110# a_n8639_n20509# vss sky130_fd_pr__nfet_05v0_nvt ad=1.45 pd=10.29 as=1.45 ps=10.29 w=10 l=0.9
X211 w_n8809_8685# a_n8609_2082# a_n8609_11046# w_n8809_8685# sky130_fd_pr__pfet_g5v0d10v5 ad=0.2175 pd=1.79 as=0.2175 ps=1.79 w=1.5 l=4
X212 a_n8639_n20509# a_n8581_n15597# vin vss sky130_fd_pr__nfet_05v0_nvt ad=1.45 pd=10.29 as=1.45 ps=10.29 w=10 l=0.9
X213 a_n8639_n20509# a_n8581_n15597# vin vss sky130_fd_pr__nfet_05v0_nvt ad=1.45 pd=10.29 as=1.45 ps=10.29 w=10 l=0.9
X214 a_n8609_14110# a_n8609_2082# w_n8809_8685# w_n8809_8685# sky130_fd_pr__pfet_g5v0d10v5 ad=0.2175 pd=1.79 as=0.2175 ps=1.79 w=1.5 l=4
X215 a_n8639_n20509# a_n8581_n15597# vin vss sky130_fd_pr__nfet_05v0_nvt ad=1.45 pd=10.29 as=1.45 ps=10.29 w=10 l=0.9
X216 w_n8809_8685# a_n8609_2082# a_n8609_11046# w_n8809_8685# sky130_fd_pr__pfet_g5v0d10v5 ad=0.2175 pd=1.79 as=0.2175 ps=1.79 w=1.5 l=4
X217 vss a_n8609_4082# a_n8609_4082# vss sky130_fd_pr__nfet_g5v0d10v5 ad=0.145 pd=1.29 as=0.145 ps=1.29 w=1 l=4
X218 a_n8639_n20509# a_n8609_14110# out vss sky130_fd_pr__nfet_05v0_nvt ad=1.45 pd=10.29 as=1.45 ps=10.29 w=10 l=0.9
X219 a_n8609_14110# a_n8609_2082# w_n8809_8685# w_n8809_8685# sky130_fd_pr__pfet_g5v0d10v5 ad=0.2175 pd=1.79 as=0.2175 ps=1.79 w=1.5 l=4
X220 ibias ibias vss vss sky130_fd_pr__nfet_g5v0d10v5 ad=0.145 pd=1.29 as=0.145 ps=1.29 w=1 l=4
X221 a_n8609_4082# a_n8609_4082# vss vss sky130_fd_pr__nfet_g5v0d10v5 ad=0.145 pd=1.29 as=0.145 ps=1.29 w=1 l=4
X222 w_n8809_8685# a_n8609_2082# a_n8609_14110# w_n8809_8685# sky130_fd_pr__pfet_g5v0d10v5 ad=0.2175 pd=1.79 as=0.435 ps=3.58 w=1.5 l=4
X223 a_n8609_14110# a_n8609_2082# w_n8809_8685# w_n8809_8685# sky130_fd_pr__pfet_g5v0d10v5 ad=0.2175 pd=1.79 as=0.2175 ps=1.79 w=1.5 l=4
X224 vss a_n8609_4082# a_n8609_4082# vss sky130_fd_pr__nfet_g5v0d10v5 ad=0.145 pd=1.29 as=0.29 ps=2.58 w=1 l=4
X225 w_n8809_8685# a_n8609_2082# a_n8609_14110# w_n8809_8685# sky130_fd_pr__pfet_g5v0d10v5 ad=0.2175 pd=1.79 as=0.2175 ps=1.79 w=1.5 l=4
X226 vss a_n8609_4082# a_n8609_4082# vss sky130_fd_pr__nfet_g5v0d10v5 ad=0.145 pd=1.29 as=0.145 ps=1.29 w=1 l=4
X227 a_n8639_n20509# a_n8581_n15597# vin vss sky130_fd_pr__nfet_05v0_nvt ad=1.45 pd=10.29 as=1.45 ps=10.29 w=10 l=0.9
X228 a_n8609_14110# a_n8609_2082# w_n8809_8685# w_n8809_8685# sky130_fd_pr__pfet_g5v0d10v5 ad=0.2175 pd=1.79 as=0.2175 ps=1.79 w=1.5 l=4
X229 w_n8809_8685# a_n8609_2082# a_n8609_14110# w_n8809_8685# sky130_fd_pr__pfet_g5v0d10v5 ad=0.2175 pd=1.79 as=0.2175 ps=1.79 w=1.5 l=4
X230 out a_n8609_14110# a_n8639_n20509# vss sky130_fd_pr__nfet_05v0_nvt ad=1.45 pd=10.29 as=1.45 ps=10.29 w=10 l=0.9
X231 a_n8639_n20509# a_n8581_n15597# vin vss sky130_fd_pr__nfet_05v0_nvt ad=1.45 pd=10.29 as=1.45 ps=10.29 w=10 l=0.9
X232 w_n8809_8685# vss sky130_fd_pr__cap_mim_m3_1 l=22.2 w=22.2
X233 vin a_n8581_n15597# a_n8639_n20509# vss sky130_fd_pr__nfet_05v0_nvt ad=1.45 pd=10.29 as=1.45 ps=10.29 w=10 l=0.9
X234 w_n8809_8685# a_n8609_2082# a_n8609_14110# w_n8809_8685# sky130_fd_pr__pfet_g5v0d10v5 ad=0.2175 pd=1.79 as=0.2175 ps=1.79 w=1.5 l=4
X235 ibias ibias vss vss sky130_fd_pr__nfet_g5v0d10v5 ad=0.145 pd=1.29 as=0.145 ps=1.29 w=1 l=4
X236 vin a_n8581_n15597# vss sky130_fd_pr__res_high_po w=1 l=97.39
X237 vin a_n8581_n15597# a_n8639_n20509# vss sky130_fd_pr__nfet_05v0_nvt ad=1.45 pd=10.29 as=1.45 ps=10.29 w=10 l=0.9
X238 w_n8809_8685# vss sky130_fd_pr__cap_mim_m3_1 l=22.2 w=22.2
X239 a_n8639_n20509# a_n8581_n15597# vin vss sky130_fd_pr__nfet_05v0_nvt ad=1.45 pd=10.29 as=1.45 ps=10.29 w=10 l=0.9
X240 vss a_n8609_4082# a_n8609_6082# vss sky130_fd_pr__nfet_g5v0d10v5 ad=0.145 pd=1.29 as=0.145 ps=1.29 w=1 l=4
X241 a_n8581_n15597# vss sky130_fd_pr__cap_mim_m3_1 l=22.2 w=22.2
X242 w_n8809_8685# a_n8609_2082# a_n8609_14110# w_n8809_8685# sky130_fd_pr__pfet_g5v0d10v5 ad=0.2175 pd=1.79 as=0.2175 ps=1.79 w=1.5 l=4
X243 a_n8609_14110# a_n8609_2082# w_n8809_8685# w_n8809_8685# sky130_fd_pr__pfet_g5v0d10v5 ad=0.2175 pd=1.79 as=0.2175 ps=1.79 w=1.5 l=4
X244 w_n8809_8685# vss sky130_fd_pr__cap_mim_m3_1 l=22.2 w=22.2
X245 w_n8809_8685# a_n8609_2082# a_n8609_14110# w_n8809_8685# sky130_fd_pr__pfet_g5v0d10v5 ad=0.2175 pd=1.79 as=0.2175 ps=1.79 w=1.5 l=4
X246 a_n8609_2082# ibias vss vss sky130_fd_pr__nfet_g5v0d10v5 ad=0.29 pd=2.58 as=0.145 ps=1.29 w=1 l=4
X247 ibias ibias vss vss sky130_fd_pr__nfet_g5v0d10v5 ad=0.145 pd=1.29 as=0.145 ps=1.29 w=1 l=4
X248 out a_n8609_14110# a_n8639_n20509# vss sky130_fd_pr__nfet_05v0_nvt ad=1.45 pd=10.29 as=1.45 ps=10.29 w=10 l=0.9
X249 a_n8609_11046# a_n8609_2082# w_n8809_8685# w_n8809_8685# sky130_fd_pr__pfet_g5v0d10v5 ad=0.2175 pd=1.79 as=0.2175 ps=1.79 w=1.5 l=4
X250 vss a_n8609_4082# a_n8609_4082# vss sky130_fd_pr__nfet_g5v0d10v5 ad=0.145 pd=1.29 as=0.145 ps=1.29 w=1 l=4
X251 a_n8609_2082# ibias vss vss sky130_fd_pr__nfet_g5v0d10v5 ad=0.145 pd=1.29 as=0.145 ps=1.29 w=1 l=4
X252 ibias ibias vss vss sky130_fd_pr__nfet_g5v0d10v5 ad=0.145 pd=1.29 as=0.145 ps=1.29 w=1 l=4
X253 vin a_n8581_n15597# a_n8639_n20509# vss sky130_fd_pr__nfet_05v0_nvt ad=1.45 pd=10.29 as=1.45 ps=10.29 w=10 l=0.9
X254 w_n8809_8685# a_n8609_2082# a_n8609_11046# w_n8809_8685# sky130_fd_pr__pfet_g5v0d10v5 ad=0.2175 pd=1.79 as=0.435 ps=3.58 w=1.5 l=4
X255 vss ibias a_n8609_2082# vss sky130_fd_pr__nfet_g5v0d10v5 ad=0.145 pd=1.29 as=0.145 ps=1.29 w=1 l=4
X256 a_n8609_11046# a_n8609_2082# w_n8809_8685# w_n8809_8685# sky130_fd_pr__pfet_g5v0d10v5 ad=0.2175 pd=1.79 as=0.2175 ps=1.79 w=1.5 l=4
X257 w_n8809_8685# vss sky130_fd_pr__cap_mim_m3_1 l=22.2 w=22.2
X258 a_n8609_2082# ibias vss vss sky130_fd_pr__nfet_g5v0d10v5 ad=0.145 pd=1.29 as=0.145 ps=1.29 w=1 l=4
X259 ibias ibias vss vss sky130_fd_pr__nfet_g5v0d10v5 ad=0.145 pd=1.29 as=0.145 ps=1.29 w=1 l=4
X260 w_n8809_8685# a_n8609_2082# a_n8609_11046# w_n8809_8685# sky130_fd_pr__pfet_g5v0d10v5 ad=0.2175 pd=1.79 as=0.2175 ps=1.79 w=1.5 l=4
X261 a_n8609_4082# a_n8609_4082# vss vss sky130_fd_pr__nfet_g5v0d10v5 ad=0.145 pd=1.29 as=0.145 ps=1.29 w=1 l=4
X262 w_n8809_8685# a_n8609_2082# a_n8609_2082# w_n8809_8685# sky130_fd_pr__pfet_g5v0d10v5 ad=0.2175 pd=1.79 as=0.2175 ps=1.79 w=1.5 l=4
X263 ibias ibias vss vss sky130_fd_pr__nfet_g5v0d10v5 ad=0.145 pd=1.29 as=0.145 ps=1.29 w=1 l=4
X264 vss ibias a_n8609_2082# vss sky130_fd_pr__nfet_g5v0d10v5 ad=0.145 pd=1.29 as=0.145 ps=1.29 w=1 l=4
X265 a_n8581_n15597# vss sky130_fd_pr__cap_mim_m3_1 l=22.2 w=22.2
X266 vin a_n8581_n15597# a_n8639_n20509# vss sky130_fd_pr__nfet_05v0_nvt ad=1.45 pd=10.29 as=1.45 ps=10.29 w=10 l=0.9
X267 a_n8639_n20509# a_n8581_n15597# vin vss sky130_fd_pr__nfet_05v0_nvt ad=1.45 pd=10.29 as=1.45 ps=10.29 w=10 l=0.9
X268 w_n8809_8685# a_n8609_2082# a_n8609_14110# w_n8809_8685# sky130_fd_pr__pfet_g5v0d10v5 ad=0.2175 pd=1.79 as=0.2175 ps=1.79 w=1.5 l=4
X269 a_n8609_14110# a_n8609_2082# w_n8809_8685# w_n8809_8685# sky130_fd_pr__pfet_g5v0d10v5 ad=0.2175 pd=1.79 as=0.2175 ps=1.79 w=1.5 l=4
X270 vin a_n8581_n15597# a_n8639_n20509# vss sky130_fd_pr__nfet_05v0_nvt ad=1.45 pd=10.29 as=1.45 ps=10.29 w=10 l=0.9
X271 vin a_n8581_n15597# a_n8639_n20509# vss sky130_fd_pr__nfet_05v0_nvt ad=1.45 pd=10.29 as=1.45 ps=10.29 w=10 l=0.9
X272 a_n8639_n20509# a_n8581_n15597# vin vss sky130_fd_pr__nfet_05v0_nvt ad=1.45 pd=10.29 as=2.9 ps=20.58 w=10 l=0.9
X273 w_n8809_8685# a_n8609_2082# a_n8609_14110# w_n8809_8685# sky130_fd_pr__pfet_g5v0d10v5 ad=0.2175 pd=1.79 as=0.2175 ps=1.79 w=1.5 l=4
X274 w_n8809_8685# a_n8609_2082# a_n8609_14110# w_n8809_8685# sky130_fd_pr__pfet_g5v0d10v5 ad=0.2175 pd=1.79 as=0.2175 ps=1.79 w=1.5 l=4
X275 a_n8609_11046# a_n8609_2082# w_n8809_8685# w_n8809_8685# sky130_fd_pr__pfet_g5v0d10v5 ad=0.2175 pd=1.79 as=0.2175 ps=1.79 w=1.5 l=4
X276 w_n8809_8685# a_n8609_2082# a_n8609_14110# w_n8809_8685# sky130_fd_pr__pfet_g5v0d10v5 ad=0.2175 pd=1.79 as=0.435 ps=3.58 w=1.5 l=4
X277 a_n8609_14110# a_n8609_2082# w_n8809_8685# w_n8809_8685# sky130_fd_pr__pfet_g5v0d10v5 ad=0.2175 pd=1.79 as=0.2175 ps=1.79 w=1.5 l=4
X278 a_n8609_2082# a_n8609_2082# w_n8809_8685# w_n8809_8685# sky130_fd_pr__pfet_g5v0d10v5 ad=0.435 pd=3.58 as=0.2175 ps=1.79 w=1.5 l=4
X279 vss ibias a_n8609_2082# vss sky130_fd_pr__nfet_g5v0d10v5 ad=0.145 pd=1.29 as=0.145 ps=1.29 w=1 l=4
X280 a_n8639_n20509# a_n8581_n15597# vin vss sky130_fd_pr__nfet_05v0_nvt ad=1.45 pd=10.29 as=1.45 ps=10.29 w=10 l=0.9
X281 a_n8609_14110# a_n8609_2082# w_n8809_8685# w_n8809_8685# sky130_fd_pr__pfet_g5v0d10v5 ad=0.2175 pd=1.79 as=0.2175 ps=1.79 w=1.5 l=4
X282 a_n8609_6082# a_n8609_4082# vss vss sky130_fd_pr__nfet_g5v0d10v5 ad=0.145 pd=1.29 as=0.145 ps=1.29 w=1 l=4
X283 a_n8609_2082# ibias vss vss sky130_fd_pr__nfet_g5v0d10v5 ad=0.145 pd=1.29 as=0.145 ps=1.29 w=1 l=4
X284 vin a_n8581_n15597# a_n8639_n20509# vss sky130_fd_pr__nfet_05v0_nvt ad=1.45 pd=10.29 as=1.45 ps=10.29 w=10 l=0.9
X285 a_n8639_n20509# a_n8581_n15597# vin vss sky130_fd_pr__nfet_05v0_nvt ad=1.45 pd=10.29 as=1.45 ps=10.29 w=10 l=0.9
X286 a_n8609_14110# a_n8609_2082# w_n8809_8685# w_n8809_8685# sky130_fd_pr__pfet_g5v0d10v5 ad=0.2175 pd=1.79 as=0.2175 ps=1.79 w=1.5 l=4
X287 w_n8809_8685# a_n8609_2082# a_n8609_14110# w_n8809_8685# sky130_fd_pr__pfet_g5v0d10v5 ad=0.2175 pd=1.79 as=0.2175 ps=1.79 w=1.5 l=4
X288 a_n8639_n20509# a_n8581_n15597# vin vss sky130_fd_pr__nfet_05v0_nvt ad=1.45 pd=10.29 as=1.45 ps=10.29 w=10 l=0.9
X289 a_n8639_n20509# a_n8581_n15597# vin vss sky130_fd_pr__nfet_05v0_nvt ad=1.45 pd=10.29 as=1.45 ps=10.29 w=10 l=0.9
X290 w_n8809_8685# a_n8609_2082# a_n8609_14110# w_n8809_8685# sky130_fd_pr__pfet_g5v0d10v5 ad=0.2175 pd=1.79 as=0.2175 ps=1.79 w=1.5 l=4
X291 a_n8609_6082# a_n8609_4082# vss vss sky130_fd_pr__nfet_g5v0d10v5 ad=0.145 pd=1.29 as=0.145 ps=1.29 w=1 l=4
X292 vss ibias a_n8609_2082# vss sky130_fd_pr__nfet_g5v0d10v5 ad=0.145 pd=1.29 as=0.29 ps=2.58 w=1 l=4
X293 a_n8609_14110# a_n8609_2082# w_n8809_8685# w_n8809_8685# sky130_fd_pr__pfet_g5v0d10v5 ad=0.2175 pd=1.79 as=0.2175 ps=1.79 w=1.5 l=4
X294 ibias ibias vss vss sky130_fd_pr__nfet_g5v0d10v5 ad=0.145 pd=1.29 as=0.145 ps=1.29 w=1 l=4
X295 vss ibias a_n8609_2082# vss sky130_fd_pr__nfet_g5v0d10v5 ad=0.145 pd=1.29 as=0.145 ps=1.29 w=1 l=4
X296 vin a_n8581_n15597# a_n8639_n20509# vss sky130_fd_pr__nfet_05v0_nvt ad=1.45 pd=10.29 as=1.45 ps=10.29 w=10 l=0.9
X297 vin a_n8581_n15597# a_n8639_n20509# vss sky130_fd_pr__nfet_05v0_nvt ad=2.9 pd=20.58 as=1.45 ps=10.29 w=10 l=0.9
X298 w_n8809_8685# a_n8609_2082# a_n8609_14110# w_n8809_8685# sky130_fd_pr__pfet_g5v0d10v5 ad=0.2175 pd=1.79 as=0.2175 ps=1.79 w=1.5 l=4
X299 w_n8809_8685# a_n8609_2082# a_n8609_14110# w_n8809_8685# sky130_fd_pr__pfet_g5v0d10v5 ad=0.2175 pd=1.79 as=0.2175 ps=1.79 w=1.5 l=4
X300 w_n8809_8685# a_n8609_2082# a_n8609_14110# w_n8809_8685# sky130_fd_pr__pfet_g5v0d10v5 ad=0.2175 pd=1.79 as=0.2175 ps=1.79 w=1.5 l=4
X301 vss a_n8609_4082# a_n8609_6082# vss sky130_fd_pr__nfet_g5v0d10v5 ad=0.145 pd=1.29 as=0.145 ps=1.29 w=1 l=4
X302 vss ibias ibias vss sky130_fd_pr__nfet_g5v0d10v5 ad=0.145 pd=1.29 as=0.145 ps=1.29 w=1 l=4
X303 vin a_n8581_n15597# a_n8639_n20509# vss sky130_fd_pr__nfet_05v0_nvt ad=1.45 pd=10.29 as=1.45 ps=10.29 w=10 l=0.9
X304 w_n8809_8685# a_n8609_2082# a_n8609_2082# w_n8809_8685# sky130_fd_pr__pfet_g5v0d10v5 ad=0.2175 pd=1.79 as=0.435 ps=3.58 w=1.5 l=4
X305 a_n8639_n20509# a_n8581_n15597# vin vss sky130_fd_pr__nfet_05v0_nvt ad=1.45 pd=10.29 as=1.45 ps=10.29 w=10 l=0.9
X306 a_n8609_14110# a_n8609_2082# w_n8809_8685# w_n8809_8685# sky130_fd_pr__pfet_g5v0d10v5 ad=0.2175 pd=1.79 as=0.2175 ps=1.79 w=1.5 l=4
X307 a_n8609_11046# a_n8609_2082# w_n8809_8685# w_n8809_8685# sky130_fd_pr__pfet_g5v0d10v5 ad=0.2175 pd=1.79 as=0.2175 ps=1.79 w=1.5 l=4
X308 vin a_n8581_n15597# a_n8639_n20509# vss sky130_fd_pr__nfet_05v0_nvt ad=1.45 pd=10.29 as=1.45 ps=10.29 w=10 l=0.9
X309 vss a_n8609_4082# a_n8609_4082# vss sky130_fd_pr__nfet_g5v0d10v5 ad=0.145 pd=1.29 as=0.145 ps=1.29 w=1 l=4
X310 vss ibias ibias vss sky130_fd_pr__nfet_g5v0d10v5 ad=0.145 pd=1.29 as=0.145 ps=1.29 w=1 l=4
X311 vin a_n8581_n15597# a_n8639_n20509# vss sky130_fd_pr__nfet_05v0_nvt ad=1.45 pd=10.29 as=1.45 ps=10.29 w=10 l=0.9
X312 a_n8639_n20509# a_n8581_n15597# vin vss sky130_fd_pr__nfet_05v0_nvt ad=1.45 pd=10.29 as=1.45 ps=10.29 w=10 l=0.9
X313 w_n8809_8685# a_n8609_2082# a_n8609_11046# w_n8809_8685# sky130_fd_pr__pfet_g5v0d10v5 ad=0.2175 pd=1.79 as=0.2175 ps=1.79 w=1.5 l=4
X314 w_n8809_8685# vss sky130_fd_pr__cap_mim_m3_1 l=22.2 w=22.2
X315 w_n8809_8685# vss sky130_fd_pr__cap_mim_m3_1 l=22.2 w=22.2
X316 vin a_n8581_n15597# a_n8639_n20509# vss sky130_fd_pr__nfet_05v0_nvt ad=1.45 pd=10.29 as=1.45 ps=10.29 w=10 l=0.9
X317 w_n8809_8685# a_n8609_2082# a_n8609_2082# w_n8809_8685# sky130_fd_pr__pfet_g5v0d10v5 ad=0.2175 pd=1.79 as=0.2175 ps=1.79 w=1.5 l=4
X318 a_n8609_6082# a_n8609_4082# vss vss sky130_fd_pr__nfet_g5v0d10v5 ad=0.145 pd=1.29 as=0.145 ps=1.29 w=1 l=4
X319 a_n8609_14110# a_n8609_2082# w_n8809_8685# w_n8809_8685# sky130_fd_pr__pfet_g5v0d10v5 ad=0.2175 pd=1.79 as=0.2175 ps=1.79 w=1.5 l=4
X320 vss a_n8609_4082# a_n8609_6082# vss sky130_fd_pr__nfet_g5v0d10v5 ad=0.145 pd=1.29 as=0.145 ps=1.29 w=1 l=4
X321 vss ibias a_n8609_2082# vss sky130_fd_pr__nfet_g5v0d10v5 ad=0.145 pd=1.29 as=0.145 ps=1.29 w=1 l=4
X322 a_n8639_n20509# a_n8609_14110# out vss sky130_fd_pr__nfet_05v0_nvt ad=1.45 pd=10.29 as=1.45 ps=10.29 w=10 l=0.9
X323 vin a_n8581_n15597# a_n8639_n20509# vss sky130_fd_pr__nfet_05v0_nvt ad=1.45 pd=10.29 as=1.45 ps=10.29 w=10 l=0.9
X324 vin a_n8581_n15597# a_n8639_n20509# vss sky130_fd_pr__nfet_05v0_nvt ad=1.45 pd=10.29 as=1.45 ps=10.29 w=10 l=0.9
X325 a_n8609_11046# a_n8609_2082# w_n8809_8685# w_n8809_8685# sky130_fd_pr__pfet_g5v0d10v5 ad=0.2175 pd=1.79 as=0.2175 ps=1.79 w=1.5 l=4
X326 a_n8609_11046# a_n8609_2082# w_n8809_8685# w_n8809_8685# sky130_fd_pr__pfet_g5v0d10v5 ad=0.2175 pd=1.79 as=0.2175 ps=1.79 w=1.5 l=4
X327 vss a_n8609_4082# a_n8609_6082# vss sky130_fd_pr__nfet_g5v0d10v5 ad=0.145 pd=1.29 as=0.145 ps=1.29 w=1 l=4
X328 vin a_n8581_n15597# a_n8639_n20509# vss sky130_fd_pr__nfet_05v0_nvt ad=1.45 pd=10.29 as=1.45 ps=10.29 w=10 l=0.9
X329 a_n8639_n20509# a_n8581_n15597# vin vss sky130_fd_pr__nfet_05v0_nvt ad=1.45 pd=10.29 as=1.45 ps=10.29 w=10 l=0.9
X330 a_n8609_14110# a_n8609_2082# w_n8809_8685# w_n8809_8685# sky130_fd_pr__pfet_g5v0d10v5 ad=0.435 pd=3.58 as=0.2175 ps=1.79 w=1.5 l=4
X331 w_n8809_8685# a_n8609_2082# a_n8609_2082# w_n8809_8685# sky130_fd_pr__pfet_g5v0d10v5 ad=0.2175 pd=1.79 as=0.2175 ps=1.79 w=1.5 l=4
X332 a_n8609_6082# a_n8609_4082# vss vss sky130_fd_pr__nfet_g5v0d10v5 ad=0.29 pd=2.58 as=0.145 ps=1.29 w=1 l=4
X333 a_n8609_2082# ibias vss vss sky130_fd_pr__nfet_g5v0d10v5 ad=0.145 pd=1.29 as=0.145 ps=1.29 w=1 l=4
X334 vss ibias ibias vss sky130_fd_pr__nfet_g5v0d10v5 ad=0.145 pd=1.29 as=0.145 ps=1.29 w=1 l=4
X335 w_n8809_8685# vss sky130_fd_pr__cap_mim_m3_1 l=22.2 w=22.2
X336 a_n8609_14110# a_n8609_2082# w_n8809_8685# w_n8809_8685# sky130_fd_pr__pfet_g5v0d10v5 ad=0.2175 pd=1.79 as=0.2175 ps=1.79 w=1.5 l=4
X337 w_n8809_8685# a_n8609_2082# a_n8609_11046# w_n8809_8685# sky130_fd_pr__pfet_g5v0d10v5 ad=0.2175 pd=1.79 as=0.2175 ps=1.79 w=1.5 l=4
X338 w_n8809_8685# a_n8609_2082# a_n8609_14110# w_n8809_8685# sky130_fd_pr__pfet_g5v0d10v5 ad=0.2175 pd=1.79 as=0.2175 ps=1.79 w=1.5 l=4
X339 a_n8639_n20509# a_n8609_14110# out vss sky130_fd_pr__nfet_05v0_nvt ad=1.45 pd=10.29 as=1.45 ps=10.29 w=10 l=0.9
X340 a_n8609_14110# a_n8609_2082# w_n8809_8685# w_n8809_8685# sky130_fd_pr__pfet_g5v0d10v5 ad=0.2175 pd=1.79 as=0.2175 ps=1.79 w=1.5 l=4
X341 vin a_n8581_n15597# a_n8639_n20509# vss sky130_fd_pr__nfet_05v0_nvt ad=1.45 pd=10.29 as=1.45 ps=10.29 w=10 l=0.9
X342 w_n8809_8685# a_n8609_2082# a_n8609_14110# w_n8809_8685# sky130_fd_pr__pfet_g5v0d10v5 ad=0.2175 pd=1.79 as=0.2175 ps=1.79 w=1.5 l=4
X343 a_n8639_n20509# a_n8581_n15597# vin vss sky130_fd_pr__nfet_05v0_nvt ad=1.45 pd=10.29 as=1.45 ps=10.29 w=10 l=0.9
X344 ibias ibias vss vss sky130_fd_pr__nfet_g5v0d10v5 ad=0.29 pd=2.58 as=0.145 ps=1.29 w=1 l=4
X345 ibias ibias vss vss sky130_fd_pr__nfet_g5v0d10v5 ad=0.145 pd=1.29 as=0.145 ps=1.29 w=1 l=4
X346 w_n8809_8685# a_n8609_2082# a_n8609_14110# w_n8809_8685# sky130_fd_pr__pfet_g5v0d10v5 ad=0.2175 pd=1.79 as=0.435 ps=3.58 w=1.5 l=4
X347 a_n8639_n20509# a_n8581_n15597# vin vss sky130_fd_pr__nfet_05v0_nvt ad=1.45 pd=10.29 as=1.45 ps=10.29 w=10 l=0.9
X348 a_n8609_14110# a_n8609_2082# w_n8809_8685# w_n8809_8685# sky130_fd_pr__pfet_g5v0d10v5 ad=0.2175 pd=1.79 as=0.2175 ps=1.79 w=1.5 l=4
X349 a_n8609_2082# a_n8609_2082# w_n8809_8685# w_n8809_8685# sky130_fd_pr__pfet_g5v0d10v5 ad=0.2175 pd=1.79 as=0.2175 ps=1.79 w=1.5 l=4
X350 a_n8609_14110# a_n8609_2082# w_n8809_8685# w_n8809_8685# sky130_fd_pr__pfet_g5v0d10v5 ad=0.2175 pd=1.79 as=0.2175 ps=1.79 w=1.5 l=4
X351 a_n8639_n20509# a_n8581_n15597# vin vss sky130_fd_pr__nfet_05v0_nvt ad=1.45 pd=10.29 as=1.45 ps=10.29 w=10 l=0.9
X352 a_n8609_4082# a_n8609_4082# vss vss sky130_fd_pr__nfet_g5v0d10v5 ad=0.145 pd=1.29 as=0.145 ps=1.29 w=1 l=4
X353 w_n8809_8685# a_n8609_2082# a_n8609_14110# w_n8809_8685# sky130_fd_pr__pfet_g5v0d10v5 ad=0.2175 pd=1.79 as=0.2175 ps=1.79 w=1.5 l=4
X354 w_n8809_8685# a_n8609_2082# a_n8609_14110# w_n8809_8685# sky130_fd_pr__pfet_g5v0d10v5 ad=0.2175 pd=1.79 as=0.2175 ps=1.79 w=1.5 l=4
X355 a_n8609_14110# a_n8609_2082# w_n8809_8685# w_n8809_8685# sky130_fd_pr__pfet_g5v0d10v5 ad=0.2175 pd=1.79 as=0.2175 ps=1.79 w=1.5 l=4
X356 a_n8609_11046# a_n8609_2082# w_n8809_8685# w_n8809_8685# sky130_fd_pr__pfet_g5v0d10v5 ad=0.2175 pd=1.79 as=0.2175 ps=1.79 w=1.5 l=4
X357 a_n8581_n15597# vss sky130_fd_pr__cap_mim_m3_1 l=22.2 w=22.2
X358 out a_n8609_14110# a_n8639_n20509# vss sky130_fd_pr__nfet_05v0_nvt ad=1.45 pd=10.29 as=1.45 ps=10.29 w=10 l=0.9
X359 a_n8609_4082# a_n8609_4082# vss vss sky130_fd_pr__nfet_g5v0d10v5 ad=0.145 pd=1.29 as=0.145 ps=1.29 w=1 l=4
X360 a_n8639_n20509# a_n8581_n15597# vin vss sky130_fd_pr__nfet_05v0_nvt ad=1.45 pd=10.29 as=1.45 ps=10.29 w=10 l=0.9
X361 vin a_n8581_n15597# a_n8639_n20509# vss sky130_fd_pr__nfet_05v0_nvt ad=1.45 pd=10.29 as=1.45 ps=10.29 w=10 l=0.9
X362 vin a_n8581_n15597# a_n8639_n20509# vss sky130_fd_pr__nfet_05v0_nvt ad=1.45 pd=10.29 as=1.45 ps=10.29 w=10 l=0.9
X363 a_n8609_14110# a_n8609_2082# w_n8809_8685# w_n8809_8685# sky130_fd_pr__pfet_g5v0d10v5 ad=0.2175 pd=1.79 as=0.2175 ps=1.79 w=1.5 l=4
X364 a_n8609_14110# a_n8609_2082# w_n8809_8685# w_n8809_8685# sky130_fd_pr__pfet_g5v0d10v5 ad=0.2175 pd=1.79 as=0.2175 ps=1.79 w=1.5 l=4
X365 vss a_n8609_4082# a_n8609_6082# vss sky130_fd_pr__nfet_g5v0d10v5 ad=0.145 pd=1.29 as=0.145 ps=1.29 w=1 l=4
X366 out a_n8609_14110# a_n8639_n20509# vss sky130_fd_pr__nfet_05v0_nvt ad=1.45 pd=10.29 as=1.45 ps=10.29 w=10 l=0.9
X367 vin a_n8581_n15597# a_n8639_n20509# vss sky130_fd_pr__nfet_05v0_nvt ad=1.45 pd=10.29 as=1.45 ps=10.29 w=10 l=0.9
X368 vin a_n8581_n15597# a_n8639_n20509# vss sky130_fd_pr__nfet_05v0_nvt ad=1.45 pd=10.29 as=1.45 ps=10.29 w=10 l=0.9
X369 a_n8609_14110# a_n8609_2082# w_n8809_8685# w_n8809_8685# sky130_fd_pr__pfet_g5v0d10v5 ad=0.2175 pd=1.79 as=0.2175 ps=1.79 w=1.5 l=4
X370 a_n8609_11046# a_n8609_2082# w_n8809_8685# w_n8809_8685# sky130_fd_pr__pfet_g5v0d10v5 ad=0.2175 pd=1.79 as=0.2175 ps=1.79 w=1.5 l=4
X371 out a_n8609_14110# a_n8639_n20509# vss sky130_fd_pr__nfet_05v0_nvt ad=1.45 pd=10.29 as=1.45 ps=10.29 w=10 l=0.9
X372 vss a_n8609_4082# a_n8609_4082# vss sky130_fd_pr__nfet_g5v0d10v5 ad=0.145 pd=1.29 as=0.145 ps=1.29 w=1 l=4
X373 w_n8809_8685# vss sky130_fd_pr__cap_mim_m3_1 l=22.2 w=22.2
X374 w_n8809_8685# a_n8609_2082# a_n8609_14110# w_n8809_8685# sky130_fd_pr__pfet_g5v0d10v5 ad=0.2175 pd=1.79 as=0.2175 ps=1.79 w=1.5 l=4
X375 vin a_n8581_n15597# a_n8639_n20509# vss sky130_fd_pr__nfet_05v0_nvt ad=1.45 pd=10.29 as=1.45 ps=10.29 w=10 l=0.9
X376 w_n8809_8685# a_n8609_2082# a_n8609_11046# w_n8809_8685# sky130_fd_pr__pfet_g5v0d10v5 ad=0.2175 pd=1.79 as=0.435 ps=3.58 w=1.5 l=4
X377 a_n8609_11046# a_n8609_2082# w_n8809_8685# w_n8809_8685# sky130_fd_pr__pfet_g5v0d10v5 ad=0.435 pd=3.58 as=0.2175 ps=1.79 w=1.5 l=4
X378 vss ibias a_n8609_2082# vss sky130_fd_pr__nfet_g5v0d10v5 ad=0.145 pd=1.29 as=0.145 ps=1.29 w=1 l=4
X379 a_n8639_n20509# a_n8581_n15597# vin vss sky130_fd_pr__nfet_05v0_nvt ad=1.45 pd=10.29 as=1.45 ps=10.29 w=10 l=0.9
X380 vin a_n8581_n15597# a_n8639_n20509# vss sky130_fd_pr__nfet_05v0_nvt ad=1.45 pd=10.29 as=1.45 ps=10.29 w=10 l=0.9
X381 a_n8609_11046# a_n8609_2082# w_n8809_8685# w_n8809_8685# sky130_fd_pr__pfet_g5v0d10v5 ad=0.2175 pd=1.79 as=0.2175 ps=1.79 w=1.5 l=4
X382 vin a_n8581_n15597# a_n8639_n20509# vss sky130_fd_pr__nfet_05v0_nvt ad=2.9 pd=20.58 as=1.45 ps=10.29 w=10 l=0.9
X383 a_n8639_n20509# a_n8581_n15597# vin vss sky130_fd_pr__nfet_05v0_nvt ad=1.45 pd=10.29 as=1.45 ps=10.29 w=10 l=0.9
X384 ibias ibias vss vss sky130_fd_pr__nfet_g5v0d10v5 ad=0.145 pd=1.29 as=0.145 ps=1.29 w=1 l=4
X385 out a_n8609_14110# a_n8639_n20509# vss sky130_fd_pr__nfet_05v0_nvt ad=1.45 pd=10.29 as=1.45 ps=10.29 w=10 l=0.9
X386 a_n8609_14110# a_n8609_2082# w_n8809_8685# w_n8809_8685# sky130_fd_pr__pfet_g5v0d10v5 ad=0.2175 pd=1.79 as=0.2175 ps=1.79 w=1.5 l=4
X387 a_n8639_n20509# a_n8581_n15597# vin vss sky130_fd_pr__nfet_05v0_nvt ad=1.45 pd=10.29 as=1.45 ps=10.29 w=10 l=0.9
X388 a_n8609_4082# a_n8609_4082# vss vss sky130_fd_pr__nfet_g5v0d10v5 ad=0.145 pd=1.29 as=0.145 ps=1.29 w=1 l=4
X389 vss a_n8609_4082# a_n8609_4082# vss sky130_fd_pr__nfet_g5v0d10v5 ad=0.145 pd=1.29 as=0.145 ps=1.29 w=1 l=4
X390 w_n8809_8685# a_n8609_2082# a_n8609_11046# w_n8809_8685# sky130_fd_pr__pfet_g5v0d10v5 ad=0.2175 pd=1.79 as=0.2175 ps=1.79 w=1.5 l=4
X391 a_n8609_11046# a_n8609_2082# w_n8809_8685# w_n8809_8685# sky130_fd_pr__pfet_g5v0d10v5 ad=0.2175 pd=1.79 as=0.2175 ps=1.79 w=1.5 l=4
X392 out a_n8609_14110# a_n8639_n20509# vss sky130_fd_pr__nfet_05v0_nvt ad=1.45 pd=10.29 as=1.45 ps=10.29 w=10 l=0.9
X393 vin a_n8581_n15597# a_n8639_n20509# vss sky130_fd_pr__nfet_05v0_nvt ad=1.45 pd=10.29 as=1.45 ps=10.29 w=10 l=0.9
X394 ibias ibias vss vss sky130_fd_pr__nfet_g5v0d10v5 ad=0.145 pd=1.29 as=0.145 ps=1.29 w=1 l=4
X395 a_n8609_14110# a_n8609_2082# w_n8809_8685# w_n8809_8685# sky130_fd_pr__pfet_g5v0d10v5 ad=0.2175 pd=1.79 as=0.2175 ps=1.79 w=1.5 l=4
X396 a_n8609_14110# a_n8609_2082# w_n8809_8685# w_n8809_8685# sky130_fd_pr__pfet_g5v0d10v5 ad=0.2175 pd=1.79 as=0.2175 ps=1.79 w=1.5 l=4
X397 vss a_n8609_4082# a_n8609_4082# vss sky130_fd_pr__nfet_g5v0d10v5 ad=0.145 pd=1.29 as=0.145 ps=1.29 w=1 l=4
X398 out a_n8609_14110# a_n8639_n20509# vss sky130_fd_pr__nfet_05v0_nvt ad=1.45 pd=10.29 as=1.45 ps=10.29 w=10 l=0.9
X399 a_n8609_11046# a_n8609_2082# w_n8809_8685# w_n8809_8685# sky130_fd_pr__pfet_g5v0d10v5 ad=0.2175 pd=1.79 as=0.2175 ps=1.79 w=1.5 l=4
X400 a_n8609_4082# a_n8609_4082# vss vss sky130_fd_pr__nfet_g5v0d10v5 ad=0.29 pd=2.58 as=0.145 ps=1.29 w=1 l=4
X401 w_n8809_8685# a_n8609_2082# a_n8609_14110# w_n8809_8685# sky130_fd_pr__pfet_g5v0d10v5 ad=0.2175 pd=1.79 as=0.2175 ps=1.79 w=1.5 l=4
X402 w_n8809_8685# a_n8609_2082# a_n8609_14110# w_n8809_8685# sky130_fd_pr__pfet_g5v0d10v5 ad=0.2175 pd=1.79 as=0.2175 ps=1.79 w=1.5 l=4
X403 out a_n8609_14110# a_n8639_n20509# vss sky130_fd_pr__nfet_05v0_nvt ad=1.45 pd=10.29 as=1.45 ps=10.29 w=10 l=0.9
X404 a_n8639_n20509# a_n8581_n15597# vin vss sky130_fd_pr__nfet_05v0_nvt ad=1.45 pd=10.29 as=1.45 ps=10.29 w=10 l=0.9
X405 a_n8609_14110# a_n8609_2082# w_n8809_8685# w_n8809_8685# sky130_fd_pr__pfet_g5v0d10v5 ad=0.435 pd=3.58 as=0.2175 ps=1.79 w=1.5 l=4
X406 w_n8809_8685# a_n8609_2082# a_n8609_14110# w_n8809_8685# sky130_fd_pr__pfet_g5v0d10v5 ad=0.2175 pd=1.79 as=0.2175 ps=1.79 w=1.5 l=4
X407 a_n8639_n20509# a_n8609_14110# out vss sky130_fd_pr__nfet_05v0_nvt ad=1.45 pd=10.29 as=1.45 ps=10.29 w=10 l=0.9
X408 out a_n8609_14110# a_n8639_n20509# vss sky130_fd_pr__nfet_05v0_nvt ad=1.45 pd=10.29 as=1.45 ps=10.29 w=10 l=0.9
X409 a_n8609_14110# a_n8609_2082# w_n8809_8685# w_n8809_8685# sky130_fd_pr__pfet_g5v0d10v5 ad=0.2175 pd=1.79 as=0.2175 ps=1.79 w=1.5 l=4
X410 w_n8809_8685# a_n8609_2082# a_n8609_2082# w_n8809_8685# sky130_fd_pr__pfet_g5v0d10v5 ad=0.2175 pd=1.79 as=0.2175 ps=1.79 w=1.5 l=4
X411 a_n8609_14110# a_n8609_2082# w_n8809_8685# w_n8809_8685# sky130_fd_pr__pfet_g5v0d10v5 ad=0.2175 pd=1.79 as=0.2175 ps=1.79 w=1.5 l=4
X412 a_n8609_14110# a_n8609_2082# w_n8809_8685# w_n8809_8685# sky130_fd_pr__pfet_g5v0d10v5 ad=0.2175 pd=1.79 as=0.2175 ps=1.79 w=1.5 l=4
X413 a_n8609_11046# a_n8609_2082# w_n8809_8685# w_n8809_8685# sky130_fd_pr__pfet_g5v0d10v5 ad=0.2175 pd=1.79 as=0.2175 ps=1.79 w=1.5 l=4
X414 a_n8639_n20509# a_n8581_n15597# vin vss sky130_fd_pr__nfet_05v0_nvt ad=1.45 pd=10.29 as=1.45 ps=10.29 w=10 l=0.9
X415 w_n8809_8685# a_n8609_2082# a_n8609_14110# w_n8809_8685# sky130_fd_pr__pfet_g5v0d10v5 ad=0.2175 pd=1.79 as=0.435 ps=3.58 w=1.5 l=4
X416 a_n8609_14110# a_n8609_2082# w_n8809_8685# w_n8809_8685# sky130_fd_pr__pfet_g5v0d10v5 ad=0.2175 pd=1.79 as=0.2175 ps=1.79 w=1.5 l=4
X417 vss a_n8609_4082# a_n8609_6082# vss sky130_fd_pr__nfet_g5v0d10v5 ad=0.145 pd=1.29 as=0.145 ps=1.29 w=1 l=4
X418 a_n8609_2082# ibias vss vss sky130_fd_pr__nfet_g5v0d10v5 ad=0.145 pd=1.29 as=0.145 ps=1.29 w=1 l=4
X419 a_n8609_6082# a_n8609_4082# vss vss sky130_fd_pr__nfet_g5v0d10v5 ad=0.145 pd=1.29 as=0.145 ps=1.29 w=1 l=4
X420 w_n8809_8685# a_n8609_2082# a_n8609_14110# w_n8809_8685# sky130_fd_pr__pfet_g5v0d10v5 ad=0.2175 pd=1.79 as=0.2175 ps=1.79 w=1.5 l=4
X421 w_n8809_8685# vss sky130_fd_pr__cap_mim_m3_1 l=22.2 w=22.2
X422 w_n8809_8685# a_n8609_2082# a_n8609_14110# w_n8809_8685# sky130_fd_pr__pfet_g5v0d10v5 ad=0.2175 pd=1.79 as=0.2175 ps=1.79 w=1.5 l=4
X423 a_n8639_n20509# a_n8609_14110# out vss sky130_fd_pr__nfet_05v0_nvt ad=1.45 pd=10.29 as=1.45 ps=10.29 w=10 l=0.9
X424 a_n8609_14110# a_n8609_2082# w_n8809_8685# w_n8809_8685# sky130_fd_pr__pfet_g5v0d10v5 ad=0.2175 pd=1.79 as=0.2175 ps=1.79 w=1.5 l=4
X425 w_n8809_8685# a_n8609_2082# a_n8609_14110# w_n8809_8685# sky130_fd_pr__pfet_g5v0d10v5 ad=0.2175 pd=1.79 as=0.2175 ps=1.79 w=1.5 l=4
X426 a_n8609_2082# ibias vss vss sky130_fd_pr__nfet_g5v0d10v5 ad=0.145 pd=1.29 as=0.145 ps=1.29 w=1 l=4
X427 a_n8609_11046# a_n8609_2082# w_n8809_8685# w_n8809_8685# sky130_fd_pr__pfet_g5v0d10v5 ad=0.2175 pd=1.79 as=0.2175 ps=1.79 w=1.5 l=4
X428 a_n8581_n15597# vss sky130_fd_pr__cap_mim_m3_1 l=22.2 w=22.2
X429 w_n8809_8685# vss sky130_fd_pr__cap_mim_m3_1 l=22.2 w=22.2
X430 a_n8639_n20509# a_n8609_14110# out vss sky130_fd_pr__nfet_05v0_nvt ad=1.45 pd=10.29 as=1.45 ps=10.29 w=10 l=0.9
X431 a_n8609_2082# a_n8609_2082# w_n8809_8685# w_n8809_8685# sky130_fd_pr__pfet_g5v0d10v5 ad=0.2175 pd=1.79 as=0.2175 ps=1.79 w=1.5 l=4
X432 ibias ibias vss vss sky130_fd_pr__nfet_g5v0d10v5 ad=0.145 pd=1.29 as=0.145 ps=1.29 w=1 l=4
X433 vss a_n8609_4082# a_n8609_4082# vss sky130_fd_pr__nfet_g5v0d10v5 ad=0.145 pd=1.29 as=0.145 ps=1.29 w=1 l=4
X434 w_n8809_8685# a_n8609_2082# a_n8609_11046# w_n8809_8685# sky130_fd_pr__pfet_g5v0d10v5 ad=0.2175 pd=1.79 as=0.2175 ps=1.79 w=1.5 l=4
X435 out a_n8609_14110# a_n8639_n20509# vss sky130_fd_pr__nfet_05v0_nvt ad=1.45 pd=10.29 as=1.45 ps=10.29 w=10 l=0.9
X436 a_n8609_2082# a_n8609_2082# w_n8809_8685# w_n8809_8685# sky130_fd_pr__pfet_g5v0d10v5 ad=0.2175 pd=1.79 as=0.2175 ps=1.79 w=1.5 l=4
X437 vss ibias a_n8609_2082# vss sky130_fd_pr__nfet_g5v0d10v5 ad=0.145 pd=1.29 as=0.145 ps=1.29 w=1 l=4
X438 a_n8639_n20509# a_n8581_n15597# vin vss sky130_fd_pr__nfet_05v0_nvt ad=1.45 pd=10.29 as=1.45 ps=10.29 w=10 l=0.9
X439 vin a_n8581_n15597# a_n8639_n20509# vss sky130_fd_pr__nfet_05v0_nvt ad=1.45 pd=10.29 as=1.45 ps=10.29 w=10 l=0.9
X440 vss ibias ibias vss sky130_fd_pr__nfet_g5v0d10v5 ad=0.145 pd=1.29 as=0.145 ps=1.29 w=1 l=4
X441 a_n8609_14110# a_n8609_2082# w_n8809_8685# w_n8809_8685# sky130_fd_pr__pfet_g5v0d10v5 ad=0.2175 pd=1.79 as=0.2175 ps=1.79 w=1.5 l=4
X442 vin a_n8581_n15597# a_n8639_n20509# vss sky130_fd_pr__nfet_05v0_nvt ad=1.45 pd=10.29 as=1.45 ps=10.29 w=10 l=0.9
X443 w_n8809_8685# a_n8609_2082# a_n8609_14110# w_n8809_8685# sky130_fd_pr__pfet_g5v0d10v5 ad=0.2175 pd=1.79 as=0.2175 ps=1.79 w=1.5 l=4
X444 a_n8609_14110# a_n8609_2082# w_n8809_8685# w_n8809_8685# sky130_fd_pr__pfet_g5v0d10v5 ad=0.2175 pd=1.79 as=0.2175 ps=1.79 w=1.5 l=4
X445 a_n8639_n20509# a_n8609_14110# out vss sky130_fd_pr__nfet_05v0_nvt ad=1.45 pd=10.29 as=1.45 ps=10.29 w=10 l=0.9
X446 out a_n8609_14110# a_n8639_n20509# vss sky130_fd_pr__nfet_05v0_nvt ad=1.45 pd=10.29 as=1.45 ps=10.29 w=10 l=0.9
X447 w_n8809_8685# a_n8609_2082# a_n8609_14110# w_n8809_8685# sky130_fd_pr__pfet_g5v0d10v5 ad=0.2175 pd=1.79 as=0.435 ps=3.58 w=1.5 l=4
X448 a_n8609_14110# a_n8609_2082# w_n8809_8685# w_n8809_8685# sky130_fd_pr__pfet_g5v0d10v5 ad=0.2175 pd=1.79 as=0.2175 ps=1.79 w=1.5 l=4
X449 a_n8581_n15597# vss sky130_fd_pr__cap_mim_m3_1 l=22.2 w=22.2
X450 a_n8609_11046# a_n8609_2082# w_n8809_8685# w_n8809_8685# sky130_fd_pr__pfet_g5v0d10v5 ad=0.2175 pd=1.79 as=0.2175 ps=1.79 w=1.5 l=4
X451 a_n8609_11046# a_n8609_2082# w_n8809_8685# w_n8809_8685# sky130_fd_pr__pfet_g5v0d10v5 ad=0.2175 pd=1.79 as=0.2175 ps=1.79 w=1.5 l=4
X452 w_n8809_8685# a_n8609_2082# a_n8609_2082# w_n8809_8685# sky130_fd_pr__pfet_g5v0d10v5 ad=0.2175 pd=1.79 as=0.2175 ps=1.79 w=1.5 l=4
X453 out a_n8609_14110# a_n8639_n20509# vss sky130_fd_pr__nfet_05v0_nvt ad=1.45 pd=10.29 as=1.45 ps=10.29 w=10 l=0.9
X454 a_n8639_n20509# a_n8581_n15597# vin vss sky130_fd_pr__nfet_05v0_nvt ad=1.45 pd=10.29 as=1.45 ps=10.29 w=10 l=0.9
X455 vin a_n8581_n15597# a_n8639_n20509# vss sky130_fd_pr__nfet_05v0_nvt ad=1.45 pd=10.29 as=1.45 ps=10.29 w=10 l=0.9
X456 a_n8609_2082# ibias vss vss sky130_fd_pr__nfet_g5v0d10v5 ad=0.145 pd=1.29 as=0.145 ps=1.29 w=1 l=4
X457 a_n8609_14110# a_n8609_2082# w_n8809_8685# w_n8809_8685# sky130_fd_pr__pfet_g5v0d10v5 ad=0.2175 pd=1.79 as=0.2175 ps=1.79 w=1.5 l=4
X458 w_n8809_8685# a_n8609_2082# a_n8609_14110# w_n8809_8685# sky130_fd_pr__pfet_g5v0d10v5 ad=0.2175 pd=1.79 as=0.2175 ps=1.79 w=1.5 l=4
X459 vss ibias a_n8609_2082# vss sky130_fd_pr__nfet_g5v0d10v5 ad=0.145 pd=1.29 as=0.145 ps=1.29 w=1 l=4
X460 a_n8639_n20509# a_n8609_14110# out vss sky130_fd_pr__nfet_05v0_nvt ad=2.9 pd=20.58 as=1.45 ps=10.29 w=10 l=0.9
X461 a_n8609_14110# a_n8609_2082# w_n8809_8685# w_n8809_8685# sky130_fd_pr__pfet_g5v0d10v5 ad=0.2175 pd=1.79 as=0.2175 ps=1.79 w=1.5 l=4
X462 out a_n8609_14110# a_n8639_n20509# vss sky130_fd_pr__nfet_05v0_nvt ad=1.45 pd=10.29 as=1.45 ps=10.29 w=10 l=0.9
X463 a_n8639_n20509# a_n8581_n15597# vin vss sky130_fd_pr__nfet_05v0_nvt ad=1.45 pd=10.29 as=1.45 ps=10.29 w=10 l=0.9
X464 a_n8609_6082# a_n8609_4082# vss vss sky130_fd_pr__nfet_g5v0d10v5 ad=0.145 pd=1.29 as=0.145 ps=1.29 w=1 l=4
X465 vss ibias a_n8609_2082# vss sky130_fd_pr__nfet_g5v0d10v5 ad=0.145 pd=1.29 as=0.145 ps=1.29 w=1 l=4
X466 a_n8609_14110# a_n8609_2082# w_n8809_8685# w_n8809_8685# sky130_fd_pr__pfet_g5v0d10v5 ad=0.435 pd=3.58 as=0.2175 ps=1.79 w=1.5 l=4
X467 a_n8609_2082# a_n8609_2082# w_n8809_8685# w_n8809_8685# sky130_fd_pr__pfet_g5v0d10v5 ad=0.2175 pd=1.79 as=0.2175 ps=1.79 w=1.5 l=4
X468 vss a_n8609_4082# a_n8609_6082# vss sky130_fd_pr__nfet_g5v0d10v5 ad=0.145 pd=1.29 as=0.145 ps=1.29 w=1 l=4
X469 a_n8609_2082# ibias vss vss sky130_fd_pr__nfet_g5v0d10v5 ad=0.29 pd=2.58 as=0.145 ps=1.29 w=1 l=4
X470 w_n8809_8685# vss sky130_fd_pr__cap_mim_m3_1 l=22.2 w=22.2
X471 a_n8639_n20509# a_n8609_14110# out vss sky130_fd_pr__nfet_05v0_nvt ad=2.9 pd=20.58 as=1.45 ps=10.29 w=10 l=0.9
X472 a_n8639_n20509# a_n8609_14110# out vss sky130_fd_pr__nfet_05v0_nvt ad=1.45 pd=10.29 as=1.45 ps=10.29 w=10 l=0.9
X473 w_n8809_8685# a_n8609_2082# a_n8609_14110# w_n8809_8685# sky130_fd_pr__pfet_g5v0d10v5 ad=0.2175 pd=1.79 as=0.2175 ps=1.79 w=1.5 l=4
X474 a_n8609_14110# a_n8609_2082# w_n8809_8685# w_n8809_8685# sky130_fd_pr__pfet_g5v0d10v5 ad=0.2175 pd=1.79 as=0.2175 ps=1.79 w=1.5 l=4
X475 a_n8639_n20509# a_n8581_n15597# vin vss sky130_fd_pr__nfet_05v0_nvt ad=1.45 pd=10.29 as=1.45 ps=10.29 w=10 l=0.9
X476 a_n8609_14110# a_n8609_2082# w_n8809_8685# w_n8809_8685# sky130_fd_pr__pfet_g5v0d10v5 ad=0.2175 pd=1.79 as=0.2175 ps=1.79 w=1.5 l=4
X477 w_n8809_8685# a_n8609_2082# a_n8609_14110# w_n8809_8685# sky130_fd_pr__pfet_g5v0d10v5 ad=0.2175 pd=1.79 as=0.2175 ps=1.79 w=1.5 l=4
X478 w_n8809_8685# a_n8609_2082# a_n8609_2082# w_n8809_8685# sky130_fd_pr__pfet_g5v0d10v5 ad=0.2175 pd=1.79 as=0.2175 ps=1.79 w=1.5 l=4
X479 a_n8639_n20509# a_n8581_n15597# vin vss sky130_fd_pr__nfet_05v0_nvt ad=1.45 pd=10.29 as=1.45 ps=10.29 w=10 l=0.9
X480 vss ibias ibias vss sky130_fd_pr__nfet_g5v0d10v5 ad=0.145 pd=1.29 as=0.145 ps=1.29 w=1 l=4
X481 a_n8609_11046# a_n8609_2082# w_n8809_8685# w_n8809_8685# sky130_fd_pr__pfet_g5v0d10v5 ad=0.2175 pd=1.79 as=0.2175 ps=1.79 w=1.5 l=4
X482 vss ibias ibias vss sky130_fd_pr__nfet_g5v0d10v5 ad=0.145 pd=1.29 as=0.145 ps=1.29 w=1 l=4
X483 vss ibias ibias vss sky130_fd_pr__nfet_g5v0d10v5 ad=0.145 pd=1.29 as=0.145 ps=1.29 w=1 l=4
X484 vin a_n8581_n15597# a_n8639_n20509# vss sky130_fd_pr__nfet_05v0_nvt ad=1.45 pd=10.29 as=1.45 ps=10.29 w=10 l=0.9
X485 w_n8809_8685# a_n8609_2082# a_n8609_14110# w_n8809_8685# sky130_fd_pr__pfet_g5v0d10v5 ad=0.2175 pd=1.79 as=0.2175 ps=1.79 w=1.5 l=4
X486 out a_n8609_14110# a_n8639_n20509# vss sky130_fd_pr__nfet_05v0_nvt ad=1.45 pd=10.29 as=1.45 ps=10.29 w=10 l=0.9
X487 vin a_n8581_n15597# a_n8639_n20509# vss sky130_fd_pr__nfet_05v0_nvt ad=1.45 pd=10.29 as=1.45 ps=10.29 w=10 l=0.9
X488 a_n8639_n20509# a_n8581_n15597# vin vss sky130_fd_pr__nfet_05v0_nvt ad=1.45 pd=10.29 as=1.45 ps=10.29 w=10 l=0.9
X489 a_n8639_n20509# a_n8609_14110# out vss sky130_fd_pr__nfet_05v0_nvt ad=1.45 pd=10.29 as=1.45 ps=10.29 w=10 l=0.9
X490 a_n8639_n20509# a_n8581_n15597# vin vss sky130_fd_pr__nfet_05v0_nvt ad=1.45 pd=10.29 as=1.45 ps=10.29 w=10 l=0.9
X491 a_n8609_6082# a_n8609_4082# vss vss sky130_fd_pr__nfet_g5v0d10v5 ad=0.145 pd=1.29 as=0.145 ps=1.29 w=1 l=4
X492 vss a_n8609_4082# a_n8609_4082# vss sky130_fd_pr__nfet_g5v0d10v5 ad=0.145 pd=1.29 as=0.145 ps=1.29 w=1 l=4
X493 a_n8609_14110# a_n8609_2082# w_n8809_8685# w_n8809_8685# sky130_fd_pr__pfet_g5v0d10v5 ad=0.2175 pd=1.79 as=0.2175 ps=1.79 w=1.5 l=4
X494 vin a_n8581_n15597# a_n8639_n20509# vss sky130_fd_pr__nfet_05v0_nvt ad=1.45 pd=10.29 as=1.45 ps=10.29 w=10 l=0.9
X495 vin a_n8581_n15597# a_n8639_n20509# vss sky130_fd_pr__nfet_05v0_nvt ad=1.45 pd=10.29 as=1.45 ps=10.29 w=10 l=0.9
X496 w_n8809_8685# a_n8609_2082# a_n8609_2082# w_n8809_8685# sky130_fd_pr__pfet_g5v0d10v5 ad=0.2175 pd=1.79 as=0.2175 ps=1.79 w=1.5 l=4
X497 a_n8609_4082# a_n8609_4082# vss vss sky130_fd_pr__nfet_g5v0d10v5 ad=0.145 pd=1.29 as=0.145 ps=1.29 w=1 l=4
X498 a_n8609_14110# a_n8609_2082# w_n8809_8685# w_n8809_8685# sky130_fd_pr__pfet_g5v0d10v5 ad=0.2175 pd=1.79 as=0.2175 ps=1.79 w=1.5 l=4
X499 a_n8609_11046# a_n8609_2082# w_n8809_8685# w_n8809_8685# sky130_fd_pr__pfet_g5v0d10v5 ad=0.2175 pd=1.79 as=0.2175 ps=1.79 w=1.5 l=4
X500 w_n8809_8685# a_n8609_2082# a_n8609_11046# w_n8809_8685# sky130_fd_pr__pfet_g5v0d10v5 ad=0.2175 pd=1.79 as=0.2175 ps=1.79 w=1.5 l=4
X501 vin a_n8581_n15597# a_n8639_n20509# vss sky130_fd_pr__nfet_05v0_nvt ad=1.45 pd=10.29 as=1.45 ps=10.29 w=10 l=0.9
X502 vin a_n8581_n15597# a_n8639_n20509# vss sky130_fd_pr__nfet_05v0_nvt ad=1.45 pd=10.29 as=1.45 ps=10.29 w=10 l=0.9
X503 out a_n8609_14110# a_n8639_n20509# vss sky130_fd_pr__nfet_05v0_nvt ad=1.45 pd=10.29 as=1.45 ps=10.29 w=10 l=0.9
X504 a_n8609_6082# a_n8609_4082# vss vss sky130_fd_pr__nfet_g5v0d10v5 ad=0.29 pd=2.58 as=0.145 ps=1.29 w=1 l=4
X505 w_n8809_8685# a_n8609_2082# a_n8609_14110# w_n8809_8685# sky130_fd_pr__pfet_g5v0d10v5 ad=0.2175 pd=1.79 as=0.2175 ps=1.79 w=1.5 l=4
X506 a_n8609_11046# a_n8609_2082# w_n8809_8685# w_n8809_8685# sky130_fd_pr__pfet_g5v0d10v5 ad=0.435 pd=3.58 as=0.2175 ps=1.79 w=1.5 l=4
X507 w_n8809_8685# a_n8609_2082# a_n8609_14110# w_n8809_8685# sky130_fd_pr__pfet_g5v0d10v5 ad=0.2175 pd=1.79 as=0.2175 ps=1.79 w=1.5 l=4
X508 a_n8609_14110# a_n8609_2082# w_n8809_8685# w_n8809_8685# sky130_fd_pr__pfet_g5v0d10v5 ad=0.2175 pd=1.79 as=0.2175 ps=1.79 w=1.5 l=4
X509 vss ibias a_n8609_2082# vss sky130_fd_pr__nfet_g5v0d10v5 ad=0.145 pd=1.29 as=0.145 ps=1.29 w=1 l=4
X510 w_n8809_8685# vss sky130_fd_pr__cap_mim_m3_1 l=22.2 w=22.2
X511 w_n8809_8685# vss sky130_fd_pr__cap_mim_m3_1 l=22.2 w=22.2
X512 a_n8639_n20509# a_n8581_n15597# vin vss sky130_fd_pr__nfet_05v0_nvt ad=1.45 pd=10.29 as=1.45 ps=10.29 w=10 l=0.9
X513 a_n8609_11046# a_n8609_2082# w_n8809_8685# w_n8809_8685# sky130_fd_pr__pfet_g5v0d10v5 ad=0.2175 pd=1.79 as=0.2175 ps=1.79 w=1.5 l=4
X514 vin a_n8581_n15597# a_n8639_n20509# vss sky130_fd_pr__nfet_05v0_nvt ad=1.45 pd=10.29 as=1.45 ps=10.29 w=10 l=0.9
X515 a_n8639_n20509# a_n8581_n15597# vin vss sky130_fd_pr__nfet_05v0_nvt ad=1.45 pd=10.29 as=1.45 ps=10.29 w=10 l=0.9
X516 a_4700_n3568# a_n8609_14110# sky130_fd_pr__cap_mim_m3_1 l=22.2 w=22.2
X517 vin a_n8581_n15597# a_n8639_n20509# vss sky130_fd_pr__nfet_05v0_nvt ad=1.45 pd=10.29 as=1.45 ps=10.29 w=10 l=0.9
X518 a_n8609_14110# a_n8609_2082# w_n8809_8685# w_n8809_8685# sky130_fd_pr__pfet_g5v0d10v5 ad=0.2175 pd=1.79 as=0.2175 ps=1.79 w=1.5 l=4
X519 a_n8639_n20509# a_n8581_n15597# vin vss sky130_fd_pr__nfet_05v0_nvt ad=1.45 pd=10.29 as=1.45 ps=10.29 w=10 l=0.9
X520 w_n8809_8685# a_n8609_2082# a_n8609_14110# w_n8809_8685# sky130_fd_pr__pfet_g5v0d10v5 ad=0.2175 pd=1.79 as=0.2175 ps=1.79 w=1.5 l=4
X521 a_n8609_14110# a_n8609_2082# w_n8809_8685# w_n8809_8685# sky130_fd_pr__pfet_g5v0d10v5 ad=0.2175 pd=1.79 as=0.2175 ps=1.79 w=1.5 l=4
X522 a_n8639_n20509# a_n8581_n15597# vin vss sky130_fd_pr__nfet_05v0_nvt ad=1.45 pd=10.29 as=1.45 ps=10.29 w=10 l=0.9
X523 a_n8609_11046# a_n8609_2082# w_n8809_8685# w_n8809_8685# sky130_fd_pr__pfet_g5v0d10v5 ad=0.2175 pd=1.79 as=0.2175 ps=1.79 w=1.5 l=4
X524 vin a_n8581_n15597# a_n8639_n20509# vss sky130_fd_pr__nfet_05v0_nvt ad=1.45 pd=10.29 as=1.45 ps=10.29 w=10 l=0.9
X525 a_n8609_6082# a_n8609_4082# vss vss sky130_fd_pr__nfet_g5v0d10v5 ad=0.145 pd=1.29 as=0.145 ps=1.29 w=1 l=4
X526 a_n8639_n20509# a_n8581_n15597# vin vss sky130_fd_pr__nfet_05v0_nvt ad=1.45 pd=10.29 as=1.45 ps=10.29 w=10 l=0.9
X527 a_n8639_n20509# a_n8581_n15597# vin vss sky130_fd_pr__nfet_05v0_nvt ad=1.45 pd=10.29 as=1.45 ps=10.29 w=10 l=0.9
X528 a_n8609_4082# a_n8609_4082# vss vss sky130_fd_pr__nfet_g5v0d10v5 ad=0.145 pd=1.29 as=0.145 ps=1.29 w=1 l=4
X529 vss ibias ibias vss sky130_fd_pr__nfet_g5v0d10v5 ad=0.145 pd=1.29 as=0.145 ps=1.29 w=1 l=4
X530 vin a_n8581_n15597# a_n8639_n20509# vss sky130_fd_pr__nfet_05v0_nvt ad=1.45 pd=10.29 as=1.45 ps=10.29 w=10 l=0.9
X531 w_n8809_8685# a_n8609_2082# a_n8609_11046# w_n8809_8685# sky130_fd_pr__pfet_g5v0d10v5 ad=0.2175 pd=1.79 as=0.2175 ps=1.79 w=1.5 l=4
X532 a_n8609_14110# a_n8609_2082# w_n8809_8685# w_n8809_8685# sky130_fd_pr__pfet_g5v0d10v5 ad=0.2175 pd=1.79 as=0.2175 ps=1.79 w=1.5 l=4
X533 vss a_n8609_4082# a_n8609_4082# vss sky130_fd_pr__nfet_g5v0d10v5 ad=0.145 pd=1.29 as=0.145 ps=1.29 w=1 l=4
X534 out a_n8609_14110# a_n8639_n20509# vss sky130_fd_pr__nfet_05v0_nvt ad=1.45 pd=10.29 as=1.45 ps=10.29 w=10 l=0.9
X535 vin a_n8581_n15597# a_n8639_n20509# vss sky130_fd_pr__nfet_05v0_nvt ad=1.45 pd=10.29 as=1.45 ps=10.29 w=10 l=0.9
X536 vss a_n8609_4082# a_n8609_6082# vss sky130_fd_pr__nfet_g5v0d10v5 ad=0.145 pd=1.29 as=0.145 ps=1.29 w=1 l=4
X537 a_n8609_14110# a_n8609_2082# w_n8809_8685# w_n8809_8685# sky130_fd_pr__pfet_g5v0d10v5 ad=0.2175 pd=1.79 as=0.2175 ps=1.79 w=1.5 l=4
X538 a_n8609_11046# a_n8609_2082# w_n8809_8685# w_n8809_8685# sky130_fd_pr__pfet_g5v0d10v5 ad=0.2175 pd=1.79 as=0.2175 ps=1.79 w=1.5 l=4
X539 a_n8639_n20509# a_n8581_n15597# vin vss sky130_fd_pr__nfet_05v0_nvt ad=1.45 pd=10.29 as=1.45 ps=10.29 w=10 l=0.9
X540 vin a_n8581_n15597# a_n8639_n20509# vss sky130_fd_pr__nfet_05v0_nvt ad=1.45 pd=10.29 as=1.45 ps=10.29 w=10 l=0.9
X541 a_n8609_14110# a_n8609_2082# w_n8809_8685# w_n8809_8685# sky130_fd_pr__pfet_g5v0d10v5 ad=0.2175 pd=1.79 as=0.2175 ps=1.79 w=1.5 l=4
X542 w_n8809_8685# a_n8609_2082# a_n8609_14110# w_n8809_8685# sky130_fd_pr__pfet_g5v0d10v5 ad=0.2175 pd=1.79 as=0.2175 ps=1.79 w=1.5 l=4
X543 a_n8609_14110# a_n8609_2082# w_n8809_8685# w_n8809_8685# sky130_fd_pr__pfet_g5v0d10v5 ad=0.435 pd=3.58 as=0.2175 ps=1.79 w=1.5 l=4
X544 vss a_n8609_4082# a_n8609_6082# vss sky130_fd_pr__nfet_g5v0d10v5 ad=0.145 pd=1.29 as=0.145 ps=1.29 w=1 l=4
X545 w_n8809_8685# vss sky130_fd_pr__cap_mim_m3_1 l=22.2 w=22.2
X546 w_n8809_8685# a_n8609_2082# a_n8609_14110# w_n8809_8685# sky130_fd_pr__pfet_g5v0d10v5 ad=0.2175 pd=1.79 as=0.2175 ps=1.79 w=1.5 l=4
X547 out a_n8609_14110# a_n8639_n20509# vss sky130_fd_pr__nfet_05v0_nvt ad=1.45 pd=10.29 as=1.45 ps=10.29 w=10 l=0.9
X548 a_n8639_n20509# a_n8581_n15597# vin vss sky130_fd_pr__nfet_05v0_nvt ad=1.45 pd=10.29 as=1.45 ps=10.29 w=10 l=0.9
X549 a_n8609_14110# a_n8609_2082# w_n8809_8685# w_n8809_8685# sky130_fd_pr__pfet_g5v0d10v5 ad=0.2175 pd=1.79 as=0.2175 ps=1.79 w=1.5 l=4
X550 a_n8609_11046# a_n8609_2082# w_n8809_8685# w_n8809_8685# sky130_fd_pr__pfet_g5v0d10v5 ad=0.2175 pd=1.79 as=0.2175 ps=1.79 w=1.5 l=4
X551 w_n8809_8685# a_n8609_2082# a_n8609_11046# w_n8809_8685# sky130_fd_pr__pfet_g5v0d10v5 ad=0.2175 pd=1.79 as=0.2175 ps=1.79 w=1.5 l=4
X552 w_n8809_8685# a_n8609_2082# a_n8609_14110# w_n8809_8685# sky130_fd_pr__pfet_g5v0d10v5 ad=0.2175 pd=1.79 as=0.2175 ps=1.79 w=1.5 l=4
X553 a_n8609_6082# a_n8609_4082# vss vss sky130_fd_pr__nfet_g5v0d10v5 ad=0.145 pd=1.29 as=0.145 ps=1.29 w=1 l=4
X554 vin a_n8581_n15597# a_n8639_n20509# vss sky130_fd_pr__nfet_05v0_nvt ad=1.45 pd=10.29 as=1.45 ps=10.29 w=10 l=0.9
X555 a_n8639_n20509# a_n8581_n15597# vin vss sky130_fd_pr__nfet_05v0_nvt ad=1.45 pd=10.29 as=1.45 ps=10.29 w=10 l=0.9
X556 w_n8809_8685# a_n8609_2082# a_n8609_14110# w_n8809_8685# sky130_fd_pr__pfet_g5v0d10v5 ad=0.2175 pd=1.79 as=0.2175 ps=1.79 w=1.5 l=4
X557 a_n8609_4082# a_n8609_4082# vss vss sky130_fd_pr__nfet_g5v0d10v5 ad=0.145 pd=1.29 as=0.145 ps=1.29 w=1 l=4
X558 vss ibias a_n8609_2082# vss sky130_fd_pr__nfet_g5v0d10v5 ad=0.145 pd=1.29 as=0.145 ps=1.29 w=1 l=4
X559 a_n8609_2082# ibias vss vss sky130_fd_pr__nfet_g5v0d10v5 ad=0.145 pd=1.29 as=0.145 ps=1.29 w=1 l=4
X560 a_n8639_n20509# a_n8581_n15597# vin vss sky130_fd_pr__nfet_05v0_nvt ad=1.45 pd=10.29 as=1.45 ps=10.29 w=10 l=0.9
X561 vin a_n8581_n15597# a_n8639_n20509# vss sky130_fd_pr__nfet_05v0_nvt ad=1.45 pd=10.29 as=1.45 ps=10.29 w=10 l=0.9
X562 a_n8639_n20509# a_n8581_n15597# vin vss sky130_fd_pr__nfet_05v0_nvt ad=1.45 pd=10.29 as=1.45 ps=10.29 w=10 l=0.9
X563 a_n8609_14110# a_n8609_2082# w_n8809_8685# w_n8809_8685# sky130_fd_pr__pfet_g5v0d10v5 ad=0.2175 pd=1.79 as=0.2175 ps=1.79 w=1.5 l=4
X564 ibias ibias vss vss sky130_fd_pr__nfet_g5v0d10v5 ad=0.145 pd=1.29 as=0.145 ps=1.29 w=1 l=4
X565 a_n8581_n15597# vss sky130_fd_pr__cap_mim_m3_1 l=22.2 w=22.2
X566 a_n8639_n20509# a_n8581_n15597# vin vss sky130_fd_pr__nfet_05v0_nvt ad=1.45 pd=10.29 as=1.45 ps=10.29 w=10 l=0.9
X567 a_n8639_n20509# a_n8581_n15597# vin vss sky130_fd_pr__nfet_05v0_nvt ad=1.45 pd=10.29 as=1.45 ps=10.29 w=10 l=0.9
X568 a_n8609_14110# a_n8609_2082# w_n8809_8685# w_n8809_8685# sky130_fd_pr__pfet_g5v0d10v5 ad=0.2175 pd=1.79 as=0.2175 ps=1.79 w=1.5 l=4
X569 a_n8609_14110# a_n8609_2082# w_n8809_8685# w_n8809_8685# sky130_fd_pr__pfet_g5v0d10v5 ad=0.2175 pd=1.79 as=0.2175 ps=1.79 w=1.5 l=4
X570 a_n8609_4082# a_n8609_4082# vss vss sky130_fd_pr__nfet_g5v0d10v5 ad=0.29 pd=2.58 as=0.145 ps=1.29 w=1 l=4
X571 a_n8639_n20509# a_n8581_n15597# vin vss sky130_fd_pr__nfet_05v0_nvt ad=1.45 pd=10.29 as=1.45 ps=10.29 w=10 l=0.9
X572 vss ibias ibias vss sky130_fd_pr__nfet_g5v0d10v5 ad=0.145 pd=1.29 as=0.145 ps=1.29 w=1 l=4
X573 a_n8609_11046# a_n8609_2082# w_n8809_8685# w_n8809_8685# sky130_fd_pr__pfet_g5v0d10v5 ad=0.2175 pd=1.79 as=0.2175 ps=1.79 w=1.5 l=4
X574 a_n8609_11046# a_n8609_2082# w_n8809_8685# w_n8809_8685# sky130_fd_pr__pfet_g5v0d10v5 ad=0.2175 pd=1.79 as=0.2175 ps=1.79 w=1.5 l=4
X575 vss off a_n8609_14110# vss sky130_fd_pr__nfet_g5v0d10v5 ad=2.9 pd=20.58 as=2.9 ps=20.58 w=10 l=0.5
X576 w_n8809_8685# a_n8609_2082# a_n8609_14110# w_n8809_8685# sky130_fd_pr__pfet_g5v0d10v5 ad=0.2175 pd=1.79 as=0.2175 ps=1.79 w=1.5 l=4
X577 a_n8609_14110# a_n8609_2082# w_n8809_8685# w_n8809_8685# sky130_fd_pr__pfet_g5v0d10v5 ad=0.2175 pd=1.79 as=0.2175 ps=1.79 w=1.5 l=4
X578 a_n8639_n20509# a_n8581_n15597# vin vss sky130_fd_pr__nfet_05v0_nvt ad=1.45 pd=10.29 as=1.45 ps=10.29 w=10 l=0.9
X579 w_n8809_8685# a_n8609_2082# a_n8609_14110# w_n8809_8685# sky130_fd_pr__pfet_g5v0d10v5 ad=0.2175 pd=1.79 as=0.2175 ps=1.79 w=1.5 l=4
X580 vin a_n8581_n15597# a_n8639_n20509# vss sky130_fd_pr__nfet_05v0_nvt ad=1.45 pd=10.29 as=1.45 ps=10.29 w=10 l=0.9
X581 w_n8809_8685# a_n8609_2082# a_n8609_14110# w_n8809_8685# sky130_fd_pr__pfet_g5v0d10v5 ad=0.2175 pd=1.79 as=0.435 ps=3.58 w=1.5 l=4
X582 vin a_n8581_n15597# a_n8639_n20509# vss sky130_fd_pr__nfet_05v0_nvt ad=1.45 pd=10.29 as=1.45 ps=10.29 w=10 l=0.9
X583 a_n8609_14110# a_n8609_2082# w_n8809_8685# w_n8809_8685# sky130_fd_pr__pfet_g5v0d10v5 ad=0.2175 pd=1.79 as=0.2175 ps=1.79 w=1.5 l=4
X584 vss ibias ibias vss sky130_fd_pr__nfet_g5v0d10v5 ad=0.145 pd=1.29 as=0.145 ps=1.29 w=1 l=4
X585 a_n8639_n20509# a_n8581_n15597# vin vss sky130_fd_pr__nfet_05v0_nvt ad=1.45 pd=10.29 as=1.45 ps=10.29 w=10 l=0.9
X586 vss a_n8609_6082# a_n8609_14110# vss sky130_fd_pr__nfet_g5v0d10v5 ad=1.45 pd=10.29 as=1.45 ps=10.29 w=10 l=0.5
X587 a_n8609_14110# a_n8609_2082# w_n8809_8685# w_n8809_8685# sky130_fd_pr__pfet_g5v0d10v5 ad=0.435 pd=3.58 as=0.2175 ps=1.79 w=1.5 l=4
X588 a_n8609_14110# a_n8609_2082# w_n8809_8685# w_n8809_8685# sky130_fd_pr__pfet_g5v0d10v5 ad=0.2175 pd=1.79 as=0.2175 ps=1.79 w=1.5 l=4
X589 w_n8809_8685# vss sky130_fd_pr__cap_mim_m3_1 l=22.2 w=22.2
X590 a_n8639_n20509# a_n8581_n15597# vin vss sky130_fd_pr__nfet_05v0_nvt ad=1.45 pd=10.29 as=1.45 ps=10.29 w=10 l=0.9
X591 a_n8609_14110# a_n8609_2082# w_n8809_8685# w_n8809_8685# sky130_fd_pr__pfet_g5v0d10v5 ad=0.2175 pd=1.79 as=0.2175 ps=1.79 w=1.5 l=4
X592 w_n8809_8685# a_n8609_2082# a_n8609_14110# w_n8809_8685# sky130_fd_pr__pfet_g5v0d10v5 ad=0.2175 pd=1.79 as=0.2175 ps=1.79 w=1.5 l=4
X593 w_n8809_8685# a_n8609_2082# a_n8609_2082# w_n8809_8685# sky130_fd_pr__pfet_g5v0d10v5 ad=0.2175 pd=1.79 as=0.2175 ps=1.79 w=1.5 l=4
X594 a_n8609_2082# a_n8609_2082# w_n8809_8685# w_n8809_8685# sky130_fd_pr__pfet_g5v0d10v5 ad=0.2175 pd=1.79 as=0.2175 ps=1.79 w=1.5 l=4
X595 vss a_n8609_4082# a_n8609_6082# vss sky130_fd_pr__nfet_g5v0d10v5 ad=0.145 pd=1.29 as=0.145 ps=1.29 w=1 l=4
X596 a_n8609_4082# a_n8609_4082# vss vss sky130_fd_pr__nfet_g5v0d10v5 ad=0.145 pd=1.29 as=0.145 ps=1.29 w=1 l=4
X597 vin a_n8581_n15597# a_n8639_n20509# vss sky130_fd_pr__nfet_05v0_nvt ad=1.45 pd=10.29 as=1.45 ps=10.29 w=10 l=0.9
X598 w_n8809_8685# a_n8609_2082# a_n8609_14110# w_n8809_8685# sky130_fd_pr__pfet_g5v0d10v5 ad=0.2175 pd=1.79 as=0.435 ps=3.58 w=1.5 l=4
X599 a_n8639_n20509# a_n8609_14110# out vss sky130_fd_pr__nfet_05v0_nvt ad=1.45 pd=10.29 as=1.45 ps=10.29 w=10 l=0.9
X600 vin a_n8581_n15597# a_n8639_n20509# vss sky130_fd_pr__nfet_05v0_nvt ad=1.45 pd=10.29 as=1.45 ps=10.29 w=10 l=0.9
X601 a_n8609_14110# a_n8609_2082# w_n8809_8685# w_n8809_8685# sky130_fd_pr__pfet_g5v0d10v5 ad=0.2175 pd=1.79 as=0.2175 ps=1.79 w=1.5 l=4
X602 a_n8609_14110# a_n8609_2082# w_n8809_8685# w_n8809_8685# sky130_fd_pr__pfet_g5v0d10v5 ad=0.2175 pd=1.79 as=0.2175 ps=1.79 w=1.5 l=4
X603 a_n8609_2082# ibias vss vss sky130_fd_pr__nfet_g5v0d10v5 ad=0.145 pd=1.29 as=0.145 ps=1.29 w=1 l=4
X604 a_n8609_14110# a_n8609_2082# w_n8809_8685# w_n8809_8685# sky130_fd_pr__pfet_g5v0d10v5 ad=0.2175 pd=1.79 as=0.2175 ps=1.79 w=1.5 l=4
X605 a_n8581_n15597# vss sky130_fd_pr__cap_mim_m3_1 l=22.2 w=22.2
X606 a_n8639_n20509# a_n8609_14110# out vss sky130_fd_pr__nfet_05v0_nvt ad=1.45 pd=10.29 as=1.45 ps=10.29 w=10 l=0.9
X607 vin a_n8581_n15597# a_n8639_n20509# vss sky130_fd_pr__nfet_05v0_nvt ad=1.45 pd=10.29 as=1.45 ps=10.29 w=10 l=0.9
X608 a_n8609_11046# a_n8609_2082# w_n8809_8685# w_n8809_8685# sky130_fd_pr__pfet_g5v0d10v5 ad=0.2175 pd=1.79 as=0.2175 ps=1.79 w=1.5 l=4
X609 vss ibias a_n8609_2082# vss sky130_fd_pr__nfet_g5v0d10v5 ad=0.145 pd=1.29 as=0.145 ps=1.29 w=1 l=4
X610 vss a_n8609_4082# a_n8609_4082# vss sky130_fd_pr__nfet_g5v0d10v5 ad=0.145 pd=1.29 as=0.145 ps=1.29 w=1 l=4
X611 a_n8639_n20509# a_n8581_n15597# vin vss sky130_fd_pr__nfet_05v0_nvt ad=1.45 pd=10.29 as=1.45 ps=10.29 w=10 l=0.9
X612 w_n8809_8685# a_n8609_2082# a_n8609_14110# w_n8809_8685# sky130_fd_pr__pfet_g5v0d10v5 ad=0.2175 pd=1.79 as=0.2175 ps=1.79 w=1.5 l=4
X613 a_n8639_n20509# a_n8581_n15597# vin vss sky130_fd_pr__nfet_05v0_nvt ad=1.45 pd=10.29 as=1.45 ps=10.29 w=10 l=0.9
X614 vss ibias ibias vss sky130_fd_pr__nfet_g5v0d10v5 ad=0.145 pd=1.29 as=0.145 ps=1.29 w=1 l=4
X615 vss a_n8609_4082# a_n8609_4082# vss sky130_fd_pr__nfet_g5v0d10v5 ad=0.145 pd=1.29 as=0.145 ps=1.29 w=1 l=4
X616 a_n8639_n20509# a_n8581_n15597# vin vss sky130_fd_pr__nfet_05v0_nvt ad=1.45 pd=10.29 as=1.45 ps=10.29 w=10 l=0.9
X617 a_n8639_n20509# a_n8609_14110# out vss sky130_fd_pr__nfet_05v0_nvt ad=1.45 pd=10.29 as=1.45 ps=10.29 w=10 l=0.9
X618 a_n8609_14110# a_n8609_2082# w_n8809_8685# w_n8809_8685# sky130_fd_pr__pfet_g5v0d10v5 ad=0.2175 pd=1.79 as=0.2175 ps=1.79 w=1.5 l=4
X619 a_n8639_n20509# a_n8609_14110# out vss sky130_fd_pr__nfet_05v0_nvt ad=1.45 pd=10.29 as=1.45 ps=10.29 w=10 l=0.9
X620 a_n8639_n20509# a_n8581_n15597# vin vss sky130_fd_pr__nfet_05v0_nvt ad=1.45 pd=10.29 as=1.45 ps=10.29 w=10 l=0.9
X621 w_n8809_8685# a_n8609_2082# a_n8609_11046# w_n8809_8685# sky130_fd_pr__pfet_g5v0d10v5 ad=0.2175 pd=1.79 as=0.2175 ps=1.79 w=1.5 l=4
X622 out a_n8609_14110# a_n8639_n20509# vss sky130_fd_pr__nfet_05v0_nvt ad=1.45 pd=10.29 as=1.45 ps=10.29 w=10 l=0.9
X623 a_n8609_14110# a_n8609_2082# w_n8809_8685# w_n8809_8685# sky130_fd_pr__pfet_g5v0d10v5 ad=0.2175 pd=1.79 as=0.2175 ps=1.79 w=1.5 l=4
X624 w_n8809_8685# a_n8609_2082# a_n8609_14110# w_n8809_8685# sky130_fd_pr__pfet_g5v0d10v5 ad=0.2175 pd=1.79 as=0.2175 ps=1.79 w=1.5 l=4
X625 w_n8809_8685# vss sky130_fd_pr__cap_mim_m3_1 l=22.2 w=22.2
X626 a_n8581_n15597# vss sky130_fd_pr__cap_mim_m3_1 l=22.2 w=22.2
X627 a_4700_n3568# a_n8609_14110# sky130_fd_pr__cap_mim_m3_1 l=22.2 w=22.2
X628 a_n8609_14110# a_n8609_6082# vss vss sky130_fd_pr__nfet_g5v0d10v5 ad=2.9 pd=20.58 as=1.45 ps=10.29 w=10 l=0.5
X629 a_n8609_4082# a_n8609_4082# vss vss sky130_fd_pr__nfet_g5v0d10v5 ad=0.145 pd=1.29 as=0.145 ps=1.29 w=1 l=4
X630 vin a_n8581_n15597# a_n8639_n20509# vss sky130_fd_pr__nfet_05v0_nvt ad=1.45 pd=10.29 as=1.45 ps=10.29 w=10 l=0.9
X631 vin a_n8581_n15597# a_n8639_n20509# vss sky130_fd_pr__nfet_05v0_nvt ad=1.45 pd=10.29 as=1.45 ps=10.29 w=10 l=0.9
X632 a_n8609_11046# a_n8609_2082# w_n8809_8685# w_n8809_8685# sky130_fd_pr__pfet_g5v0d10v5 ad=0.435 pd=3.58 as=0.2175 ps=1.79 w=1.5 l=4
X633 a_n8609_2082# ibias vss vss sky130_fd_pr__nfet_g5v0d10v5 ad=0.145 pd=1.29 as=0.145 ps=1.29 w=1 l=4
X634 w_n8809_8685# a_n8609_2082# a_n8609_14110# w_n8809_8685# sky130_fd_pr__pfet_g5v0d10v5 ad=0.2175 pd=1.79 as=0.2175 ps=1.79 w=1.5 l=4
X635 a_n8609_14110# a_n8609_2082# w_n8809_8685# w_n8809_8685# sky130_fd_pr__pfet_g5v0d10v5 ad=0.2175 pd=1.79 as=0.2175 ps=1.79 w=1.5 l=4
X636 vin a_n8581_n15597# a_n8639_n20509# vss sky130_fd_pr__nfet_05v0_nvt ad=2.9 pd=20.58 as=1.45 ps=10.29 w=10 l=0.9
X637 a_n8609_14110# a_n8609_2082# w_n8809_8685# w_n8809_8685# sky130_fd_pr__pfet_g5v0d10v5 ad=0.2175 pd=1.79 as=0.2175 ps=1.79 w=1.5 l=4
X638 a_n8639_n20509# a_n8581_n15597# vin vss sky130_fd_pr__nfet_05v0_nvt ad=1.45 pd=10.29 as=2.9 ps=20.58 w=10 l=0.9
X639 a_n8609_11046# a_n8609_2082# w_n8809_8685# w_n8809_8685# sky130_fd_pr__pfet_g5v0d10v5 ad=0.2175 pd=1.79 as=0.2175 ps=1.79 w=1.5 l=4
X640 out a_n8609_14110# a_n8639_n20509# vss sky130_fd_pr__nfet_05v0_nvt ad=1.45 pd=10.29 as=1.45 ps=10.29 w=10 l=0.9
X641 out a_n8609_14110# a_n8639_n20509# vss sky130_fd_pr__nfet_05v0_nvt ad=1.45 pd=10.29 as=1.45 ps=10.29 w=10 l=0.9
X642 a_n8609_2082# a_n8609_2082# w_n8809_8685# w_n8809_8685# sky130_fd_pr__pfet_g5v0d10v5 ad=0.2175 pd=1.79 as=0.2175 ps=1.79 w=1.5 l=4
X643 vss a_n8609_4082# a_n8609_6082# vss sky130_fd_pr__nfet_g5v0d10v5 ad=0.145 pd=1.29 as=0.145 ps=1.29 w=1 l=4
X644 a_n8609_14110# a_n8609_6082# vss vss sky130_fd_pr__nfet_g5v0d10v5 ad=1.45 pd=10.29 as=1.45 ps=10.29 w=10 l=0.5
X645 a_n8609_2082# ibias vss vss sky130_fd_pr__nfet_g5v0d10v5 ad=0.29 pd=2.58 as=0.145 ps=1.29 w=1 l=4
X646 a_n8639_n20509# a_n8609_14110# out vss sky130_fd_pr__nfet_05v0_nvt ad=1.45 pd=10.29 as=1.45 ps=10.29 w=10 l=0.9
X647 w_n8809_8685# a_n8609_2082# a_n8609_14110# w_n8809_8685# sky130_fd_pr__pfet_g5v0d10v5 ad=0.2175 pd=1.79 as=0.2175 ps=1.79 w=1.5 l=4
X648 a_n8639_n20509# a_n8609_14110# out vss sky130_fd_pr__nfet_05v0_nvt ad=1.45 pd=10.29 as=1.45 ps=10.29 w=10 l=0.9
X649 a_n8609_14110# a_n8609_2082# w_n8809_8685# w_n8809_8685# sky130_fd_pr__pfet_g5v0d10v5 ad=0.2175 pd=1.79 as=0.2175 ps=1.79 w=1.5 l=4
X650 w_n8809_8685# a_n8609_2082# a_n8609_14110# w_n8809_8685# sky130_fd_pr__pfet_g5v0d10v5 ad=0.2175 pd=1.79 as=0.2175 ps=1.79 w=1.5 l=4
X651 out a_n8609_14110# a_n8639_n20509# vss sky130_fd_pr__nfet_05v0_nvt ad=1.45 pd=10.29 as=1.45 ps=10.29 w=10 l=0.9
X652 vin a_n8581_n15597# a_n8639_n20509# vss sky130_fd_pr__nfet_05v0_nvt ad=1.45 pd=10.29 as=1.45 ps=10.29 w=10 l=0.9
X653 vss a_n8609_4082# a_n8609_6082# vss sky130_fd_pr__nfet_g5v0d10v5 ad=0.145 pd=1.29 as=0.145 ps=1.29 w=1 l=4
X654 vss ibias ibias vss sky130_fd_pr__nfet_g5v0d10v5 ad=0.145 pd=1.29 as=0.29 ps=2.58 w=1 l=4
X655 a_n8609_6082# a_n8609_4082# vss vss sky130_fd_pr__nfet_g5v0d10v5 ad=0.145 pd=1.29 as=0.145 ps=1.29 w=1 l=4
X656 out a_n8609_14110# a_n8639_n20509# vss sky130_fd_pr__nfet_05v0_nvt ad=1.45 pd=10.29 as=1.45 ps=10.29 w=10 l=0.9
X657 a_n8609_2082# a_n8609_2082# w_n8809_8685# w_n8809_8685# sky130_fd_pr__pfet_g5v0d10v5 ad=0.435 pd=3.58 as=0.2175 ps=1.79 w=1.5 l=4
X658 vss ibias ibias vss sky130_fd_pr__nfet_g5v0d10v5 ad=0.145 pd=1.29 as=0.145 ps=1.29 w=1 l=4
X659 a_n8639_n20509# a_n8581_n15597# vin vss sky130_fd_pr__nfet_05v0_nvt ad=1.45 pd=10.29 as=1.45 ps=10.29 w=10 l=0.9
X660 a_n8609_14110# a_n8609_2082# w_n8809_8685# w_n8809_8685# sky130_fd_pr__pfet_g5v0d10v5 ad=0.435 pd=3.58 as=0.2175 ps=1.79 w=1.5 l=4
X661 a_n8639_n20509# a_n8609_14110# out vss sky130_fd_pr__nfet_05v0_nvt ad=1.45 pd=10.29 as=1.45 ps=10.29 w=10 l=0.9
X662 a_n8639_n20509# a_n8609_14110# out vss sky130_fd_pr__nfet_05v0_nvt ad=1.45 pd=10.29 as=1.45 ps=10.29 w=10 l=0.9
X663 w_n8809_8685# a_n8609_2082# a_n8609_11046# w_n8809_8685# sky130_fd_pr__pfet_g5v0d10v5 ad=0.2175 pd=1.79 as=0.2175 ps=1.79 w=1.5 l=4
X664 a_n8639_n20509# a_n8609_14110# out vss sky130_fd_pr__nfet_05v0_nvt ad=1.45 pd=10.29 as=1.45 ps=10.29 w=10 l=0.9
X665 a_n8639_n20509# a_n8581_n15597# vin vss sky130_fd_pr__nfet_05v0_nvt ad=1.45 pd=10.29 as=1.45 ps=10.29 w=10 l=0.9
X666 w_n8809_8685# a_n8609_2082# a_n8609_14110# w_n8809_8685# sky130_fd_pr__pfet_g5v0d10v5 ad=0.2175 pd=1.79 as=0.2175 ps=1.79 w=1.5 l=4
X667 w_n8809_8685# a_n8609_2082# a_n8609_14110# w_n8809_8685# sky130_fd_pr__pfet_g5v0d10v5 ad=0.2175 pd=1.79 as=0.2175 ps=1.79 w=1.5 l=4
X668 out a_n8609_14110# a_n8639_n20509# vss sky130_fd_pr__nfet_05v0_nvt ad=1.45 pd=10.29 as=1.45 ps=10.29 w=10 l=0.9
X669 a_n8609_14110# a_n8609_2082# w_n8809_8685# w_n8809_8685# sky130_fd_pr__pfet_g5v0d10v5 ad=0.2175 pd=1.79 as=0.2175 ps=1.79 w=1.5 l=4
X670 a_n8609_11046# a_n8609_2082# w_n8809_8685# w_n8809_8685# sky130_fd_pr__pfet_g5v0d10v5 ad=0.2175 pd=1.79 as=0.2175 ps=1.79 w=1.5 l=4
X671 a_n8609_2082# a_n8609_2082# w_n8809_8685# w_n8809_8685# sky130_fd_pr__pfet_g5v0d10v5 ad=0.2175 pd=1.79 as=0.2175 ps=1.79 w=1.5 l=4
X672 vin a_n8581_n15597# a_n8639_n20509# vss sky130_fd_pr__nfet_05v0_nvt ad=1.45 pd=10.29 as=1.45 ps=10.29 w=10 l=0.9
X673 a_n8639_n20509# a_n8581_n15597# vin vss sky130_fd_pr__nfet_05v0_nvt ad=1.45 pd=10.29 as=1.45 ps=10.29 w=10 l=0.9
X674 ibias ibias vss vss sky130_fd_pr__nfet_g5v0d10v5 ad=0.145 pd=1.29 as=0.145 ps=1.29 w=1 l=4
X675 a_n8609_14110# a_n8609_2082# w_n8809_8685# w_n8809_8685# sky130_fd_pr__pfet_g5v0d10v5 ad=0.2175 pd=1.79 as=0.2175 ps=1.79 w=1.5 l=4
X676 vss a_n8609_4082# a_n8609_4082# vss sky130_fd_pr__nfet_g5v0d10v5 ad=0.145 pd=1.29 as=0.145 ps=1.29 w=1 l=4
X677 a_n8609_2082# ibias vss vss sky130_fd_pr__nfet_g5v0d10v5 ad=0.145 pd=1.29 as=0.145 ps=1.29 w=1 l=4
X678 w_n8809_8685# vss sky130_fd_pr__cap_mim_m3_1 l=22.2 w=22.2
X679 a_n8639_n20509# a_n8609_14110# out vss sky130_fd_pr__nfet_05v0_nvt ad=1.45 pd=10.29 as=1.45 ps=10.29 w=10 l=0.9
X680 a_n8639_n20509# a_n8609_14110# out vss sky130_fd_pr__nfet_05v0_nvt ad=1.45 pd=10.29 as=1.45 ps=10.29 w=10 l=0.9
X681 out a_n8609_14110# a_n8639_n20509# vss sky130_fd_pr__nfet_05v0_nvt ad=1.45 pd=10.29 as=1.45 ps=10.29 w=10 l=0.9
X682 vss ibias a_n8609_2082# vss sky130_fd_pr__nfet_g5v0d10v5 ad=0.145 pd=1.29 as=0.145 ps=1.29 w=1 l=4
X683 out a_n8609_14110# a_n8639_n20509# vss sky130_fd_pr__nfet_05v0_nvt ad=1.45 pd=10.29 as=1.45 ps=10.29 w=10 l=0.9
X684 w_n8809_8685# a_n8609_2082# a_n8609_11046# w_n8809_8685# sky130_fd_pr__pfet_g5v0d10v5 ad=0.2175 pd=1.79 as=0.2175 ps=1.79 w=1.5 l=4
X685 w_n8809_8685# a_n8609_2082# a_n8609_11046# w_n8809_8685# sky130_fd_pr__pfet_g5v0d10v5 ad=0.2175 pd=1.79 as=0.2175 ps=1.79 w=1.5 l=4
X686 w_n8809_8685# a_n8609_2082# a_n8609_14110# w_n8809_8685# sky130_fd_pr__pfet_g5v0d10v5 ad=0.2175 pd=1.79 as=0.2175 ps=1.79 w=1.5 l=4
X687 w_n8809_8685# a_n8609_2082# a_n8609_14110# w_n8809_8685# sky130_fd_pr__pfet_g5v0d10v5 ad=0.2175 pd=1.79 as=0.2175 ps=1.79 w=1.5 l=4
X688 vss ibias a_n8609_2082# vss sky130_fd_pr__nfet_g5v0d10v5 ad=0.145 pd=1.29 as=0.145 ps=1.29 w=1 l=4
X689 a_n8639_n20509# a_n8581_n15597# vin vss sky130_fd_pr__nfet_05v0_nvt ad=1.45 pd=10.29 as=1.45 ps=10.29 w=10 l=0.9
X690 a_n8639_n20509# a_n8609_14110# out vss sky130_fd_pr__nfet_05v0_nvt ad=1.45 pd=10.29 as=1.45 ps=10.29 w=10 l=0.9
X691 ibias ibias vss vss sky130_fd_pr__nfet_g5v0d10v5 ad=0.29 pd=2.58 as=0.145 ps=1.29 w=1 l=4
X692 w_n8809_8685# a_n8609_2082# a_n8609_2082# w_n8809_8685# sky130_fd_pr__pfet_g5v0d10v5 ad=0.2175 pd=1.79 as=0.2175 ps=1.79 w=1.5 l=4
X693 a_n8609_6082# a_n8609_4082# vss vss sky130_fd_pr__nfet_g5v0d10v5 ad=0.145 pd=1.29 as=0.145 ps=1.29 w=1 l=4
X694 out a_n8609_14110# a_n8639_n20509# vss sky130_fd_pr__nfet_05v0_nvt ad=1.45 pd=10.29 as=1.45 ps=10.29 w=10 l=0.9
X695 vin a_n8581_n15597# a_n8639_n20509# vss sky130_fd_pr__nfet_05v0_nvt ad=1.45 pd=10.29 as=1.45 ps=10.29 w=10 l=0.9
X696 a_n8609_14110# a_n8609_2082# w_n8809_8685# w_n8809_8685# sky130_fd_pr__pfet_g5v0d10v5 ad=0.2175 pd=1.79 as=0.2175 ps=1.79 w=1.5 l=4
X697 vss a_n8609_4082# a_n8609_6082# vss sky130_fd_pr__nfet_g5v0d10v5 ad=0.145 pd=1.29 as=0.145 ps=1.29 w=1 l=4
X698 out a_n8609_14110# a_n8639_n20509# vss sky130_fd_pr__nfet_05v0_nvt ad=1.45 pd=10.29 as=1.45 ps=10.29 w=10 l=0.9
X699 a_n8609_14110# a_n8609_2082# w_n8809_8685# w_n8809_8685# sky130_fd_pr__pfet_g5v0d10v5 ad=0.2175 pd=1.79 as=0.2175 ps=1.79 w=1.5 l=4
X700 a_n8609_2082# ibias vss vss sky130_fd_pr__nfet_g5v0d10v5 ad=0.145 pd=1.29 as=0.145 ps=1.29 w=1 l=4
X701 a_n8639_n20509# a_n8609_14110# out vss sky130_fd_pr__nfet_05v0_nvt ad=1.45 pd=10.29 as=1.45 ps=10.29 w=10 l=0.9
X702 w_n8809_8685# a_n8609_2082# a_n8609_14110# w_n8809_8685# sky130_fd_pr__pfet_g5v0d10v5 ad=0.2175 pd=1.79 as=0.2175 ps=1.79 w=1.5 l=4
X703 a_n8639_n20509# a_n8609_14110# out vss sky130_fd_pr__nfet_05v0_nvt ad=1.45 pd=10.29 as=1.45 ps=10.29 w=10 l=0.9
X704 a_n8609_14110# a_n8609_2082# w_n8809_8685# w_n8809_8685# sky130_fd_pr__pfet_g5v0d10v5 ad=0.2175 pd=1.79 as=0.2175 ps=1.79 w=1.5 l=4
X705 a_n8609_11046# a_n8609_2082# w_n8809_8685# w_n8809_8685# sky130_fd_pr__pfet_g5v0d10v5 ad=0.2175 pd=1.79 as=0.2175 ps=1.79 w=1.5 l=4
X706 vss ibias ibias vss sky130_fd_pr__nfet_g5v0d10v5 ad=0.145 pd=1.29 as=0.145 ps=1.29 w=1 l=4
X707 vss ibias ibias vss sky130_fd_pr__nfet_g5v0d10v5 ad=0.145 pd=1.29 as=0.145 ps=1.29 w=1 l=4
X708 vin a_n8581_n15597# a_n8639_n20509# vss sky130_fd_pr__nfet_05v0_nvt ad=1.45 pd=10.29 as=1.45 ps=10.29 w=10 l=0.9
X709 a_n8609_2082# a_n8609_2082# w_n8809_8685# w_n8809_8685# sky130_fd_pr__pfet_g5v0d10v5 ad=0.2175 pd=1.79 as=0.2175 ps=1.79 w=1.5 l=4
X710 vin a_n8581_n15597# a_n8639_n20509# vss sky130_fd_pr__nfet_05v0_nvt ad=1.45 pd=10.29 as=1.45 ps=10.29 w=10 l=0.9
X711 w_n8809_8685# a_n8609_2082# a_n8609_14110# w_n8809_8685# sky130_fd_pr__pfet_g5v0d10v5 ad=0.2175 pd=1.79 as=0.2175 ps=1.79 w=1.5 l=4
X712 w_n8809_8685# vss sky130_fd_pr__cap_mim_m3_1 l=22.2 w=22.2
X713 w_n8809_8685# a_n8609_2082# a_n8609_14110# w_n8809_8685# sky130_fd_pr__pfet_g5v0d10v5 ad=0.2175 pd=1.79 as=0.2175 ps=1.79 w=1.5 l=4
X714 vss a_n8609_4082# a_n8609_4082# vss sky130_fd_pr__nfet_g5v0d10v5 ad=0.145 pd=1.29 as=0.145 ps=1.29 w=1 l=4
X715 a_n8639_n20509# a_n8609_14110# out vss sky130_fd_pr__nfet_05v0_nvt ad=1.45 pd=10.29 as=1.45 ps=10.29 w=10 l=0.9
X716 a_n8639_n20509# a_n8581_n15597# vin vss sky130_fd_pr__nfet_05v0_nvt ad=1.45 pd=10.29 as=1.45 ps=10.29 w=10 l=0.9
X717 a_n8609_14110# a_n8609_2082# w_n8809_8685# w_n8809_8685# sky130_fd_pr__pfet_g5v0d10v5 ad=0.2175 pd=1.79 as=0.2175 ps=1.79 w=1.5 l=4
X718 vss a_n8609_4082# a_n8609_6082# vss sky130_fd_pr__nfet_g5v0d10v5 ad=0.145 pd=1.29 as=0.145 ps=1.29 w=1 l=4
X719 a_n8609_6082# a_n8609_4082# vss vss sky130_fd_pr__nfet_g5v0d10v5 ad=0.145 pd=1.29 as=0.145 ps=1.29 w=1 l=4
X720 vss a_n8609_4082# a_n8609_4082# vss sky130_fd_pr__nfet_g5v0d10v5 ad=0.145 pd=1.29 as=0.145 ps=1.29 w=1 l=4
X721 a_n8639_n20509# a_n8609_14110# out vss sky130_fd_pr__nfet_05v0_nvt ad=1.45 pd=10.29 as=1.45 ps=10.29 w=10 l=0.9
X722 out a_n8609_14110# a_n8639_n20509# vss sky130_fd_pr__nfet_05v0_nvt ad=1.45 pd=10.29 as=1.45 ps=10.29 w=10 l=0.9
X723 a_n8609_14110# a_n8609_2082# w_n8809_8685# w_n8809_8685# sky130_fd_pr__pfet_g5v0d10v5 ad=0.435 pd=3.58 as=0.2175 ps=1.79 w=1.5 l=4
X724 w_n8809_8685# a_n8609_2082# a_n8609_14110# w_n8809_8685# sky130_fd_pr__pfet_g5v0d10v5 ad=0.2175 pd=1.79 as=0.2175 ps=1.79 w=1.5 l=4
X725 a_n8609_4082# a_n8609_4082# vss vss sky130_fd_pr__nfet_g5v0d10v5 ad=0.145 pd=1.29 as=0.145 ps=1.29 w=1 l=4
X726 a_n8639_n20509# a_n8609_14110# out vss sky130_fd_pr__nfet_05v0_nvt ad=1.45 pd=10.29 as=1.45 ps=10.29 w=10 l=0.9
X727 w_n8809_8685# a_n8609_2082# a_n8609_14110# w_n8809_8685# sky130_fd_pr__pfet_g5v0d10v5 ad=0.2175 pd=1.79 as=0.435 ps=3.58 w=1.5 l=4
X728 a_n8639_n20509# a_n8581_n15597# vin vss sky130_fd_pr__nfet_05v0_nvt ad=1.45 pd=10.29 as=1.45 ps=10.29 w=10 l=0.9
X729 a_n8609_14110# a_n8609_2082# w_n8809_8685# w_n8809_8685# sky130_fd_pr__pfet_g5v0d10v5 ad=0.2175 pd=1.79 as=0.2175 ps=1.79 w=1.5 l=4
X730 a_n8609_14110# a_n8609_2082# w_n8809_8685# w_n8809_8685# sky130_fd_pr__pfet_g5v0d10v5 ad=0.2175 pd=1.79 as=0.2175 ps=1.79 w=1.5 l=4
X731 vin a_n8581_n15597# a_n8639_n20509# vss sky130_fd_pr__nfet_05v0_nvt ad=1.45 pd=10.29 as=1.45 ps=10.29 w=10 l=0.9
X732 a_n8609_11046# a_n8609_2082# w_n8809_8685# w_n8809_8685# sky130_fd_pr__pfet_g5v0d10v5 ad=0.2175 pd=1.79 as=0.2175 ps=1.79 w=1.5 l=4
X733 w_n8809_8685# a_n8609_2082# a_n8609_11046# w_n8809_8685# sky130_fd_pr__pfet_g5v0d10v5 ad=0.2175 pd=1.79 as=0.2175 ps=1.79 w=1.5 l=4
X734 a_n8609_2082# a_n8609_2082# w_n8809_8685# w_n8809_8685# sky130_fd_pr__pfet_g5v0d10v5 ad=0.2175 pd=1.79 as=0.2175 ps=1.79 w=1.5 l=4
X735 vss a_n8609_4082# a_n8609_6082# vss sky130_fd_pr__nfet_g5v0d10v5 ad=0.145 pd=1.29 as=0.29 ps=2.58 w=1 l=4
X736 out a_n8609_14110# a_n8639_n20509# vss sky130_fd_pr__nfet_05v0_nvt ad=1.45 pd=10.29 as=1.45 ps=10.29 w=10 l=0.9
X737 a_n8609_14110# a_n8609_2082# w_n8809_8685# w_n8809_8685# sky130_fd_pr__pfet_g5v0d10v5 ad=0.2175 pd=1.79 as=0.2175 ps=1.79 w=1.5 l=4
X738 w_n8809_8685# a_n8609_2082# a_n8609_14110# w_n8809_8685# sky130_fd_pr__pfet_g5v0d10v5 ad=0.2175 pd=1.79 as=0.2175 ps=1.79 w=1.5 l=4
X739 a_n8639_n20509# a_n8609_14110# out vss sky130_fd_pr__nfet_05v0_nvt ad=1.45 pd=10.29 as=1.45 ps=10.29 w=10 l=0.9
X740 vss ibias a_n8609_2082# vss sky130_fd_pr__nfet_g5v0d10v5 ad=0.145 pd=1.29 as=0.145 ps=1.29 w=1 l=4
X741 a_n8639_n20509# a_n8581_n15597# vin vss sky130_fd_pr__nfet_05v0_nvt ad=1.45 pd=10.29 as=1.45 ps=10.29 w=10 l=0.9
X742 a_n8581_n15597# vss sky130_fd_pr__cap_mim_m3_1 l=22.2 w=22.2
X743 a_n8639_n20509# a_n8581_n15597# vin vss sky130_fd_pr__nfet_05v0_nvt ad=1.45 pd=10.29 as=1.45 ps=10.29 w=10 l=0.9
X744 a_n8609_14110# a_n8609_2082# w_n8809_8685# w_n8809_8685# sky130_fd_pr__pfet_g5v0d10v5 ad=0.2175 pd=1.79 as=0.2175 ps=1.79 w=1.5 l=4
X745 w_n8809_8685# a_n8609_2082# a_n8609_11046# w_n8809_8685# sky130_fd_pr__pfet_g5v0d10v5 ad=0.2175 pd=1.79 as=0.2175 ps=1.79 w=1.5 l=4
X746 w_n8809_8685# a_n8609_2082# a_n8609_14110# w_n8809_8685# sky130_fd_pr__pfet_g5v0d10v5 ad=0.2175 pd=1.79 as=0.2175 ps=1.79 w=1.5 l=4
X747 a_n8609_14110# a_n8609_2082# w_n8809_8685# w_n8809_8685# sky130_fd_pr__pfet_g5v0d10v5 ad=0.2175 pd=1.79 as=0.2175 ps=1.79 w=1.5 l=4
X748 a_n8581_n15597# vss sky130_fd_pr__cap_mim_m3_1 l=22.2 w=22.2
X749 w_n8809_8685# vss sky130_fd_pr__cap_mim_m3_1 l=22.2 w=22.2
X750 a_n8609_11046# a_n8609_2082# w_n8809_8685# w_n8809_8685# sky130_fd_pr__pfet_g5v0d10v5 ad=0.435 pd=3.58 as=0.2175 ps=1.79 w=1.5 l=4
X751 w_n8809_8685# a_n8609_2082# a_n8609_14110# w_n8809_8685# sky130_fd_pr__pfet_g5v0d10v5 ad=0.2175 pd=1.79 as=0.2175 ps=1.79 w=1.5 l=4
X752 a_n8609_14110# a_n8609_2082# w_n8809_8685# w_n8809_8685# sky130_fd_pr__pfet_g5v0d10v5 ad=0.2175 pd=1.79 as=0.2175 ps=1.79 w=1.5 l=4
X753 vin a_n8581_n15597# a_n8639_n20509# vss sky130_fd_pr__nfet_05v0_nvt ad=1.45 pd=10.29 as=1.45 ps=10.29 w=10 l=0.9
X754 a_n8609_6082# a_n8609_4082# vss vss sky130_fd_pr__nfet_g5v0d10v5 ad=0.145 pd=1.29 as=0.145 ps=1.29 w=1 l=4
X755 a_n8639_n20509# a_n8581_n15597# vin vss sky130_fd_pr__nfet_05v0_nvt ad=1.45 pd=10.29 as=1.45 ps=10.29 w=10 l=0.9
X756 w_n8809_8685# a_n8609_2082# a_n8609_14110# w_n8809_8685# sky130_fd_pr__pfet_g5v0d10v5 ad=0.2175 pd=1.79 as=0.2175 ps=1.79 w=1.5 l=4
X757 vss a_n8609_4082# a_n8609_6082# vss sky130_fd_pr__nfet_g5v0d10v5 ad=0.145 pd=1.29 as=0.145 ps=1.29 w=1 l=4
X758 a_n8609_4082# a_n8609_4082# vss vss sky130_fd_pr__nfet_g5v0d10v5 ad=0.145 pd=1.29 as=0.145 ps=1.29 w=1 l=4
X759 vss ibias ibias vss sky130_fd_pr__nfet_g5v0d10v5 ad=0.145 pd=1.29 as=0.145 ps=1.29 w=1 l=4
X760 vin a_n8581_n15597# a_n8639_n20509# vss sky130_fd_pr__nfet_05v0_nvt ad=1.45 pd=10.29 as=1.45 ps=10.29 w=10 l=0.9
X761 a_n8609_14110# a_n8609_2082# w_n8809_8685# w_n8809_8685# sky130_fd_pr__pfet_g5v0d10v5 ad=0.2175 pd=1.79 as=0.2175 ps=1.79 w=1.5 l=4
X762 a_n8609_11046# a_n8609_2082# w_n8809_8685# w_n8809_8685# sky130_fd_pr__pfet_g5v0d10v5 ad=0.2175 pd=1.79 as=0.2175 ps=1.79 w=1.5 l=4
X763 vss a_n8609_4082# a_n8609_4082# vss sky130_fd_pr__nfet_g5v0d10v5 ad=0.145 pd=1.29 as=0.145 ps=1.29 w=1 l=4
X764 vin a_n8581_n15597# a_n8639_n20509# vss sky130_fd_pr__nfet_05v0_nvt ad=1.45 pd=10.29 as=1.45 ps=10.29 w=10 l=0.9
X765 w_n8809_8685# a_n8609_2082# a_n8609_14110# w_n8809_8685# sky130_fd_pr__pfet_g5v0d10v5 ad=0.2175 pd=1.79 as=0.2175 ps=1.79 w=1.5 l=4
X766 a_n8639_n20509# a_n8581_n15597# vin vss sky130_fd_pr__nfet_05v0_nvt ad=1.45 pd=10.29 as=1.45 ps=10.29 w=10 l=0.9
X767 w_n8809_8685# a_n8609_2082# a_n8609_14110# w_n8809_8685# sky130_fd_pr__pfet_g5v0d10v5 ad=0.2175 pd=1.79 as=0.2175 ps=1.79 w=1.5 l=4
X768 a_n8609_6082# a_n8609_4082# vss vss sky130_fd_pr__nfet_g5v0d10v5 ad=0.145 pd=1.29 as=0.145 ps=1.29 w=1 l=4
X769 vss ibias ibias vss sky130_fd_pr__nfet_g5v0d10v5 ad=0.145 pd=1.29 as=0.29 ps=2.58 w=1 l=4
X770 w_n8809_8685# a_n8609_2082# a_n8609_14110# w_n8809_8685# sky130_fd_pr__pfet_g5v0d10v5 ad=0.2175 pd=1.79 as=0.2175 ps=1.79 w=1.5 l=4
X771 a_n8609_14110# a_n8609_2082# w_n8809_8685# w_n8809_8685# sky130_fd_pr__pfet_g5v0d10v5 ad=0.2175 pd=1.79 as=0.2175 ps=1.79 w=1.5 l=4
X772 a_n8609_14110# a_n8609_2082# w_n8809_8685# w_n8809_8685# sky130_fd_pr__pfet_g5v0d10v5 ad=0.2175 pd=1.79 as=0.2175 ps=1.79 w=1.5 l=4
X773 out a_n8609_14110# a_n8639_n20509# vss sky130_fd_pr__nfet_05v0_nvt ad=1.45 pd=10.29 as=1.45 ps=10.29 w=10 l=0.9
X774 w_n8809_8685# a_n8609_2082# a_n8609_2082# w_n8809_8685# sky130_fd_pr__pfet_g5v0d10v5 ad=0.2175 pd=1.79 as=0.2175 ps=1.79 w=1.5 l=4
X775 vin a_n8581_n15597# a_n8639_n20509# vss sky130_fd_pr__nfet_05v0_nvt ad=1.45 pd=10.29 as=1.45 ps=10.29 w=10 l=0.9
X776 vin a_n8581_n15597# a_n8639_n20509# vss sky130_fd_pr__nfet_05v0_nvt ad=1.45 pd=10.29 as=1.45 ps=10.29 w=10 l=0.9
X777 vin a_n8581_n15597# a_n8639_n20509# vss sky130_fd_pr__nfet_05v0_nvt ad=1.45 pd=10.29 as=1.45 ps=10.29 w=10 l=0.9
X778 a_n8609_14110# a_n8609_2082# w_n8809_8685# w_n8809_8685# sky130_fd_pr__pfet_g5v0d10v5 ad=0.2175 pd=1.79 as=0.2175 ps=1.79 w=1.5 l=4
X779 vss ibias a_n8609_2082# vss sky130_fd_pr__nfet_g5v0d10v5 ad=0.145 pd=1.29 as=0.145 ps=1.29 w=1 l=4
X780 vin a_n8581_n15597# a_n8639_n20509# vss sky130_fd_pr__nfet_05v0_nvt ad=1.45 pd=10.29 as=1.45 ps=10.29 w=10 l=0.9
X781 a_n8639_n20509# a_n8581_n15597# vin vss sky130_fd_pr__nfet_05v0_nvt ad=1.45 pd=10.29 as=1.45 ps=10.29 w=10 l=0.9
X782 a_n8639_n20509# a_n8581_n15597# vin vss sky130_fd_pr__nfet_05v0_nvt ad=1.45 pd=10.29 as=1.45 ps=10.29 w=10 l=0.9
X783 w_n8809_8685# a_n8609_2082# a_n8609_11046# w_n8809_8685# sky130_fd_pr__pfet_g5v0d10v5 ad=0.2175 pd=1.79 as=0.2175 ps=1.79 w=1.5 l=4
X784 a_n8609_6082# a_n8609_4082# vss vss sky130_fd_pr__nfet_g5v0d10v5 ad=0.145 pd=1.29 as=0.145 ps=1.29 w=1 l=4
X785 w_n8809_8685# a_n8609_2082# a_n8609_14110# w_n8809_8685# sky130_fd_pr__pfet_g5v0d10v5 ad=0.2175 pd=1.79 as=0.2175 ps=1.79 w=1.5 l=4
X786 a_n8609_14110# a_n8609_2082# w_n8809_8685# w_n8809_8685# sky130_fd_pr__pfet_g5v0d10v5 ad=0.2175 pd=1.79 as=0.2175 ps=1.79 w=1.5 l=4
X787 vss a_n8609_4082# a_n8609_4082# vss sky130_fd_pr__nfet_g5v0d10v5 ad=0.145 pd=1.29 as=0.145 ps=1.29 w=1 l=4
X788 a_n8609_4082# a_n8609_4082# vss vss sky130_fd_pr__nfet_g5v0d10v5 ad=0.145 pd=1.29 as=0.145 ps=1.29 w=1 l=4
X789 vss ibias a_n8609_2082# vss sky130_fd_pr__nfet_g5v0d10v5 ad=0.145 pd=1.29 as=0.145 ps=1.29 w=1 l=4
X790 out a_n8609_14110# a_n8639_n20509# vss sky130_fd_pr__nfet_05v0_nvt ad=1.45 pd=10.29 as=1.45 ps=10.29 w=10 l=0.9
X791 w_n8809_8685# vss sky130_fd_pr__cap_mim_m3_1 l=22.2 w=22.2
X792 ibias ibias vss vss sky130_fd_pr__nfet_g5v0d10v5 ad=0.145 pd=1.29 as=0.145 ps=1.29 w=1 l=4
X793 a_n8609_11046# a_n8609_2082# w_n8809_8685# w_n8809_8685# sky130_fd_pr__pfet_g5v0d10v5 ad=0.2175 pd=1.79 as=0.2175 ps=1.79 w=1.5 l=4
X794 w_n8809_8685# a_n8609_2082# a_n8609_2082# w_n8809_8685# sky130_fd_pr__pfet_g5v0d10v5 ad=0.2175 pd=1.79 as=0.2175 ps=1.79 w=1.5 l=4
X795 a_n8609_2082# ibias vss vss sky130_fd_pr__nfet_g5v0d10v5 ad=0.145 pd=1.29 as=0.145 ps=1.29 w=1 l=4
X796 a_n8609_14110# a_n8609_2082# w_n8809_8685# w_n8809_8685# sky130_fd_pr__pfet_g5v0d10v5 ad=0.435 pd=3.58 as=0.2175 ps=1.79 w=1.5 l=4
X797 a_n8639_n20509# a_n8581_n15597# vin vss sky130_fd_pr__nfet_05v0_nvt ad=1.45 pd=10.29 as=1.45 ps=10.29 w=10 l=0.9
X798 vin a_n8581_n15597# a_n8639_n20509# vss sky130_fd_pr__nfet_05v0_nvt ad=1.45 pd=10.29 as=1.45 ps=10.29 w=10 l=0.9
X799 vin a_n8581_n15597# a_n8639_n20509# vss sky130_fd_pr__nfet_05v0_nvt ad=1.45 pd=10.29 as=1.45 ps=10.29 w=10 l=0.9
X800 a_n8609_14110# a_n8609_2082# w_n8809_8685# w_n8809_8685# sky130_fd_pr__pfet_g5v0d10v5 ad=0.2175 pd=1.79 as=0.2175 ps=1.79 w=1.5 l=4
X801 a_n8609_14110# a_n8609_2082# w_n8809_8685# w_n8809_8685# sky130_fd_pr__pfet_g5v0d10v5 ad=0.2175 pd=1.79 as=0.2175 ps=1.79 w=1.5 l=4
X802 vss a_n8609_4082# a_n8609_4082# vss sky130_fd_pr__nfet_g5v0d10v5 ad=0.145 pd=1.29 as=0.29 ps=2.58 w=1 l=4
X803 vin a_n8581_n15597# a_n8639_n20509# vss sky130_fd_pr__nfet_05v0_nvt ad=1.45 pd=10.29 as=1.45 ps=10.29 w=10 l=0.9
X804 a_n8609_14110# a_n8609_2082# w_n8809_8685# w_n8809_8685# sky130_fd_pr__pfet_g5v0d10v5 ad=0.2175 pd=1.79 as=0.2175 ps=1.79 w=1.5 l=4
X805 w_n8809_8685# a_n8609_2082# a_n8609_11046# w_n8809_8685# sky130_fd_pr__pfet_g5v0d10v5 ad=0.2175 pd=1.79 as=0.2175 ps=1.79 w=1.5 l=4
X806 w_n8809_8685# a_n8609_2082# a_n8609_11046# w_n8809_8685# sky130_fd_pr__pfet_g5v0d10v5 ad=0.2175 pd=1.79 as=0.2175 ps=1.79 w=1.5 l=4
X807 vss ibias ibias vss sky130_fd_pr__nfet_g5v0d10v5 ad=0.145 pd=1.29 as=0.145 ps=1.29 w=1 l=4
X808 vss ibias ibias vss sky130_fd_pr__nfet_g5v0d10v5 ad=0.145 pd=1.29 as=0.145 ps=1.29 w=1 l=4
X809 w_n8809_8685# a_n8609_2082# a_n8609_11046# w_n8809_8685# sky130_fd_pr__pfet_g5v0d10v5 ad=0.2175 pd=1.79 as=0.2175 ps=1.79 w=1.5 l=4
X810 a_n8639_n20509# a_n8581_n15597# vin vss sky130_fd_pr__nfet_05v0_nvt ad=1.45 pd=10.29 as=2.9 ps=20.58 w=10 l=0.9
X811 w_n8809_8685# a_n8609_2082# a_n8609_14110# w_n8809_8685# sky130_fd_pr__pfet_g5v0d10v5 ad=0.2175 pd=1.79 as=0.2175 ps=1.79 w=1.5 l=4
X812 a_n8639_n20509# a_n8581_n15597# vin vss sky130_fd_pr__nfet_05v0_nvt ad=1.45 pd=10.29 as=1.45 ps=10.29 w=10 l=0.9
X813 a_n8639_n20509# a_n8581_n15597# vin vss sky130_fd_pr__nfet_05v0_nvt ad=1.45 pd=10.29 as=1.45 ps=10.29 w=10 l=0.9
X814 a_n8639_n20509# a_n8581_n15597# vin vss sky130_fd_pr__nfet_05v0_nvt ad=1.45 pd=10.29 as=1.45 ps=10.29 w=10 l=0.9
X815 out a_n8609_14110# a_n8639_n20509# vss sky130_fd_pr__nfet_05v0_nvt ad=1.45 pd=10.29 as=1.45 ps=10.29 w=10 l=0.9
X816 vin a_n8581_n15597# a_n8639_n20509# vss sky130_fd_pr__nfet_05v0_nvt ad=1.45 pd=10.29 as=1.45 ps=10.29 w=10 l=0.9
X817 vin a_n8581_n15597# a_n8639_n20509# vss sky130_fd_pr__nfet_05v0_nvt ad=1.45 pd=10.29 as=1.45 ps=10.29 w=10 l=0.9
X818 vin a_n8581_n15597# a_n8639_n20509# vss sky130_fd_pr__nfet_05v0_nvt ad=1.45 pd=10.29 as=1.45 ps=10.29 w=10 l=0.9
X819 vss a_n8609_4082# a_n8609_6082# vss sky130_fd_pr__nfet_g5v0d10v5 ad=0.145 pd=1.29 as=0.145 ps=1.29 w=1 l=4
X820 a_n8639_n20509# a_n8581_n15597# vin vss sky130_fd_pr__nfet_05v0_nvt ad=1.45 pd=10.29 as=1.45 ps=10.29 w=10 l=0.9
X821 a_n8609_14110# a_n8609_2082# w_n8809_8685# w_n8809_8685# sky130_fd_pr__pfet_g5v0d10v5 ad=0.435 pd=3.58 as=0.2175 ps=1.79 w=1.5 l=4
X822 w_n8809_8685# a_n8609_2082# a_n8609_14110# w_n8809_8685# sky130_fd_pr__pfet_g5v0d10v5 ad=0.2175 pd=1.79 as=0.2175 ps=1.79 w=1.5 l=4
X823 a_n8609_6082# a_n8609_4082# vss vss sky130_fd_pr__nfet_g5v0d10v5 ad=0.145 pd=1.29 as=0.145 ps=1.29 w=1 l=4
X824 vin a_n8581_n15597# a_n8639_n20509# vss sky130_fd_pr__nfet_05v0_nvt ad=1.45 pd=10.29 as=1.45 ps=10.29 w=10 l=0.9
X825 a_n8639_n20509# a_n8609_14110# out vss sky130_fd_pr__nfet_05v0_nvt ad=1.45 pd=10.29 as=1.45 ps=10.29 w=10 l=0.9
X826 vin w_n8809_8685# vss sky130_fd_pr__res_high_po w=2 l=11.43
X827 vss a_n8609_4082# a_n8609_6082# vss sky130_fd_pr__nfet_g5v0d10v5 ad=0.145 pd=1.29 as=0.145 ps=1.29 w=1 l=4
X828 a_n8609_4082# a_n8609_4082# vss vss sky130_fd_pr__nfet_g5v0d10v5 ad=0.145 pd=1.29 as=0.145 ps=1.29 w=1 l=4
X829 vss a_n8609_4082# a_n8609_4082# vss sky130_fd_pr__nfet_g5v0d10v5 ad=0.145 pd=1.29 as=0.145 ps=1.29 w=1 l=4
X830 a_n8609_2082# ibias vss vss sky130_fd_pr__nfet_g5v0d10v5 ad=0.145 pd=1.29 as=0.145 ps=1.29 w=1 l=4
X831 out a_n8609_14110# a_n8639_n20509# vss sky130_fd_pr__nfet_05v0_nvt ad=1.45 pd=10.29 as=1.45 ps=10.29 w=10 l=0.9
X832 vin a_n8581_n15597# a_n8639_n20509# vss sky130_fd_pr__nfet_05v0_nvt ad=1.45 pd=10.29 as=1.45 ps=10.29 w=10 l=0.9
X833 vin a_n8581_n15597# a_n8639_n20509# vss sky130_fd_pr__nfet_05v0_nvt ad=1.45 pd=10.29 as=1.45 ps=10.29 w=10 l=0.9
X834 w_n8809_8685# a_n8609_2082# a_n8609_14110# w_n8809_8685# sky130_fd_pr__pfet_g5v0d10v5 ad=0.2175 pd=1.79 as=0.2175 ps=1.79 w=1.5 l=4
X835 w_n8809_8685# a_n8609_2082# a_n8609_14110# w_n8809_8685# sky130_fd_pr__pfet_g5v0d10v5 ad=0.2175 pd=1.79 as=0.2175 ps=1.79 w=1.5 l=4
X836 a_n8609_14110# a_n8609_2082# w_n8809_8685# w_n8809_8685# sky130_fd_pr__pfet_g5v0d10v5 ad=0.2175 pd=1.79 as=0.2175 ps=1.79 w=1.5 l=4
X837 a_n8639_n20509# a_n8581_n15597# vin vss sky130_fd_pr__nfet_05v0_nvt ad=1.45 pd=10.29 as=1.45 ps=10.29 w=10 l=0.9
X838 a_n8609_14110# a_n8609_2082# w_n8809_8685# w_n8809_8685# sky130_fd_pr__pfet_g5v0d10v5 ad=0.2175 pd=1.79 as=0.2175 ps=1.79 w=1.5 l=4
X839 vss ibias a_n8609_2082# vss sky130_fd_pr__nfet_g5v0d10v5 ad=0.145 pd=1.29 as=0.145 ps=1.29 w=1 l=4
X840 ibias ibias vss vss sky130_fd_pr__nfet_g5v0d10v5 ad=0.145 pd=1.29 as=0.145 ps=1.29 w=1 l=4
X841 w_n8809_8685# a_n8609_2082# a_n8609_14110# w_n8809_8685# sky130_fd_pr__pfet_g5v0d10v5 ad=0.2175 pd=1.79 as=0.2175 ps=1.79 w=1.5 l=4
X842 ibias ibias vss vss sky130_fd_pr__nfet_g5v0d10v5 ad=0.145 pd=1.29 as=0.145 ps=1.29 w=1 l=4
X843 a_n8639_n20509# a_n8609_14110# out vss sky130_fd_pr__nfet_05v0_nvt ad=1.45 pd=10.29 as=1.45 ps=10.29 w=10 l=0.9
X844 vin a_n8581_n15597# a_n8639_n20509# vss sky130_fd_pr__nfet_05v0_nvt ad=1.45 pd=10.29 as=1.45 ps=10.29 w=10 l=0.9
X845 a_n8609_4082# a_n8609_4082# vss vss sky130_fd_pr__nfet_g5v0d10v5 ad=0.145 pd=1.29 as=0.145 ps=1.29 w=1 l=4
X846 a_n8609_14110# a_n8609_2082# w_n8809_8685# w_n8809_8685# sky130_fd_pr__pfet_g5v0d10v5 ad=0.2175 pd=1.79 as=0.2175 ps=1.79 w=1.5 l=4
X847 out a_n8609_14110# a_n8639_n20509# vss sky130_fd_pr__nfet_05v0_nvt ad=1.45 pd=10.29 as=1.45 ps=10.29 w=10 l=0.9
X848 w_n8809_8685# a_n8609_2082# a_n8609_14110# w_n8809_8685# sky130_fd_pr__pfet_g5v0d10v5 ad=0.2175 pd=1.79 as=0.2175 ps=1.79 w=1.5 l=4
X849 vin a_n8581_n15597# a_n8639_n20509# vss sky130_fd_pr__nfet_05v0_nvt ad=1.45 pd=10.29 as=1.45 ps=10.29 w=10 l=0.9
X850 a_n8639_n20509# a_n8581_n15597# vin vss sky130_fd_pr__nfet_05v0_nvt ad=1.45 pd=10.29 as=1.45 ps=10.29 w=10 l=0.9
X851 vin a_n8581_n15597# a_n8639_n20509# vss sky130_fd_pr__nfet_05v0_nvt ad=1.45 pd=10.29 as=1.45 ps=10.29 w=10 l=0.9
X852 a_n8639_n20509# a_n8609_14110# out vss sky130_fd_pr__nfet_05v0_nvt ad=1.45 pd=10.29 as=1.45 ps=10.29 w=10 l=0.9
X853 ibias ibias vss vss sky130_fd_pr__nfet_g5v0d10v5 ad=0.145 pd=1.29 as=0.145 ps=1.29 w=1 l=4
X854 a_n8609_4082# a_n8609_4082# vss vss sky130_fd_pr__nfet_g5v0d10v5 ad=0.145 pd=1.29 as=0.145 ps=1.29 w=1 l=4
X855 a_n8639_n20509# a_n8581_n15597# vin vss sky130_fd_pr__nfet_05v0_nvt ad=1.45 pd=10.29 as=1.45 ps=10.29 w=10 l=0.9
X856 w_n8809_8685# a_n8609_2082# a_n8609_11046# w_n8809_8685# sky130_fd_pr__pfet_g5v0d10v5 ad=0.2175 pd=1.79 as=0.2175 ps=1.79 w=1.5 l=4
X857 vss ibias a_n8609_2082# vss sky130_fd_pr__nfet_g5v0d10v5 ad=0.145 pd=1.29 as=0.145 ps=1.29 w=1 l=4
X858 a_n8609_2082# ibias vss vss sky130_fd_pr__nfet_g5v0d10v5 ad=0.145 pd=1.29 as=0.145 ps=1.29 w=1 l=4
X859 a_n8609_14110# a_n8609_2082# w_n8809_8685# w_n8809_8685# sky130_fd_pr__pfet_g5v0d10v5 ad=0.2175 pd=1.79 as=0.2175 ps=1.79 w=1.5 l=4
X860 a_n8609_6082# a_n8609_4082# vss vss sky130_fd_pr__nfet_g5v0d10v5 ad=0.145 pd=1.29 as=0.145 ps=1.29 w=1 l=4
X861 ibias ibias vss vss sky130_fd_pr__nfet_g5v0d10v5 ad=0.29 pd=2.58 as=0.145 ps=1.29 w=1 l=4
X862 ibias ibias vss vss sky130_fd_pr__nfet_g5v0d10v5 ad=0.145 pd=1.29 as=0.145 ps=1.29 w=1 l=4
X863 out a_n8609_14110# a_n8639_n20509# vss sky130_fd_pr__nfet_05v0_nvt ad=1.45 pd=10.29 as=1.45 ps=10.29 w=10 l=0.9
X864 a_n8609_6082# a_n8609_4082# vss vss sky130_fd_pr__nfet_g5v0d10v5 ad=0.145 pd=1.29 as=0.145 ps=1.29 w=1 l=4
X865 w_n8809_8685# vss sky130_fd_pr__cap_mim_m3_1 l=22.2 w=22.2
X866 a_n8639_n20509# a_n8609_14110# out vss sky130_fd_pr__nfet_05v0_nvt ad=1.45 pd=10.29 as=1.45 ps=10.29 w=10 l=0.9
X867 w_n8809_8685# a_n8609_2082# a_n8609_2082# w_n8809_8685# sky130_fd_pr__pfet_g5v0d10v5 ad=0.2175 pd=1.79 as=0.2175 ps=1.79 w=1.5 l=4
X868 a_n8609_6082# a_n8609_4082# vss vss sky130_fd_pr__nfet_g5v0d10v5 ad=0.145 pd=1.29 as=0.145 ps=1.29 w=1 l=4
X869 a_n8639_n20509# a_n8609_14110# out vss sky130_fd_pr__nfet_05v0_nvt ad=1.45 pd=10.29 as=1.45 ps=10.29 w=10 l=0.9
X870 a_n8609_6082# a_4700_n3568# vss sky130_fd_pr__res_high_po w=1 l=5.12
X871 w_n8809_8685# a_n8609_2082# a_n8609_2082# w_n8809_8685# sky130_fd_pr__pfet_g5v0d10v5 ad=0.2175 pd=1.79 as=0.2175 ps=1.79 w=1.5 l=4
X872 vss ibias a_n8609_2082# vss sky130_fd_pr__nfet_g5v0d10v5 ad=0.145 pd=1.29 as=0.29 ps=2.58 w=1 l=4
X873 w_n8809_8685# a_n8609_2082# a_n8609_11046# w_n8809_8685# sky130_fd_pr__pfet_g5v0d10v5 ad=0.2175 pd=1.79 as=0.2175 ps=1.79 w=1.5 l=4
X874 vin a_n8581_n15597# a_n8639_n20509# vss sky130_fd_pr__nfet_05v0_nvt ad=1.45 pd=10.29 as=1.45 ps=10.29 w=10 l=0.9
X875 a_n8609_14110# a_n8609_2082# w_n8809_8685# w_n8809_8685# sky130_fd_pr__pfet_g5v0d10v5 ad=0.2175 pd=1.79 as=0.2175 ps=1.79 w=1.5 l=4
X876 w_n8809_8685# a_n8609_2082# a_n8609_14110# w_n8809_8685# sky130_fd_pr__pfet_g5v0d10v5 ad=0.2175 pd=1.79 as=0.2175 ps=1.79 w=1.5 l=4
X877 a_n8639_n20509# a_n8581_n15597# vin vss sky130_fd_pr__nfet_05v0_nvt ad=1.45 pd=10.29 as=1.45 ps=10.29 w=10 l=0.9
X878 vss ibias ibias vss sky130_fd_pr__nfet_g5v0d10v5 ad=0.145 pd=1.29 as=0.145 ps=1.29 w=1 l=4
X879 vin a_n8581_n15597# a_n8639_n20509# vss sky130_fd_pr__nfet_05v0_nvt ad=1.45 pd=10.29 as=1.45 ps=10.29 w=10 l=0.9
X880 vss a_n8609_4082# a_n8609_6082# vss sky130_fd_pr__nfet_g5v0d10v5 ad=0.145 pd=1.29 as=0.145 ps=1.29 w=1 l=4
X881 a_n8581_n15597# vss sky130_fd_pr__cap_mim_m3_1 l=22.2 w=22.2
X882 a_n8639_n20509# a_n8609_14110# out vss sky130_fd_pr__nfet_05v0_nvt ad=1.45 pd=10.29 as=1.45 ps=10.29 w=10 l=0.9
X883 vin a_n8581_n15597# a_n8639_n20509# vss sky130_fd_pr__nfet_05v0_nvt ad=1.45 pd=10.29 as=1.45 ps=10.29 w=10 l=0.9
X884 out a_n8609_14110# a_n8639_n20509# vss sky130_fd_pr__nfet_05v0_nvt ad=1.45 pd=10.29 as=1.45 ps=10.29 w=10 l=0.9
X885 w_n8809_8685# vss sky130_fd_pr__cap_mim_m3_1 l=22.2 w=22.2
X886 w_n8809_8685# a_n8609_2082# a_n8609_14110# w_n8809_8685# sky130_fd_pr__pfet_g5v0d10v5 ad=0.2175 pd=1.79 as=0.2175 ps=1.79 w=1.5 l=4
X887 a_n8609_6082# a_n8609_4082# vss vss sky130_fd_pr__nfet_g5v0d10v5 ad=0.145 pd=1.29 as=0.145 ps=1.29 w=1 l=4
X888 vss a_n8609_4082# a_n8609_4082# vss sky130_fd_pr__nfet_g5v0d10v5 ad=0.145 pd=1.29 as=0.145 ps=1.29 w=1 l=4
X889 a_n8639_n20509# a_n8609_14110# out vss sky130_fd_pr__nfet_05v0_nvt ad=1.45 pd=10.29 as=1.45 ps=10.29 w=10 l=0.9
X890 a_n8639_n20509# a_n8581_n15597# vin vss sky130_fd_pr__nfet_05v0_nvt ad=1.45 pd=10.29 as=1.45 ps=10.29 w=10 l=0.9
X891 a_n8609_4082# a_n8609_4082# vss vss sky130_fd_pr__nfet_g5v0d10v5 ad=0.145 pd=1.29 as=0.145 ps=1.29 w=1 l=4
X892 w_n8809_8685# a_n8609_2082# a_n8609_14110# w_n8809_8685# sky130_fd_pr__pfet_g5v0d10v5 ad=0.2175 pd=1.79 as=0.2175 ps=1.79 w=1.5 l=4
X893 w_n8809_8685# a_n8609_2082# a_n8609_14110# w_n8809_8685# sky130_fd_pr__pfet_g5v0d10v5 ad=0.2175 pd=1.79 as=0.2175 ps=1.79 w=1.5 l=4
X894 w_n8809_8685# a_n8609_2082# a_n8609_14110# w_n8809_8685# sky130_fd_pr__pfet_g5v0d10v5 ad=0.2175 pd=1.79 as=0.2175 ps=1.79 w=1.5 l=4
X895 a_n8609_6082# a_n8609_4082# vss vss sky130_fd_pr__nfet_g5v0d10v5 ad=0.145 pd=1.29 as=0.145 ps=1.29 w=1 l=4
X896 vin a_n8581_n15597# a_n8639_n20509# vss sky130_fd_pr__nfet_05v0_nvt ad=1.45 pd=10.29 as=1.45 ps=10.29 w=10 l=0.9
X897 vss a_n8609_4082# a_n8609_4082# vss sky130_fd_pr__nfet_g5v0d10v5 ad=0.145 pd=1.29 as=0.145 ps=1.29 w=1 l=4
X898 a_n8609_2082# ibias vss vss sky130_fd_pr__nfet_g5v0d10v5 ad=0.145 pd=1.29 as=0.145 ps=1.29 w=1 l=4
X899 w_n8809_8685# a_n8609_2082# a_n8609_14110# w_n8809_8685# sky130_fd_pr__pfet_g5v0d10v5 ad=0.2175 pd=1.79 as=0.2175 ps=1.79 w=1.5 l=4
X900 vss ibias a_n8609_2082# vss sky130_fd_pr__nfet_g5v0d10v5 ad=0.145 pd=1.29 as=0.145 ps=1.29 w=1 l=4
X901 a_n8581_n15597# vss sky130_fd_pr__cap_mim_m3_1 l=22.2 w=22.2
X902 out a_n8609_14110# a_n8639_n20509# vss sky130_fd_pr__nfet_05v0_nvt ad=1.45 pd=10.29 as=1.45 ps=10.29 w=10 l=0.9
X903 out a_n8609_14110# a_n8639_n20509# vss sky130_fd_pr__nfet_05v0_nvt ad=1.45 pd=10.29 as=1.45 ps=10.29 w=10 l=0.9
X904 a_n8609_14110# a_n8609_2082# w_n8809_8685# w_n8809_8685# sky130_fd_pr__pfet_g5v0d10v5 ad=0.2175 pd=1.79 as=0.2175 ps=1.79 w=1.5 l=4
X905 w_n8809_8685# vss sky130_fd_pr__cap_mim_m3_1 l=22.2 w=22.2
X906 a_n8639_n20509# a_n8609_14110# out vss sky130_fd_pr__nfet_05v0_nvt ad=1.45 pd=10.29 as=1.45 ps=10.29 w=10 l=0.9
X907 w_n8809_8685# a_n8609_2082# a_n8609_2082# w_n8809_8685# sky130_fd_pr__pfet_g5v0d10v5 ad=0.2175 pd=1.79 as=0.435 ps=3.58 w=1.5 l=4
X908 w_n8809_8685# a_n8609_2082# a_n8609_11046# w_n8809_8685# sky130_fd_pr__pfet_g5v0d10v5 ad=0.2175 pd=1.79 as=0.2175 ps=1.79 w=1.5 l=4
X909 vss a_n8609_4082# a_n8609_6082# vss sky130_fd_pr__nfet_g5v0d10v5 ad=0.145 pd=1.29 as=0.145 ps=1.29 w=1 l=4
X910 a_n8609_2082# ibias vss vss sky130_fd_pr__nfet_g5v0d10v5 ad=0.145 pd=1.29 as=0.145 ps=1.29 w=1 l=4
X911 w_n8809_8685# a_n8609_2082# a_n8609_14110# w_n8809_8685# sky130_fd_pr__pfet_g5v0d10v5 ad=0.2175 pd=1.79 as=0.2175 ps=1.79 w=1.5 l=4
X912 a_n8609_14110# a_n8609_2082# w_n8809_8685# w_n8809_8685# sky130_fd_pr__pfet_g5v0d10v5 ad=0.2175 pd=1.79 as=0.2175 ps=1.79 w=1.5 l=4
X913 out a_n8609_14110# a_n8639_n20509# vss sky130_fd_pr__nfet_05v0_nvt ad=1.45 pd=10.29 as=1.45 ps=10.29 w=10 l=0.9
X914 out a_n8609_14110# a_n8639_n20509# vss sky130_fd_pr__nfet_05v0_nvt ad=1.45 pd=10.29 as=1.45 ps=10.29 w=10 l=0.9
X915 vss ibias ibias vss sky130_fd_pr__nfet_g5v0d10v5 ad=0.145 pd=1.29 as=0.145 ps=1.29 w=1 l=4
X916 ibias ibias vss vss sky130_fd_pr__nfet_g5v0d10v5 ad=0.145 pd=1.29 as=0.145 ps=1.29 w=1 l=4
X917 vss a_n8609_4082# a_n8609_6082# vss sky130_fd_pr__nfet_g5v0d10v5 ad=0.145 pd=1.29 as=0.145 ps=1.29 w=1 l=4
X918 a_n8639_n20509# a_n8609_14110# out vss sky130_fd_pr__nfet_05v0_nvt ad=1.45 pd=10.29 as=1.45 ps=10.29 w=10 l=0.9
X919 a_n8609_2082# ibias vss vss sky130_fd_pr__nfet_g5v0d10v5 ad=0.145 pd=1.29 as=0.145 ps=1.29 w=1 l=4
X920 a_n8609_14110# a_n8609_2082# w_n8809_8685# w_n8809_8685# sky130_fd_pr__pfet_g5v0d10v5 ad=0.2175 pd=1.79 as=0.2175 ps=1.79 w=1.5 l=4
X921 a_n8609_14110# a_n8609_2082# w_n8809_8685# w_n8809_8685# sky130_fd_pr__pfet_g5v0d10v5 ad=0.2175 pd=1.79 as=0.2175 ps=1.79 w=1.5 l=4
X922 a_n8609_6082# a_n8609_4082# vss vss sky130_fd_pr__nfet_g5v0d10v5 ad=0.145 pd=1.29 as=0.145 ps=1.29 w=1 l=4
X923 a_n8609_4082# a_n8609_4082# vss vss sky130_fd_pr__nfet_g5v0d10v5 ad=0.145 pd=1.29 as=0.145 ps=1.29 w=1 l=4
X924 out a_n8609_14110# a_n8639_n20509# vss sky130_fd_pr__nfet_05v0_nvt ad=1.45 pd=10.29 as=1.45 ps=10.29 w=10 l=0.9
X925 vin a_n8581_n15597# a_n8639_n20509# vss sky130_fd_pr__nfet_05v0_nvt ad=1.45 pd=10.29 as=1.45 ps=10.29 w=10 l=0.9
X926 w_n8809_8685# a_n8609_2082# a_n8609_11046# w_n8809_8685# sky130_fd_pr__pfet_g5v0d10v5 ad=0.2175 pd=1.79 as=0.2175 ps=1.79 w=1.5 l=4
X927 w_n8809_8685# a_n8609_2082# a_n8609_11046# w_n8809_8685# sky130_fd_pr__pfet_g5v0d10v5 ad=0.2175 pd=1.79 as=0.2175 ps=1.79 w=1.5 l=4
X928 w_n8809_8685# a_n8609_2082# a_n8609_11046# w_n8809_8685# sky130_fd_pr__pfet_g5v0d10v5 ad=0.2175 pd=1.79 as=0.2175 ps=1.79 w=1.5 l=4
X929 a_n8609_4082# a_n8609_4082# vss vss sky130_fd_pr__nfet_g5v0d10v5 ad=0.145 pd=1.29 as=0.145 ps=1.29 w=1 l=4
X930 out a_n8609_14110# a_n8639_n20509# vss sky130_fd_pr__nfet_05v0_nvt ad=1.45 pd=10.29 as=1.45 ps=10.29 w=10 l=0.9
X931 w_n8809_8685# a_n8609_2082# a_n8609_14110# w_n8809_8685# sky130_fd_pr__pfet_g5v0d10v5 ad=0.2175 pd=1.79 as=0.435 ps=3.58 w=1.5 l=4
X932 a_n8609_14110# a_n8609_2082# w_n8809_8685# w_n8809_8685# sky130_fd_pr__pfet_g5v0d10v5 ad=0.2175 pd=1.79 as=0.2175 ps=1.79 w=1.5 l=4
X933 w_n8809_8685# vss sky130_fd_pr__cap_mim_m3_1 l=22.2 w=22.2
X934 w_n8809_8685# a_n8609_2082# a_n8609_2082# w_n8809_8685# sky130_fd_pr__pfet_g5v0d10v5 ad=0.2175 pd=1.79 as=0.2175 ps=1.79 w=1.5 l=4
X935 a_n8639_n20509# a_n8609_14110# out vss sky130_fd_pr__nfet_05v0_nvt ad=1.45 pd=10.29 as=1.45 ps=10.29 w=10 l=0.9
X936 w_n8809_8685# a_n8609_2082# a_n8609_11046# w_n8809_8685# sky130_fd_pr__pfet_g5v0d10v5 ad=0.2175 pd=1.79 as=0.2175 ps=1.79 w=1.5 l=4
X937 a_n8609_4082# a_n8609_4082# vss vss sky130_fd_pr__nfet_g5v0d10v5 ad=0.145 pd=1.29 as=0.145 ps=1.29 w=1 l=4
X938 w_n8809_8685# a_n8609_2082# a_n8609_14110# w_n8809_8685# sky130_fd_pr__pfet_g5v0d10v5 ad=0.2175 pd=1.79 as=0.2175 ps=1.79 w=1.5 l=4
X939 w_n8809_8685# a_n8609_2082# a_n8609_14110# w_n8809_8685# sky130_fd_pr__pfet_g5v0d10v5 ad=0.2175 pd=1.79 as=0.2175 ps=1.79 w=1.5 l=4
X940 a_n8609_14110# a_n8609_2082# w_n8809_8685# w_n8809_8685# sky130_fd_pr__pfet_g5v0d10v5 ad=0.2175 pd=1.79 as=0.2175 ps=1.79 w=1.5 l=4
X941 out a_n8609_14110# a_n8639_n20509# vss sky130_fd_pr__nfet_05v0_nvt ad=1.45 pd=10.29 as=1.45 ps=10.29 w=10 l=0.9
X942 vin a_n8581_n15597# a_n8639_n20509# vss sky130_fd_pr__nfet_05v0_nvt ad=1.45 pd=10.29 as=1.45 ps=10.29 w=10 l=0.9
X943 vss ibias ibias vss sky130_fd_pr__nfet_g5v0d10v5 ad=0.145 pd=1.29 as=0.29 ps=2.58 w=1 l=4
X944 out a_n8609_14110# a_n8639_n20509# vss sky130_fd_pr__nfet_05v0_nvt ad=1.45 pd=10.29 as=1.45 ps=10.29 w=10 l=0.9
X945 w_n8809_8685# a_n8609_2082# a_n8609_14110# w_n8809_8685# sky130_fd_pr__pfet_g5v0d10v5 ad=0.2175 pd=1.79 as=0.2175 ps=1.79 w=1.5 l=4
X946 a_n8609_2082# a_n8609_2082# w_n8809_8685# w_n8809_8685# sky130_fd_pr__pfet_g5v0d10v5 ad=0.2175 pd=1.79 as=0.2175 ps=1.79 w=1.5 l=4
X947 a_n8639_n20509# a_n8581_n15597# vin vss sky130_fd_pr__nfet_05v0_nvt ad=1.45 pd=10.29 as=1.45 ps=10.29 w=10 l=0.9
X948 w_n8809_8685# a_n8609_2082# a_n8609_14110# w_n8809_8685# sky130_fd_pr__pfet_g5v0d10v5 ad=0.2175 pd=1.79 as=0.2175 ps=1.79 w=1.5 l=4
X949 vss a_n8609_4082# a_n8609_4082# vss sky130_fd_pr__nfet_g5v0d10v5 ad=0.145 pd=1.29 as=0.145 ps=1.29 w=1 l=4
X950 w_n8809_8685# vss sky130_fd_pr__cap_mim_m3_1 l=22.2 w=22.2
X951 a_n8609_14110# a_n8609_2082# w_n8809_8685# w_n8809_8685# sky130_fd_pr__pfet_g5v0d10v5 ad=0.2175 pd=1.79 as=0.2175 ps=1.79 w=1.5 l=4
X952 a_n8609_6082# a_n8609_4082# vss vss sky130_fd_pr__nfet_g5v0d10v5 ad=0.145 pd=1.29 as=0.145 ps=1.29 w=1 l=4
X953 out a_n8609_14110# a_n8639_n20509# vss sky130_fd_pr__nfet_05v0_nvt ad=1.45 pd=10.29 as=1.45 ps=10.29 w=10 l=0.9
X954 a_n8639_n20509# a_n8581_n15597# vin vss sky130_fd_pr__nfet_05v0_nvt ad=1.45 pd=10.29 as=1.45 ps=10.29 w=10 l=0.9
X955 w_n8809_8685# a_n8609_2082# a_n8609_14110# w_n8809_8685# sky130_fd_pr__pfet_g5v0d10v5 ad=0.2175 pd=1.79 as=0.2175 ps=1.79 w=1.5 l=4
X956 a_n8609_4082# a_n8609_4082# vss vss sky130_fd_pr__nfet_g5v0d10v5 ad=0.145 pd=1.29 as=0.145 ps=1.29 w=1 l=4
X957 vss a_n8609_4082# a_n8609_6082# vss sky130_fd_pr__nfet_g5v0d10v5 ad=0.145 pd=1.29 as=0.29 ps=2.58 w=1 l=4
X958 vss ibias a_n8609_2082# vss sky130_fd_pr__nfet_g5v0d10v5 ad=0.145 pd=1.29 as=0.145 ps=1.29 w=1 l=4
X959 vss ibias ibias vss sky130_fd_pr__nfet_g5v0d10v5 ad=0.145 pd=1.29 as=0.145 ps=1.29 w=1 l=4
X960 a_n8609_14110# a_n8609_2082# w_n8809_8685# w_n8809_8685# sky130_fd_pr__pfet_g5v0d10v5 ad=0.435 pd=3.58 as=0.2175 ps=1.79 w=1.5 l=4
X961 a_n8609_2082# ibias vss vss sky130_fd_pr__nfet_g5v0d10v5 ad=0.145 pd=1.29 as=0.145 ps=1.29 w=1 l=4
X962 a_n8639_n20509# a_n8609_14110# out vss sky130_fd_pr__nfet_05v0_nvt ad=1.45 pd=10.29 as=1.45 ps=10.29 w=10 l=0.9
C0 ibias a_n8581_n15597# 0.00596f
C1 w_n8809_8685# a_n8581_n15597# 1.52739f
C2 a_n8639_n20509# a_n8609_14110# 79.1501f
C3 a_n8609_14110# a_n8609_11046# 0.21921f
C4 a_n8609_6082# a_n8581_n15597# 0.00341f
C5 a_n8609_2082# a_n8609_11046# 27.7727f
C6 a_n8609_2082# a_n8609_14110# 82.5728f
C7 a_4700_n3568# a_n8639_n20509# 0.06798f
C8 a_4700_n3568# a_n8609_14110# 87.6491f
C9 a_n8639_n20509# out 58.3767f
C10 a_n8609_4082# a_n8609_11046# 2.04588f
C11 a_n8609_14110# out 71.1227f
C12 a_n8609_14110# a_n8609_4082# 1.50247f
C13 ref a_n8609_11046# 1.06208f
C14 off a_n8609_14110# 0.51515f
C15 a_n8609_2082# a_n8609_4082# 1.98831f
C16 fb a_n8609_11046# 1.01597f
C17 a_4700_n3568# out 0.02376f
C18 a_n8639_n20509# vin 0.13231p
C19 a_n8609_11046# vin 0.00194f
C20 a_n8609_14110# vin 4.79646f
C21 ibias a_n8609_11046# 1.23305f
C22 ibias a_n8609_14110# 1.51595f
C23 a_4700_n3568# vin 0.25868f
C24 w_n8809_8685# a_n8609_11046# 18.4504f
C25 ibias a_n8609_2082# 16.6013f
C26 w_n8809_8685# a_n8609_14110# 39.3225f
C27 w_n8809_8685# a_n8609_2082# 0.52003p
C28 a_n8609_6082# a_n8609_11046# 1.18819f
C29 fb a_n8609_4082# 1.00097f
C30 a_n8609_6082# a_n8609_14110# 3.40414f
C31 a_4700_n3568# w_n8809_8685# 0.17799f
C32 a_n8609_6082# a_n8609_2082# 1.24343f
C33 a_n8639_n20509# a_n8581_n15597# 0.15563p
C34 a_4700_n3568# a_n8609_6082# 0.00724f
C35 a_n8581_n15597# a_n8609_11046# 0.0107f
C36 ref vin 0
C37 a_n8609_14110# a_n8581_n15597# 7.73457f
C38 ibias a_n8609_4082# 2.02946f
C39 a_n8609_2082# a_n8581_n15597# 0.29664f
C40 fb vin 0
C41 off ibias 0.50631f
C42 ref ibias 0.00612f
C43 w_n8809_8685# a_n8609_4082# 4.98412f
C44 a_4700_n3568# a_n8581_n15597# 0.27563f
C45 w_n8809_8685# ref 0.64506f
C46 ibias fb 0.00612f
C47 a_n8609_6082# a_n8609_4082# 20.8688f
C48 w_n8809_8685# fb 0.57886f
C49 ibias vin 0.01188f
C50 a_n8609_6082# ref 1.00084f
C51 w_n8809_8685# vin 0.68395f
C52 a_n8581_n15597# a_n8609_4082# 0.00596f
C53 w_n8809_8685# ibias 3.79415f
C54 a_n8609_6082# ibias 4.34362f
C55 a_n8581_n15597# vin 0.15932p
C56 w_n8809_8685# a_n8609_6082# 2.56972f
C57 vin vss 55.7777f
C58 ref vss 0.16259f
C59 fb vss 0.16425f
C60 off vss 2.50645f
C61 ibias vss 0.14673p
C62 a_n8639_n20509# vss 4.97081f
C63 a_n8581_n15597# vss 0.83485p
C64 a_4700_n3568# vss 7.12342f
C65 a_n8609_6082# vss 20.2764f
C66 a_n8609_4082# vss 0.1457p
C67 a_n8609_11046# vss 7.68461f
C68 a_n8609_14110# vss 79.87749f
C69 w_n8809_8685# vss 2.07857p
.ends
