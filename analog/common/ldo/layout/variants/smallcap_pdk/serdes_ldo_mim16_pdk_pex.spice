* NGSPICE file created from serdes_ldo_mim16_pdk.ext - technology: sky130A

.subckt serdes_ldo_mim16_pdk a b
X0 a b sky130_fd_pr__cap_mim_m3_1 l=22.2 w=22.2
X1 a b sky130_fd_pr__cap_mim_m3_1 l=22.2 w=22.2
X2 a b sky130_fd_pr__cap_mim_m3_1 l=22.2 w=22.2
X3 a b sky130_fd_pr__cap_mim_m3_1 l=22.2 w=22.2
X4 a b sky130_fd_pr__cap_mim_m3_1 l=22.2 w=22.2
X5 a b sky130_fd_pr__cap_mim_m3_1 l=22.2 w=22.2
X6 a b sky130_fd_pr__cap_mim_m3_1 l=22.2 w=22.2
X7 a b sky130_fd_pr__cap_mim_m3_1 l=22.2 w=22.2
X8 a b sky130_fd_pr__cap_mim_m3_1 l=22.2 w=22.2
X9 a b sky130_fd_pr__cap_mim_m3_1 l=22.2 w=22.2
X10 a b sky130_fd_pr__cap_mim_m3_1 l=22.2 w=22.2
X11 a b sky130_fd_pr__cap_mim_m3_1 l=22.2 w=22.2
X12 a b sky130_fd_pr__cap_mim_m3_1 l=22.2 w=22.2
X13 a b sky130_fd_pr__cap_mim_m3_1 l=22.2 w=22.2
X14 a b sky130_fd_pr__cap_mim_m3_1 l=22.2 w=22.2
X15 a b sky130_fd_pr__cap_mim_m3_1 l=22.2 w=22.2
C0 b a 0.7023p
C1 a VSUBS 15.6539f
C2 b VSUBS 0.14496p
.ends
