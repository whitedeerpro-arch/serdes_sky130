* NGSPICE file created from serdes_ldo_mim32_pdk.ext - technology: sky130A

.subckt serdes_ldo_mim32_pdk a b
X0 a b sky130_fd_pr__cap_mim_m3_1 l=22.2 w=22.2
X1 a b sky130_fd_pr__cap_mim_m3_1 l=22.2 w=22.2
X2 a b sky130_fd_pr__cap_mim_m3_1 l=22.2 w=22.2
X3 a b sky130_fd_pr__cap_mim_m3_1 l=22.2 w=22.2
X4 a b sky130_fd_pr__cap_mim_m3_1 l=22.2 w=22.2
X5 a b sky130_fd_pr__cap_mim_m3_1 l=22.2 w=22.2
X6 a b sky130_fd_pr__cap_mim_m3_1 l=22.2 w=22.2
X7 a b sky130_fd_pr__cap_mim_m3_1 l=22.2 w=22.2
X8 a b sky130_fd_pr__cap_mim_m3_1 l=22.2 w=22.2
X9 a b sky130_fd_pr__cap_mim_m3_1 l=22.2 w=22.2
X10 a b sky130_fd_pr__cap_mim_m3_1 l=22.2 w=22.2
X11 a b sky130_fd_pr__cap_mim_m3_1 l=22.2 w=22.2
X12 a b sky130_fd_pr__cap_mim_m3_1 l=22.2 w=22.2
X13 a b sky130_fd_pr__cap_mim_m3_1 l=22.2 w=22.2
X14 a b sky130_fd_pr__cap_mim_m3_1 l=22.2 w=22.2
X15 a b sky130_fd_pr__cap_mim_m3_1 l=22.2 w=22.2
X16 a b sky130_fd_pr__cap_mim_m3_1 l=22.2 w=22.2
X17 a b sky130_fd_pr__cap_mim_m3_1 l=22.2 w=22.2
X18 a b sky130_fd_pr__cap_mim_m3_1 l=22.2 w=22.2
X19 a b sky130_fd_pr__cap_mim_m3_1 l=22.2 w=22.2
X20 a b sky130_fd_pr__cap_mim_m3_1 l=22.2 w=22.2
X21 a b sky130_fd_pr__cap_mim_m3_1 l=22.2 w=22.2
X22 a b sky130_fd_pr__cap_mim_m3_1 l=22.2 w=22.2
X23 a b sky130_fd_pr__cap_mim_m3_1 l=22.2 w=22.2
X24 a b sky130_fd_pr__cap_mim_m3_1 l=22.2 w=22.2
X25 a b sky130_fd_pr__cap_mim_m3_1 l=22.2 w=22.2
X26 a b sky130_fd_pr__cap_mim_m3_1 l=22.2 w=22.2
X27 a b sky130_fd_pr__cap_mim_m3_1 l=22.2 w=22.2
X28 a b sky130_fd_pr__cap_mim_m3_1 l=22.2 w=22.2
X29 a b sky130_fd_pr__cap_mim_m3_1 l=22.2 w=22.2
X30 a b sky130_fd_pr__cap_mim_m3_1 l=22.2 w=22.2
X31 a b sky130_fd_pr__cap_mim_m3_1 l=22.2 w=22.2
C0 b a 1.40857p
C1 a VSUBS 26.6058f
C2 b VSUBS 0.27294p
.ends
