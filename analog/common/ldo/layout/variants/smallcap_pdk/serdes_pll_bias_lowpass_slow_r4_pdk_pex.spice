* NGSPICE file created from serdes_pll_bias_lowpass_slow_r4_pdk.ext - technology: sky130A

.subckt serdes_pll_bias_lowpass_slow_r4_pdk original filtered vss
X0 filtered a_4192_n10155# vss sky130_fd_pr__res_high_po w=1 l=97.39
X1 a_3896_9723# a_3600_n10155# vss sky130_fd_pr__res_high_po w=1 l=97.39
X2 filtered vss sky130_fd_pr__cap_mim_m3_1 l=22.2 w=22.2
X3 filtered vss sky130_fd_pr__cap_mim_m3_1 l=22.2 w=22.2
X4 filtered vss sky130_fd_pr__cap_mim_m3_1 l=22.2 w=22.2
X5 filtered vss sky130_fd_pr__cap_mim_m3_1 l=22.2 w=22.2
X6 a_n4392_9723# a_n4688_n10155# vss sky130_fd_pr__res_high_po w=1 l=97.39
X7 a_n4392_9723# a_n4096_n10155# vss sky130_fd_pr__res_high_po w=1 l=97.39
X8 a_2120_9723# a_1824_n10155# vss sky130_fd_pr__res_high_po w=1 l=97.39
X9 a_3304_9723# a_3600_n10155# vss sky130_fd_pr__res_high_po w=1 l=97.39
X10 filtered vss sky130_fd_pr__cap_mim_m3_1 l=22.2 w=22.2
X11 filtered vss sky130_fd_pr__cap_mim_m3_1 l=22.2 w=22.2
X12 original a_n4688_n10155# vss sky130_fd_pr__res_high_po w=1 l=97.39
X13 a_936_9723# a_1232_n10155# vss sky130_fd_pr__res_high_po w=1 l=97.39
X14 a_2712_9723# a_2416_n10155# vss sky130_fd_pr__res_high_po w=1 l=97.39
X15 a_3304_9723# a_3008_n10155# vss sky130_fd_pr__res_high_po w=1 l=97.39
X16 filtered vss sky130_fd_pr__cap_mim_m3_1 l=22.2 w=22.2
X17 a_2712_9723# a_3008_n10155# vss sky130_fd_pr__res_high_po w=1 l=97.39
X18 a_n3800_9723# a_n4096_n10155# vss sky130_fd_pr__res_high_po w=1 l=97.39
X19 a_344_9723# a_640_n10155# vss sky130_fd_pr__res_high_po w=1 l=97.39
X20 a_1528_9723# a_1824_n10155# vss sky130_fd_pr__res_high_po w=1 l=97.39
X21 a_2120_9723# a_2416_n10155# vss sky130_fd_pr__res_high_po w=1 l=97.39
X22 filtered vss sky130_fd_pr__cap_mim_m3_1 l=22.2 w=22.2
X23 filtered vss sky130_fd_pr__cap_mim_m3_1 l=22.2 w=22.2
X24 a_344_9723# a_48_n10155# vss sky130_fd_pr__res_high_po w=1 l=97.39
X25 a_1528_9723# a_1232_n10155# vss sky130_fd_pr__res_high_po w=1 l=97.39
X26 filtered vss sky130_fd_pr__cap_mim_m3_1 l=22.2 w=22.2
X27 a_n3800_9723# a_n3504_n10155# vss sky130_fd_pr__res_high_po w=1 l=97.39
X28 a_n2024_9723# a_n2320_n10155# vss sky130_fd_pr__res_high_po w=1 l=97.39
X29 a_936_9723# a_640_n10155# vss sky130_fd_pr__res_high_po w=1 l=97.39
X30 filtered vss sky130_fd_pr__cap_mim_m3_1 l=22.2 w=22.2
X31 a_n3208_9723# a_n2912_n10155# vss sky130_fd_pr__res_high_po w=1 l=97.39
X32 a_n1432_9723# a_n1728_n10155# vss sky130_fd_pr__res_high_po w=1 l=97.39
X33 a_n840_9723# a_n544_n10155# vss sky130_fd_pr__res_high_po w=1 l=97.39
X34 filtered vss sky130_fd_pr__cap_mim_m3_1 l=22.2 w=22.2
X35 a_n3208_9723# a_n3504_n10155# vss sky130_fd_pr__res_high_po w=1 l=97.39
X36 a_n2616_9723# a_n2912_n10155# vss sky130_fd_pr__res_high_po w=1 l=97.39
X37 a_n1432_9723# a_n1136_n10155# vss sky130_fd_pr__res_high_po w=1 l=97.39
X38 a_n248_9723# a_n544_n10155# vss sky130_fd_pr__res_high_po w=1 l=97.39
X39 a_n2616_9723# a_n2320_n10155# vss sky130_fd_pr__res_high_po w=1 l=97.39
X40 a_n2024_9723# a_n1728_n10155# vss sky130_fd_pr__res_high_po w=1 l=97.39
X41 a_n840_9723# a_n1136_n10155# vss sky130_fd_pr__res_high_po w=1 l=97.39
X42 filtered vss sky130_fd_pr__cap_mim_m3_1 l=22.2 w=22.2
X43 filtered vss sky130_fd_pr__cap_mim_m3_1 l=22.2 w=22.2
X44 filtered vss sky130_fd_pr__cap_mim_m3_1 l=22.2 w=22.2
X45 a_3896_9723# a_4192_n10155# vss sky130_fd_pr__res_high_po w=1 l=97.39
X46 a_n248_9723# a_48_n10155# vss sky130_fd_pr__res_high_po w=1 l=97.39
X47 filtered vss sky130_fd_pr__cap_mim_m3_1 l=22.2 w=22.2
C0 a_3008_n10155# filtered 0.01941f
C1 a_3600_n10155# a_4192_n10155# 0.15377f
C2 filtered a_1528_9723# 0.08066f
C3 a_n544_n10155# a_n1136_n10155# 0.15377f
C4 a_n1136_n10155# a_n1728_n10155# 0.15377f
C5 a_n2912_n10155# a_n2320_n10155# 0.15377f
C6 a_3304_9723# filtered 0.08556f
C7 a_3600_n10155# filtered 0.01941f
C8 filtered a_1824_n10155# 0.01941f
C9 a_n544_n10155# a_48_n10155# 0.15377f
C10 a_n248_9723# a_n840_9723# 0.15377f
C11 filtered a_n3208_9723# 0.08479f
C12 a_1232_n10155# a_1824_n10155# 0.15377f
C13 a_2120_9723# a_1528_9723# 0.15377f
C14 a_n544_n10155# filtered 0.00241f
C15 filtered a_n1728_n10155# 0.01941f
C16 filtered a_n2320_n10155# 0.01941f
C17 a_n3800_9723# filtered 0.07908f
C18 a_3600_n10155# a_3008_n10155# 0.15377f
C19 filtered a_3896_9723# 0.2557f
C20 a_n840_9723# a_n1432_9723# 0.15377f
C21 filtered a_936_9723# 0.07788f
C22 a_344_9723# a_936_9723# 0.15377f
C23 a_n3800_9723# a_n4392_9723# 0.15377f
C24 filtered a_n840_9723# 0.0707f
C25 a_n248_9723# filtered 0.0638f
C26 a_n2616_9723# filtered 0.08437f
C27 a_344_9723# a_n248_9723# 0.15377f
C28 filtered original 0.046f
C29 filtered a_n4688_n10155# 0.01941f
C30 a_n2912_n10155# a_n3504_n10155# 0.15377f
C31 filtered a_2416_n10155# 0.01965f
C32 a_n4096_n10155# a_n4688_n10155# 0.15377f
C33 a_640_n10155# a_48_n10155# 0.15377f
C34 a_936_9723# a_1528_9723# 0.15377f
C35 a_n2616_9723# a_n2024_9723# 0.15377f
C36 filtered a_2712_9723# 0.08287f
C37 a_640_n10155# filtered 0.01941f
C38 a_n4392_9723# original 0.15196f
C39 a_3304_9723# a_3896_9723# 0.15377f
C40 filtered a_n2912_n10155# 0.02037f
C41 a_n3800_9723# a_n3208_9723# 0.15377f
C42 a_n1136_n10155# filtered 0.01941f
C43 filtered a_n1432_9723# 0.07711f
C44 a_640_n10155# a_1232_n10155# 0.15377f
C45 a_n2320_n10155# a_n1728_n10155# 0.15377f
C46 filtered a_n3504_n10155# 0.01941f
C47 a_n4096_n10155# a_n3504_n10155# 0.15377f
C48 filtered a_4192_n10155# 0.01352f
C49 filtered a_48_n10155# 0.01239f
C50 a_3008_n10155# a_2416_n10155# 0.15377f
C51 a_2120_9723# a_2712_9723# 0.15377f
C52 a_n2024_9723# a_n1432_9723# 0.15377f
C53 a_n4096_n10155# filtered 0.01941f
C54 a_344_9723# filtered 0.0762f
C55 a_1824_n10155# a_2416_n10155# 0.15377f
C56 a_n2616_9723# a_n3208_9723# 0.15377f
C57 a_1232_n10155# filtered 0.01941f
C58 filtered a_n2024_9723# 0.07901f
C59 a_3304_9723# a_2712_9723# 0.15377f
C60 filtered a_n4392_9723# 0.07718f
C61 filtered a_2120_9723# 0.09004f
C62 filtered vss 0.70023p
C63 original vss 0.46584f
C64 a_4192_n10155# vss 1.02185f
C65 a_3896_9723# vss 0.70824f
C66 a_3600_n10155# vss 0.85339f
C67 a_3304_9723# vss 0.7057f
C68 a_3008_n10155# vss 0.85149f
C69 a_2712_9723# vss 0.70566f
C70 a_2416_n10155# vss 0.85075f
C71 a_2120_9723# vss 0.70566f
C72 a_1824_n10155# vss 0.85075f
C73 a_1528_9723# vss 0.70566f
C74 a_1232_n10155# vss 0.85293f
C75 a_936_9723# vss 0.70566f
C76 a_640_n10155# vss 0.85796f
C77 a_344_9723# vss 0.70566f
C78 a_48_n10155# vss 0.8795f
C79 a_n248_9723# vss 0.68835f
C80 a_n544_n10155# vss 0.89207f
C81 a_n840_9723# vss 0.70566f
C82 a_n1136_n10155# vss 0.85949f
C83 a_n1432_9723# vss 0.70566f
C84 a_n1728_n10155# vss 0.85403f
C85 a_n2024_9723# vss 0.70566f
C86 a_n2320_n10155# vss 0.85075f
C87 a_n2616_9723# vss 0.70566f
C88 a_n2912_n10155# vss 0.85075f
C89 a_n3208_9723# vss 0.70566f
C90 a_n3504_n10155# vss 0.85077f
C91 a_n3800_9723# vss 0.7057f
C92 a_n4096_n10155# vss 0.85247f
C93 a_n4392_9723# vss 0.70856f
C94 a_n4688_n10155# vss 1.01561f
.ends
