* NGSPICE file created from serdes_pll_supply_hv18_smallcap_pdk.ext - technology: sky130A

.subckt serdes_pll_supply_hv18_smallcap_pdk vin host quiet bg vgi enable t0 t1 t2
+ t3 t4 t5 vss
X0 w_n8809_8685# a_n8609_2082# a_n8609_14110# w_n8809_8685# sky130_fd_pr__pfet_g5v0d10v5 ad=0.2175 pd=1.79 as=0.2175 ps=1.79 w=1.5 l=4
X1 a_n8609_4082# a_n8609_4082# vss vss sky130_fd_pr__nfet_g5v0d10v5 ad=0.145 pd=1.29 as=0.145 ps=1.29 w=1 l=4
X2 vss a_n15687_2040# a_n8609_2082# vss sky130_fd_pr__nfet_g5v0d10v5 ad=0.145 pd=1.29 as=0.145 ps=1.29 w=1 l=4
X3 quiet a_n8609_14110# a_n8639_n20509# vss sky130_fd_pr__nfet_05v0_nvt ad=1.45 pd=10.29 as=2.9 ps=20.58 w=10 l=0.9
X4 vin a_n8581_n15597# a_n8639_n20509# vss sky130_fd_pr__nfet_05v0_nvt ad=1.45 pd=10.29 as=1.45 ps=10.29 w=10 l=0.9
X5 w_n8809_8685# a_n8609_2082# a_n8609_14110# w_n8809_8685# sky130_fd_pr__pfet_g5v0d10v5 ad=0.2175 pd=1.79 as=0.2175 ps=1.79 w=1.5 l=4
X6 w_n8809_8685# a_n8609_2082# a_n8609_14110# w_n8809_8685# sky130_fd_pr__pfet_g5v0d10v5 ad=0.2175 pd=1.79 as=0.2175 ps=1.79 w=1.5 l=4
X7 a_n8609_14110# a_n8609_2082# w_n8809_8685# w_n8809_8685# sky130_fd_pr__pfet_g5v0d10v5 ad=0.2175 pd=1.79 as=0.2175 ps=1.79 w=1.5 l=4
X8 w_n8809_8685# a_n8609_2082# a_n8609_2082# w_n8809_8685# sky130_fd_pr__pfet_g5v0d10v5 ad=0.2175 pd=1.79 as=0.2175 ps=1.79 w=1.5 l=4
X9 vin a_n8581_n15597# a_n8639_n20509# vss sky130_fd_pr__nfet_05v0_nvt ad=1.45 pd=10.29 as=1.45 ps=10.29 w=10 l=0.9
X10 vin a_n8581_n15597# a_n8639_n20509# vss sky130_fd_pr__nfet_05v0_nvt ad=1.45 pd=10.29 as=1.45 ps=10.29 w=10 l=0.9
X11 vss a_n15687_2040# a_n15687_2040# vss sky130_fd_pr__nfet_g5v0d10v5 ad=0.145 pd=1.29 as=0.145 ps=1.29 w=1 l=4
X12 a_n8609_2082# a_n8609_2082# w_n8809_8685# w_n8809_8685# sky130_fd_pr__pfet_g5v0d10v5 ad=0.2175 pd=1.79 as=0.2175 ps=1.79 w=1.5 l=4
X13 a_n8609_14110# a_n8609_2082# w_n8809_8685# w_n8809_8685# sky130_fd_pr__pfet_g5v0d10v5 ad=0.435 pd=3.58 as=0.2175 ps=1.79 w=1.5 l=4
X14 w_n8809_8685# a_n8609_2082# a_n8609_14110# w_n8809_8685# sky130_fd_pr__pfet_g5v0d10v5 ad=0.2175 pd=1.79 as=0.2175 ps=1.79 w=1.5 l=4
X15 vss a_n8609_4082# a_n8609_4082# vss sky130_fd_pr__nfet_g5v0d10v5 ad=0.145 pd=1.29 as=0.145 ps=1.29 w=1 l=4
X16 a_n20056_n717# a_n20352_n20595# vss sky130_fd_pr__res_high_po w=1 l=97.39
X17 a_n8639_n20509# a_n8609_14110# quiet vss sky130_fd_pr__nfet_05v0_nvt ad=1.45 pd=10.29 as=1.45 ps=10.29 w=10 l=0.9
X18 w_n8809_8685# vss sky130_fd_pr__cap_mim_m3_1 l=22.2 w=22.2
X19 w_n8809_8685# a_n8609_2082# a_n8609_11046# w_n8809_8685# sky130_fd_pr__pfet_g5v0d10v5 ad=0.2175 pd=1.79 as=0.2175 ps=1.79 w=1.5 l=4
X20 w_n8809_8685# a_n8609_2082# a_n8609_11046# w_n8809_8685# sky130_fd_pr__pfet_g5v0d10v5 ad=0.2175 pd=1.79 as=0.435 ps=3.58 w=1.5 l=4
X21 quiet a_n8609_14110# a_n8639_n20509# vss sky130_fd_pr__nfet_05v0_nvt ad=1.45 pd=10.29 as=2.9 ps=20.58 w=10 l=0.9
X22 a_n8609_11046# a_n8609_2082# w_n8809_8685# w_n8809_8685# sky130_fd_pr__pfet_g5v0d10v5 ad=0.2175 pd=1.79 as=0.2175 ps=1.79 w=1.5 l=4
X23 a_n8609_14110# a_n8609_2082# w_n8809_8685# w_n8809_8685# sky130_fd_pr__pfet_g5v0d10v5 ad=0.2175 pd=1.79 as=0.2175 ps=1.79 w=1.5 l=4
X24 vss a_n8609_4082# a_n8609_6082# vss sky130_fd_pr__nfet_g5v0d10v5 ad=0.145 pd=1.29 as=0.145 ps=1.29 w=1 l=4
X25 a_n25621_6140# t2 a_n23421_6140# vss sky130_fd_pr__nfet_01v8 ad=0.825 pd=5.33 as=1.55 ps=10.62 w=5 l=0.15
X26 a_n24073_2440# vss sky130_fd_pr__cap_mim_m3_1 l=22.2 w=22.2
X27 a_n8639_n20509# a_n8581_n15597# vin vss sky130_fd_pr__nfet_05v0_nvt ad=1.45 pd=10.29 as=1.45 ps=10.29 w=10 l=0.9
X28 w_n8809_8685# a_n8609_2082# a_n8609_11046# w_n8809_8685# sky130_fd_pr__pfet_g5v0d10v5 ad=0.2175 pd=1.79 as=0.2175 ps=1.79 w=1.5 l=4
X29 vss a_n8609_4082# a_n8609_4082# vss sky130_fd_pr__nfet_g5v0d10v5 ad=0.145 pd=1.29 as=0.145 ps=1.29 w=1 l=4
X30 w_n8809_8685# a_n8609_2082# a_n8609_14110# w_n8809_8685# sky130_fd_pr__pfet_g5v0d10v5 ad=0.2175 pd=1.79 as=0.2175 ps=1.79 w=1.5 l=4
X31 w_n8809_8685# vss sky130_fd_pr__cap_mim_m3_1 l=22.2 w=22.2
X32 vin a_n8581_n15597# a_n8639_n20509# vss sky130_fd_pr__nfet_05v0_nvt ad=1.45 pd=10.29 as=1.45 ps=10.29 w=10 l=0.9
X33 vss a_n8609_4082# a_n8609_6082# vss sky130_fd_pr__nfet_g5v0d10v5 ad=0.145 pd=1.29 as=0.145 ps=1.29 w=1 l=4
X34 a_n8609_6082# a_n8609_4082# vss vss sky130_fd_pr__nfet_g5v0d10v5 ad=0.145 pd=1.29 as=0.145 ps=1.29 w=1 l=4
X35 a_n8609_4082# a_n8609_4082# vss vss sky130_fd_pr__nfet_g5v0d10v5 ad=0.145 pd=1.29 as=0.145 ps=1.29 w=1 l=4
X36 vin a_n8581_n15597# a_n8639_n20509# vss sky130_fd_pr__nfet_05v0_nvt ad=1.45 pd=10.29 as=1.45 ps=10.29 w=10 l=0.9
X37 w_n8809_8685# a_n8609_2082# a_n8609_14110# w_n8809_8685# sky130_fd_pr__pfet_g5v0d10v5 ad=0.2175 pd=1.79 as=0.2175 ps=1.79 w=1.5 l=4
X38 a_n8609_14110# a_n8609_2082# w_n8809_8685# w_n8809_8685# sky130_fd_pr__pfet_g5v0d10v5 ad=0.2175 pd=1.79 as=0.2175 ps=1.79 w=1.5 l=4
X39 a_n8609_2082# a_n15687_2040# vss vss sky130_fd_pr__nfet_g5v0d10v5 ad=0.145 pd=1.29 as=0.145 ps=1.29 w=1 l=4
X40 a_n8639_n20509# a_n8581_n15597# vin vss sky130_fd_pr__nfet_05v0_nvt ad=1.45 pd=10.29 as=1.45 ps=10.29 w=10 l=0.9
X41 a_n8609_2082# a_n15687_2040# vss vss sky130_fd_pr__nfet_g5v0d10v5 ad=0.145 pd=1.29 as=0.145 ps=1.29 w=1 l=4
X42 vss a_n25673_2540# a_n15687_2040# vss sky130_fd_pr__nfet_g5v0d10v5 ad=2.9 pd=20.58 as=2.9 ps=20.58 w=10 l=0.5
X43 a_n15687_2040# a_n15687_2040# vss vss sky130_fd_pr__nfet_g5v0d10v5 ad=0.145 pd=1.29 as=0.145 ps=1.29 w=1 l=4
X44 a_n8609_11046# a_n13856_8466# a_n8609_4082# w_n8809_8685# sky130_fd_pr__pfet_g5v0d10v5 ad=4.35 pd=30.58 as=4.35 ps=30.58 w=15 l=1
X45 a_n8639_n20509# a_n8581_n15597# vin vss sky130_fd_pr__nfet_05v0_nvt ad=1.45 pd=10.29 as=1.45 ps=10.29 w=10 l=0.9
X46 vss a_n8609_6082# a_n8609_14110# vss sky130_fd_pr__nfet_g5v0d10v5 ad=1.45 pd=10.29 as=1.45 ps=10.29 w=10 l=0.5
X47 a_n8609_2082# a_n15687_2040# vss vss sky130_fd_pr__nfet_g5v0d10v5 ad=0.145 pd=1.29 as=0.145 ps=1.29 w=1 l=4
X48 a_n15687_2040# a_n15687_2040# vss vss sky130_fd_pr__nfet_g5v0d10v5 ad=0.145 pd=1.29 as=0.145 ps=1.29 w=1 l=4
X49 a_n14152_18586# a_n14448_8466# vss sky130_fd_pr__res_high_po w=1 l=48.6
X50 w_n8809_8685# a_n8609_2082# a_n8609_14110# w_n8809_8685# sky130_fd_pr__pfet_g5v0d10v5 ad=0.2175 pd=1.79 as=0.2175 ps=1.79 w=1.5 l=4
X51 w_n8809_8685# a_n8609_2082# a_n8609_14110# w_n8809_8685# sky130_fd_pr__pfet_g5v0d10v5 ad=0.2175 pd=1.79 as=0.435 ps=3.58 w=1.5 l=4
X52 a_n8609_14110# a_n8609_2082# w_n8809_8685# w_n8809_8685# sky130_fd_pr__pfet_g5v0d10v5 ad=0.2175 pd=1.79 as=0.2175 ps=1.79 w=1.5 l=4
X53 a_n27821_6140# vss vss sky130_fd_pr__res_high_po w=2 l=5.12
X54 a_n8639_n20509# a_n8581_n15597# vin vss sky130_fd_pr__nfet_05v0_nvt ad=1.45 pd=10.29 as=1.45 ps=10.29 w=10 l=0.9
X55 a_n8609_14110# a_n8609_2082# w_n8809_8685# w_n8809_8685# sky130_fd_pr__pfet_g5v0d10v5 ad=0.2175 pd=1.79 as=0.2175 ps=1.79 w=1.5 l=4
X56 a_n8609_2082# a_n8609_2082# w_n8809_8685# w_n8809_8685# sky130_fd_pr__pfet_g5v0d10v5 ad=0.2175 pd=1.79 as=0.2175 ps=1.79 w=1.5 l=4
X57 vss a_n15687_2040# a_n15687_2040# vss sky130_fd_pr__nfet_g5v0d10v5 ad=0.145 pd=1.29 as=0.145 ps=1.29 w=1 l=4
X58 vin a_n8581_n15597# a_n8639_n20509# vss sky130_fd_pr__nfet_05v0_nvt ad=1.45 pd=10.29 as=1.45 ps=10.29 w=10 l=0.9
X59 a_n23421_6140# t3 a_n21221_6140# vss sky130_fd_pr__nfet_01v8 ad=0.825 pd=5.33 as=0.825 ps=5.33 w=5 l=0.15
X60 a_47252_n2559# a_47548_n18673# vss sky130_fd_pr__res_high_po w=1 l=78.57
X61 w_n8809_8685# a_n8609_2082# a_n8609_14110# w_n8809_8685# sky130_fd_pr__pfet_g5v0d10v5 ad=0.2175 pd=1.79 as=0.2175 ps=1.79 w=1.5 l=4
X62 w_n8809_8685# a_n8609_2082# a_n8609_14110# w_n8809_8685# sky130_fd_pr__pfet_g5v0d10v5 ad=0.2175 pd=1.79 as=0.2175 ps=1.79 w=1.5 l=4
X63 a_n27821_6140# t1 a_n25621_6140# vss sky130_fd_pr__nfet_01v8 ad=0.825 pd=5.33 as=0.825 ps=5.33 w=5 l=0.15
X64 vss a_n15687_2040# a_n8609_2082# vss sky130_fd_pr__nfet_g5v0d10v5 ad=0.145 pd=1.29 as=0.145 ps=1.29 w=1 l=4
X65 vss a_n8609_6082# a_n8609_14110# vss sky130_fd_pr__nfet_g5v0d10v5 ad=1.45 pd=10.29 as=2.9 ps=20.58 w=10 l=0.5
X66 a_n8639_n20509# a_n8581_n15597# vin vss sky130_fd_pr__nfet_05v0_nvt ad=1.45 pd=10.29 as=1.45 ps=10.29 w=10 l=0.9
X67 w_n8809_8685# a_n8609_2082# a_n8609_14110# w_n8809_8685# sky130_fd_pr__pfet_g5v0d10v5 ad=0.2175 pd=1.79 as=0.2175 ps=1.79 w=1.5 l=4
X68 a_n8581_n15597# vss sky130_fd_pr__cap_mim_m3_1 l=22.2 w=22.2
X69 w_n8809_8685# a_n8609_2082# a_n8609_14110# w_n8809_8685# sky130_fd_pr__pfet_g5v0d10v5 ad=0.2175 pd=1.79 as=0.2175 ps=1.79 w=1.5 l=4
X70 a_n8609_4082# a_n8609_4082# vss vss sky130_fd_pr__nfet_g5v0d10v5 ad=0.145 pd=1.29 as=0.145 ps=1.29 w=1 l=4
X71 vin a_n8581_n15597# a_n8639_n20509# vss sky130_fd_pr__nfet_05v0_nvt ad=1.45 pd=10.29 as=1.45 ps=10.29 w=10 l=0.9
X72 vss a_n8609_4082# a_n8609_4082# vss sky130_fd_pr__nfet_g5v0d10v5 ad=0.145 pd=1.29 as=0.29 ps=2.58 w=1 l=4
X73 a_n8609_2082# a_n15687_2040# vss vss sky130_fd_pr__nfet_g5v0d10v5 ad=0.145 pd=1.29 as=0.145 ps=1.29 w=1 l=4
X74 a_n15687_2040# a_n15687_2040# vss vss sky130_fd_pr__nfet_g5v0d10v5 ad=0.145 pd=1.29 as=0.145 ps=1.29 w=1 l=4
X75 vin a_n8581_n15597# a_n8639_n20509# vss sky130_fd_pr__nfet_05v0_nvt ad=1.45 pd=10.29 as=1.45 ps=10.29 w=10 l=0.9
X76 a_n8609_2082# a_n15687_2040# vss vss sky130_fd_pr__nfet_g5v0d10v5 ad=0.145 pd=1.29 as=0.145 ps=1.29 w=1 l=4
X77 vss a_n15687_2040# a_n15687_2040# vss sky130_fd_pr__nfet_g5v0d10v5 ad=0.145 pd=1.29 as=0.145 ps=1.29 w=1 l=4
X78 a_n8639_n20509# a_n8581_n15597# vin vss sky130_fd_pr__nfet_05v0_nvt ad=1.45 pd=10.29 as=1.45 ps=10.29 w=10 l=0.9
X79 a_n8639_n20509# a_n8581_n15597# vin vss sky130_fd_pr__nfet_05v0_nvt ad=1.45 pd=10.29 as=1.45 ps=10.29 w=10 l=0.9
X80 a_n8639_n20509# a_n8581_n15597# vin vss sky130_fd_pr__nfet_05v0_nvt ad=1.45 pd=10.29 as=1.45 ps=10.29 w=10 l=0.9
X81 a_n8609_2082# a_n8609_2082# w_n8809_8685# w_n8809_8685# sky130_fd_pr__pfet_g5v0d10v5 ad=0.2175 pd=1.79 as=0.2175 ps=1.79 w=1.5 l=4
X82 a_n8609_2082# a_n8609_2082# w_n8809_8685# w_n8809_8685# sky130_fd_pr__pfet_g5v0d10v5 ad=0.2175 pd=1.79 as=0.2175 ps=1.79 w=1.5 l=4
X83 vin a_n8581_n15597# a_n8639_n20509# vss sky130_fd_pr__nfet_05v0_nvt ad=1.45 pd=10.29 as=1.45 ps=10.29 w=10 l=0.9
X84 w_n8809_8685# a_n8609_2082# a_n8609_11046# w_n8809_8685# sky130_fd_pr__pfet_g5v0d10v5 ad=0.2175 pd=1.79 as=0.2175 ps=1.79 w=1.5 l=4
X85 a_n15687_2040# a_n15687_2040# vss vss sky130_fd_pr__nfet_g5v0d10v5 ad=0.145 pd=1.29 as=0.145 ps=1.29 w=1 l=4
X86 a_n8639_n20509# a_n8581_n15597# vin vss sky130_fd_pr__nfet_05v0_nvt ad=1.45 pd=10.29 as=1.45 ps=10.29 w=10 l=0.9
X87 a_n8639_n20509# a_n8581_n15597# vin vss sky130_fd_pr__nfet_05v0_nvt ad=1.45 pd=10.29 as=1.45 ps=10.29 w=10 l=0.9
X88 a_n14744_18586# a_n14448_8466# vss sky130_fd_pr__res_high_po w=1 l=48.6
X89 a_n8609_2082# a_n8609_2082# w_n8809_8685# w_n8809_8685# sky130_fd_pr__pfet_g5v0d10v5 ad=0.2175 pd=1.79 as=0.2175 ps=1.79 w=1.5 l=4
X90 a_n8581_n15597# vss sky130_fd_pr__cap_mim_m3_1 l=22.2 w=22.2
X91 vss a_n15687_2040# a_n8609_2082# vss sky130_fd_pr__nfet_g5v0d10v5 ad=0.145 pd=1.29 as=0.145 ps=1.29 w=1 l=4
X92 a_n20056_n717# a_n19760_n20595# vss sky130_fd_pr__res_high_po w=1 l=97.39
X93 a_n8639_n20509# a_n8581_n15597# vin vss sky130_fd_pr__nfet_05v0_nvt ad=1.45 pd=10.29 as=1.45 ps=10.29 w=10 l=0.9
X94 a_n8609_14110# a_n8609_2082# w_n8809_8685# w_n8809_8685# sky130_fd_pr__pfet_g5v0d10v5 ad=0.2175 pd=1.79 as=0.2175 ps=1.79 w=1.5 l=4
X95 a_n15687_2040# a_n15687_2040# vss vss sky130_fd_pr__nfet_g5v0d10v5 ad=0.145 pd=1.29 as=0.145 ps=1.29 w=1 l=4
X96 a_n8581_n15597# vss sky130_fd_pr__cap_mim_m3_1 l=22.2 w=22.2
X97 a_n8609_14110# a_n8609_2082# w_n8809_8685# w_n8809_8685# sky130_fd_pr__pfet_g5v0d10v5 ad=0.2175 pd=1.79 as=0.2175 ps=1.79 w=1.5 l=4
X98 a_n22424_n717# a_n22720_n20595# vss sky130_fd_pr__res_high_po w=1 l=97.39
X99 w_n8809_8685# a_n8609_2082# a_n8609_11046# w_n8809_8685# sky130_fd_pr__pfet_g5v0d10v5 ad=0.2175 pd=1.79 as=0.2175 ps=1.79 w=1.5 l=4
X100 w_n8809_8685# a_n8609_2082# a_n8609_2082# w_n8809_8685# sky130_fd_pr__pfet_g5v0d10v5 ad=0.2175 pd=1.79 as=0.2175 ps=1.79 w=1.5 l=4
X101 vin a_n8581_n15597# a_n8639_n20509# vss sky130_fd_pr__nfet_05v0_nvt ad=1.45 pd=10.29 as=1.45 ps=10.29 w=10 l=0.9
X102 a_n8609_14110# a_n8609_6082# vss vss sky130_fd_pr__nfet_g5v0d10v5 ad=1.45 pd=10.29 as=1.45 ps=10.29 w=10 l=0.5
X103 w_n8809_8685# a_n8609_2082# a_n8609_11046# w_n8809_8685# sky130_fd_pr__pfet_g5v0d10v5 ad=0.2175 pd=1.79 as=0.2175 ps=1.79 w=1.5 l=4
X104 vss a_n8609_4082# a_n8609_4082# vss sky130_fd_pr__nfet_g5v0d10v5 ad=0.145 pd=1.29 as=0.145 ps=1.29 w=1 l=4
X105 a_n15687_2040# a_n15687_2040# vss vss sky130_fd_pr__nfet_g5v0d10v5 ad=0.145 pd=1.29 as=0.145 ps=1.29 w=1 l=4
X106 a_n8639_n20509# a_n8581_n15597# vin vss sky130_fd_pr__nfet_05v0_nvt ad=1.45 pd=10.29 as=1.45 ps=10.29 w=10 l=0.9
X107 vss a_n25673_2540# a_n24073_2440# vss sky130_fd_pr__nfet_01v8 ad=0.58 pd=4.58 as=0.58 ps=4.58 w=2 l=0.15
X108 vss a_n15687_2040# a_n8609_2082# vss sky130_fd_pr__nfet_g5v0d10v5 ad=0.145 pd=1.29 as=0.145 ps=1.29 w=1 l=4
X109 w_n8809_8685# a_n8609_2082# a_n8609_11046# w_n8809_8685# sky130_fd_pr__pfet_g5v0d10v5 ad=0.2175 pd=1.79 as=0.2175 ps=1.79 w=1.5 l=4
X110 vin a_n8581_n15597# a_n8639_n20509# vss sky130_fd_pr__nfet_05v0_nvt ad=1.45 pd=10.29 as=1.45 ps=10.29 w=10 l=0.9
X111 w_n8809_8685# vss sky130_fd_pr__cap_mim_m3_1 l=22.2 w=22.2
X112 w_n8809_8685# a_n8609_2082# a_n8609_14110# w_n8809_8685# sky130_fd_pr__pfet_g5v0d10v5 ad=0.2175 pd=1.79 as=0.2175 ps=1.79 w=1.5 l=4
X113 vss a_n8609_4082# a_n8609_4082# vss sky130_fd_pr__nfet_g5v0d10v5 ad=0.145 pd=1.29 as=0.145 ps=1.29 w=1 l=4
X114 a_n8609_4082# a_n8609_4082# vss vss sky130_fd_pr__nfet_g5v0d10v5 ad=0.145 pd=1.29 as=0.145 ps=1.29 w=1 l=4
X115 a_n8609_2082# a_n15687_2040# vss vss sky130_fd_pr__nfet_g5v0d10v5 ad=0.145 pd=1.29 as=0.145 ps=1.29 w=1 l=4
X116 w_n8809_8685# a_n8609_2082# a_n8609_14110# w_n8809_8685# sky130_fd_pr__pfet_g5v0d10v5 ad=0.2175 pd=1.79 as=0.435 ps=3.58 w=1.5 l=4
X117 a_n8609_2082# a_n8609_2082# w_n8809_8685# w_n8809_8685# sky130_fd_pr__pfet_g5v0d10v5 ad=0.2175 pd=1.79 as=0.2175 ps=1.79 w=1.5 l=4
X118 w_n8809_8685# vss sky130_fd_pr__cap_mim_m3_1 l=22.2 w=22.2
X119 w_n8809_8685# a_n8609_2082# a_n8609_14110# w_n8809_8685# sky130_fd_pr__pfet_g5v0d10v5 ad=0.2175 pd=1.79 as=0.2175 ps=1.79 w=1.5 l=4
X120 a_n8609_14110# a_n8609_2082# w_n8809_8685# w_n8809_8685# sky130_fd_pr__pfet_g5v0d10v5 ad=0.2175 pd=1.79 as=0.2175 ps=1.79 w=1.5 l=4
X121 a_n17096_n717# a_n16800_n20595# vss sky130_fd_pr__res_high_po w=1 l=97.39
X122 a_n8639_n20509# a_n8581_n15597# vin vss sky130_fd_pr__nfet_05v0_nvt ad=1.45 pd=10.29 as=1.45 ps=10.29 w=10 l=0.9
X123 w_n8809_8685# vss sky130_fd_pr__cap_mim_m3_1 l=22.2 w=22.2
X124 vin a_n8581_n15597# a_n8639_n20509# vss sky130_fd_pr__nfet_05v0_nvt ad=1.45 pd=10.29 as=1.45 ps=10.29 w=10 l=0.9
X125 w_n8809_8685# a_n8609_2082# a_n8609_14110# w_n8809_8685# sky130_fd_pr__pfet_g5v0d10v5 ad=0.2175 pd=1.79 as=0.2175 ps=1.79 w=1.5 l=4
X126 a_n8609_14110# a_n8609_2082# w_n8809_8685# w_n8809_8685# sky130_fd_pr__pfet_g5v0d10v5 ad=0.2175 pd=1.79 as=0.2175 ps=1.79 w=1.5 l=4
X127 a_n8609_14110# a_n8609_2082# w_n8809_8685# w_n8809_8685# sky130_fd_pr__pfet_g5v0d10v5 ad=0.2175 pd=1.79 as=0.2175 ps=1.79 w=1.5 l=4
X128 w_n8809_8685# a_n8609_2082# a_n8609_14110# w_n8809_8685# sky130_fd_pr__pfet_g5v0d10v5 ad=0.2175 pd=1.79 as=0.2175 ps=1.79 w=1.5 l=4
X129 a_n8609_2082# a_n8609_2082# w_n8809_8685# w_n8809_8685# sky130_fd_pr__pfet_g5v0d10v5 ad=0.2175 pd=1.79 as=0.2175 ps=1.79 w=1.5 l=4
X130 w_n8809_8685# a_n8609_2082# a_n8609_14110# w_n8809_8685# sky130_fd_pr__pfet_g5v0d10v5 ad=0.2175 pd=1.79 as=0.2175 ps=1.79 w=1.5 l=4
X131 w_n8809_8685# a_n8609_2082# a_n8609_2082# w_n8809_8685# sky130_fd_pr__pfet_g5v0d10v5 ad=0.2175 pd=1.79 as=0.2175 ps=1.79 w=1.5 l=4
X132 a_n8609_6082# a_n8609_4082# vss vss sky130_fd_pr__nfet_g5v0d10v5 ad=0.29 pd=2.58 as=0.145 ps=1.29 w=1 l=4
X133 a_n8639_n20509# a_n8581_n15597# vin vss sky130_fd_pr__nfet_05v0_nvt ad=1.45 pd=10.29 as=1.45 ps=10.29 w=10 l=0.9
X134 a_n8609_6082# a_n8609_4082# vss vss sky130_fd_pr__nfet_g5v0d10v5 ad=0.145 pd=1.29 as=0.145 ps=1.29 w=1 l=4
X135 vss a_n15687_2040# a_n15687_2040# vss sky130_fd_pr__nfet_g5v0d10v5 ad=0.145 pd=1.29 as=0.145 ps=1.29 w=1 l=4
X136 a_n8639_n20509# a_n8609_14110# quiet vss sky130_fd_pr__nfet_05v0_nvt ad=1.45 pd=10.29 as=1.45 ps=10.29 w=10 l=0.9
X137 a_n8639_n20509# a_n8581_n15597# vin vss sky130_fd_pr__nfet_05v0_nvt ad=1.45 pd=10.29 as=1.45 ps=10.29 w=10 l=0.9
X138 a_n8639_n20509# a_n8581_n15597# vin vss sky130_fd_pr__nfet_05v0_nvt ad=1.45 pd=10.29 as=1.45 ps=10.29 w=10 l=0.9
X139 w_n8809_8685# a_n8609_2082# a_n8609_14110# w_n8809_8685# sky130_fd_pr__pfet_g5v0d10v5 ad=0.2175 pd=1.79 as=0.2175 ps=1.79 w=1.5 l=4
X140 vss a_n8609_4082# a_n8609_6082# vss sky130_fd_pr__nfet_g5v0d10v5 ad=0.145 pd=1.29 as=0.145 ps=1.29 w=1 l=4
X141 a_n21221_6140# t4 a_n19021_6140# vss sky130_fd_pr__nfet_01v8 ad=0.825 pd=5.33 as=1.55 ps=10.62 w=5 l=0.15
X142 a_n8609_6082# a_n8609_4082# vss vss sky130_fd_pr__nfet_g5v0d10v5 ad=0.145 pd=1.29 as=0.145 ps=1.29 w=1 l=4
X143 a_n8609_2082# a_n15687_2040# vss vss sky130_fd_pr__nfet_g5v0d10v5 ad=0.145 pd=1.29 as=0.145 ps=1.29 w=1 l=4
X144 vin a_n8581_n15597# a_n8639_n20509# vss sky130_fd_pr__nfet_05v0_nvt ad=1.45 pd=10.29 as=1.45 ps=10.29 w=10 l=0.9
X145 w_n8809_8685# a_n8609_2082# a_n8609_14110# w_n8809_8685# sky130_fd_pr__pfet_g5v0d10v5 ad=0.2175 pd=1.79 as=0.2175 ps=1.79 w=1.5 l=4
X146 a_n8609_11046# a_n8609_2082# w_n8809_8685# w_n8809_8685# sky130_fd_pr__pfet_g5v0d10v5 ad=0.2175 pd=1.79 as=0.2175 ps=1.79 w=1.5 l=4
X147 vss a_n15687_2040# a_n8609_2082# vss sky130_fd_pr__nfet_g5v0d10v5 ad=0.145 pd=1.29 as=0.29 ps=2.58 w=1 l=4
X148 a_n8609_14110# a_n8609_2082# w_n8809_8685# w_n8809_8685# sky130_fd_pr__pfet_g5v0d10v5 ad=0.435 pd=3.58 as=0.2175 ps=1.79 w=1.5 l=4
X149 a_n8639_n20509# a_n8609_14110# quiet vss sky130_fd_pr__nfet_05v0_nvt ad=1.45 pd=10.29 as=1.45 ps=10.29 w=10 l=0.9
X150 vin a_n8581_n15597# a_n8639_n20509# vss sky130_fd_pr__nfet_05v0_nvt ad=2.9 pd=20.58 as=1.45 ps=10.29 w=10 l=0.9
X151 a_n8639_n20509# a_n8581_n15597# vin vss sky130_fd_pr__nfet_05v0_nvt ad=1.45 pd=10.29 as=1.45 ps=10.29 w=10 l=0.9
X152 w_n8809_8685# a_n8609_2082# a_n8609_14110# w_n8809_8685# sky130_fd_pr__pfet_g5v0d10v5 ad=0.2175 pd=1.79 as=0.2175 ps=1.79 w=1.5 l=4
X153 a_n8639_n20509# a_n8609_14110# quiet vss sky130_fd_pr__nfet_05v0_nvt ad=1.45 pd=10.29 as=1.45 ps=10.29 w=10 l=0.9
X154 w_n8809_8685# a_n8609_2082# a_n8609_11046# w_n8809_8685# sky130_fd_pr__pfet_g5v0d10v5 ad=0.2175 pd=1.79 as=0.2175 ps=1.79 w=1.5 l=4
X155 w_n8809_8685# a_n8609_2082# a_n8609_11046# w_n8809_8685# sky130_fd_pr__pfet_g5v0d10v5 ad=0.2175 pd=1.79 as=0.435 ps=3.58 w=1.5 l=4
X156 vss a_n8609_4082# a_n8609_6082# vss sky130_fd_pr__nfet_g5v0d10v5 ad=0.145 pd=1.29 as=0.145 ps=1.29 w=1 l=4
X157 vss a_n15687_2040# a_n15687_2040# vss sky130_fd_pr__nfet_g5v0d10v5 ad=0.145 pd=1.29 as=0.145 ps=1.29 w=1 l=4
X158 a_n8609_14110# a_n8609_2082# w_n8809_8685# w_n8809_8685# sky130_fd_pr__pfet_g5v0d10v5 ad=0.2175 pd=1.79 as=0.2175 ps=1.79 w=1.5 l=4
X159 a_n8609_11046# a_n8609_2082# w_n8809_8685# w_n8809_8685# sky130_fd_pr__pfet_g5v0d10v5 ad=0.2175 pd=1.79 as=0.2175 ps=1.79 w=1.5 l=4
X160 a_n8609_2082# a_n8609_2082# w_n8809_8685# w_n8809_8685# sky130_fd_pr__pfet_g5v0d10v5 ad=0.2175 pd=1.79 as=0.2175 ps=1.79 w=1.5 l=4
X161 quiet vss sky130_fd_pr__cap_mim_m3_1 l=22.2 w=22.2
X162 a_n8609_14110# a_n8609_2082# w_n8809_8685# w_n8809_8685# sky130_fd_pr__pfet_g5v0d10v5 ad=0.2175 pd=1.79 as=0.2175 ps=1.79 w=1.5 l=4
X163 a_n15687_2040# a_n15687_2040# vss vss sky130_fd_pr__nfet_g5v0d10v5 ad=0.145 pd=1.29 as=0.145 ps=1.29 w=1 l=4
X164 a_n15687_2040# a_n15687_2040# vss vss sky130_fd_pr__nfet_g5v0d10v5 ad=0.145 pd=1.29 as=0.145 ps=1.29 w=1 l=4
X165 a_n8639_n20509# a_n8581_n15597# vin vss sky130_fd_pr__nfet_05v0_nvt ad=1.45 pd=10.29 as=1.45 ps=10.29 w=10 l=0.9
X166 w_n8809_8685# a_n8609_2082# a_n8609_14110# w_n8809_8685# sky130_fd_pr__pfet_g5v0d10v5 ad=0.2175 pd=1.79 as=0.2175 ps=1.79 w=1.5 l=4
X167 w_n8809_8685# a_n8609_2082# a_n8609_11046# w_n8809_8685# sky130_fd_pr__pfet_g5v0d10v5 ad=0.2175 pd=1.79 as=0.2175 ps=1.79 w=1.5 l=4
X168 quiet a_46956_n18673# vss sky130_fd_pr__res_high_po w=1 l=78.57
X169 a_n24073_2440# vss sky130_fd_pr__cap_mim_m3_1 l=22.2 w=22.2
X170 a_n8639_n20509# a_n8609_14110# quiet vss sky130_fd_pr__nfet_05v0_nvt ad=1.45 pd=10.29 as=1.45 ps=10.29 w=10 l=0.9
X171 vss a_n8609_4082# a_n8609_6082# vss sky130_fd_pr__nfet_g5v0d10v5 ad=0.145 pd=1.29 as=0.145 ps=1.29 w=1 l=4
X172 vin a_n8581_n15597# a_n8639_n20509# vss sky130_fd_pr__nfet_05v0_nvt ad=1.45 pd=10.29 as=1.45 ps=10.29 w=10 l=0.9
X173 a_n8609_6082# a_n8609_4082# vss vss sky130_fd_pr__nfet_g5v0d10v5 ad=0.145 pd=1.29 as=0.145 ps=1.29 w=1 l=4
X174 a_n8609_14110# a_n8609_2082# w_n8809_8685# w_n8809_8685# sky130_fd_pr__pfet_g5v0d10v5 ad=0.2175 pd=1.79 as=0.2175 ps=1.79 w=1.5 l=4
X175 w_n8809_8685# a_n8609_2082# a_n8609_14110# w_n8809_8685# sky130_fd_pr__pfet_g5v0d10v5 ad=0.2175 pd=1.79 as=0.2175 ps=1.79 w=1.5 l=4
X176 vss a_n15687_2040# a_n8609_2082# vss sky130_fd_pr__nfet_g5v0d10v5 ad=0.145 pd=1.29 as=0.145 ps=1.29 w=1 l=4
X177 a_n27821_6140# t0 vss vss sky130_fd_pr__nfet_01v8 ad=0.825 pd=5.33 as=0.825 ps=5.33 w=5 l=0.15
X178 a_n8609_11046# a_n8609_2082# w_n8809_8685# w_n8809_8685# sky130_fd_pr__pfet_g5v0d10v5 ad=0.2175 pd=1.79 as=0.2175 ps=1.79 w=1.5 l=4
X179 a_n8639_n20509# a_n8609_14110# quiet vss sky130_fd_pr__nfet_05v0_nvt ad=1.45 pd=10.29 as=1.45 ps=10.29 w=10 l=0.9
X180 w_n8809_8685# a_n8609_2082# a_n8609_14110# w_n8809_8685# sky130_fd_pr__pfet_g5v0d10v5 ad=0.2175 pd=1.79 as=0.2175 ps=1.79 w=1.5 l=4
X181 a_n8609_14110# a_n8609_2082# w_n8809_8685# w_n8809_8685# sky130_fd_pr__pfet_g5v0d10v5 ad=0.2175 pd=1.79 as=0.2175 ps=1.79 w=1.5 l=4
X182 w_n8809_8685# a_n8609_2082# a_n8609_14110# w_n8809_8685# sky130_fd_pr__pfet_g5v0d10v5 ad=0.2175 pd=1.79 as=0.2175 ps=1.79 w=1.5 l=4
X183 a_n21221_6140# t3 a_n23421_6140# vss sky130_fd_pr__nfet_01v8 ad=0.825 pd=5.33 as=0.825 ps=5.33 w=5 l=0.15
X184 vss a_n8609_4082# a_n8609_6082# vss sky130_fd_pr__nfet_g5v0d10v5 ad=0.145 pd=1.29 as=0.29 ps=2.58 w=1 l=4
X185 vss a_n15687_2040# a_n15687_2040# vss sky130_fd_pr__nfet_g5v0d10v5 ad=0.145 pd=1.29 as=0.145 ps=1.29 w=1 l=4
X186 a_n8639_n20509# a_n8609_14110# quiet vss sky130_fd_pr__nfet_05v0_nvt ad=1.45 pd=10.29 as=1.45 ps=10.29 w=10 l=0.9
X187 a_n8639_n20509# a_n8581_n15597# vin vss sky130_fd_pr__nfet_05v0_nvt ad=1.45 pd=10.29 as=1.45 ps=10.29 w=10 l=0.9
X188 vin a_n8581_n15597# a_n8639_n20509# vss sky130_fd_pr__nfet_05v0_nvt ad=1.45 pd=10.29 as=1.45 ps=10.29 w=10 l=0.9
X189 vss a_n8609_4082# a_n8609_6082# vss sky130_fd_pr__nfet_g5v0d10v5 ad=0.145 pd=1.29 as=0.145 ps=1.29 w=1 l=4
X190 vin a_n8581_n15597# a_n8639_n20509# vss sky130_fd_pr__nfet_05v0_nvt ad=1.45 pd=10.29 as=1.45 ps=10.29 w=10 l=0.9
X191 vss a_n15687_2040# a_n8609_2082# vss sky130_fd_pr__nfet_g5v0d10v5 ad=0.145 pd=1.29 as=0.145 ps=1.29 w=1 l=4
X192 a_n8609_2082# a_n15687_2040# vss vss sky130_fd_pr__nfet_g5v0d10v5 ad=0.145 pd=1.29 as=0.145 ps=1.29 w=1 l=4
X193 w_n8809_8685# vss sky130_fd_pr__cap_mim_m3_1 l=22.2 w=22.2
X194 a_n8609_14110# a_n8609_2082# w_n8809_8685# w_n8809_8685# sky130_fd_pr__pfet_g5v0d10v5 ad=0.2175 pd=1.79 as=0.2175 ps=1.79 w=1.5 l=4
X195 w_n8809_8685# a_n8609_2082# a_n8609_14110# w_n8809_8685# sky130_fd_pr__pfet_g5v0d10v5 ad=0.2175 pd=1.79 as=0.2175 ps=1.79 w=1.5 l=4
X196 vss a_n15687_2040# a_n15687_2040# vss sky130_fd_pr__nfet_g5v0d10v5 ad=0.145 pd=1.29 as=0.145 ps=1.29 w=1 l=4
X197 a_n8639_n20509# a_n8581_n15597# vin vss sky130_fd_pr__nfet_05v0_nvt ad=1.45 pd=10.29 as=2.9 ps=20.58 w=10 l=0.9
X198 vin a_n8581_n15597# a_n8639_n20509# vss sky130_fd_pr__nfet_05v0_nvt ad=1.45 pd=10.29 as=1.45 ps=10.29 w=10 l=0.9
X199 w_n8809_8685# a_n8609_2082# a_n8609_14110# w_n8809_8685# sky130_fd_pr__pfet_g5v0d10v5 ad=0.2175 pd=1.79 as=0.2175 ps=1.79 w=1.5 l=4
X200 a_n22424_n717# a_n22128_n20595# vss sky130_fd_pr__res_high_po w=1 l=97.39
X201 a_n8639_n20509# a_n8609_14110# quiet vss sky130_fd_pr__nfet_05v0_nvt ad=1.45 pd=10.29 as=1.45 ps=10.29 w=10 l=0.9
X202 a_n8639_n20509# a_n8609_14110# quiet vss sky130_fd_pr__nfet_05v0_nvt ad=1.45 pd=10.29 as=1.45 ps=10.29 w=10 l=0.9
X203 w_n8809_8685# a_n8609_2082# a_n8609_14110# w_n8809_8685# sky130_fd_pr__pfet_g5v0d10v5 ad=0.2175 pd=1.79 as=0.2175 ps=1.79 w=1.5 l=4
X204 w_n8809_8685# a_n8609_2082# a_n8609_14110# w_n8809_8685# sky130_fd_pr__pfet_g5v0d10v5 ad=0.2175 pd=1.79 as=0.435 ps=3.58 w=1.5 l=4
X205 a_n8609_14110# a_n8609_2082# w_n8809_8685# w_n8809_8685# sky130_fd_pr__pfet_g5v0d10v5 ad=0.2175 pd=1.79 as=0.2175 ps=1.79 w=1.5 l=4
X206 w_n8809_8685# vss sky130_fd_pr__cap_mim_m3_1 l=22.2 w=22.2
X207 w_n8809_8685# a_n8609_2082# a_n8609_2082# w_n8809_8685# sky130_fd_pr__pfet_g5v0d10v5 ad=0.2175 pd=1.79 as=0.2175 ps=1.79 w=1.5 l=4
X208 a_n8609_4082# a_n8609_4082# vss vss sky130_fd_pr__nfet_g5v0d10v5 ad=0.29 pd=2.58 as=0.145 ps=1.29 w=1 l=4
X209 a_n21832_n717# a_n22128_n20595# vss sky130_fd_pr__res_high_po w=1 l=97.39
X210 w_n8809_8685# a_n8609_2082# a_n8609_14110# w_n8809_8685# sky130_fd_pr__pfet_g5v0d10v5 ad=0.2175 pd=1.79 as=0.2175 ps=1.79 w=1.5 l=4
X211 w_n8809_8685# a_n8609_2082# a_n8609_14110# w_n8809_8685# sky130_fd_pr__pfet_g5v0d10v5 ad=0.2175 pd=1.79 as=0.2175 ps=1.79 w=1.5 l=4
X212 a_n8609_11046# a_n24073_2440# a_n8609_6082# w_n8809_8685# sky130_fd_pr__pfet_g5v0d10v5 ad=4.35 pd=30.58 as=4.35 ps=30.58 w=15 l=1
X213 a_n8609_14110# a_n8609_2082# w_n8809_8685# w_n8809_8685# sky130_fd_pr__pfet_g5v0d10v5 ad=0.2175 pd=1.79 as=0.2175 ps=1.79 w=1.5 l=4
X214 w_n8809_8685# a_n8609_2082# a_n8609_14110# w_n8809_8685# sky130_fd_pr__pfet_g5v0d10v5 ad=0.2175 pd=1.79 as=0.2175 ps=1.79 w=1.5 l=4
X215 a_n8609_4082# a_n8609_4082# vss vss sky130_fd_pr__nfet_g5v0d10v5 ad=0.145 pd=1.29 as=0.145 ps=1.29 w=1 l=4
X216 a_n8609_11046# a_n8609_2082# w_n8809_8685# w_n8809_8685# sky130_fd_pr__pfet_g5v0d10v5 ad=0.2175 pd=1.79 as=0.2175 ps=1.79 w=1.5 l=4
X217 vss a_n8609_4082# a_n8609_6082# vss sky130_fd_pr__nfet_g5v0d10v5 ad=0.145 pd=1.29 as=0.145 ps=1.29 w=1 l=4
X218 a_n23421_6140# t2 a_n25621_6140# vss sky130_fd_pr__nfet_01v8 ad=1.55 pd=10.62 as=0.825 ps=5.33 w=5 l=0.15
X219 vss a_n8609_4082# a_n8609_4082# vss sky130_fd_pr__nfet_g5v0d10v5 ad=0.145 pd=1.29 as=0.145 ps=1.29 w=1 l=4
X220 a_n8581_n15597# vss sky130_fd_pr__cap_mim_m3_1 l=22.2 w=22.2
X221 quiet a_n8609_14110# a_n8639_n20509# vss sky130_fd_pr__nfet_05v0_nvt ad=1.45 pd=10.29 as=1.45 ps=10.29 w=10 l=0.9
X222 w_n8809_8685# a_n8609_2082# a_n8609_11046# w_n8809_8685# sky130_fd_pr__pfet_g5v0d10v5 ad=0.2175 pd=1.79 as=0.2175 ps=1.79 w=1.5 l=4
X223 a_n8609_4082# a_n8609_4082# vss vss sky130_fd_pr__nfet_g5v0d10v5 ad=0.145 pd=1.29 as=0.145 ps=1.29 w=1 l=4
X224 vin a_n8581_n15597# a_n8639_n20509# vss sky130_fd_pr__nfet_05v0_nvt ad=1.45 pd=10.29 as=1.45 ps=10.29 w=10 l=0.9
X225 a_n8609_6082# a_n8609_4082# vss vss sky130_fd_pr__nfet_g5v0d10v5 ad=0.145 pd=1.29 as=0.145 ps=1.29 w=1 l=4
X226 a_n8639_n20509# a_n8609_14110# quiet vss sky130_fd_pr__nfet_05v0_nvt ad=1.45 pd=10.29 as=1.45 ps=10.29 w=10 l=0.9
X227 a_n8639_n20509# a_n8581_n15597# vin vss sky130_fd_pr__nfet_05v0_nvt ad=1.45 pd=10.29 as=1.45 ps=10.29 w=10 l=0.9
X228 a_n24073_2440# vss sky130_fd_pr__cap_mim_m3_1 l=22.2 w=22.2
X229 a_n8639_n20509# a_n8581_n15597# vin vss sky130_fd_pr__nfet_05v0_nvt ad=1.45 pd=10.29 as=1.45 ps=10.29 w=10 l=0.9
X230 w_n8809_8685# a_n8609_2082# a_n8609_14110# w_n8809_8685# sky130_fd_pr__pfet_g5v0d10v5 ad=0.2175 pd=1.79 as=0.2175 ps=1.79 w=1.5 l=4
X231 vss a_n8609_4082# a_n8609_4082# vss sky130_fd_pr__nfet_g5v0d10v5 ad=0.145 pd=1.29 as=0.145 ps=1.29 w=1 l=4
X232 a_n8609_11046# a_n8609_2082# w_n8809_8685# w_n8809_8685# sky130_fd_pr__pfet_g5v0d10v5 ad=0.2175 pd=1.79 as=0.2175 ps=1.79 w=1.5 l=4
X233 quiet a_n8609_14110# a_n8639_n20509# vss sky130_fd_pr__nfet_05v0_nvt ad=1.45 pd=10.29 as=1.45 ps=10.29 w=10 l=0.9
X234 w_n8809_8685# a_n8609_2082# a_n8609_11046# w_n8809_8685# sky130_fd_pr__pfet_g5v0d10v5 ad=0.2175 pd=1.79 as=0.2175 ps=1.79 w=1.5 l=4
X235 a_n8639_n20509# a_n8581_n15597# vin vss sky130_fd_pr__nfet_05v0_nvt ad=1.45 pd=10.29 as=1.45 ps=10.29 w=10 l=0.9
X236 a_n8639_n20509# a_n8581_n15597# vin vss sky130_fd_pr__nfet_05v0_nvt ad=1.45 pd=10.29 as=1.45 ps=10.29 w=10 l=0.9
X237 a_n8609_14110# a_n8609_2082# w_n8809_8685# w_n8809_8685# sky130_fd_pr__pfet_g5v0d10v5 ad=0.2175 pd=1.79 as=0.2175 ps=1.79 w=1.5 l=4
X238 a_n8639_n20509# a_n8581_n15597# vin vss sky130_fd_pr__nfet_05v0_nvt ad=1.45 pd=10.29 as=1.45 ps=10.29 w=10 l=0.9
X239 w_n8809_8685# a_n8609_2082# a_n8609_11046# w_n8809_8685# sky130_fd_pr__pfet_g5v0d10v5 ad=0.2175 pd=1.79 as=0.2175 ps=1.79 w=1.5 l=4
X240 vss a_n8609_4082# a_n8609_4082# vss sky130_fd_pr__nfet_g5v0d10v5 ad=0.145 pd=1.29 as=0.145 ps=1.29 w=1 l=4
X241 a_n8639_n20509# a_n8609_14110# quiet vss sky130_fd_pr__nfet_05v0_nvt ad=1.45 pd=10.29 as=1.45 ps=10.29 w=10 l=0.9
X242 a_n8609_14110# a_n8609_2082# w_n8809_8685# w_n8809_8685# sky130_fd_pr__pfet_g5v0d10v5 ad=0.2175 pd=1.79 as=0.2175 ps=1.79 w=1.5 l=4
X243 a_n15687_2040# a_n15687_2040# vss vss sky130_fd_pr__nfet_g5v0d10v5 ad=0.145 pd=1.29 as=0.145 ps=1.29 w=1 l=4
X244 a_n12048_20734# a_n13856_8466# vss sky130_fd_pr__res_high_po w=1 l=59.34
X245 a_n8609_4082# a_n8609_4082# vss vss sky130_fd_pr__nfet_g5v0d10v5 ad=0.145 pd=1.29 as=0.145 ps=1.29 w=1 l=4
X246 w_n8809_8685# a_n8609_2082# a_n8609_14110# w_n8809_8685# sky130_fd_pr__pfet_g5v0d10v5 ad=0.2175 pd=1.79 as=0.435 ps=3.58 w=1.5 l=4
X247 a_n8609_14110# a_n8609_2082# w_n8809_8685# w_n8809_8685# sky130_fd_pr__pfet_g5v0d10v5 ad=0.2175 pd=1.79 as=0.2175 ps=1.79 w=1.5 l=4
X248 vss a_n8609_4082# a_n8609_4082# vss sky130_fd_pr__nfet_g5v0d10v5 ad=0.145 pd=1.29 as=0.29 ps=2.58 w=1 l=4
X249 vss enable a_n25673_2540# vss sky130_fd_pr__nfet_01v8 ad=0.29 pd=2.58 as=0.29 ps=2.58 w=1 l=0.15
X250 w_n8809_8685# a_n8609_2082# a_n8609_14110# w_n8809_8685# sky130_fd_pr__pfet_g5v0d10v5 ad=0.2175 pd=1.79 as=0.2175 ps=1.79 w=1.5 l=4
X251 vss a_n8609_4082# a_n8609_4082# vss sky130_fd_pr__nfet_g5v0d10v5 ad=0.145 pd=1.29 as=0.145 ps=1.29 w=1 l=4
X252 a_n8639_n20509# a_n8581_n15597# vin vss sky130_fd_pr__nfet_05v0_nvt ad=1.45 pd=10.29 as=1.45 ps=10.29 w=10 l=0.9
X253 a_n8609_14110# a_n8609_2082# w_n8809_8685# w_n8809_8685# sky130_fd_pr__pfet_g5v0d10v5 ad=0.2175 pd=1.79 as=0.2175 ps=1.79 w=1.5 l=4
X254 w_n8809_8685# a_n8609_2082# a_n8609_14110# w_n8809_8685# sky130_fd_pr__pfet_g5v0d10v5 ad=0.2175 pd=1.79 as=0.2175 ps=1.79 w=1.5 l=4
X255 quiet a_n8609_14110# a_n8639_n20509# vss sky130_fd_pr__nfet_05v0_nvt ad=1.45 pd=10.29 as=1.45 ps=10.29 w=10 l=0.9
X256 a_n8639_n20509# a_n8581_n15597# vin vss sky130_fd_pr__nfet_05v0_nvt ad=1.45 pd=10.29 as=1.45 ps=10.29 w=10 l=0.9
X257 w_n8809_8685# vss sky130_fd_pr__cap_mim_m3_1 l=22.2 w=22.2
X258 vin a_n8581_n15597# a_n8639_n20509# vss sky130_fd_pr__nfet_05v0_nvt ad=1.45 pd=10.29 as=1.45 ps=10.29 w=10 l=0.9
X259 w_n8809_8685# a_n8609_2082# a_n8609_14110# w_n8809_8685# sky130_fd_pr__pfet_g5v0d10v5 ad=0.2175 pd=1.79 as=0.2175 ps=1.79 w=1.5 l=4
X260 a_n15687_2040# a_n15687_2040# vss vss sky130_fd_pr__nfet_g5v0d10v5 ad=0.145 pd=1.29 as=0.145 ps=1.29 w=1 l=4
X261 vin a_n8581_n15597# vss sky130_fd_pr__res_high_po w=1 l=97.39
X262 vin a_n8581_n15597# a_n8639_n20509# vss sky130_fd_pr__nfet_05v0_nvt ad=1.45 pd=10.29 as=1.45 ps=10.29 w=10 l=0.9
X263 w_n8809_8685# vss sky130_fd_pr__cap_mim_m3_1 l=22.2 w=22.2
X264 a_n8639_n20509# a_n8581_n15597# vin vss sky130_fd_pr__nfet_05v0_nvt ad=1.45 pd=10.29 as=1.45 ps=10.29 w=10 l=0.9
X265 vss a_n8609_4082# a_n8609_6082# vss sky130_fd_pr__nfet_g5v0d10v5 ad=0.145 pd=1.29 as=0.145 ps=1.29 w=1 l=4
X266 a_n8581_n15597# vss sky130_fd_pr__cap_mim_m3_1 l=22.2 w=22.2
X267 w_n8809_8685# a_n8609_2082# a_n8609_14110# w_n8809_8685# sky130_fd_pr__pfet_g5v0d10v5 ad=0.2175 pd=1.79 as=0.2175 ps=1.79 w=1.5 l=4
X268 a_n8609_14110# a_n8609_2082# w_n8809_8685# w_n8809_8685# sky130_fd_pr__pfet_g5v0d10v5 ad=0.2175 pd=1.79 as=0.2175 ps=1.79 w=1.5 l=4
X269 w_n8809_8685# vss sky130_fd_pr__cap_mim_m3_1 l=22.2 w=22.2
X270 w_n8809_8685# a_n8609_2082# a_n8609_14110# w_n8809_8685# sky130_fd_pr__pfet_g5v0d10v5 ad=0.2175 pd=1.79 as=0.2175 ps=1.79 w=1.5 l=4
X271 a_n8609_2082# a_n15687_2040# vss vss sky130_fd_pr__nfet_g5v0d10v5 ad=0.29 pd=2.58 as=0.145 ps=1.29 w=1 l=4
X272 a_n15687_2040# a_n15687_2040# vss vss sky130_fd_pr__nfet_g5v0d10v5 ad=0.145 pd=1.29 as=0.145 ps=1.29 w=1 l=4
X273 quiet a_n8609_14110# a_n8639_n20509# vss sky130_fd_pr__nfet_05v0_nvt ad=1.45 pd=10.29 as=1.45 ps=10.29 w=10 l=0.9
X274 a_n8609_11046# a_n8609_2082# w_n8809_8685# w_n8809_8685# sky130_fd_pr__pfet_g5v0d10v5 ad=0.2175 pd=1.79 as=0.2175 ps=1.79 w=1.5 l=4
X275 vss a_n8609_4082# a_n8609_4082# vss sky130_fd_pr__nfet_g5v0d10v5 ad=0.145 pd=1.29 as=0.145 ps=1.29 w=1 l=4
X276 a_n8609_2082# a_n15687_2040# vss vss sky130_fd_pr__nfet_g5v0d10v5 ad=0.145 pd=1.29 as=0.145 ps=1.29 w=1 l=4
X277 a_n15687_2040# a_n15687_2040# vss vss sky130_fd_pr__nfet_g5v0d10v5 ad=0.145 pd=1.29 as=0.145 ps=1.29 w=1 l=4
X278 a_n27185_2440# a_n25088_n20595# vss sky130_fd_pr__res_high_po w=1 l=97.39
X279 vin a_n8581_n15597# a_n8639_n20509# vss sky130_fd_pr__nfet_05v0_nvt ad=1.45 pd=10.29 as=1.45 ps=10.29 w=10 l=0.9
X280 w_n8809_8685# a_n8609_2082# a_n8609_11046# w_n8809_8685# sky130_fd_pr__pfet_g5v0d10v5 ad=0.2175 pd=1.79 as=0.435 ps=3.58 w=1.5 l=4
X281 vss a_n15687_2040# a_n8609_2082# vss sky130_fd_pr__nfet_g5v0d10v5 ad=0.145 pd=1.29 as=0.145 ps=1.29 w=1 l=4
X282 a_n8609_11046# a_n8609_2082# w_n8809_8685# w_n8809_8685# sky130_fd_pr__pfet_g5v0d10v5 ad=0.2175 pd=1.79 as=0.2175 ps=1.79 w=1.5 l=4
X283 w_n8809_8685# vss sky130_fd_pr__cap_mim_m3_1 l=22.2 w=22.2
X284 a_n8609_2082# a_n15687_2040# vss vss sky130_fd_pr__nfet_g5v0d10v5 ad=0.145 pd=1.29 as=0.145 ps=1.29 w=1 l=4
X285 a_n24792_n717# a_n25088_n20595# vss sky130_fd_pr__res_high_po w=1 l=97.39
X286 a_n16821_6140# t5 a_n19021_6140# vss sky130_fd_pr__nfet_01v8 ad=0.825 pd=5.33 as=0.825 ps=5.33 w=5 l=0.15
X287 a_n15687_2040# a_n15687_2040# vss vss sky130_fd_pr__nfet_g5v0d10v5 ad=0.145 pd=1.29 as=0.145 ps=1.29 w=1 l=4
X288 w_n8809_8685# a_n8609_2082# a_n8609_11046# w_n8809_8685# sky130_fd_pr__pfet_g5v0d10v5 ad=0.2175 pd=1.79 as=0.2175 ps=1.79 w=1.5 l=4
X289 a_n8609_4082# a_n8609_4082# vss vss sky130_fd_pr__nfet_g5v0d10v5 ad=0.145 pd=1.29 as=0.145 ps=1.29 w=1 l=4
X290 w_n8809_8685# a_n8609_2082# a_n8609_2082# w_n8809_8685# sky130_fd_pr__pfet_g5v0d10v5 ad=0.2175 pd=1.79 as=0.2175 ps=1.79 w=1.5 l=4
X291 a_n15687_2040# a_n15687_2040# vss vss sky130_fd_pr__nfet_g5v0d10v5 ad=0.145 pd=1.29 as=0.145 ps=1.29 w=1 l=4
X292 a_n21832_n717# a_n21536_n20595# vss sky130_fd_pr__res_high_po w=1 l=97.39
X293 vss a_n15687_2040# a_n8609_2082# vss sky130_fd_pr__nfet_g5v0d10v5 ad=0.145 pd=1.29 as=0.145 ps=1.29 w=1 l=4
X294 a_n8581_n15597# vss sky130_fd_pr__cap_mim_m3_1 l=22.2 w=22.2
X295 vin a_n8581_n15597# a_n8639_n20509# vss sky130_fd_pr__nfet_05v0_nvt ad=1.45 pd=10.29 as=1.45 ps=10.29 w=10 l=0.9
X296 a_n8639_n20509# a_n8581_n15597# vin vss sky130_fd_pr__nfet_05v0_nvt ad=1.45 pd=10.29 as=1.45 ps=10.29 w=10 l=0.9
X297 w_n8809_8685# a_n8609_2082# a_n8609_14110# w_n8809_8685# sky130_fd_pr__pfet_g5v0d10v5 ad=0.2175 pd=1.79 as=0.2175 ps=1.79 w=1.5 l=4
X298 a_n8609_14110# a_n8609_2082# w_n8809_8685# w_n8809_8685# sky130_fd_pr__pfet_g5v0d10v5 ad=0.2175 pd=1.79 as=0.2175 ps=1.79 w=1.5 l=4
X299 host vgi a_n15687_2040# host sky130_fd_pr__pfet_01v8_lvt ad=0.87 pd=6.29 as=0.87 ps=6.29 w=6 l=4
X300 vin a_n8581_n15597# a_n8639_n20509# vss sky130_fd_pr__nfet_05v0_nvt ad=1.45 pd=10.29 as=1.45 ps=10.29 w=10 l=0.9
X301 vin a_n8581_n15597# a_n8639_n20509# vss sky130_fd_pr__nfet_05v0_nvt ad=1.45 pd=10.29 as=1.45 ps=10.29 w=10 l=0.9
X302 a_n8639_n20509# a_n8581_n15597# vin vss sky130_fd_pr__nfet_05v0_nvt ad=1.45 pd=10.29 as=2.9 ps=20.58 w=10 l=0.9
X303 a_n21221_6140# a_n23421_6140# vss sky130_fd_pr__res_high_po w=1 l=24.04
X304 w_n8809_8685# a_n8609_2082# a_n8609_14110# w_n8809_8685# sky130_fd_pr__pfet_g5v0d10v5 ad=0.2175 pd=1.79 as=0.2175 ps=1.79 w=1.5 l=4
X305 w_n8809_8685# a_n8609_2082# a_n8609_14110# w_n8809_8685# sky130_fd_pr__pfet_g5v0d10v5 ad=0.2175 pd=1.79 as=0.2175 ps=1.79 w=1.5 l=4
X306 a_n8609_11046# a_n8609_2082# w_n8809_8685# w_n8809_8685# sky130_fd_pr__pfet_g5v0d10v5 ad=0.2175 pd=1.79 as=0.2175 ps=1.79 w=1.5 l=4
X307 w_n8809_8685# a_n8609_2082# a_n8609_14110# w_n8809_8685# sky130_fd_pr__pfet_g5v0d10v5 ad=0.2175 pd=1.79 as=0.435 ps=3.58 w=1.5 l=4
X308 a_n8609_14110# a_n8609_2082# w_n8809_8685# w_n8809_8685# sky130_fd_pr__pfet_g5v0d10v5 ad=0.2175 pd=1.79 as=0.2175 ps=1.79 w=1.5 l=4
X309 a_n8609_2082# a_n8609_2082# w_n8809_8685# w_n8809_8685# sky130_fd_pr__pfet_g5v0d10v5 ad=0.435 pd=3.58 as=0.2175 ps=1.79 w=1.5 l=4
X310 vss a_n15687_2040# a_n8609_2082# vss sky130_fd_pr__nfet_g5v0d10v5 ad=0.145 pd=1.29 as=0.145 ps=1.29 w=1 l=4
X311 a_n8639_n20509# a_n8581_n15597# vin vss sky130_fd_pr__nfet_05v0_nvt ad=1.45 pd=10.29 as=1.45 ps=10.29 w=10 l=0.9
X312 a_n8609_14110# a_n8609_2082# w_n8809_8685# w_n8809_8685# sky130_fd_pr__pfet_g5v0d10v5 ad=0.2175 pd=1.79 as=0.2175 ps=1.79 w=1.5 l=4
X313 a_n8609_6082# a_n8609_4082# vss vss sky130_fd_pr__nfet_g5v0d10v5 ad=0.145 pd=1.29 as=0.145 ps=1.29 w=1 l=4
X314 a_n8609_2082# a_n15687_2040# vss vss sky130_fd_pr__nfet_g5v0d10v5 ad=0.145 pd=1.29 as=0.145 ps=1.29 w=1 l=4
X315 vin a_n8581_n15597# a_n8639_n20509# vss sky130_fd_pr__nfet_05v0_nvt ad=1.45 pd=10.29 as=1.45 ps=10.29 w=10 l=0.9
X316 a_n8639_n20509# a_n8581_n15597# vin vss sky130_fd_pr__nfet_05v0_nvt ad=1.45 pd=10.29 as=1.45 ps=10.29 w=10 l=0.9
X317 a_n8609_14110# a_n8609_2082# w_n8809_8685# w_n8809_8685# sky130_fd_pr__pfet_g5v0d10v5 ad=0.2175 pd=1.79 as=0.2175 ps=1.79 w=1.5 l=4
X318 w_n8809_8685# a_n8609_2082# a_n8609_14110# w_n8809_8685# sky130_fd_pr__pfet_g5v0d10v5 ad=0.2175 pd=1.79 as=0.2175 ps=1.79 w=1.5 l=4
X319 a_n24073_2440# vss sky130_fd_pr__cap_mim_m3_1 l=22.2 w=22.2
X320 a_n8639_n20509# a_n8581_n15597# vin vss sky130_fd_pr__nfet_05v0_nvt ad=1.45 pd=10.29 as=1.45 ps=10.29 w=10 l=0.9
X321 a_n8639_n20509# a_n8581_n15597# vin vss sky130_fd_pr__nfet_05v0_nvt ad=1.45 pd=10.29 as=1.45 ps=10.29 w=10 l=0.9
X322 w_n8809_8685# a_n8609_2082# a_n8609_14110# w_n8809_8685# sky130_fd_pr__pfet_g5v0d10v5 ad=0.2175 pd=1.79 as=0.2175 ps=1.79 w=1.5 l=4
X323 a_n8609_6082# a_n8609_4082# vss vss sky130_fd_pr__nfet_g5v0d10v5 ad=0.145 pd=1.29 as=0.145 ps=1.29 w=1 l=4
X324 a_n27185_2440# a_n25673_2540# bg host sky130_fd_pr__pfet_01v8 ad=1.16 pd=8.58 as=1.16 ps=8.58 w=4 l=0.15
X325 a_n19021_6140# t4 a_n21221_6140# vss sky130_fd_pr__nfet_01v8 ad=1.55 pd=10.62 as=0.825 ps=5.33 w=5 l=0.15
X326 vss a_n15687_2040# a_n8609_2082# vss sky130_fd_pr__nfet_g5v0d10v5 ad=0.145 pd=1.29 as=0.29 ps=2.58 w=1 l=4
X327 a_n8609_14110# a_n8609_2082# w_n8809_8685# w_n8809_8685# sky130_fd_pr__pfet_g5v0d10v5 ad=0.2175 pd=1.79 as=0.2175 ps=1.79 w=1.5 l=4
X328 a_n15687_2040# a_n15687_2040# vss vss sky130_fd_pr__nfet_g5v0d10v5 ad=0.145 pd=1.29 as=0.145 ps=1.29 w=1 l=4
X329 vss a_n15687_2040# a_n8609_2082# vss sky130_fd_pr__nfet_g5v0d10v5 ad=0.145 pd=1.29 as=0.145 ps=1.29 w=1 l=4
X330 vin a_n8581_n15597# a_n8639_n20509# vss sky130_fd_pr__nfet_05v0_nvt ad=1.45 pd=10.29 as=1.45 ps=10.29 w=10 l=0.9
X331 vin a_n8581_n15597# a_n8639_n20509# vss sky130_fd_pr__nfet_05v0_nvt ad=2.9 pd=20.58 as=1.45 ps=10.29 w=10 l=0.9
X332 w_n8809_8685# a_n8609_2082# a_n8609_14110# w_n8809_8685# sky130_fd_pr__pfet_g5v0d10v5 ad=0.2175 pd=1.79 as=0.2175 ps=1.79 w=1.5 l=4
X333 w_n8809_8685# a_n8609_2082# a_n8609_14110# w_n8809_8685# sky130_fd_pr__pfet_g5v0d10v5 ad=0.2175 pd=1.79 as=0.2175 ps=1.79 w=1.5 l=4
X334 w_n8809_8685# a_n8609_2082# a_n8609_14110# w_n8809_8685# sky130_fd_pr__pfet_g5v0d10v5 ad=0.2175 pd=1.79 as=0.2175 ps=1.79 w=1.5 l=4
X335 vss a_n8609_4082# a_n8609_6082# vss sky130_fd_pr__nfet_g5v0d10v5 ad=0.145 pd=1.29 as=0.145 ps=1.29 w=1 l=4
X336 vss a_n15687_2040# a_n15687_2040# vss sky130_fd_pr__nfet_g5v0d10v5 ad=0.145 pd=1.29 as=0.145 ps=1.29 w=1 l=4
X337 vin a_n8581_n15597# a_n8639_n20509# vss sky130_fd_pr__nfet_05v0_nvt ad=1.45 pd=10.29 as=1.45 ps=10.29 w=10 l=0.9
X338 w_n8809_8685# a_n8609_2082# a_n8609_2082# w_n8809_8685# sky130_fd_pr__pfet_g5v0d10v5 ad=0.2175 pd=1.79 as=0.435 ps=3.58 w=1.5 l=4
X339 a_n8639_n20509# a_n8581_n15597# vin vss sky130_fd_pr__nfet_05v0_nvt ad=1.45 pd=10.29 as=1.45 ps=10.29 w=10 l=0.9
X340 a_n8609_14110# a_n8609_2082# w_n8809_8685# w_n8809_8685# sky130_fd_pr__pfet_g5v0d10v5 ad=0.2175 pd=1.79 as=0.2175 ps=1.79 w=1.5 l=4
X341 a_n8609_11046# a_n8609_2082# w_n8809_8685# w_n8809_8685# sky130_fd_pr__pfet_g5v0d10v5 ad=0.2175 pd=1.79 as=0.2175 ps=1.79 w=1.5 l=4
X342 vin a_n8581_n15597# a_n8639_n20509# vss sky130_fd_pr__nfet_05v0_nvt ad=1.45 pd=10.29 as=1.45 ps=10.29 w=10 l=0.9
X343 vss a_n8609_4082# a_n8609_4082# vss sky130_fd_pr__nfet_g5v0d10v5 ad=0.145 pd=1.29 as=0.145 ps=1.29 w=1 l=4
X344 vss a_n15687_2040# a_n15687_2040# vss sky130_fd_pr__nfet_g5v0d10v5 ad=0.145 pd=1.29 as=0.145 ps=1.29 w=1 l=4
X345 vin a_n8581_n15597# a_n8639_n20509# vss sky130_fd_pr__nfet_05v0_nvt ad=1.45 pd=10.29 as=1.45 ps=10.29 w=10 l=0.9
X346 a_n8639_n20509# a_n8581_n15597# vin vss sky130_fd_pr__nfet_05v0_nvt ad=1.45 pd=10.29 as=1.45 ps=10.29 w=10 l=0.9
X347 w_n8809_8685# a_n8609_2082# a_n8609_11046# w_n8809_8685# sky130_fd_pr__pfet_g5v0d10v5 ad=0.2175 pd=1.79 as=0.2175 ps=1.79 w=1.5 l=4
X348 w_n8809_8685# vss sky130_fd_pr__cap_mim_m3_1 l=22.2 w=22.2
X349 w_n8809_8685# vss sky130_fd_pr__cap_mim_m3_1 l=22.2 w=22.2
X350 vin a_n8581_n15597# a_n8639_n20509# vss sky130_fd_pr__nfet_05v0_nvt ad=1.45 pd=10.29 as=1.45 ps=10.29 w=10 l=0.9
X351 w_n8809_8685# a_n8609_2082# a_n8609_2082# w_n8809_8685# sky130_fd_pr__pfet_g5v0d10v5 ad=0.2175 pd=1.79 as=0.2175 ps=1.79 w=1.5 l=4
X352 a_n8609_6082# a_n8609_4082# vss vss sky130_fd_pr__nfet_g5v0d10v5 ad=0.145 pd=1.29 as=0.145 ps=1.29 w=1 l=4
X353 a_n8609_14110# a_n8609_2082# w_n8809_8685# w_n8809_8685# sky130_fd_pr__pfet_g5v0d10v5 ad=0.2175 pd=1.79 as=0.2175 ps=1.79 w=1.5 l=4
X354 vss a_n8609_4082# a_n8609_6082# vss sky130_fd_pr__nfet_g5v0d10v5 ad=0.145 pd=1.29 as=0.145 ps=1.29 w=1 l=4
X355 a_n27185_2440# enable bg vss sky130_fd_pr__nfet_01v8 ad=0.58 pd=4.58 as=0.58 ps=4.58 w=2 l=0.15
X356 vss a_n15687_2040# a_n8609_2082# vss sky130_fd_pr__nfet_g5v0d10v5 ad=0.145 pd=1.29 as=0.145 ps=1.29 w=1 l=4
X357 a_n24073_2440# vss sky130_fd_pr__cap_mim_m3_1 l=22.2 w=22.2
X358 a_n8639_n20509# a_n8609_14110# quiet vss sky130_fd_pr__nfet_05v0_nvt ad=1.45 pd=10.29 as=1.45 ps=10.29 w=10 l=0.9
X359 vin a_n8581_n15597# a_n8639_n20509# vss sky130_fd_pr__nfet_05v0_nvt ad=1.45 pd=10.29 as=1.45 ps=10.29 w=10 l=0.9
X360 a_n17688_n717# a_n17392_n20595# vss sky130_fd_pr__res_high_po w=1 l=97.39
X361 vin a_n8581_n15597# a_n8639_n20509# vss sky130_fd_pr__nfet_05v0_nvt ad=1.45 pd=10.29 as=1.45 ps=10.29 w=10 l=0.9
X362 a_n8609_11046# a_n8609_2082# w_n8809_8685# w_n8809_8685# sky130_fd_pr__pfet_g5v0d10v5 ad=0.2175 pd=1.79 as=0.2175 ps=1.79 w=1.5 l=4
X363 a_n8609_11046# a_n8609_2082# w_n8809_8685# w_n8809_8685# sky130_fd_pr__pfet_g5v0d10v5 ad=0.2175 pd=1.79 as=0.2175 ps=1.79 w=1.5 l=4
X364 vss a_n8609_4082# a_n8609_6082# vss sky130_fd_pr__nfet_g5v0d10v5 ad=0.145 pd=1.29 as=0.145 ps=1.29 w=1 l=4
X365 vin a_n8581_n15597# a_n8639_n20509# vss sky130_fd_pr__nfet_05v0_nvt ad=1.45 pd=10.29 as=1.45 ps=10.29 w=10 l=0.9
X366 a_n8639_n20509# a_n8581_n15597# vin vss sky130_fd_pr__nfet_05v0_nvt ad=1.45 pd=10.29 as=1.45 ps=10.29 w=10 l=0.9
X367 a_n8609_14110# a_n8609_2082# w_n8809_8685# w_n8809_8685# sky130_fd_pr__pfet_g5v0d10v5 ad=0.435 pd=3.58 as=0.2175 ps=1.79 w=1.5 l=4
X368 w_n8809_8685# a_n8609_2082# a_n8609_2082# w_n8809_8685# sky130_fd_pr__pfet_g5v0d10v5 ad=0.2175 pd=1.79 as=0.2175 ps=1.79 w=1.5 l=4
X369 a_n8609_6082# a_n8609_4082# vss vss sky130_fd_pr__nfet_g5v0d10v5 ad=0.29 pd=2.58 as=0.145 ps=1.29 w=1 l=4
X370 a_n8609_2082# a_n15687_2040# vss vss sky130_fd_pr__nfet_g5v0d10v5 ad=0.145 pd=1.29 as=0.145 ps=1.29 w=1 l=4
X371 vss a_n15687_2040# a_n15687_2040# vss sky130_fd_pr__nfet_g5v0d10v5 ad=0.145 pd=1.29 as=0.145 ps=1.29 w=1 l=4
X372 w_n8809_8685# vss sky130_fd_pr__cap_mim_m3_1 l=22.2 w=22.2
X373 a_n8609_14110# a_n8609_2082# w_n8809_8685# w_n8809_8685# sky130_fd_pr__pfet_g5v0d10v5 ad=0.2175 pd=1.79 as=0.2175 ps=1.79 w=1.5 l=4
X374 w_n8809_8685# a_n8609_2082# a_n8609_11046# w_n8809_8685# sky130_fd_pr__pfet_g5v0d10v5 ad=0.2175 pd=1.79 as=0.2175 ps=1.79 w=1.5 l=4
X375 a_n27821_6140# t1 a_n25621_6140# vss sky130_fd_pr__nfet_01v8 ad=0.825 pd=5.33 as=1.55 ps=10.62 w=5 l=0.15
X376 w_n8809_8685# a_n8609_2082# a_n8609_14110# w_n8809_8685# sky130_fd_pr__pfet_g5v0d10v5 ad=0.2175 pd=1.79 as=0.2175 ps=1.79 w=1.5 l=4
X377 a_n8639_n20509# a_n8609_14110# quiet vss sky130_fd_pr__nfet_05v0_nvt ad=1.45 pd=10.29 as=1.45 ps=10.29 w=10 l=0.9
X378 a_n8609_14110# a_n8609_2082# w_n8809_8685# w_n8809_8685# sky130_fd_pr__pfet_g5v0d10v5 ad=0.2175 pd=1.79 as=0.2175 ps=1.79 w=1.5 l=4
X379 vin a_n8581_n15597# a_n8639_n20509# vss sky130_fd_pr__nfet_05v0_nvt ad=1.45 pd=10.29 as=1.45 ps=10.29 w=10 l=0.9
X380 w_n8809_8685# a_n8609_2082# a_n8609_14110# w_n8809_8685# sky130_fd_pr__pfet_g5v0d10v5 ad=0.2175 pd=1.79 as=0.2175 ps=1.79 w=1.5 l=4
X381 a_n15687_2040# a_n15687_2040# vss vss sky130_fd_pr__nfet_g5v0d10v5 ad=0.145 pd=1.29 as=0.145 ps=1.29 w=1 l=4
X382 a_n15687_2040# a_n15687_2040# vss vss sky130_fd_pr__nfet_g5v0d10v5 ad=0.29 pd=2.58 as=0.145 ps=1.29 w=1 l=4
X383 a_n24200_n717# a_n23904_n20595# vss sky130_fd_pr__res_high_po w=1 l=97.39
X384 a_n8639_n20509# a_n8581_n15597# vin vss sky130_fd_pr__nfet_05v0_nvt ad=1.45 pd=10.29 as=1.45 ps=10.29 w=10 l=0.9
X385 w_n8809_8685# a_n8609_2082# a_n8609_14110# w_n8809_8685# sky130_fd_pr__pfet_g5v0d10v5 ad=0.2175 pd=1.79 as=0.435 ps=3.58 w=1.5 l=4
X386 a_n8639_n20509# a_n8581_n15597# vin vss sky130_fd_pr__nfet_05v0_nvt ad=1.45 pd=10.29 as=1.45 ps=10.29 w=10 l=0.9
X387 a_n8609_14110# a_n8609_2082# w_n8809_8685# w_n8809_8685# sky130_fd_pr__pfet_g5v0d10v5 ad=0.2175 pd=1.79 as=0.2175 ps=1.79 w=1.5 l=4
X388 a_n8609_2082# a_n8609_2082# w_n8809_8685# w_n8809_8685# sky130_fd_pr__pfet_g5v0d10v5 ad=0.2175 pd=1.79 as=0.2175 ps=1.79 w=1.5 l=4
X389 a_n8609_14110# a_n8609_2082# w_n8809_8685# w_n8809_8685# sky130_fd_pr__pfet_g5v0d10v5 ad=0.2175 pd=1.79 as=0.2175 ps=1.79 w=1.5 l=4
X390 a_n24073_2440# vss sky130_fd_pr__cap_mim_m3_1 l=22.2 w=22.2
X391 a_n8639_n20509# a_n8581_n15597# vin vss sky130_fd_pr__nfet_05v0_nvt ad=1.45 pd=10.29 as=1.45 ps=10.29 w=10 l=0.9
X392 a_n8609_4082# a_n8609_4082# vss vss sky130_fd_pr__nfet_g5v0d10v5 ad=0.145 pd=1.29 as=0.145 ps=1.29 w=1 l=4
X393 a_n24792_n717# a_n24496_n20595# vss sky130_fd_pr__res_high_po w=1 l=97.39
X394 a_n14744_18586# a_n16821_6140# vss sky130_fd_pr__res_high_po w=1 l=48.6
X395 w_n8809_8685# a_n8609_2082# a_n8609_14110# w_n8809_8685# sky130_fd_pr__pfet_g5v0d10v5 ad=0.2175 pd=1.79 as=0.2175 ps=1.79 w=1.5 l=4
X396 w_n8809_8685# a_n8609_2082# a_n8609_14110# w_n8809_8685# sky130_fd_pr__pfet_g5v0d10v5 ad=0.2175 pd=1.79 as=0.2175 ps=1.79 w=1.5 l=4
X397 a_n8609_14110# a_n8609_2082# w_n8809_8685# w_n8809_8685# sky130_fd_pr__pfet_g5v0d10v5 ad=0.2175 pd=1.79 as=0.2175 ps=1.79 w=1.5 l=4
X398 a_n8609_11046# a_n8609_2082# w_n8809_8685# w_n8809_8685# sky130_fd_pr__pfet_g5v0d10v5 ad=0.2175 pd=1.79 as=0.2175 ps=1.79 w=1.5 l=4
X399 a_n8581_n15597# vss sky130_fd_pr__cap_mim_m3_1 l=22.2 w=22.2
X400 quiet a_n8609_14110# a_n8639_n20509# vss sky130_fd_pr__nfet_05v0_nvt ad=1.45 pd=10.29 as=1.45 ps=10.29 w=10 l=0.9
X401 a_n8609_4082# a_n8609_4082# vss vss sky130_fd_pr__nfet_g5v0d10v5 ad=0.145 pd=1.29 as=0.145 ps=1.29 w=1 l=4
X402 a_n21240_n717# a_n21536_n20595# vss sky130_fd_pr__res_high_po w=1 l=97.39
X403 a_n8639_n20509# a_n8581_n15597# vin vss sky130_fd_pr__nfet_05v0_nvt ad=1.45 pd=10.29 as=1.45 ps=10.29 w=10 l=0.9
X404 vin a_n8581_n15597# a_n8639_n20509# vss sky130_fd_pr__nfet_05v0_nvt ad=1.45 pd=10.29 as=1.45 ps=10.29 w=10 l=0.9
X405 vin a_n8581_n15597# a_n8639_n20509# vss sky130_fd_pr__nfet_05v0_nvt ad=1.45 pd=10.29 as=1.45 ps=10.29 w=10 l=0.9
X406 a_n8609_14110# a_n8609_2082# w_n8809_8685# w_n8809_8685# sky130_fd_pr__pfet_g5v0d10v5 ad=0.2175 pd=1.79 as=0.2175 ps=1.79 w=1.5 l=4
X407 vss t0 a_n27821_6140# vss sky130_fd_pr__nfet_01v8 ad=0.825 pd=5.33 as=0.825 ps=5.33 w=5 l=0.15
X408 a_n21240_n717# a_n20944_n20595# vss sky130_fd_pr__res_high_po w=1 l=97.39
X409 a_n8609_14110# a_n8609_2082# w_n8809_8685# w_n8809_8685# sky130_fd_pr__pfet_g5v0d10v5 ad=0.2175 pd=1.79 as=0.2175 ps=1.79 w=1.5 l=4
X410 vss a_n8609_4082# a_n8609_6082# vss sky130_fd_pr__nfet_g5v0d10v5 ad=0.145 pd=1.29 as=0.145 ps=1.29 w=1 l=4
X411 quiet a_n8609_14110# a_n8639_n20509# vss sky130_fd_pr__nfet_05v0_nvt ad=1.45 pd=10.29 as=1.45 ps=10.29 w=10 l=0.9
X412 vin a_n8581_n15597# a_n8639_n20509# vss sky130_fd_pr__nfet_05v0_nvt ad=1.45 pd=10.29 as=1.45 ps=10.29 w=10 l=0.9
X413 vin a_n8581_n15597# a_n8639_n20509# vss sky130_fd_pr__nfet_05v0_nvt ad=1.45 pd=10.29 as=1.45 ps=10.29 w=10 l=0.9
X414 a_n8609_14110# a_n8609_2082# w_n8809_8685# w_n8809_8685# sky130_fd_pr__pfet_g5v0d10v5 ad=0.2175 pd=1.79 as=0.2175 ps=1.79 w=1.5 l=4
X415 a_n8609_11046# a_n8609_2082# w_n8809_8685# w_n8809_8685# sky130_fd_pr__pfet_g5v0d10v5 ad=0.2175 pd=1.79 as=0.2175 ps=1.79 w=1.5 l=4
X416 quiet a_n8609_14110# a_n8639_n20509# vss sky130_fd_pr__nfet_05v0_nvt ad=1.45 pd=10.29 as=1.45 ps=10.29 w=10 l=0.9
X417 vss a_n8609_4082# a_n8609_4082# vss sky130_fd_pr__nfet_g5v0d10v5 ad=0.145 pd=1.29 as=0.145 ps=1.29 w=1 l=4
X418 w_n8809_8685# vss sky130_fd_pr__cap_mim_m3_1 l=22.2 w=22.2
X419 w_n8809_8685# a_n8609_2082# a_n8609_14110# w_n8809_8685# sky130_fd_pr__pfet_g5v0d10v5 ad=0.2175 pd=1.79 as=0.2175 ps=1.79 w=1.5 l=4
X420 vin a_n8581_n15597# a_n8639_n20509# vss sky130_fd_pr__nfet_05v0_nvt ad=1.45 pd=10.29 as=1.45 ps=10.29 w=10 l=0.9
X421 w_n8809_8685# a_n8609_2082# a_n8609_11046# w_n8809_8685# sky130_fd_pr__pfet_g5v0d10v5 ad=0.2175 pd=1.79 as=0.435 ps=3.58 w=1.5 l=4
X422 a_n8609_11046# a_n8609_2082# w_n8809_8685# w_n8809_8685# sky130_fd_pr__pfet_g5v0d10v5 ad=0.435 pd=3.58 as=0.2175 ps=1.79 w=1.5 l=4
X423 a_n15687_2040# vgi host host sky130_fd_pr__pfet_01v8_lvt ad=0.87 pd=6.29 as=1.74 ps=12.58 w=6 l=4
X424 vss a_n15687_2040# a_n8609_2082# vss sky130_fd_pr__nfet_g5v0d10v5 ad=0.145 pd=1.29 as=0.145 ps=1.29 w=1 l=4
X425 a_n8639_n20509# a_n8581_n15597# vin vss sky130_fd_pr__nfet_05v0_nvt ad=1.45 pd=10.29 as=1.45 ps=10.29 w=10 l=0.9
X426 vin a_n8581_n15597# a_n8639_n20509# vss sky130_fd_pr__nfet_05v0_nvt ad=1.45 pd=10.29 as=1.45 ps=10.29 w=10 l=0.9
X427 a_n8609_11046# a_n8609_2082# w_n8809_8685# w_n8809_8685# sky130_fd_pr__pfet_g5v0d10v5 ad=0.2175 pd=1.79 as=0.2175 ps=1.79 w=1.5 l=4
X428 vin a_n8581_n15597# a_n8639_n20509# vss sky130_fd_pr__nfet_05v0_nvt ad=2.9 pd=20.58 as=1.45 ps=10.29 w=10 l=0.9
X429 a_n8639_n20509# a_n8581_n15597# vin vss sky130_fd_pr__nfet_05v0_nvt ad=1.45 pd=10.29 as=1.45 ps=10.29 w=10 l=0.9
X430 a_n15687_2040# a_n15687_2040# vss vss sky130_fd_pr__nfet_g5v0d10v5 ad=0.145 pd=1.29 as=0.145 ps=1.29 w=1 l=4
X431 quiet a_n8609_14110# a_n8639_n20509# vss sky130_fd_pr__nfet_05v0_nvt ad=1.45 pd=10.29 as=1.45 ps=10.29 w=10 l=0.9
X432 a_n8609_14110# a_n8609_2082# w_n8809_8685# w_n8809_8685# sky130_fd_pr__pfet_g5v0d10v5 ad=0.2175 pd=1.79 as=0.2175 ps=1.79 w=1.5 l=4
X433 a_n8639_n20509# a_n8581_n15597# vin vss sky130_fd_pr__nfet_05v0_nvt ad=1.45 pd=10.29 as=1.45 ps=10.29 w=10 l=0.9
X434 a_n8609_4082# a_n8609_4082# vss vss sky130_fd_pr__nfet_g5v0d10v5 ad=0.145 pd=1.29 as=0.145 ps=1.29 w=1 l=4
X435 vss a_n8609_4082# a_n8609_4082# vss sky130_fd_pr__nfet_g5v0d10v5 ad=0.145 pd=1.29 as=0.145 ps=1.29 w=1 l=4
X436 a_n14152_18586# a_n13856_8466# vss sky130_fd_pr__res_high_po w=1 l=48.6
X437 w_n8809_8685# a_n8609_2082# a_n8609_11046# w_n8809_8685# sky130_fd_pr__pfet_g5v0d10v5 ad=0.2175 pd=1.79 as=0.2175 ps=1.79 w=1.5 l=4
X438 a_n8609_11046# a_n8609_2082# w_n8809_8685# w_n8809_8685# sky130_fd_pr__pfet_g5v0d10v5 ad=0.2175 pd=1.79 as=0.2175 ps=1.79 w=1.5 l=4
X439 a_n24073_2440# vss sky130_fd_pr__cap_mim_m3_1 l=22.2 w=22.2
X440 quiet a_n8609_14110# a_n8639_n20509# vss sky130_fd_pr__nfet_05v0_nvt ad=1.45 pd=10.29 as=1.45 ps=10.29 w=10 l=0.9
X441 vin a_n8581_n15597# a_n8639_n20509# vss sky130_fd_pr__nfet_05v0_nvt ad=1.45 pd=10.29 as=1.45 ps=10.29 w=10 l=0.9
X442 a_n15687_2040# a_n15687_2040# vss vss sky130_fd_pr__nfet_g5v0d10v5 ad=0.145 pd=1.29 as=0.145 ps=1.29 w=1 l=4
X443 a_n8609_14110# a_n8609_2082# w_n8809_8685# w_n8809_8685# sky130_fd_pr__pfet_g5v0d10v5 ad=0.2175 pd=1.79 as=0.2175 ps=1.79 w=1.5 l=4
X444 a_n8609_14110# a_n8609_2082# w_n8809_8685# w_n8809_8685# sky130_fd_pr__pfet_g5v0d10v5 ad=0.2175 pd=1.79 as=0.2175 ps=1.79 w=1.5 l=4
X445 vss a_n8609_4082# a_n8609_4082# vss sky130_fd_pr__nfet_g5v0d10v5 ad=0.145 pd=1.29 as=0.145 ps=1.29 w=1 l=4
X446 quiet a_n8609_14110# a_n8639_n20509# vss sky130_fd_pr__nfet_05v0_nvt ad=1.45 pd=10.29 as=1.45 ps=10.29 w=10 l=0.9
X447 a_n8609_11046# a_n8609_2082# w_n8809_8685# w_n8809_8685# sky130_fd_pr__pfet_g5v0d10v5 ad=0.2175 pd=1.79 as=0.2175 ps=1.79 w=1.5 l=4
X448 a_n8609_4082# a_n8609_4082# vss vss sky130_fd_pr__nfet_g5v0d10v5 ad=0.29 pd=2.58 as=0.145 ps=1.29 w=1 l=4
X449 w_n8809_8685# a_n8609_2082# a_n8609_14110# w_n8809_8685# sky130_fd_pr__pfet_g5v0d10v5 ad=0.2175 pd=1.79 as=0.2175 ps=1.79 w=1.5 l=4
X450 w_n8809_8685# a_n8609_2082# a_n8609_14110# w_n8809_8685# sky130_fd_pr__pfet_g5v0d10v5 ad=0.2175 pd=1.79 as=0.2175 ps=1.79 w=1.5 l=4
X451 quiet a_n8609_14110# a_n8639_n20509# vss sky130_fd_pr__nfet_05v0_nvt ad=1.45 pd=10.29 as=1.45 ps=10.29 w=10 l=0.9
X452 a_n8639_n20509# a_n8581_n15597# vin vss sky130_fd_pr__nfet_05v0_nvt ad=1.45 pd=10.29 as=1.45 ps=10.29 w=10 l=0.9
X453 a_n8609_14110# a_n8609_2082# w_n8809_8685# w_n8809_8685# sky130_fd_pr__pfet_g5v0d10v5 ad=0.435 pd=3.58 as=0.2175 ps=1.79 w=1.5 l=4
X454 w_n8809_8685# a_n8609_2082# a_n8609_14110# w_n8809_8685# sky130_fd_pr__pfet_g5v0d10v5 ad=0.2175 pd=1.79 as=0.2175 ps=1.79 w=1.5 l=4
X455 a_n16504_n717# a_n16800_n20595# vss sky130_fd_pr__res_high_po w=1 l=97.39
X456 a_n8639_n20509# a_n8609_14110# quiet vss sky130_fd_pr__nfet_05v0_nvt ad=1.45 pd=10.29 as=1.45 ps=10.29 w=10 l=0.9
X457 quiet a_n8609_14110# a_n8639_n20509# vss sky130_fd_pr__nfet_05v0_nvt ad=1.45 pd=10.29 as=1.45 ps=10.29 w=10 l=0.9
X458 a_n8609_14110# a_n8609_2082# w_n8809_8685# w_n8809_8685# sky130_fd_pr__pfet_g5v0d10v5 ad=0.2175 pd=1.79 as=0.2175 ps=1.79 w=1.5 l=4
X459 w_n8809_8685# a_n8609_2082# a_n8609_2082# w_n8809_8685# sky130_fd_pr__pfet_g5v0d10v5 ad=0.2175 pd=1.79 as=0.2175 ps=1.79 w=1.5 l=4
X460 a_n8609_14110# a_n8609_2082# w_n8809_8685# w_n8809_8685# sky130_fd_pr__pfet_g5v0d10v5 ad=0.2175 pd=1.79 as=0.2175 ps=1.79 w=1.5 l=4
X461 a_n8609_14110# a_n8609_2082# w_n8809_8685# w_n8809_8685# sky130_fd_pr__pfet_g5v0d10v5 ad=0.2175 pd=1.79 as=0.2175 ps=1.79 w=1.5 l=4
X462 a_n8609_11046# a_n8609_2082# w_n8809_8685# w_n8809_8685# sky130_fd_pr__pfet_g5v0d10v5 ad=0.2175 pd=1.79 as=0.2175 ps=1.79 w=1.5 l=4
X463 a_n8639_n20509# a_n8581_n15597# vin vss sky130_fd_pr__nfet_05v0_nvt ad=1.45 pd=10.29 as=1.45 ps=10.29 w=10 l=0.9
X464 w_n8809_8685# a_n8609_2082# a_n8609_14110# w_n8809_8685# sky130_fd_pr__pfet_g5v0d10v5 ad=0.2175 pd=1.79 as=0.435 ps=3.58 w=1.5 l=4
X465 a_n17096_n717# a_n17392_n20595# vss sky130_fd_pr__res_high_po w=1 l=97.39
X466 a_n8609_14110# a_n8609_2082# w_n8809_8685# w_n8809_8685# sky130_fd_pr__pfet_g5v0d10v5 ad=0.2175 pd=1.79 as=0.2175 ps=1.79 w=1.5 l=4
X467 vss a_n8609_4082# a_n8609_6082# vss sky130_fd_pr__nfet_g5v0d10v5 ad=0.145 pd=1.29 as=0.145 ps=1.29 w=1 l=4
X468 a_n8609_2082# a_n15687_2040# vss vss sky130_fd_pr__nfet_g5v0d10v5 ad=0.145 pd=1.29 as=0.145 ps=1.29 w=1 l=4
X469 a_n8609_6082# a_n8609_4082# vss vss sky130_fd_pr__nfet_g5v0d10v5 ad=0.145 pd=1.29 as=0.145 ps=1.29 w=1 l=4
X470 w_n8809_8685# a_n8609_2082# a_n8609_14110# w_n8809_8685# sky130_fd_pr__pfet_g5v0d10v5 ad=0.2175 pd=1.79 as=0.2175 ps=1.79 w=1.5 l=4
X471 w_n8809_8685# vss sky130_fd_pr__cap_mim_m3_1 l=22.2 w=22.2
X472 w_n8809_8685# a_n8609_2082# a_n8609_14110# w_n8809_8685# sky130_fd_pr__pfet_g5v0d10v5 ad=0.2175 pd=1.79 as=0.2175 ps=1.79 w=1.5 l=4
X473 a_n8639_n20509# a_n8609_14110# quiet vss sky130_fd_pr__nfet_05v0_nvt ad=1.45 pd=10.29 as=1.45 ps=10.29 w=10 l=0.9
X474 a_n8609_14110# a_n8609_2082# w_n8809_8685# w_n8809_8685# sky130_fd_pr__pfet_g5v0d10v5 ad=0.2175 pd=1.79 as=0.2175 ps=1.79 w=1.5 l=4
X475 w_n8809_8685# a_n8609_2082# a_n8609_14110# w_n8809_8685# sky130_fd_pr__pfet_g5v0d10v5 ad=0.2175 pd=1.79 as=0.2175 ps=1.79 w=1.5 l=4
X476 a_n8609_2082# a_n15687_2040# vss vss sky130_fd_pr__nfet_g5v0d10v5 ad=0.145 pd=1.29 as=0.145 ps=1.29 w=1 l=4
X477 a_n8609_11046# a_n8609_2082# w_n8809_8685# w_n8809_8685# sky130_fd_pr__pfet_g5v0d10v5 ad=0.2175 pd=1.79 as=0.2175 ps=1.79 w=1.5 l=4
X478 a_n8581_n15597# vss sky130_fd_pr__cap_mim_m3_1 l=22.2 w=22.2
X479 w_n8809_8685# vss sky130_fd_pr__cap_mim_m3_1 l=22.2 w=22.2
X480 a_n8639_n20509# a_n8609_14110# quiet vss sky130_fd_pr__nfet_05v0_nvt ad=1.45 pd=10.29 as=1.45 ps=10.29 w=10 l=0.9
X481 a_n8609_2082# a_n8609_2082# w_n8809_8685# w_n8809_8685# sky130_fd_pr__pfet_g5v0d10v5 ad=0.2175 pd=1.79 as=0.2175 ps=1.79 w=1.5 l=4
X482 a_n15687_2040# a_n15687_2040# vss vss sky130_fd_pr__nfet_g5v0d10v5 ad=0.145 pd=1.29 as=0.145 ps=1.29 w=1 l=4
X483 a_n23608_n717# a_n23904_n20595# vss sky130_fd_pr__res_high_po w=1 l=97.39
X484 vss a_n8609_4082# a_n8609_4082# vss sky130_fd_pr__nfet_g5v0d10v5 ad=0.145 pd=1.29 as=0.145 ps=1.29 w=1 l=4
X485 w_n8809_8685# a_n8609_2082# a_n8609_11046# w_n8809_8685# sky130_fd_pr__pfet_g5v0d10v5 ad=0.2175 pd=1.79 as=0.2175 ps=1.79 w=1.5 l=4
X486 quiet a_n8609_14110# a_n8639_n20509# vss sky130_fd_pr__nfet_05v0_nvt ad=1.45 pd=10.29 as=1.45 ps=10.29 w=10 l=0.9
X487 a_n8609_2082# a_n8609_2082# w_n8809_8685# w_n8809_8685# sky130_fd_pr__pfet_g5v0d10v5 ad=0.2175 pd=1.79 as=0.2175 ps=1.79 w=1.5 l=4
X488 vss a_n15687_2040# a_n8609_2082# vss sky130_fd_pr__nfet_g5v0d10v5 ad=0.145 pd=1.29 as=0.145 ps=1.29 w=1 l=4
X489 a_n8639_n20509# a_n8581_n15597# vin vss sky130_fd_pr__nfet_05v0_nvt ad=1.45 pd=10.29 as=1.45 ps=10.29 w=10 l=0.9
X490 vss a_n15687_2040# a_n15687_2040# vss sky130_fd_pr__nfet_g5v0d10v5 ad=0.145 pd=1.29 as=0.145 ps=1.29 w=1 l=4
X491 vin a_n8581_n15597# a_n8639_n20509# vss sky130_fd_pr__nfet_05v0_nvt ad=1.45 pd=10.29 as=1.45 ps=10.29 w=10 l=0.9
X492 a_n8609_14110# a_n8609_2082# w_n8809_8685# w_n8809_8685# sky130_fd_pr__pfet_g5v0d10v5 ad=0.2175 pd=1.79 as=0.2175 ps=1.79 w=1.5 l=4
X493 a_n24200_n717# a_n24496_n20595# vss sky130_fd_pr__res_high_po w=1 l=97.39
X494 vin a_n8581_n15597# a_n8639_n20509# vss sky130_fd_pr__nfet_05v0_nvt ad=1.45 pd=10.29 as=1.45 ps=10.29 w=10 l=0.9
X495 w_n8809_8685# a_n8609_2082# a_n8609_14110# w_n8809_8685# sky130_fd_pr__pfet_g5v0d10v5 ad=0.2175 pd=1.79 as=0.2175 ps=1.79 w=1.5 l=4
X496 a_n8609_14110# a_n8609_2082# w_n8809_8685# w_n8809_8685# sky130_fd_pr__pfet_g5v0d10v5 ad=0.2175 pd=1.79 as=0.2175 ps=1.79 w=1.5 l=4
X497 a_n8639_n20509# a_n8609_14110# quiet vss sky130_fd_pr__nfet_05v0_nvt ad=1.45 pd=10.29 as=1.45 ps=10.29 w=10 l=0.9
X498 quiet a_n8609_14110# a_n8639_n20509# vss sky130_fd_pr__nfet_05v0_nvt ad=1.45 pd=10.29 as=1.45 ps=10.29 w=10 l=0.9
X499 w_n8809_8685# a_n8609_2082# a_n8609_14110# w_n8809_8685# sky130_fd_pr__pfet_g5v0d10v5 ad=0.2175 pd=1.79 as=0.435 ps=3.58 w=1.5 l=4
X500 a_n8609_14110# a_n8609_2082# w_n8809_8685# w_n8809_8685# sky130_fd_pr__pfet_g5v0d10v5 ad=0.2175 pd=1.79 as=0.2175 ps=1.79 w=1.5 l=4
X501 a_n8581_n15597# vss sky130_fd_pr__cap_mim_m3_1 l=22.2 w=22.2
X502 a_n8609_11046# a_n8609_2082# w_n8809_8685# w_n8809_8685# sky130_fd_pr__pfet_g5v0d10v5 ad=0.2175 pd=1.79 as=0.2175 ps=1.79 w=1.5 l=4
X503 a_n8609_11046# a_n8609_2082# w_n8809_8685# w_n8809_8685# sky130_fd_pr__pfet_g5v0d10v5 ad=0.2175 pd=1.79 as=0.2175 ps=1.79 w=1.5 l=4
X504 w_n8809_8685# a_n8609_2082# a_n8609_2082# w_n8809_8685# sky130_fd_pr__pfet_g5v0d10v5 ad=0.2175 pd=1.79 as=0.2175 ps=1.79 w=1.5 l=4
X505 quiet a_n8609_14110# a_n8639_n20509# vss sky130_fd_pr__nfet_05v0_nvt ad=1.45 pd=10.29 as=1.45 ps=10.29 w=10 l=0.9
X506 a_n8639_n20509# a_n8581_n15597# vin vss sky130_fd_pr__nfet_05v0_nvt ad=1.45 pd=10.29 as=1.45 ps=10.29 w=10 l=0.9
X507 vin a_n8581_n15597# a_n8639_n20509# vss sky130_fd_pr__nfet_05v0_nvt ad=1.45 pd=10.29 as=1.45 ps=10.29 w=10 l=0.9
X508 a_n8609_2082# a_n15687_2040# vss vss sky130_fd_pr__nfet_g5v0d10v5 ad=0.145 pd=1.29 as=0.145 ps=1.29 w=1 l=4
X509 a_n8609_14110# a_n8609_2082# w_n8809_8685# w_n8809_8685# sky130_fd_pr__pfet_g5v0d10v5 ad=0.2175 pd=1.79 as=0.2175 ps=1.79 w=1.5 l=4
X510 w_n8809_8685# a_n8609_2082# a_n8609_14110# w_n8809_8685# sky130_fd_pr__pfet_g5v0d10v5 ad=0.2175 pd=1.79 as=0.2175 ps=1.79 w=1.5 l=4
X511 vss a_n15687_2040# a_n8609_2082# vss sky130_fd_pr__nfet_g5v0d10v5 ad=0.145 pd=1.29 as=0.145 ps=1.29 w=1 l=4
X512 a_n8639_n20509# a_n8609_14110# quiet vss sky130_fd_pr__nfet_05v0_nvt ad=2.9 pd=20.58 as=1.45 ps=10.29 w=10 l=0.9
X513 a_n8609_14110# a_n8609_2082# w_n8809_8685# w_n8809_8685# sky130_fd_pr__pfet_g5v0d10v5 ad=0.2175 pd=1.79 as=0.2175 ps=1.79 w=1.5 l=4
X514 a_n20648_n717# a_n20944_n20595# vss sky130_fd_pr__res_high_po w=1 l=97.39
X515 quiet a_n8609_14110# a_n8639_n20509# vss sky130_fd_pr__nfet_05v0_nvt ad=1.45 pd=10.29 as=1.45 ps=10.29 w=10 l=0.9
X516 a_n24073_2440# vss sky130_fd_pr__cap_mim_m3_1 l=22.2 w=22.2
X517 a_n8639_n20509# a_n8581_n15597# vin vss sky130_fd_pr__nfet_05v0_nvt ad=1.45 pd=10.29 as=1.45 ps=10.29 w=10 l=0.9
X518 a_n8609_6082# a_n8609_4082# vss vss sky130_fd_pr__nfet_g5v0d10v5 ad=0.145 pd=1.29 as=0.145 ps=1.29 w=1 l=4
X519 a_47252_n2559# a_46956_n18673# vss sky130_fd_pr__res_high_po w=1 l=78.57
X520 vss a_n15687_2040# a_n8609_2082# vss sky130_fd_pr__nfet_g5v0d10v5 ad=0.145 pd=1.29 as=0.145 ps=1.29 w=1 l=4
X521 a_n8609_14110# a_n8609_2082# w_n8809_8685# w_n8809_8685# sky130_fd_pr__pfet_g5v0d10v5 ad=0.435 pd=3.58 as=0.2175 ps=1.79 w=1.5 l=4
X522 a_n8609_2082# a_n8609_2082# w_n8809_8685# w_n8809_8685# sky130_fd_pr__pfet_g5v0d10v5 ad=0.2175 pd=1.79 as=0.2175 ps=1.79 w=1.5 l=4
X523 vss a_n8609_4082# a_n8609_6082# vss sky130_fd_pr__nfet_g5v0d10v5 ad=0.145 pd=1.29 as=0.145 ps=1.29 w=1 l=4
X524 a_n8609_2082# a_n15687_2040# vss vss sky130_fd_pr__nfet_g5v0d10v5 ad=0.29 pd=2.58 as=0.145 ps=1.29 w=1 l=4
X525 w_n8809_8685# vss sky130_fd_pr__cap_mim_m3_1 l=22.2 w=22.2
X526 a_n8639_n20509# a_n8609_14110# quiet vss sky130_fd_pr__nfet_05v0_nvt ad=2.9 pd=20.58 as=1.45 ps=10.29 w=10 l=0.9
X527 a_n24073_2440# vss sky130_fd_pr__cap_mim_m3_1 l=22.2 w=22.2
X528 a_n8639_n20509# a_n8609_14110# quiet vss sky130_fd_pr__nfet_05v0_nvt ad=1.45 pd=10.29 as=1.45 ps=10.29 w=10 l=0.9
X529 w_n8809_8685# a_n8609_2082# a_n8609_14110# w_n8809_8685# sky130_fd_pr__pfet_g5v0d10v5 ad=0.2175 pd=1.79 as=0.2175 ps=1.79 w=1.5 l=4
X530 a_n19021_6140# t5 a_n16821_6140# vss sky130_fd_pr__nfet_01v8 ad=0.825 pd=5.33 as=0.825 ps=5.33 w=5 l=0.15
X531 a_n8609_14110# a_n8609_2082# w_n8809_8685# w_n8809_8685# sky130_fd_pr__pfet_g5v0d10v5 ad=0.2175 pd=1.79 as=0.2175 ps=1.79 w=1.5 l=4
X532 a_n23421_6140# t2 a_n25621_6140# vss sky130_fd_pr__nfet_01v8 ad=0.825 pd=5.33 as=0.825 ps=5.33 w=5 l=0.15
X533 a_n8639_n20509# a_n8581_n15597# vin vss sky130_fd_pr__nfet_05v0_nvt ad=1.45 pd=10.29 as=1.45 ps=10.29 w=10 l=0.9
X534 a_n8609_14110# a_n8609_2082# w_n8809_8685# w_n8809_8685# sky130_fd_pr__pfet_g5v0d10v5 ad=0.2175 pd=1.79 as=0.2175 ps=1.79 w=1.5 l=4
X535 w_n8809_8685# a_n8609_2082# a_n8609_14110# w_n8809_8685# sky130_fd_pr__pfet_g5v0d10v5 ad=0.2175 pd=1.79 as=0.2175 ps=1.79 w=1.5 l=4
X536 w_n8809_8685# a_n8609_2082# a_n8609_2082# w_n8809_8685# sky130_fd_pr__pfet_g5v0d10v5 ad=0.2175 pd=1.79 as=0.2175 ps=1.79 w=1.5 l=4
X537 vss a_n15687_2040# a_n15687_2040# vss sky130_fd_pr__nfet_g5v0d10v5 ad=0.145 pd=1.29 as=0.145 ps=1.29 w=1 l=4
X538 a_n8639_n20509# a_n8581_n15597# vin vss sky130_fd_pr__nfet_05v0_nvt ad=1.45 pd=10.29 as=1.45 ps=10.29 w=10 l=0.9
X539 a_n8609_11046# a_n8609_2082# w_n8809_8685# w_n8809_8685# sky130_fd_pr__pfet_g5v0d10v5 ad=0.2175 pd=1.79 as=0.2175 ps=1.79 w=1.5 l=4
X540 vss a_n15687_2040# a_n15687_2040# vss sky130_fd_pr__nfet_g5v0d10v5 ad=0.145 pd=1.29 as=0.145 ps=1.29 w=1 l=4
X541 vss a_n15687_2040# a_n15687_2040# vss sky130_fd_pr__nfet_g5v0d10v5 ad=0.145 pd=1.29 as=0.145 ps=1.29 w=1 l=4
X542 vin a_n8581_n15597# a_n8639_n20509# vss sky130_fd_pr__nfet_05v0_nvt ad=1.45 pd=10.29 as=1.45 ps=10.29 w=10 l=0.9
X543 w_n8809_8685# a_n8609_2082# a_n8609_14110# w_n8809_8685# sky130_fd_pr__pfet_g5v0d10v5 ad=0.2175 pd=1.79 as=0.2175 ps=1.79 w=1.5 l=4
X544 quiet a_n8609_14110# a_n8639_n20509# vss sky130_fd_pr__nfet_05v0_nvt ad=1.45 pd=10.29 as=1.45 ps=10.29 w=10 l=0.9
X545 vin a_n8581_n15597# a_n8639_n20509# vss sky130_fd_pr__nfet_05v0_nvt ad=1.45 pd=10.29 as=1.45 ps=10.29 w=10 l=0.9
X546 a_n8639_n20509# a_n8581_n15597# vin vss sky130_fd_pr__nfet_05v0_nvt ad=1.45 pd=10.29 as=1.45 ps=10.29 w=10 l=0.9
X547 a_n8639_n20509# a_n8609_14110# quiet vss sky130_fd_pr__nfet_05v0_nvt ad=1.45 pd=10.29 as=1.45 ps=10.29 w=10 l=0.9
X548 a_n8639_n20509# a_n8581_n15597# vin vss sky130_fd_pr__nfet_05v0_nvt ad=1.45 pd=10.29 as=1.45 ps=10.29 w=10 l=0.9
X549 a_n8609_6082# a_n8609_4082# vss vss sky130_fd_pr__nfet_g5v0d10v5 ad=0.145 pd=1.29 as=0.145 ps=1.29 w=1 l=4
X550 vss a_n8609_4082# a_n8609_4082# vss sky130_fd_pr__nfet_g5v0d10v5 ad=0.145 pd=1.29 as=0.145 ps=1.29 w=1 l=4
X551 a_n8609_14110# a_n8609_2082# w_n8809_8685# w_n8809_8685# sky130_fd_pr__pfet_g5v0d10v5 ad=0.2175 pd=1.79 as=0.2175 ps=1.79 w=1.5 l=4
X552 vin a_n8581_n15597# a_n8639_n20509# vss sky130_fd_pr__nfet_05v0_nvt ad=1.45 pd=10.29 as=1.45 ps=10.29 w=10 l=0.9
X553 vin a_n8581_n15597# a_n8639_n20509# vss sky130_fd_pr__nfet_05v0_nvt ad=1.45 pd=10.29 as=1.45 ps=10.29 w=10 l=0.9
X554 w_n8809_8685# a_n8609_2082# a_n8609_2082# w_n8809_8685# sky130_fd_pr__pfet_g5v0d10v5 ad=0.2175 pd=1.79 as=0.2175 ps=1.79 w=1.5 l=4
X555 a_n8609_4082# a_n8609_4082# vss vss sky130_fd_pr__nfet_g5v0d10v5 ad=0.145 pd=1.29 as=0.145 ps=1.29 w=1 l=4
X556 a_n19464_n717# a_n19760_n20595# vss sky130_fd_pr__res_high_po w=1 l=97.39
X557 a_n8609_14110# a_n8609_2082# w_n8809_8685# w_n8809_8685# sky130_fd_pr__pfet_g5v0d10v5 ad=0.2175 pd=1.79 as=0.2175 ps=1.79 w=1.5 l=4
X558 a_n8609_11046# a_n8609_2082# w_n8809_8685# w_n8809_8685# sky130_fd_pr__pfet_g5v0d10v5 ad=0.2175 pd=1.79 as=0.2175 ps=1.79 w=1.5 l=4
X559 w_n8809_8685# a_n8609_2082# a_n8609_11046# w_n8809_8685# sky130_fd_pr__pfet_g5v0d10v5 ad=0.2175 pd=1.79 as=0.2175 ps=1.79 w=1.5 l=4
X560 vin a_n8581_n15597# a_n8639_n20509# vss sky130_fd_pr__nfet_05v0_nvt ad=1.45 pd=10.29 as=1.45 ps=10.29 w=10 l=0.9
X561 vin a_n8581_n15597# a_n8639_n20509# vss sky130_fd_pr__nfet_05v0_nvt ad=1.45 pd=10.29 as=1.45 ps=10.29 w=10 l=0.9
X562 a_n16504_n717# a_n16208_n20595# vss sky130_fd_pr__res_high_po w=1 l=97.39
X563 quiet a_n8609_14110# a_n8639_n20509# vss sky130_fd_pr__nfet_05v0_nvt ad=1.45 pd=10.29 as=1.45 ps=10.29 w=10 l=0.9
X564 a_n8609_6082# a_n8609_4082# vss vss sky130_fd_pr__nfet_g5v0d10v5 ad=0.29 pd=2.58 as=0.145 ps=1.29 w=1 l=4
X565 w_n8809_8685# a_n8609_2082# a_n8609_14110# w_n8809_8685# sky130_fd_pr__pfet_g5v0d10v5 ad=0.2175 pd=1.79 as=0.2175 ps=1.79 w=1.5 l=4
X566 a_n8609_11046# a_n8609_2082# w_n8809_8685# w_n8809_8685# sky130_fd_pr__pfet_g5v0d10v5 ad=0.435 pd=3.58 as=0.2175 ps=1.79 w=1.5 l=4
X567 a_n21221_6140# t3 a_n23421_6140# vss sky130_fd_pr__nfet_01v8 ad=1.55 pd=10.62 as=0.825 ps=5.33 w=5 l=0.15
X568 w_n8809_8685# a_n8609_2082# a_n8609_14110# w_n8809_8685# sky130_fd_pr__pfet_g5v0d10v5 ad=0.2175 pd=1.79 as=0.2175 ps=1.79 w=1.5 l=4
X569 a_n8609_14110# a_n8609_2082# w_n8809_8685# w_n8809_8685# sky130_fd_pr__pfet_g5v0d10v5 ad=0.2175 pd=1.79 as=0.2175 ps=1.79 w=1.5 l=4
X570 vss a_n15687_2040# a_n8609_2082# vss sky130_fd_pr__nfet_g5v0d10v5 ad=0.145 pd=1.29 as=0.145 ps=1.29 w=1 l=4
X571 w_n8809_8685# vss sky130_fd_pr__cap_mim_m3_1 l=22.2 w=22.2
X572 a_n25621_6140# t1 a_n27821_6140# vss sky130_fd_pr__nfet_01v8 ad=1.55 pd=10.62 as=0.825 ps=5.33 w=5 l=0.15
X573 a_n24073_2440# a_n16208_n20595# vss sky130_fd_pr__res_high_po w=1 l=97.39
X574 w_n8809_8685# vss sky130_fd_pr__cap_mim_m3_1 l=22.2 w=22.2
X575 a_n8639_n20509# a_n8581_n15597# vin vss sky130_fd_pr__nfet_05v0_nvt ad=1.45 pd=10.29 as=1.45 ps=10.29 w=10 l=0.9
X576 a_n8609_11046# a_n8609_2082# w_n8809_8685# w_n8809_8685# sky130_fd_pr__pfet_g5v0d10v5 ad=0.2175 pd=1.79 as=0.2175 ps=1.79 w=1.5 l=4
X577 vin a_n8581_n15597# a_n8639_n20509# vss sky130_fd_pr__nfet_05v0_nvt ad=1.45 pd=10.29 as=1.45 ps=10.29 w=10 l=0.9
X578 a_n8639_n20509# a_n8581_n15597# vin vss sky130_fd_pr__nfet_05v0_nvt ad=1.45 pd=10.29 as=1.45 ps=10.29 w=10 l=0.9
X579 a_4700_n3568# a_n8609_14110# sky130_fd_pr__cap_mim_m3_1 l=22.2 w=22.2
X580 vin a_n8581_n15597# a_n8639_n20509# vss sky130_fd_pr__nfet_05v0_nvt ad=1.45 pd=10.29 as=1.45 ps=10.29 w=10 l=0.9
X581 a_n8609_14110# a_n8609_2082# w_n8809_8685# w_n8809_8685# sky130_fd_pr__pfet_g5v0d10v5 ad=0.2175 pd=1.79 as=0.2175 ps=1.79 w=1.5 l=4
X582 a_n8639_n20509# a_n8581_n15597# vin vss sky130_fd_pr__nfet_05v0_nvt ad=1.45 pd=10.29 as=1.45 ps=10.29 w=10 l=0.9
X583 w_n8809_8685# a_n8609_2082# a_n8609_14110# w_n8809_8685# sky130_fd_pr__pfet_g5v0d10v5 ad=0.2175 pd=1.79 as=0.2175 ps=1.79 w=1.5 l=4
X584 a_n8609_14110# a_n8609_2082# w_n8809_8685# w_n8809_8685# sky130_fd_pr__pfet_g5v0d10v5 ad=0.2175 pd=1.79 as=0.2175 ps=1.79 w=1.5 l=4
X585 a_n8639_n20509# a_n8581_n15597# vin vss sky130_fd_pr__nfet_05v0_nvt ad=1.45 pd=10.29 as=1.45 ps=10.29 w=10 l=0.9
X586 a_n8609_11046# a_n8609_2082# w_n8809_8685# w_n8809_8685# sky130_fd_pr__pfet_g5v0d10v5 ad=0.2175 pd=1.79 as=0.2175 ps=1.79 w=1.5 l=4
X587 vin a_n8581_n15597# a_n8639_n20509# vss sky130_fd_pr__nfet_05v0_nvt ad=1.45 pd=10.29 as=1.45 ps=10.29 w=10 l=0.9
X588 a_n8609_6082# a_n8609_4082# vss vss sky130_fd_pr__nfet_g5v0d10v5 ad=0.145 pd=1.29 as=0.145 ps=1.29 w=1 l=4
X589 a_n8639_n20509# a_n8581_n15597# vin vss sky130_fd_pr__nfet_05v0_nvt ad=1.45 pd=10.29 as=1.45 ps=10.29 w=10 l=0.9
X590 a_n8639_n20509# a_n8581_n15597# vin vss sky130_fd_pr__nfet_05v0_nvt ad=1.45 pd=10.29 as=1.45 ps=10.29 w=10 l=0.9
X591 a_n8609_4082# a_n8609_4082# vss vss sky130_fd_pr__nfet_g5v0d10v5 ad=0.145 pd=1.29 as=0.145 ps=1.29 w=1 l=4
X592 vss a_n15687_2040# a_n15687_2040# vss sky130_fd_pr__nfet_g5v0d10v5 ad=0.145 pd=1.29 as=0.145 ps=1.29 w=1 l=4
X593 vin a_n8581_n15597# a_n8639_n20509# vss sky130_fd_pr__nfet_05v0_nvt ad=1.45 pd=10.29 as=1.45 ps=10.29 w=10 l=0.9
X594 w_n8809_8685# a_n8609_2082# a_n8609_11046# w_n8809_8685# sky130_fd_pr__pfet_g5v0d10v5 ad=0.2175 pd=1.79 as=0.2175 ps=1.79 w=1.5 l=4
X595 a_n8609_14110# a_n8609_2082# w_n8809_8685# w_n8809_8685# sky130_fd_pr__pfet_g5v0d10v5 ad=0.2175 pd=1.79 as=0.2175 ps=1.79 w=1.5 l=4
X596 vss a_n8609_4082# a_n8609_4082# vss sky130_fd_pr__nfet_g5v0d10v5 ad=0.145 pd=1.29 as=0.145 ps=1.29 w=1 l=4
X597 quiet a_n8609_14110# a_n8639_n20509# vss sky130_fd_pr__nfet_05v0_nvt ad=1.45 pd=10.29 as=1.45 ps=10.29 w=10 l=0.9
X598 vin a_n8581_n15597# a_n8639_n20509# vss sky130_fd_pr__nfet_05v0_nvt ad=1.45 pd=10.29 as=1.45 ps=10.29 w=10 l=0.9
X599 vss a_n8609_4082# a_n8609_6082# vss sky130_fd_pr__nfet_g5v0d10v5 ad=0.145 pd=1.29 as=0.145 ps=1.29 w=1 l=4
X600 a_n8609_14110# a_n8609_2082# w_n8809_8685# w_n8809_8685# sky130_fd_pr__pfet_g5v0d10v5 ad=0.2175 pd=1.79 as=0.2175 ps=1.79 w=1.5 l=4
X601 a_n8609_11046# a_n8609_2082# w_n8809_8685# w_n8809_8685# sky130_fd_pr__pfet_g5v0d10v5 ad=0.2175 pd=1.79 as=0.2175 ps=1.79 w=1.5 l=4
X602 a_n8639_n20509# a_n8581_n15597# vin vss sky130_fd_pr__nfet_05v0_nvt ad=1.45 pd=10.29 as=1.45 ps=10.29 w=10 l=0.9
X603 vin a_n8581_n15597# a_n8639_n20509# vss sky130_fd_pr__nfet_05v0_nvt ad=1.45 pd=10.29 as=1.45 ps=10.29 w=10 l=0.9
X604 a_n8609_14110# a_n8609_2082# w_n8809_8685# w_n8809_8685# sky130_fd_pr__pfet_g5v0d10v5 ad=0.2175 pd=1.79 as=0.2175 ps=1.79 w=1.5 l=4
X605 w_n8809_8685# a_n8609_2082# a_n8609_14110# w_n8809_8685# sky130_fd_pr__pfet_g5v0d10v5 ad=0.2175 pd=1.79 as=0.2175 ps=1.79 w=1.5 l=4
X606 a_n8609_14110# a_n8609_2082# w_n8809_8685# w_n8809_8685# sky130_fd_pr__pfet_g5v0d10v5 ad=0.435 pd=3.58 as=0.2175 ps=1.79 w=1.5 l=4
X607 vss a_n8609_4082# a_n8609_6082# vss sky130_fd_pr__nfet_g5v0d10v5 ad=0.145 pd=1.29 as=0.145 ps=1.29 w=1 l=4
X608 w_n8809_8685# vss sky130_fd_pr__cap_mim_m3_1 l=22.2 w=22.2
X609 w_n8809_8685# a_n8609_2082# a_n8609_14110# w_n8809_8685# sky130_fd_pr__pfet_g5v0d10v5 ad=0.2175 pd=1.79 as=0.2175 ps=1.79 w=1.5 l=4
X610 host vgi a_n15687_2040# host sky130_fd_pr__pfet_01v8_lvt ad=1.74 pd=12.58 as=0.87 ps=6.29 w=6 l=4
X611 quiet a_n8609_14110# a_n8639_n20509# vss sky130_fd_pr__nfet_05v0_nvt ad=1.45 pd=10.29 as=1.45 ps=10.29 w=10 l=0.9
X612 a_n8639_n20509# a_n8581_n15597# vin vss sky130_fd_pr__nfet_05v0_nvt ad=1.45 pd=10.29 as=1.45 ps=10.29 w=10 l=0.9
X613 a_n8609_14110# a_n8609_2082# w_n8809_8685# w_n8809_8685# sky130_fd_pr__pfet_g5v0d10v5 ad=0.2175 pd=1.79 as=0.2175 ps=1.79 w=1.5 l=4
X614 a_n8609_11046# a_n8609_2082# w_n8809_8685# w_n8809_8685# sky130_fd_pr__pfet_g5v0d10v5 ad=0.2175 pd=1.79 as=0.2175 ps=1.79 w=1.5 l=4
X615 w_n8809_8685# a_n8609_2082# a_n8609_11046# w_n8809_8685# sky130_fd_pr__pfet_g5v0d10v5 ad=0.2175 pd=1.79 as=0.2175 ps=1.79 w=1.5 l=4
X616 w_n8809_8685# a_n8609_2082# a_n8609_14110# w_n8809_8685# sky130_fd_pr__pfet_g5v0d10v5 ad=0.2175 pd=1.79 as=0.2175 ps=1.79 w=1.5 l=4
X617 a_n8609_6082# a_n8609_4082# vss vss sky130_fd_pr__nfet_g5v0d10v5 ad=0.145 pd=1.29 as=0.145 ps=1.29 w=1 l=4
X618 vin a_n8581_n15597# a_n8639_n20509# vss sky130_fd_pr__nfet_05v0_nvt ad=1.45 pd=10.29 as=1.45 ps=10.29 w=10 l=0.9
X619 a_n8639_n20509# a_n8581_n15597# vin vss sky130_fd_pr__nfet_05v0_nvt ad=1.45 pd=10.29 as=1.45 ps=10.29 w=10 l=0.9
X620 w_n8809_8685# a_n8609_2082# a_n8609_14110# w_n8809_8685# sky130_fd_pr__pfet_g5v0d10v5 ad=0.2175 pd=1.79 as=0.2175 ps=1.79 w=1.5 l=4
X621 a_n8609_4082# a_n8609_4082# vss vss sky130_fd_pr__nfet_g5v0d10v5 ad=0.145 pd=1.29 as=0.145 ps=1.29 w=1 l=4
X622 vss a_n15687_2040# a_n8609_2082# vss sky130_fd_pr__nfet_g5v0d10v5 ad=0.145 pd=1.29 as=0.145 ps=1.29 w=1 l=4
X623 a_n8609_2082# a_n15687_2040# vss vss sky130_fd_pr__nfet_g5v0d10v5 ad=0.145 pd=1.29 as=0.145 ps=1.29 w=1 l=4
X624 a_n8639_n20509# a_n8581_n15597# vin vss sky130_fd_pr__nfet_05v0_nvt ad=1.45 pd=10.29 as=1.45 ps=10.29 w=10 l=0.9
X625 vin a_n8581_n15597# a_n8639_n20509# vss sky130_fd_pr__nfet_05v0_nvt ad=1.45 pd=10.29 as=1.45 ps=10.29 w=10 l=0.9
X626 a_n8639_n20509# a_n8581_n15597# vin vss sky130_fd_pr__nfet_05v0_nvt ad=1.45 pd=10.29 as=1.45 ps=10.29 w=10 l=0.9
X627 a_n8609_14110# a_n8609_2082# w_n8809_8685# w_n8809_8685# sky130_fd_pr__pfet_g5v0d10v5 ad=0.2175 pd=1.79 as=0.2175 ps=1.79 w=1.5 l=4
X628 a_n15687_2040# a_n15687_2040# vss vss sky130_fd_pr__nfet_g5v0d10v5 ad=0.145 pd=1.29 as=0.145 ps=1.29 w=1 l=4
X629 a_n8581_n15597# vss sky130_fd_pr__cap_mim_m3_1 l=22.2 w=22.2
X630 a_n8639_n20509# a_n8581_n15597# vin vss sky130_fd_pr__nfet_05v0_nvt ad=1.45 pd=10.29 as=1.45 ps=10.29 w=10 l=0.9
X631 a_n8639_n20509# a_n8581_n15597# vin vss sky130_fd_pr__nfet_05v0_nvt ad=1.45 pd=10.29 as=1.45 ps=10.29 w=10 l=0.9
X632 a_n8609_14110# a_n8609_2082# w_n8809_8685# w_n8809_8685# sky130_fd_pr__pfet_g5v0d10v5 ad=0.2175 pd=1.79 as=0.2175 ps=1.79 w=1.5 l=4
X633 a_n8609_14110# a_n8609_2082# w_n8809_8685# w_n8809_8685# sky130_fd_pr__pfet_g5v0d10v5 ad=0.2175 pd=1.79 as=0.2175 ps=1.79 w=1.5 l=4
X634 a_n8609_4082# a_n8609_4082# vss vss sky130_fd_pr__nfet_g5v0d10v5 ad=0.29 pd=2.58 as=0.145 ps=1.29 w=1 l=4
X635 vss a_n15687_2040# a_n15687_2040# vss sky130_fd_pr__nfet_g5v0d10v5 ad=0.145 pd=1.29 as=0.145 ps=1.29 w=1 l=4
X636 a_n8639_n20509# a_n8581_n15597# vin vss sky130_fd_pr__nfet_05v0_nvt ad=1.45 pd=10.29 as=1.45 ps=10.29 w=10 l=0.9
X637 a_n8609_11046# a_n8609_2082# w_n8809_8685# w_n8809_8685# sky130_fd_pr__pfet_g5v0d10v5 ad=0.2175 pd=1.79 as=0.2175 ps=1.79 w=1.5 l=4
X638 a_n8609_11046# a_n8609_2082# w_n8809_8685# w_n8809_8685# sky130_fd_pr__pfet_g5v0d10v5 ad=0.2175 pd=1.79 as=0.2175 ps=1.79 w=1.5 l=4
X639 vss a_n25673_2540# a_n8609_14110# vss sky130_fd_pr__nfet_g5v0d10v5 ad=2.9 pd=20.58 as=2.9 ps=20.58 w=10 l=0.5
X640 w_n8809_8685# a_n8609_2082# a_n8609_14110# w_n8809_8685# sky130_fd_pr__pfet_g5v0d10v5 ad=0.2175 pd=1.79 as=0.2175 ps=1.79 w=1.5 l=4
X641 a_n8609_14110# a_n8609_2082# w_n8809_8685# w_n8809_8685# sky130_fd_pr__pfet_g5v0d10v5 ad=0.2175 pd=1.79 as=0.2175 ps=1.79 w=1.5 l=4
X642 a_n8639_n20509# a_n8581_n15597# vin vss sky130_fd_pr__nfet_05v0_nvt ad=1.45 pd=10.29 as=1.45 ps=10.29 w=10 l=0.9
X643 w_n8809_8685# a_n8609_2082# a_n8609_14110# w_n8809_8685# sky130_fd_pr__pfet_g5v0d10v5 ad=0.2175 pd=1.79 as=0.2175 ps=1.79 w=1.5 l=4
X644 a_n19021_6140# t4 a_n21221_6140# vss sky130_fd_pr__nfet_01v8 ad=0.825 pd=5.33 as=0.825 ps=5.33 w=5 l=0.15
X645 vin a_n8581_n15597# a_n8639_n20509# vss sky130_fd_pr__nfet_05v0_nvt ad=1.45 pd=10.29 as=1.45 ps=10.29 w=10 l=0.9
X646 w_n8809_8685# a_n8609_2082# a_n8609_14110# w_n8809_8685# sky130_fd_pr__pfet_g5v0d10v5 ad=0.2175 pd=1.79 as=0.435 ps=3.58 w=1.5 l=4
X647 a_n19464_n717# a_n19168_n20595# vss sky130_fd_pr__res_high_po w=1 l=97.39
X648 vin a_n8581_n15597# a_n8639_n20509# vss sky130_fd_pr__nfet_05v0_nvt ad=1.45 pd=10.29 as=1.45 ps=10.29 w=10 l=0.9
X649 a_n8609_14110# a_n8609_2082# w_n8809_8685# w_n8809_8685# sky130_fd_pr__pfet_g5v0d10v5 ad=0.2175 pd=1.79 as=0.2175 ps=1.79 w=1.5 l=4
X650 vss a_n15687_2040# a_n15687_2040# vss sky130_fd_pr__nfet_g5v0d10v5 ad=0.145 pd=1.29 as=0.145 ps=1.29 w=1 l=4
X651 a_n8639_n20509# a_n8581_n15597# vin vss sky130_fd_pr__nfet_05v0_nvt ad=1.45 pd=10.29 as=1.45 ps=10.29 w=10 l=0.9
X652 vss a_n8609_6082# a_n8609_14110# vss sky130_fd_pr__nfet_g5v0d10v5 ad=1.45 pd=10.29 as=1.45 ps=10.29 w=10 l=0.5
X653 a_n8609_14110# a_n8609_2082# w_n8809_8685# w_n8809_8685# sky130_fd_pr__pfet_g5v0d10v5 ad=0.435 pd=3.58 as=0.2175 ps=1.79 w=1.5 l=4
X654 a_n18872_n717# a_n19168_n20595# vss sky130_fd_pr__res_high_po w=1 l=97.39
X655 a_n8609_14110# a_n8609_2082# w_n8809_8685# w_n8809_8685# sky130_fd_pr__pfet_g5v0d10v5 ad=0.2175 pd=1.79 as=0.2175 ps=1.79 w=1.5 l=4
X656 w_n8809_8685# vss sky130_fd_pr__cap_mim_m3_1 l=22.2 w=22.2
X657 a_n8639_n20509# a_n8581_n15597# vin vss sky130_fd_pr__nfet_05v0_nvt ad=1.45 pd=10.29 as=1.45 ps=10.29 w=10 l=0.9
X658 a_n8609_14110# a_n8609_2082# w_n8809_8685# w_n8809_8685# sky130_fd_pr__pfet_g5v0d10v5 ad=0.2175 pd=1.79 as=0.2175 ps=1.79 w=1.5 l=4
X659 w_n8809_8685# a_n8609_2082# a_n8609_14110# w_n8809_8685# sky130_fd_pr__pfet_g5v0d10v5 ad=0.2175 pd=1.79 as=0.2175 ps=1.79 w=1.5 l=4
X660 w_n8809_8685# a_n8609_2082# a_n8609_2082# w_n8809_8685# sky130_fd_pr__pfet_g5v0d10v5 ad=0.2175 pd=1.79 as=0.2175 ps=1.79 w=1.5 l=4
X661 a_n8609_2082# a_n8609_2082# w_n8809_8685# w_n8809_8685# sky130_fd_pr__pfet_g5v0d10v5 ad=0.2175 pd=1.79 as=0.2175 ps=1.79 w=1.5 l=4
X662 vss a_n8609_4082# a_n8609_6082# vss sky130_fd_pr__nfet_g5v0d10v5 ad=0.145 pd=1.29 as=0.145 ps=1.29 w=1 l=4
X663 a_n8609_4082# a_n8609_4082# vss vss sky130_fd_pr__nfet_g5v0d10v5 ad=0.145 pd=1.29 as=0.145 ps=1.29 w=1 l=4
X664 vin a_n8581_n15597# a_n8639_n20509# vss sky130_fd_pr__nfet_05v0_nvt ad=1.45 pd=10.29 as=1.45 ps=10.29 w=10 l=0.9
X665 a_n23421_6140# a_n25621_6140# vss sky130_fd_pr__res_high_po w=1 l=11.43
X666 w_n8809_8685# a_n8609_2082# a_n8609_14110# w_n8809_8685# sky130_fd_pr__pfet_g5v0d10v5 ad=0.2175 pd=1.79 as=0.435 ps=3.58 w=1.5 l=4
X667 a_n8639_n20509# a_n8609_14110# quiet vss sky130_fd_pr__nfet_05v0_nvt ad=1.45 pd=10.29 as=1.45 ps=10.29 w=10 l=0.9
X668 vin a_n8581_n15597# a_n8639_n20509# vss sky130_fd_pr__nfet_05v0_nvt ad=1.45 pd=10.29 as=1.45 ps=10.29 w=10 l=0.9
X669 a_n8609_14110# a_n8609_2082# w_n8809_8685# w_n8809_8685# sky130_fd_pr__pfet_g5v0d10v5 ad=0.2175 pd=1.79 as=0.2175 ps=1.79 w=1.5 l=4
X670 a_n8609_14110# a_n8609_2082# w_n8809_8685# w_n8809_8685# sky130_fd_pr__pfet_g5v0d10v5 ad=0.2175 pd=1.79 as=0.2175 ps=1.79 w=1.5 l=4
X671 a_n8609_2082# a_n15687_2040# vss vss sky130_fd_pr__nfet_g5v0d10v5 ad=0.145 pd=1.29 as=0.145 ps=1.29 w=1 l=4
X672 a_n8609_14110# a_n8609_2082# w_n8809_8685# w_n8809_8685# sky130_fd_pr__pfet_g5v0d10v5 ad=0.2175 pd=1.79 as=0.2175 ps=1.79 w=1.5 l=4
X673 a_n8581_n15597# vss sky130_fd_pr__cap_mim_m3_1 l=22.2 w=22.2
X674 a_n8639_n20509# a_n8609_14110# quiet vss sky130_fd_pr__nfet_05v0_nvt ad=1.45 pd=10.29 as=1.45 ps=10.29 w=10 l=0.9
X675 vin a_n8581_n15597# a_n8639_n20509# vss sky130_fd_pr__nfet_05v0_nvt ad=1.45 pd=10.29 as=1.45 ps=10.29 w=10 l=0.9
X676 a_n8609_11046# a_n8609_2082# w_n8809_8685# w_n8809_8685# sky130_fd_pr__pfet_g5v0d10v5 ad=0.2175 pd=1.79 as=0.2175 ps=1.79 w=1.5 l=4
X677 vss a_n15687_2040# a_n8609_2082# vss sky130_fd_pr__nfet_g5v0d10v5 ad=0.145 pd=1.29 as=0.145 ps=1.29 w=1 l=4
X678 vss a_n8609_4082# a_n8609_4082# vss sky130_fd_pr__nfet_g5v0d10v5 ad=0.145 pd=1.29 as=0.145 ps=1.29 w=1 l=4
X679 a_n8639_n20509# a_n8581_n15597# vin vss sky130_fd_pr__nfet_05v0_nvt ad=1.45 pd=10.29 as=1.45 ps=10.29 w=10 l=0.9
X680 w_n8809_8685# a_n8609_2082# a_n8609_14110# w_n8809_8685# sky130_fd_pr__pfet_g5v0d10v5 ad=0.2175 pd=1.79 as=0.2175 ps=1.79 w=1.5 l=4
X681 vss a_n15687_2040# a_n15687_2040# vss sky130_fd_pr__nfet_g5v0d10v5 ad=0.145 pd=1.29 as=0.145 ps=1.29 w=1 l=4
X682 a_n8639_n20509# a_n8581_n15597# vin vss sky130_fd_pr__nfet_05v0_nvt ad=1.45 pd=10.29 as=1.45 ps=10.29 w=10 l=0.9
X683 vss a_n8609_4082# a_n8609_4082# vss sky130_fd_pr__nfet_g5v0d10v5 ad=0.145 pd=1.29 as=0.145 ps=1.29 w=1 l=4
X684 a_n8639_n20509# a_n8581_n15597# vin vss sky130_fd_pr__nfet_05v0_nvt ad=1.45 pd=10.29 as=1.45 ps=10.29 w=10 l=0.9
X685 a_n8639_n20509# a_n8609_14110# quiet vss sky130_fd_pr__nfet_05v0_nvt ad=1.45 pd=10.29 as=1.45 ps=10.29 w=10 l=0.9
X686 a_n8609_14110# a_n8609_2082# w_n8809_8685# w_n8809_8685# sky130_fd_pr__pfet_g5v0d10v5 ad=0.2175 pd=1.79 as=0.2175 ps=1.79 w=1.5 l=4
X687 a_n8639_n20509# a_n8609_14110# quiet vss sky130_fd_pr__nfet_05v0_nvt ad=1.45 pd=10.29 as=1.45 ps=10.29 w=10 l=0.9
X688 a_n8639_n20509# a_n8581_n15597# vin vss sky130_fd_pr__nfet_05v0_nvt ad=1.45 pd=10.29 as=1.45 ps=10.29 w=10 l=0.9
X689 w_n8809_8685# a_n8609_2082# a_n8609_11046# w_n8809_8685# sky130_fd_pr__pfet_g5v0d10v5 ad=0.2175 pd=1.79 as=0.2175 ps=1.79 w=1.5 l=4
X690 quiet a_n8609_14110# a_n8639_n20509# vss sky130_fd_pr__nfet_05v0_nvt ad=1.45 pd=10.29 as=1.45 ps=10.29 w=10 l=0.9
X691 a_n8609_14110# a_n8609_2082# w_n8809_8685# w_n8809_8685# sky130_fd_pr__pfet_g5v0d10v5 ad=0.2175 pd=1.79 as=0.2175 ps=1.79 w=1.5 l=4
X692 w_n8809_8685# a_n8609_2082# a_n8609_14110# w_n8809_8685# sky130_fd_pr__pfet_g5v0d10v5 ad=0.2175 pd=1.79 as=0.2175 ps=1.79 w=1.5 l=4
X693 w_n8809_8685# vss sky130_fd_pr__cap_mim_m3_1 l=22.2 w=22.2
X694 a_n8581_n15597# vss sky130_fd_pr__cap_mim_m3_1 l=22.2 w=22.2
X695 a_4700_n3568# a_n8609_14110# sky130_fd_pr__cap_mim_m3_1 l=22.2 w=22.2
X696 a_n8609_14110# a_n8609_6082# vss vss sky130_fd_pr__nfet_g5v0d10v5 ad=2.9 pd=20.58 as=1.45 ps=10.29 w=10 l=0.5
X697 a_n8609_4082# a_n8609_4082# vss vss sky130_fd_pr__nfet_g5v0d10v5 ad=0.145 pd=1.29 as=0.145 ps=1.29 w=1 l=4
X698 a_n23016_n717# a_n22720_n20595# vss sky130_fd_pr__res_high_po w=1 l=97.39
X699 vin a_n8581_n15597# a_n8639_n20509# vss sky130_fd_pr__nfet_05v0_nvt ad=1.45 pd=10.29 as=1.45 ps=10.29 w=10 l=0.9
X700 vin a_n8581_n15597# a_n8639_n20509# vss sky130_fd_pr__nfet_05v0_nvt ad=1.45 pd=10.29 as=1.45 ps=10.29 w=10 l=0.9
X701 a_n8609_11046# a_n8609_2082# w_n8809_8685# w_n8809_8685# sky130_fd_pr__pfet_g5v0d10v5 ad=0.435 pd=3.58 as=0.2175 ps=1.79 w=1.5 l=4
X702 a_n8609_2082# a_n15687_2040# vss vss sky130_fd_pr__nfet_g5v0d10v5 ad=0.145 pd=1.29 as=0.145 ps=1.29 w=1 l=4
X703 w_n8809_8685# a_n8609_2082# a_n8609_14110# w_n8809_8685# sky130_fd_pr__pfet_g5v0d10v5 ad=0.2175 pd=1.79 as=0.2175 ps=1.79 w=1.5 l=4
X704 a_n8609_14110# a_n8609_2082# w_n8809_8685# w_n8809_8685# sky130_fd_pr__pfet_g5v0d10v5 ad=0.2175 pd=1.79 as=0.2175 ps=1.79 w=1.5 l=4
X705 vin a_n8581_n15597# a_n8639_n20509# vss sky130_fd_pr__nfet_05v0_nvt ad=2.9 pd=20.58 as=1.45 ps=10.29 w=10 l=0.9
X706 a_n8609_14110# a_n8609_2082# w_n8809_8685# w_n8809_8685# sky130_fd_pr__pfet_g5v0d10v5 ad=0.2175 pd=1.79 as=0.2175 ps=1.79 w=1.5 l=4
X707 a_n8639_n20509# a_n8581_n15597# vin vss sky130_fd_pr__nfet_05v0_nvt ad=1.45 pd=10.29 as=2.9 ps=20.58 w=10 l=0.9
X708 a_n8609_11046# a_n8609_2082# w_n8809_8685# w_n8809_8685# sky130_fd_pr__pfet_g5v0d10v5 ad=0.2175 pd=1.79 as=0.2175 ps=1.79 w=1.5 l=4
X709 quiet a_n8609_14110# a_n8639_n20509# vss sky130_fd_pr__nfet_05v0_nvt ad=1.45 pd=10.29 as=1.45 ps=10.29 w=10 l=0.9
X710 quiet a_n8609_14110# a_n8639_n20509# vss sky130_fd_pr__nfet_05v0_nvt ad=1.45 pd=10.29 as=1.45 ps=10.29 w=10 l=0.9
X711 a_n8609_2082# a_n8609_2082# w_n8809_8685# w_n8809_8685# sky130_fd_pr__pfet_g5v0d10v5 ad=0.2175 pd=1.79 as=0.2175 ps=1.79 w=1.5 l=4
X712 vss a_n8609_4082# a_n8609_6082# vss sky130_fd_pr__nfet_g5v0d10v5 ad=0.145 pd=1.29 as=0.145 ps=1.29 w=1 l=4
X713 a_n8609_14110# a_n8609_6082# vss vss sky130_fd_pr__nfet_g5v0d10v5 ad=1.45 pd=10.29 as=1.45 ps=10.29 w=10 l=0.5
X714 a_n8609_2082# a_n15687_2040# vss vss sky130_fd_pr__nfet_g5v0d10v5 ad=0.29 pd=2.58 as=0.145 ps=1.29 w=1 l=4
X715 a_n8639_n20509# a_n8609_14110# quiet vss sky130_fd_pr__nfet_05v0_nvt ad=1.45 pd=10.29 as=1.45 ps=10.29 w=10 l=0.9
X716 w_n8809_8685# a_n8609_2082# a_n8609_14110# w_n8809_8685# sky130_fd_pr__pfet_g5v0d10v5 ad=0.2175 pd=1.79 as=0.2175 ps=1.79 w=1.5 l=4
X717 a_n8639_n20509# a_n8609_14110# quiet vss sky130_fd_pr__nfet_05v0_nvt ad=1.45 pd=10.29 as=1.45 ps=10.29 w=10 l=0.9
X718 a_n8609_14110# a_n8609_2082# w_n8809_8685# w_n8809_8685# sky130_fd_pr__pfet_g5v0d10v5 ad=0.2175 pd=1.79 as=0.2175 ps=1.79 w=1.5 l=4
X719 w_n8809_8685# a_n8609_2082# a_n8609_14110# w_n8809_8685# sky130_fd_pr__pfet_g5v0d10v5 ad=0.2175 pd=1.79 as=0.2175 ps=1.79 w=1.5 l=4
X720 a_n24073_2440# vss sky130_fd_pr__cap_mim_m3_1 l=22.2 w=22.2
X721 quiet a_n8609_14110# a_n8639_n20509# vss sky130_fd_pr__nfet_05v0_nvt ad=1.45 pd=10.29 as=1.45 ps=10.29 w=10 l=0.9
X722 vin a_n8581_n15597# a_n8639_n20509# vss sky130_fd_pr__nfet_05v0_nvt ad=1.45 pd=10.29 as=1.45 ps=10.29 w=10 l=0.9
X723 vss a_n8609_4082# a_n8609_6082# vss sky130_fd_pr__nfet_g5v0d10v5 ad=0.145 pd=1.29 as=0.145 ps=1.29 w=1 l=4
X724 vss a_n15687_2040# a_n15687_2040# vss sky130_fd_pr__nfet_g5v0d10v5 ad=0.145 pd=1.29 as=0.29 ps=2.58 w=1 l=4
X725 a_n8609_6082# a_n8609_4082# vss vss sky130_fd_pr__nfet_g5v0d10v5 ad=0.145 pd=1.29 as=0.145 ps=1.29 w=1 l=4
X726 quiet a_n8609_14110# a_n8639_n20509# vss sky130_fd_pr__nfet_05v0_nvt ad=1.45 pd=10.29 as=1.45 ps=10.29 w=10 l=0.9
X727 a_n8609_2082# a_n8609_2082# w_n8809_8685# w_n8809_8685# sky130_fd_pr__pfet_g5v0d10v5 ad=0.435 pd=3.58 as=0.2175 ps=1.79 w=1.5 l=4
X728 vss a_n15687_2040# a_n15687_2040# vss sky130_fd_pr__nfet_g5v0d10v5 ad=0.145 pd=1.29 as=0.145 ps=1.29 w=1 l=4
X729 a_n8639_n20509# a_n8581_n15597# vin vss sky130_fd_pr__nfet_05v0_nvt ad=1.45 pd=10.29 as=1.45 ps=10.29 w=10 l=0.9
X730 a_n8609_14110# a_n8609_2082# w_n8809_8685# w_n8809_8685# sky130_fd_pr__pfet_g5v0d10v5 ad=0.435 pd=3.58 as=0.2175 ps=1.79 w=1.5 l=4
X731 a_n8639_n20509# a_n8609_14110# quiet vss sky130_fd_pr__nfet_05v0_nvt ad=1.45 pd=10.29 as=1.45 ps=10.29 w=10 l=0.9
X732 a_n8639_n20509# a_n8609_14110# quiet vss sky130_fd_pr__nfet_05v0_nvt ad=1.45 pd=10.29 as=1.45 ps=10.29 w=10 l=0.9
X733 w_n8809_8685# a_n8609_2082# a_n8609_11046# w_n8809_8685# sky130_fd_pr__pfet_g5v0d10v5 ad=0.2175 pd=1.79 as=0.2175 ps=1.79 w=1.5 l=4
X734 vss t0 a_n27821_6140# vss sky130_fd_pr__nfet_01v8 ad=0.825 pd=5.33 as=1.55 ps=10.62 w=5 l=0.15
X735 a_n15687_2040# vgi host host sky130_fd_pr__pfet_01v8_lvt ad=0.87 pd=6.29 as=0.87 ps=6.29 w=6 l=4
X736 a_n8639_n20509# a_n8609_14110# quiet vss sky130_fd_pr__nfet_05v0_nvt ad=1.45 pd=10.29 as=1.45 ps=10.29 w=10 l=0.9
X737 a_n8639_n20509# a_n8581_n15597# vin vss sky130_fd_pr__nfet_05v0_nvt ad=1.45 pd=10.29 as=1.45 ps=10.29 w=10 l=0.9
X738 w_n8809_8685# a_n8609_2082# a_n8609_14110# w_n8809_8685# sky130_fd_pr__pfet_g5v0d10v5 ad=0.2175 pd=1.79 as=0.2175 ps=1.79 w=1.5 l=4
X739 w_n8809_8685# a_n8609_2082# a_n8609_14110# w_n8809_8685# sky130_fd_pr__pfet_g5v0d10v5 ad=0.2175 pd=1.79 as=0.2175 ps=1.79 w=1.5 l=4
X740 quiet a_n8609_14110# a_n8639_n20509# vss sky130_fd_pr__nfet_05v0_nvt ad=1.45 pd=10.29 as=1.45 ps=10.29 w=10 l=0.9
X741 a_n23421_6140# t3 a_n21221_6140# vss sky130_fd_pr__nfet_01v8 ad=0.825 pd=5.33 as=1.55 ps=10.62 w=5 l=0.15
X742 a_n8609_14110# a_n8609_2082# w_n8809_8685# w_n8809_8685# sky130_fd_pr__pfet_g5v0d10v5 ad=0.2175 pd=1.79 as=0.2175 ps=1.79 w=1.5 l=4
X743 a_n8609_11046# a_n8609_2082# w_n8809_8685# w_n8809_8685# sky130_fd_pr__pfet_g5v0d10v5 ad=0.2175 pd=1.79 as=0.2175 ps=1.79 w=1.5 l=4
X744 a_n8609_2082# a_n8609_2082# w_n8809_8685# w_n8809_8685# sky130_fd_pr__pfet_g5v0d10v5 ad=0.2175 pd=1.79 as=0.2175 ps=1.79 w=1.5 l=4
X745 a_n15687_2040# a_n15687_2040# vss vss sky130_fd_pr__nfet_g5v0d10v5 ad=0.145 pd=1.29 as=0.145 ps=1.29 w=1 l=4
X746 a_n24073_2440# vss sky130_fd_pr__cap_mim_m3_1 l=22.2 w=22.2
X747 vin a_n8581_n15597# a_n8639_n20509# vss sky130_fd_pr__nfet_05v0_nvt ad=1.45 pd=10.29 as=1.45 ps=10.29 w=10 l=0.9
X748 a_n8639_n20509# a_n8581_n15597# vin vss sky130_fd_pr__nfet_05v0_nvt ad=1.45 pd=10.29 as=1.45 ps=10.29 w=10 l=0.9
X749 a_n8609_14110# a_n8609_2082# w_n8809_8685# w_n8809_8685# sky130_fd_pr__pfet_g5v0d10v5 ad=0.2175 pd=1.79 as=0.2175 ps=1.79 w=1.5 l=4
X750 vss a_n8609_4082# a_n8609_4082# vss sky130_fd_pr__nfet_g5v0d10v5 ad=0.145 pd=1.29 as=0.145 ps=1.29 w=1 l=4
X751 a_n8609_2082# a_n15687_2040# vss vss sky130_fd_pr__nfet_g5v0d10v5 ad=0.145 pd=1.29 as=0.145 ps=1.29 w=1 l=4
X752 w_n8809_8685# vss sky130_fd_pr__cap_mim_m3_1 l=22.2 w=22.2
X753 a_n8639_n20509# a_n8609_14110# quiet vss sky130_fd_pr__nfet_05v0_nvt ad=1.45 pd=10.29 as=1.45 ps=10.29 w=10 l=0.9
X754 a_n8639_n20509# a_n8609_14110# quiet vss sky130_fd_pr__nfet_05v0_nvt ad=1.45 pd=10.29 as=1.45 ps=10.29 w=10 l=0.9
X755 quiet a_n8609_14110# a_n8639_n20509# vss sky130_fd_pr__nfet_05v0_nvt ad=1.45 pd=10.29 as=1.45 ps=10.29 w=10 l=0.9
X756 vss a_n15687_2040# a_n8609_2082# vss sky130_fd_pr__nfet_g5v0d10v5 ad=0.145 pd=1.29 as=0.145 ps=1.29 w=1 l=4
X757 quiet a_n8609_14110# a_n8639_n20509# vss sky130_fd_pr__nfet_05v0_nvt ad=1.45 pd=10.29 as=1.45 ps=10.29 w=10 l=0.9
X758 w_n8809_8685# a_n8609_2082# a_n8609_11046# w_n8809_8685# sky130_fd_pr__pfet_g5v0d10v5 ad=0.2175 pd=1.79 as=0.2175 ps=1.79 w=1.5 l=4
X759 w_n8809_8685# a_n8609_2082# a_n8609_11046# w_n8809_8685# sky130_fd_pr__pfet_g5v0d10v5 ad=0.2175 pd=1.79 as=0.2175 ps=1.79 w=1.5 l=4
X760 w_n8809_8685# a_n8609_2082# a_n8609_14110# w_n8809_8685# sky130_fd_pr__pfet_g5v0d10v5 ad=0.2175 pd=1.79 as=0.2175 ps=1.79 w=1.5 l=4
X761 w_n8809_8685# a_n8609_2082# a_n8609_14110# w_n8809_8685# sky130_fd_pr__pfet_g5v0d10v5 ad=0.2175 pd=1.79 as=0.2175 ps=1.79 w=1.5 l=4
X762 vss a_n15687_2040# a_n8609_2082# vss sky130_fd_pr__nfet_g5v0d10v5 ad=0.145 pd=1.29 as=0.145 ps=1.29 w=1 l=4
X763 a_n8639_n20509# a_n8581_n15597# vin vss sky130_fd_pr__nfet_05v0_nvt ad=1.45 pd=10.29 as=1.45 ps=10.29 w=10 l=0.9
X764 a_n18872_n717# a_n18576_n20595# vss sky130_fd_pr__res_high_po w=1 l=97.39
X765 a_n8639_n20509# a_n8609_14110# quiet vss sky130_fd_pr__nfet_05v0_nvt ad=1.45 pd=10.29 as=1.45 ps=10.29 w=10 l=0.9
X766 a_n15687_2040# a_n15687_2040# vss vss sky130_fd_pr__nfet_g5v0d10v5 ad=0.29 pd=2.58 as=0.145 ps=1.29 w=1 l=4
X767 w_n8809_8685# a_n8609_2082# a_n8609_2082# w_n8809_8685# sky130_fd_pr__pfet_g5v0d10v5 ad=0.2175 pd=1.79 as=0.2175 ps=1.79 w=1.5 l=4
X768 a_n8609_6082# a_n8609_4082# vss vss sky130_fd_pr__nfet_g5v0d10v5 ad=0.145 pd=1.29 as=0.145 ps=1.29 w=1 l=4
X769 quiet a_n8609_14110# a_n8639_n20509# vss sky130_fd_pr__nfet_05v0_nvt ad=1.45 pd=10.29 as=1.45 ps=10.29 w=10 l=0.9
X770 vin a_n8581_n15597# a_n8639_n20509# vss sky130_fd_pr__nfet_05v0_nvt ad=1.45 pd=10.29 as=1.45 ps=10.29 w=10 l=0.9
X771 a_n8609_14110# a_n8609_2082# w_n8809_8685# w_n8809_8685# sky130_fd_pr__pfet_g5v0d10v5 ad=0.2175 pd=1.79 as=0.2175 ps=1.79 w=1.5 l=4
X772 a_n25621_6140# t2 a_n23421_6140# vss sky130_fd_pr__nfet_01v8 ad=0.825 pd=5.33 as=0.825 ps=5.33 w=5 l=0.15
X773 vss a_n8609_4082# a_n8609_6082# vss sky130_fd_pr__nfet_g5v0d10v5 ad=0.145 pd=1.29 as=0.145 ps=1.29 w=1 l=4
X774 quiet a_n8609_14110# a_n8639_n20509# vss sky130_fd_pr__nfet_05v0_nvt ad=1.45 pd=10.29 as=1.45 ps=10.29 w=10 l=0.9
X775 a_n8609_14110# a_n8609_2082# w_n8809_8685# w_n8809_8685# sky130_fd_pr__pfet_g5v0d10v5 ad=0.2175 pd=1.79 as=0.2175 ps=1.79 w=1.5 l=4
X776 a_n8609_2082# a_n15687_2040# vss vss sky130_fd_pr__nfet_g5v0d10v5 ad=0.145 pd=1.29 as=0.145 ps=1.29 w=1 l=4
X777 a_n8639_n20509# a_n8609_14110# quiet vss sky130_fd_pr__nfet_05v0_nvt ad=1.45 pd=10.29 as=1.45 ps=10.29 w=10 l=0.9
X778 w_n8809_8685# a_n8609_2082# a_n8609_14110# w_n8809_8685# sky130_fd_pr__pfet_g5v0d10v5 ad=0.2175 pd=1.79 as=0.2175 ps=1.79 w=1.5 l=4
X779 quiet vss sky130_fd_pr__cap_mim_m3_1 l=22.2 w=22.2
X780 a_n8639_n20509# a_n8609_14110# quiet vss sky130_fd_pr__nfet_05v0_nvt ad=1.45 pd=10.29 as=1.45 ps=10.29 w=10 l=0.9
X781 a_n8609_14110# a_n8609_2082# w_n8809_8685# w_n8809_8685# sky130_fd_pr__pfet_g5v0d10v5 ad=0.2175 pd=1.79 as=0.2175 ps=1.79 w=1.5 l=4
X782 a_n8609_11046# a_n8609_2082# w_n8809_8685# w_n8809_8685# sky130_fd_pr__pfet_g5v0d10v5 ad=0.2175 pd=1.79 as=0.2175 ps=1.79 w=1.5 l=4
X783 vss a_n15687_2040# a_n15687_2040# vss sky130_fd_pr__nfet_g5v0d10v5 ad=0.145 pd=1.29 as=0.145 ps=1.29 w=1 l=4
X784 vss a_n15687_2040# a_n15687_2040# vss sky130_fd_pr__nfet_g5v0d10v5 ad=0.145 pd=1.29 as=0.145 ps=1.29 w=1 l=4
X785 vin a_n8581_n15597# a_n8639_n20509# vss sky130_fd_pr__nfet_05v0_nvt ad=1.45 pd=10.29 as=1.45 ps=10.29 w=10 l=0.9
X786 a_n8609_2082# a_n8609_2082# w_n8809_8685# w_n8809_8685# sky130_fd_pr__pfet_g5v0d10v5 ad=0.2175 pd=1.79 as=0.2175 ps=1.79 w=1.5 l=4
X787 vin a_n8581_n15597# a_n8639_n20509# vss sky130_fd_pr__nfet_05v0_nvt ad=1.45 pd=10.29 as=1.45 ps=10.29 w=10 l=0.9
X788 a_n19021_6140# a_n21221_6140# vss sky130_fd_pr__res_high_po w=1 l=49.28
X789 w_n8809_8685# a_n8609_2082# a_n8609_14110# w_n8809_8685# sky130_fd_pr__pfet_g5v0d10v5 ad=0.2175 pd=1.79 as=0.2175 ps=1.79 w=1.5 l=4
X790 w_n8809_8685# vss sky130_fd_pr__cap_mim_m3_1 l=22.2 w=22.2
X791 w_n8809_8685# a_n8609_2082# a_n8609_14110# w_n8809_8685# sky130_fd_pr__pfet_g5v0d10v5 ad=0.2175 pd=1.79 as=0.2175 ps=1.79 w=1.5 l=4
X792 vss a_n8609_4082# a_n8609_4082# vss sky130_fd_pr__nfet_g5v0d10v5 ad=0.145 pd=1.29 as=0.145 ps=1.29 w=1 l=4
X793 a_n8639_n20509# a_n8609_14110# quiet vss sky130_fd_pr__nfet_05v0_nvt ad=1.45 pd=10.29 as=1.45 ps=10.29 w=10 l=0.9
X794 a_n8639_n20509# a_n8581_n15597# vin vss sky130_fd_pr__nfet_05v0_nvt ad=1.45 pd=10.29 as=1.45 ps=10.29 w=10 l=0.9
X795 a_n8609_14110# a_n8609_2082# w_n8809_8685# w_n8809_8685# sky130_fd_pr__pfet_g5v0d10v5 ad=0.2175 pd=1.79 as=0.2175 ps=1.79 w=1.5 l=4
X796 vss a_n8609_4082# a_n8609_6082# vss sky130_fd_pr__nfet_g5v0d10v5 ad=0.145 pd=1.29 as=0.145 ps=1.29 w=1 l=4
X797 a_n8609_6082# a_n8609_4082# vss vss sky130_fd_pr__nfet_g5v0d10v5 ad=0.145 pd=1.29 as=0.145 ps=1.29 w=1 l=4
X798 vss a_n8609_4082# a_n8609_4082# vss sky130_fd_pr__nfet_g5v0d10v5 ad=0.145 pd=1.29 as=0.145 ps=1.29 w=1 l=4
X799 a_n8639_n20509# a_n8609_14110# quiet vss sky130_fd_pr__nfet_05v0_nvt ad=1.45 pd=10.29 as=1.45 ps=10.29 w=10 l=0.9
X800 quiet a_n8609_14110# a_n8639_n20509# vss sky130_fd_pr__nfet_05v0_nvt ad=1.45 pd=10.29 as=1.45 ps=10.29 w=10 l=0.9
X801 a_n8609_14110# a_n8609_2082# w_n8809_8685# w_n8809_8685# sky130_fd_pr__pfet_g5v0d10v5 ad=0.435 pd=3.58 as=0.2175 ps=1.79 w=1.5 l=4
X802 w_n8809_8685# a_n8609_2082# a_n8609_14110# w_n8809_8685# sky130_fd_pr__pfet_g5v0d10v5 ad=0.2175 pd=1.79 as=0.2175 ps=1.79 w=1.5 l=4
X803 a_n8609_4082# a_n8609_4082# vss vss sky130_fd_pr__nfet_g5v0d10v5 ad=0.145 pd=1.29 as=0.145 ps=1.29 w=1 l=4
X804 a_n8639_n20509# a_n8609_14110# quiet vss sky130_fd_pr__nfet_05v0_nvt ad=1.45 pd=10.29 as=1.45 ps=10.29 w=10 l=0.9
X805 w_n8809_8685# a_n8609_2082# a_n8609_14110# w_n8809_8685# sky130_fd_pr__pfet_g5v0d10v5 ad=0.2175 pd=1.79 as=0.435 ps=3.58 w=1.5 l=4
X806 a_n8639_n20509# a_n8581_n15597# vin vss sky130_fd_pr__nfet_05v0_nvt ad=1.45 pd=10.29 as=1.45 ps=10.29 w=10 l=0.9
X807 a_n8609_14110# a_n8609_2082# w_n8809_8685# w_n8809_8685# sky130_fd_pr__pfet_g5v0d10v5 ad=0.2175 pd=1.79 as=0.2175 ps=1.79 w=1.5 l=4
X808 a_n8609_14110# a_n8609_2082# w_n8809_8685# w_n8809_8685# sky130_fd_pr__pfet_g5v0d10v5 ad=0.2175 pd=1.79 as=0.2175 ps=1.79 w=1.5 l=4
X809 vin a_n8581_n15597# a_n8639_n20509# vss sky130_fd_pr__nfet_05v0_nvt ad=1.45 pd=10.29 as=1.45 ps=10.29 w=10 l=0.9
X810 a_n8609_11046# a_n8609_2082# w_n8809_8685# w_n8809_8685# sky130_fd_pr__pfet_g5v0d10v5 ad=0.2175 pd=1.79 as=0.2175 ps=1.79 w=1.5 l=4
X811 w_n8809_8685# a_n8609_2082# a_n8609_11046# w_n8809_8685# sky130_fd_pr__pfet_g5v0d10v5 ad=0.2175 pd=1.79 as=0.2175 ps=1.79 w=1.5 l=4
X812 a_n8609_2082# a_n8609_2082# w_n8809_8685# w_n8809_8685# sky130_fd_pr__pfet_g5v0d10v5 ad=0.2175 pd=1.79 as=0.2175 ps=1.79 w=1.5 l=4
X813 vss a_n8609_4082# a_n8609_6082# vss sky130_fd_pr__nfet_g5v0d10v5 ad=0.145 pd=1.29 as=0.29 ps=2.58 w=1 l=4
X814 quiet a_n8609_14110# a_n8639_n20509# vss sky130_fd_pr__nfet_05v0_nvt ad=1.45 pd=10.29 as=1.45 ps=10.29 w=10 l=0.9
X815 a_n8609_14110# a_n8609_2082# w_n8809_8685# w_n8809_8685# sky130_fd_pr__pfet_g5v0d10v5 ad=0.2175 pd=1.79 as=0.2175 ps=1.79 w=1.5 l=4
X816 w_n8809_8685# a_n8609_2082# a_n8609_14110# w_n8809_8685# sky130_fd_pr__pfet_g5v0d10v5 ad=0.2175 pd=1.79 as=0.2175 ps=1.79 w=1.5 l=4
X817 a_n8639_n20509# a_n8609_14110# quiet vss sky130_fd_pr__nfet_05v0_nvt ad=1.45 pd=10.29 as=1.45 ps=10.29 w=10 l=0.9
X818 vss a_n15687_2040# a_n8609_2082# vss sky130_fd_pr__nfet_g5v0d10v5 ad=0.145 pd=1.29 as=0.145 ps=1.29 w=1 l=4
X819 a_n24073_2440# vss sky130_fd_pr__cap_mim_m3_1 l=22.2 w=22.2
X820 a_n8639_n20509# a_n8581_n15597# vin vss sky130_fd_pr__nfet_05v0_nvt ad=1.45 pd=10.29 as=1.45 ps=10.29 w=10 l=0.9
X821 a_n8581_n15597# vss sky130_fd_pr__cap_mim_m3_1 l=22.2 w=22.2
X822 a_n8639_n20509# a_n8581_n15597# vin vss sky130_fd_pr__nfet_05v0_nvt ad=1.45 pd=10.29 as=1.45 ps=10.29 w=10 l=0.9
X823 a_n8609_14110# a_n8609_2082# w_n8809_8685# w_n8809_8685# sky130_fd_pr__pfet_g5v0d10v5 ad=0.2175 pd=1.79 as=0.2175 ps=1.79 w=1.5 l=4
X824 w_n8809_8685# a_n8609_2082# a_n8609_11046# w_n8809_8685# sky130_fd_pr__pfet_g5v0d10v5 ad=0.2175 pd=1.79 as=0.2175 ps=1.79 w=1.5 l=4
X825 w_n8809_8685# a_n8609_2082# a_n8609_14110# w_n8809_8685# sky130_fd_pr__pfet_g5v0d10v5 ad=0.2175 pd=1.79 as=0.2175 ps=1.79 w=1.5 l=4
X826 a_n8609_14110# a_n8609_2082# w_n8809_8685# w_n8809_8685# sky130_fd_pr__pfet_g5v0d10v5 ad=0.2175 pd=1.79 as=0.2175 ps=1.79 w=1.5 l=4
X827 a_n8581_n15597# vss sky130_fd_pr__cap_mim_m3_1 l=22.2 w=22.2
X828 w_n8809_8685# vss sky130_fd_pr__cap_mim_m3_1 l=22.2 w=22.2
X829 a_n8609_11046# a_n8609_2082# w_n8809_8685# w_n8809_8685# sky130_fd_pr__pfet_g5v0d10v5 ad=0.435 pd=3.58 as=0.2175 ps=1.79 w=1.5 l=4
X830 w_n8809_8685# a_n8609_2082# a_n8609_14110# w_n8809_8685# sky130_fd_pr__pfet_g5v0d10v5 ad=0.2175 pd=1.79 as=0.2175 ps=1.79 w=1.5 l=4
X831 a_n8609_14110# a_n8609_2082# w_n8809_8685# w_n8809_8685# sky130_fd_pr__pfet_g5v0d10v5 ad=0.2175 pd=1.79 as=0.2175 ps=1.79 w=1.5 l=4
X832 vin a_n8581_n15597# a_n8639_n20509# vss sky130_fd_pr__nfet_05v0_nvt ad=1.45 pd=10.29 as=1.45 ps=10.29 w=10 l=0.9
X833 a_n8609_6082# a_n8609_4082# vss vss sky130_fd_pr__nfet_g5v0d10v5 ad=0.145 pd=1.29 as=0.145 ps=1.29 w=1 l=4
X834 a_n8639_n20509# a_n8581_n15597# vin vss sky130_fd_pr__nfet_05v0_nvt ad=1.45 pd=10.29 as=1.45 ps=10.29 w=10 l=0.9
X835 w_n8809_8685# a_n8609_2082# a_n8609_14110# w_n8809_8685# sky130_fd_pr__pfet_g5v0d10v5 ad=0.2175 pd=1.79 as=0.2175 ps=1.79 w=1.5 l=4
X836 vss a_n8609_4082# a_n8609_6082# vss sky130_fd_pr__nfet_g5v0d10v5 ad=0.145 pd=1.29 as=0.145 ps=1.29 w=1 l=4
X837 a_n8609_4082# a_n8609_4082# vss vss sky130_fd_pr__nfet_g5v0d10v5 ad=0.145 pd=1.29 as=0.145 ps=1.29 w=1 l=4
X838 vss a_n15687_2040# a_n15687_2040# vss sky130_fd_pr__nfet_g5v0d10v5 ad=0.145 pd=1.29 as=0.145 ps=1.29 w=1 l=4
X839 vin a_n8581_n15597# a_n8639_n20509# vss sky130_fd_pr__nfet_05v0_nvt ad=1.45 pd=10.29 as=1.45 ps=10.29 w=10 l=0.9
X840 a_n8609_14110# a_n8609_2082# w_n8809_8685# w_n8809_8685# sky130_fd_pr__pfet_g5v0d10v5 ad=0.2175 pd=1.79 as=0.2175 ps=1.79 w=1.5 l=4
X841 a_n8609_11046# a_n8609_2082# w_n8809_8685# w_n8809_8685# sky130_fd_pr__pfet_g5v0d10v5 ad=0.2175 pd=1.79 as=0.2175 ps=1.79 w=1.5 l=4
X842 vss a_n8609_4082# a_n8609_4082# vss sky130_fd_pr__nfet_g5v0d10v5 ad=0.145 pd=1.29 as=0.145 ps=1.29 w=1 l=4
X843 vin a_n8581_n15597# a_n8639_n20509# vss sky130_fd_pr__nfet_05v0_nvt ad=1.45 pd=10.29 as=1.45 ps=10.29 w=10 l=0.9
X844 w_n8809_8685# a_n8609_2082# a_n8609_14110# w_n8809_8685# sky130_fd_pr__pfet_g5v0d10v5 ad=0.2175 pd=1.79 as=0.2175 ps=1.79 w=1.5 l=4
X845 a_n8639_n20509# a_n8581_n15597# vin vss sky130_fd_pr__nfet_05v0_nvt ad=1.45 pd=10.29 as=1.45 ps=10.29 w=10 l=0.9
X846 w_n8809_8685# a_n8609_2082# a_n8609_14110# w_n8809_8685# sky130_fd_pr__pfet_g5v0d10v5 ad=0.2175 pd=1.79 as=0.2175 ps=1.79 w=1.5 l=4
X847 a_n19021_6140# t5 a_n16821_6140# vss sky130_fd_pr__nfet_01v8 ad=0.825 pd=5.33 as=1.55 ps=10.62 w=5 l=0.15
X848 a_n8609_6082# a_n8609_4082# vss vss sky130_fd_pr__nfet_g5v0d10v5 ad=0.145 pd=1.29 as=0.145 ps=1.29 w=1 l=4
X849 vss a_n15687_2040# a_n15687_2040# vss sky130_fd_pr__nfet_g5v0d10v5 ad=0.145 pd=1.29 as=0.29 ps=2.58 w=1 l=4
X850 w_n8809_8685# a_n8609_2082# a_n8609_14110# w_n8809_8685# sky130_fd_pr__pfet_g5v0d10v5 ad=0.2175 pd=1.79 as=0.2175 ps=1.79 w=1.5 l=4
X851 a_n8609_14110# a_n8609_2082# w_n8809_8685# w_n8809_8685# sky130_fd_pr__pfet_g5v0d10v5 ad=0.2175 pd=1.79 as=0.2175 ps=1.79 w=1.5 l=4
X852 a_n8609_14110# a_n8609_2082# w_n8809_8685# w_n8809_8685# sky130_fd_pr__pfet_g5v0d10v5 ad=0.2175 pd=1.79 as=0.2175 ps=1.79 w=1.5 l=4
X853 quiet a_n8609_14110# a_n8639_n20509# vss sky130_fd_pr__nfet_05v0_nvt ad=1.45 pd=10.29 as=1.45 ps=10.29 w=10 l=0.9
X854 w_n8809_8685# a_n8609_2082# a_n8609_2082# w_n8809_8685# sky130_fd_pr__pfet_g5v0d10v5 ad=0.2175 pd=1.79 as=0.2175 ps=1.79 w=1.5 l=4
X855 vin a_n8581_n15597# a_n8639_n20509# vss sky130_fd_pr__nfet_05v0_nvt ad=1.45 pd=10.29 as=1.45 ps=10.29 w=10 l=0.9
X856 vin a_n8581_n15597# a_n8639_n20509# vss sky130_fd_pr__nfet_05v0_nvt ad=1.45 pd=10.29 as=1.45 ps=10.29 w=10 l=0.9
X857 vin a_n8581_n15597# a_n8639_n20509# vss sky130_fd_pr__nfet_05v0_nvt ad=1.45 pd=10.29 as=1.45 ps=10.29 w=10 l=0.9
X858 a_n8609_14110# a_n8609_2082# w_n8809_8685# w_n8809_8685# sky130_fd_pr__pfet_g5v0d10v5 ad=0.2175 pd=1.79 as=0.2175 ps=1.79 w=1.5 l=4
X859 vss a_n15687_2040# a_n8609_2082# vss sky130_fd_pr__nfet_g5v0d10v5 ad=0.145 pd=1.29 as=0.145 ps=1.29 w=1 l=4
X860 vin a_n8581_n15597# a_n8639_n20509# vss sky130_fd_pr__nfet_05v0_nvt ad=1.45 pd=10.29 as=1.45 ps=10.29 w=10 l=0.9
X861 a_n8639_n20509# a_n8581_n15597# vin vss sky130_fd_pr__nfet_05v0_nvt ad=1.45 pd=10.29 as=1.45 ps=10.29 w=10 l=0.9
X862 a_n18280_n717# a_n18576_n20595# vss sky130_fd_pr__res_high_po w=1 l=97.39
X863 a_n8639_n20509# a_n8581_n15597# vin vss sky130_fd_pr__nfet_05v0_nvt ad=1.45 pd=10.29 as=1.45 ps=10.29 w=10 l=0.9
X864 w_n8809_8685# a_n8609_2082# a_n8609_11046# w_n8809_8685# sky130_fd_pr__pfet_g5v0d10v5 ad=0.2175 pd=1.79 as=0.2175 ps=1.79 w=1.5 l=4
X865 a_n8609_6082# a_n8609_4082# vss vss sky130_fd_pr__nfet_g5v0d10v5 ad=0.145 pd=1.29 as=0.145 ps=1.29 w=1 l=4
X866 w_n8809_8685# a_n8609_2082# a_n8609_14110# w_n8809_8685# sky130_fd_pr__pfet_g5v0d10v5 ad=0.2175 pd=1.79 as=0.2175 ps=1.79 w=1.5 l=4
X867 a_n8609_14110# a_n8609_2082# w_n8809_8685# w_n8809_8685# sky130_fd_pr__pfet_g5v0d10v5 ad=0.2175 pd=1.79 as=0.2175 ps=1.79 w=1.5 l=4
X868 vss a_n8609_4082# a_n8609_4082# vss sky130_fd_pr__nfet_g5v0d10v5 ad=0.145 pd=1.29 as=0.145 ps=1.29 w=1 l=4
X869 a_n18280_n717# a_n17984_n20595# vss sky130_fd_pr__res_high_po w=1 l=97.39
X870 a_n8609_4082# a_n8609_4082# vss vss sky130_fd_pr__nfet_g5v0d10v5 ad=0.145 pd=1.29 as=0.145 ps=1.29 w=1 l=4
X871 vss a_n15687_2040# a_n8609_2082# vss sky130_fd_pr__nfet_g5v0d10v5 ad=0.145 pd=1.29 as=0.145 ps=1.29 w=1 l=4
X872 a_n15687_2040# a_n15687_2040# vss vss sky130_fd_pr__nfet_g5v0d10v5 ad=0.145 pd=1.29 as=0.145 ps=1.29 w=1 l=4
X873 quiet a_n8609_14110# a_n8639_n20509# vss sky130_fd_pr__nfet_05v0_nvt ad=1.45 pd=10.29 as=1.45 ps=10.29 w=10 l=0.9
X874 quiet vss sky130_fd_pr__cap_mim_m3_1 l=22.2 w=22.2
X875 w_n8809_8685# vss sky130_fd_pr__cap_mim_m3_1 l=22.2 w=22.2
X876 a_n8609_11046# a_n8609_2082# w_n8809_8685# w_n8809_8685# sky130_fd_pr__pfet_g5v0d10v5 ad=0.2175 pd=1.79 as=0.2175 ps=1.79 w=1.5 l=4
X877 w_n8809_8685# a_n8609_2082# a_n8609_2082# w_n8809_8685# sky130_fd_pr__pfet_g5v0d10v5 ad=0.2175 pd=1.79 as=0.2175 ps=1.79 w=1.5 l=4
X878 a_n8609_2082# a_n15687_2040# vss vss sky130_fd_pr__nfet_g5v0d10v5 ad=0.145 pd=1.29 as=0.145 ps=1.29 w=1 l=4
X879 a_n8609_14110# a_n8609_2082# w_n8809_8685# w_n8809_8685# sky130_fd_pr__pfet_g5v0d10v5 ad=0.435 pd=3.58 as=0.2175 ps=1.79 w=1.5 l=4
X880 a_n8639_n20509# a_n8581_n15597# vin vss sky130_fd_pr__nfet_05v0_nvt ad=1.45 pd=10.29 as=1.45 ps=10.29 w=10 l=0.9
X881 vin a_n8581_n15597# a_n8639_n20509# vss sky130_fd_pr__nfet_05v0_nvt ad=1.45 pd=10.29 as=1.45 ps=10.29 w=10 l=0.9
X882 vin a_n8581_n15597# a_n8639_n20509# vss sky130_fd_pr__nfet_05v0_nvt ad=1.45 pd=10.29 as=1.45 ps=10.29 w=10 l=0.9
X883 a_n8609_14110# a_n8609_2082# w_n8809_8685# w_n8809_8685# sky130_fd_pr__pfet_g5v0d10v5 ad=0.2175 pd=1.79 as=0.2175 ps=1.79 w=1.5 l=4
X884 a_n8609_14110# a_n8609_2082# w_n8809_8685# w_n8809_8685# sky130_fd_pr__pfet_g5v0d10v5 ad=0.2175 pd=1.79 as=0.2175 ps=1.79 w=1.5 l=4
X885 a_n21221_6140# t4 a_n19021_6140# vss sky130_fd_pr__nfet_01v8 ad=0.825 pd=5.33 as=0.825 ps=5.33 w=5 l=0.15
X886 vss a_n8609_4082# a_n8609_4082# vss sky130_fd_pr__nfet_g5v0d10v5 ad=0.145 pd=1.29 as=0.29 ps=2.58 w=1 l=4
X887 vin a_n8581_n15597# a_n8639_n20509# vss sky130_fd_pr__nfet_05v0_nvt ad=1.45 pd=10.29 as=1.45 ps=10.29 w=10 l=0.9
X888 a_n25621_6140# t1 a_n27821_6140# vss sky130_fd_pr__nfet_01v8 ad=0.825 pd=5.33 as=0.825 ps=5.33 w=5 l=0.15
X889 a_n8609_14110# a_n8609_2082# w_n8809_8685# w_n8809_8685# sky130_fd_pr__pfet_g5v0d10v5 ad=0.2175 pd=1.79 as=0.2175 ps=1.79 w=1.5 l=4
X890 w_n8809_8685# a_n8609_2082# a_n8609_11046# w_n8809_8685# sky130_fd_pr__pfet_g5v0d10v5 ad=0.2175 pd=1.79 as=0.2175 ps=1.79 w=1.5 l=4
X891 w_n8809_8685# a_n8609_2082# a_n8609_11046# w_n8809_8685# sky130_fd_pr__pfet_g5v0d10v5 ad=0.2175 pd=1.79 as=0.2175 ps=1.79 w=1.5 l=4
X892 vss a_n15687_2040# a_n15687_2040# vss sky130_fd_pr__nfet_g5v0d10v5 ad=0.145 pd=1.29 as=0.145 ps=1.29 w=1 l=4
X893 vss a_n15687_2040# a_n15687_2040# vss sky130_fd_pr__nfet_g5v0d10v5 ad=0.145 pd=1.29 as=0.145 ps=1.29 w=1 l=4
X894 w_n8809_8685# a_n8609_2082# a_n8609_11046# w_n8809_8685# sky130_fd_pr__pfet_g5v0d10v5 ad=0.2175 pd=1.79 as=0.2175 ps=1.79 w=1.5 l=4
X895 a_n8639_n20509# a_n8581_n15597# vin vss sky130_fd_pr__nfet_05v0_nvt ad=1.45 pd=10.29 as=2.9 ps=20.58 w=10 l=0.9
X896 w_n8809_8685# a_n8609_2082# a_n8609_14110# w_n8809_8685# sky130_fd_pr__pfet_g5v0d10v5 ad=0.2175 pd=1.79 as=0.2175 ps=1.79 w=1.5 l=4
X897 a_n8639_n20509# a_n8581_n15597# vin vss sky130_fd_pr__nfet_05v0_nvt ad=1.45 pd=10.29 as=1.45 ps=10.29 w=10 l=0.9
X898 a_n8639_n20509# a_n8581_n15597# vin vss sky130_fd_pr__nfet_05v0_nvt ad=1.45 pd=10.29 as=1.45 ps=10.29 w=10 l=0.9
X899 a_n8639_n20509# a_n8581_n15597# vin vss sky130_fd_pr__nfet_05v0_nvt ad=1.45 pd=10.29 as=1.45 ps=10.29 w=10 l=0.9
X900 quiet a_n8609_14110# a_n8639_n20509# vss sky130_fd_pr__nfet_05v0_nvt ad=1.45 pd=10.29 as=1.45 ps=10.29 w=10 l=0.9
X901 vin a_n8581_n15597# a_n8639_n20509# vss sky130_fd_pr__nfet_05v0_nvt ad=1.45 pd=10.29 as=1.45 ps=10.29 w=10 l=0.9
X902 vin a_n8581_n15597# a_n8639_n20509# vss sky130_fd_pr__nfet_05v0_nvt ad=1.45 pd=10.29 as=1.45 ps=10.29 w=10 l=0.9
X903 vin a_n8581_n15597# a_n8639_n20509# vss sky130_fd_pr__nfet_05v0_nvt ad=1.45 pd=10.29 as=1.45 ps=10.29 w=10 l=0.9
X904 vss a_n8609_4082# a_n8609_6082# vss sky130_fd_pr__nfet_g5v0d10v5 ad=0.145 pd=1.29 as=0.145 ps=1.29 w=1 l=4
X905 a_n8639_n20509# a_n8581_n15597# vin vss sky130_fd_pr__nfet_05v0_nvt ad=1.45 pd=10.29 as=1.45 ps=10.29 w=10 l=0.9
X906 a_n8609_14110# a_n8609_2082# w_n8809_8685# w_n8809_8685# sky130_fd_pr__pfet_g5v0d10v5 ad=0.435 pd=3.58 as=0.2175 ps=1.79 w=1.5 l=4
X907 w_n8809_8685# a_n8609_2082# a_n8609_14110# w_n8809_8685# sky130_fd_pr__pfet_g5v0d10v5 ad=0.2175 pd=1.79 as=0.2175 ps=1.79 w=1.5 l=4
X908 a_n8609_6082# a_n8609_4082# vss vss sky130_fd_pr__nfet_g5v0d10v5 ad=0.145 pd=1.29 as=0.145 ps=1.29 w=1 l=4
X909 vin a_n8581_n15597# a_n8639_n20509# vss sky130_fd_pr__nfet_05v0_nvt ad=1.45 pd=10.29 as=1.45 ps=10.29 w=10 l=0.9
X910 a_n8639_n20509# a_n8609_14110# quiet vss sky130_fd_pr__nfet_05v0_nvt ad=1.45 pd=10.29 as=1.45 ps=10.29 w=10 l=0.9
X911 vin w_n8809_8685# vss sky130_fd_pr__res_high_po w=2 l=11.43
X912 vss a_n8609_4082# a_n8609_6082# vss sky130_fd_pr__nfet_g5v0d10v5 ad=0.145 pd=1.29 as=0.145 ps=1.29 w=1 l=4
X913 a_n12048_20734# quiet vss sky130_fd_pr__res_high_po w=1 l=59.34
X914 a_n8609_4082# a_n8609_4082# vss vss sky130_fd_pr__nfet_g5v0d10v5 ad=0.145 pd=1.29 as=0.145 ps=1.29 w=1 l=4
X915 vss a_n8609_4082# a_n8609_4082# vss sky130_fd_pr__nfet_g5v0d10v5 ad=0.145 pd=1.29 as=0.145 ps=1.29 w=1 l=4
X916 a_n8609_2082# a_n15687_2040# vss vss sky130_fd_pr__nfet_g5v0d10v5 ad=0.145 pd=1.29 as=0.145 ps=1.29 w=1 l=4
X917 quiet a_n8609_14110# a_n8639_n20509# vss sky130_fd_pr__nfet_05v0_nvt ad=1.45 pd=10.29 as=1.45 ps=10.29 w=10 l=0.9
X918 vin a_n8581_n15597# a_n8639_n20509# vss sky130_fd_pr__nfet_05v0_nvt ad=1.45 pd=10.29 as=1.45 ps=10.29 w=10 l=0.9
X919 vin a_n8581_n15597# a_n8639_n20509# vss sky130_fd_pr__nfet_05v0_nvt ad=1.45 pd=10.29 as=1.45 ps=10.29 w=10 l=0.9
X920 w_n8809_8685# a_n8609_2082# a_n8609_14110# w_n8809_8685# sky130_fd_pr__pfet_g5v0d10v5 ad=0.2175 pd=1.79 as=0.2175 ps=1.79 w=1.5 l=4
X921 w_n8809_8685# a_n8609_2082# a_n8609_14110# w_n8809_8685# sky130_fd_pr__pfet_g5v0d10v5 ad=0.2175 pd=1.79 as=0.2175 ps=1.79 w=1.5 l=4
X922 a_n8609_14110# a_n8609_2082# w_n8809_8685# w_n8809_8685# sky130_fd_pr__pfet_g5v0d10v5 ad=0.2175 pd=1.79 as=0.2175 ps=1.79 w=1.5 l=4
X923 a_n8639_n20509# a_n8581_n15597# vin vss sky130_fd_pr__nfet_05v0_nvt ad=1.45 pd=10.29 as=1.45 ps=10.29 w=10 l=0.9
X924 a_n8609_14110# a_n8609_2082# w_n8809_8685# w_n8809_8685# sky130_fd_pr__pfet_g5v0d10v5 ad=0.2175 pd=1.79 as=0.2175 ps=1.79 w=1.5 l=4
X925 a_n27821_6140# t0 vss vss sky130_fd_pr__nfet_01v8 ad=1.55 pd=10.62 as=0.825 ps=5.33 w=5 l=0.15
X926 vss a_n15687_2040# a_n8609_2082# vss sky130_fd_pr__nfet_g5v0d10v5 ad=0.145 pd=1.29 as=0.145 ps=1.29 w=1 l=4
X927 a_n15687_2040# a_n15687_2040# vss vss sky130_fd_pr__nfet_g5v0d10v5 ad=0.145 pd=1.29 as=0.145 ps=1.29 w=1 l=4
X928 w_n8809_8685# a_n8609_2082# a_n8609_14110# w_n8809_8685# sky130_fd_pr__pfet_g5v0d10v5 ad=0.2175 pd=1.79 as=0.2175 ps=1.79 w=1.5 l=4
X929 a_n15687_2040# a_n15687_2040# vss vss sky130_fd_pr__nfet_g5v0d10v5 ad=0.145 pd=1.29 as=0.145 ps=1.29 w=1 l=4
X930 a_n8639_n20509# a_n8609_14110# quiet vss sky130_fd_pr__nfet_05v0_nvt ad=1.45 pd=10.29 as=1.45 ps=10.29 w=10 l=0.9
X931 a_n24073_2440# vss sky130_fd_pr__cap_mim_m3_1 l=22.2 w=22.2
X932 vin a_n8581_n15597# a_n8639_n20509# vss sky130_fd_pr__nfet_05v0_nvt ad=1.45 pd=10.29 as=1.45 ps=10.29 w=10 l=0.9
X933 a_n8609_4082# a_n8609_4082# vss vss sky130_fd_pr__nfet_g5v0d10v5 ad=0.145 pd=1.29 as=0.145 ps=1.29 w=1 l=4
X934 a_n8609_14110# a_n8609_2082# w_n8809_8685# w_n8809_8685# sky130_fd_pr__pfet_g5v0d10v5 ad=0.2175 pd=1.79 as=0.2175 ps=1.79 w=1.5 l=4
X935 quiet a_n8609_14110# a_n8639_n20509# vss sky130_fd_pr__nfet_05v0_nvt ad=1.45 pd=10.29 as=1.45 ps=10.29 w=10 l=0.9
X936 w_n8809_8685# a_n8609_2082# a_n8609_14110# w_n8809_8685# sky130_fd_pr__pfet_g5v0d10v5 ad=0.2175 pd=1.79 as=0.2175 ps=1.79 w=1.5 l=4
X937 vin a_n8581_n15597# a_n8639_n20509# vss sky130_fd_pr__nfet_05v0_nvt ad=1.45 pd=10.29 as=1.45 ps=10.29 w=10 l=0.9
X938 a_n8639_n20509# a_n8581_n15597# vin vss sky130_fd_pr__nfet_05v0_nvt ad=1.45 pd=10.29 as=1.45 ps=10.29 w=10 l=0.9
X939 vin a_n8581_n15597# a_n8639_n20509# vss sky130_fd_pr__nfet_05v0_nvt ad=1.45 pd=10.29 as=1.45 ps=10.29 w=10 l=0.9
X940 a_n15687_2040# a_n15687_2040# vss vss sky130_fd_pr__nfet_g5v0d10v5 ad=0.145 pd=1.29 as=0.145 ps=1.29 w=1 l=4
X941 a_n8639_n20509# a_n8609_14110# quiet vss sky130_fd_pr__nfet_05v0_nvt ad=1.45 pd=10.29 as=1.45 ps=10.29 w=10 l=0.9
X942 a_n8609_4082# a_n8609_4082# vss vss sky130_fd_pr__nfet_g5v0d10v5 ad=0.145 pd=1.29 as=0.145 ps=1.29 w=1 l=4
X943 a_n8639_n20509# a_n8581_n15597# vin vss sky130_fd_pr__nfet_05v0_nvt ad=1.45 pd=10.29 as=1.45 ps=10.29 w=10 l=0.9
X944 w_n8809_8685# a_n8609_2082# a_n8609_11046# w_n8809_8685# sky130_fd_pr__pfet_g5v0d10v5 ad=0.2175 pd=1.79 as=0.2175 ps=1.79 w=1.5 l=4
X945 vss a_n15687_2040# a_n8609_2082# vss sky130_fd_pr__nfet_g5v0d10v5 ad=0.145 pd=1.29 as=0.145 ps=1.29 w=1 l=4
X946 a_n8609_2082# a_n15687_2040# vss vss sky130_fd_pr__nfet_g5v0d10v5 ad=0.145 pd=1.29 as=0.145 ps=1.29 w=1 l=4
X947 a_n16848_18842# a_n16821_6140# vss sky130_fd_pr__res_high_po w=1 l=49.88
X948 a_n23608_n717# a_n23312_n20595# vss sky130_fd_pr__res_high_po w=1 l=97.39
X949 a_n8609_14110# a_n8609_2082# w_n8809_8685# w_n8809_8685# sky130_fd_pr__pfet_g5v0d10v5 ad=0.2175 pd=1.79 as=0.2175 ps=1.79 w=1.5 l=4
X950 a_n8609_6082# a_n8609_4082# vss vss sky130_fd_pr__nfet_g5v0d10v5 ad=0.145 pd=1.29 as=0.145 ps=1.29 w=1 l=4
X951 a_n15687_2040# a_n15687_2040# vss vss sky130_fd_pr__nfet_g5v0d10v5 ad=0.29 pd=2.58 as=0.145 ps=1.29 w=1 l=4
X952 a_n15687_2040# a_n15687_2040# vss vss sky130_fd_pr__nfet_g5v0d10v5 ad=0.145 pd=1.29 as=0.145 ps=1.29 w=1 l=4
X953 quiet a_n8609_14110# a_n8639_n20509# vss sky130_fd_pr__nfet_05v0_nvt ad=1.45 pd=10.29 as=1.45 ps=10.29 w=10 l=0.9
X954 a_n8609_6082# a_n8609_4082# vss vss sky130_fd_pr__nfet_g5v0d10v5 ad=0.145 pd=1.29 as=0.145 ps=1.29 w=1 l=4
X955 w_n8809_8685# vss sky130_fd_pr__cap_mim_m3_1 l=22.2 w=22.2
X956 a_n8639_n20509# a_n8609_14110# quiet vss sky130_fd_pr__nfet_05v0_nvt ad=1.45 pd=10.29 as=1.45 ps=10.29 w=10 l=0.9
X957 w_n8809_8685# a_n8609_2082# a_n8609_2082# w_n8809_8685# sky130_fd_pr__pfet_g5v0d10v5 ad=0.2175 pd=1.79 as=0.2175 ps=1.79 w=1.5 l=4
X958 a_n8609_6082# a_n8609_4082# vss vss sky130_fd_pr__nfet_g5v0d10v5 ad=0.145 pd=1.29 as=0.145 ps=1.29 w=1 l=4
X959 a_n8639_n20509# a_n8609_14110# quiet vss sky130_fd_pr__nfet_05v0_nvt ad=1.45 pd=10.29 as=1.45 ps=10.29 w=10 l=0.9
X960 a_n24073_2440# vss sky130_fd_pr__cap_mim_m3_1 l=22.2 w=22.2
X961 a_n8609_6082# a_4700_n3568# vss sky130_fd_pr__res_high_po w=1 l=5.12
X962 w_n8809_8685# a_n8609_2082# a_n8609_2082# w_n8809_8685# sky130_fd_pr__pfet_g5v0d10v5 ad=0.2175 pd=1.79 as=0.2175 ps=1.79 w=1.5 l=4
X963 vss a_n15687_2040# a_n8609_2082# vss sky130_fd_pr__nfet_g5v0d10v5 ad=0.145 pd=1.29 as=0.29 ps=2.58 w=1 l=4
X964 w_n8809_8685# a_n8609_2082# a_n8609_11046# w_n8809_8685# sky130_fd_pr__pfet_g5v0d10v5 ad=0.2175 pd=1.79 as=0.2175 ps=1.79 w=1.5 l=4
X965 vin a_n8581_n15597# a_n8639_n20509# vss sky130_fd_pr__nfet_05v0_nvt ad=1.45 pd=10.29 as=1.45 ps=10.29 w=10 l=0.9
X966 a_n8609_14110# a_n8609_2082# w_n8809_8685# w_n8809_8685# sky130_fd_pr__pfet_g5v0d10v5 ad=0.2175 pd=1.79 as=0.2175 ps=1.79 w=1.5 l=4
X967 w_n8809_8685# a_n8609_2082# a_n8609_14110# w_n8809_8685# sky130_fd_pr__pfet_g5v0d10v5 ad=0.2175 pd=1.79 as=0.2175 ps=1.79 w=1.5 l=4
X968 a_n8639_n20509# a_n8581_n15597# vin vss sky130_fd_pr__nfet_05v0_nvt ad=1.45 pd=10.29 as=1.45 ps=10.29 w=10 l=0.9
X969 vss a_n15687_2040# a_n15687_2040# vss sky130_fd_pr__nfet_g5v0d10v5 ad=0.145 pd=1.29 as=0.145 ps=1.29 w=1 l=4
X970 vin a_n8581_n15597# a_n8639_n20509# vss sky130_fd_pr__nfet_05v0_nvt ad=1.45 pd=10.29 as=1.45 ps=10.29 w=10 l=0.9
X971 vss a_n8609_4082# a_n8609_6082# vss sky130_fd_pr__nfet_g5v0d10v5 ad=0.145 pd=1.29 as=0.145 ps=1.29 w=1 l=4
X972 a_n17688_n717# a_n17984_n20595# vss sky130_fd_pr__res_high_po w=1 l=97.39
X973 a_n8581_n15597# vss sky130_fd_pr__cap_mim_m3_1 l=22.2 w=22.2
X974 a_n8639_n20509# a_n8609_14110# quiet vss sky130_fd_pr__nfet_05v0_nvt ad=1.45 pd=10.29 as=1.45 ps=10.29 w=10 l=0.9
X975 a_n20648_n717# a_n20352_n20595# vss sky130_fd_pr__res_high_po w=1 l=97.39
X976 vin a_n8581_n15597# a_n8639_n20509# vss sky130_fd_pr__nfet_05v0_nvt ad=1.45 pd=10.29 as=1.45 ps=10.29 w=10 l=0.9
X977 quiet a_n8609_14110# a_n8639_n20509# vss sky130_fd_pr__nfet_05v0_nvt ad=1.45 pd=10.29 as=1.45 ps=10.29 w=10 l=0.9
X978 w_n8809_8685# vss sky130_fd_pr__cap_mim_m3_1 l=22.2 w=22.2
X979 w_n8809_8685# a_n8609_2082# a_n8609_14110# w_n8809_8685# sky130_fd_pr__pfet_g5v0d10v5 ad=0.2175 pd=1.79 as=0.2175 ps=1.79 w=1.5 l=4
X980 a_n8609_6082# a_n8609_4082# vss vss sky130_fd_pr__nfet_g5v0d10v5 ad=0.145 pd=1.29 as=0.145 ps=1.29 w=1 l=4
X981 vss a_n8609_4082# a_n8609_4082# vss sky130_fd_pr__nfet_g5v0d10v5 ad=0.145 pd=1.29 as=0.145 ps=1.29 w=1 l=4
X982 a_n8639_n20509# a_n8609_14110# quiet vss sky130_fd_pr__nfet_05v0_nvt ad=1.45 pd=10.29 as=1.45 ps=10.29 w=10 l=0.9
X983 a_n8639_n20509# a_n8581_n15597# vin vss sky130_fd_pr__nfet_05v0_nvt ad=1.45 pd=10.29 as=1.45 ps=10.29 w=10 l=0.9
X984 a_n16848_18842# a_n19021_6140# vss sky130_fd_pr__res_high_po w=1 l=49.88
X985 a_n8609_4082# a_n8609_4082# vss vss sky130_fd_pr__nfet_g5v0d10v5 ad=0.145 pd=1.29 as=0.145 ps=1.29 w=1 l=4
X986 a_n24073_2440# vss sky130_fd_pr__cap_mim_m3_1 l=22.2 w=22.2
X987 w_n8809_8685# a_n8609_2082# a_n8609_14110# w_n8809_8685# sky130_fd_pr__pfet_g5v0d10v5 ad=0.2175 pd=1.79 as=0.2175 ps=1.79 w=1.5 l=4
X988 w_n8809_8685# a_n8609_2082# a_n8609_14110# w_n8809_8685# sky130_fd_pr__pfet_g5v0d10v5 ad=0.2175 pd=1.79 as=0.2175 ps=1.79 w=1.5 l=4
X989 w_n8809_8685# a_n8609_2082# a_n8609_14110# w_n8809_8685# sky130_fd_pr__pfet_g5v0d10v5 ad=0.2175 pd=1.79 as=0.2175 ps=1.79 w=1.5 l=4
X990 a_n8609_6082# a_n8609_4082# vss vss sky130_fd_pr__nfet_g5v0d10v5 ad=0.145 pd=1.29 as=0.145 ps=1.29 w=1 l=4
X991 vin a_n8581_n15597# a_n8639_n20509# vss sky130_fd_pr__nfet_05v0_nvt ad=1.45 pd=10.29 as=1.45 ps=10.29 w=10 l=0.9
X992 vss a_n8609_4082# a_n8609_4082# vss sky130_fd_pr__nfet_g5v0d10v5 ad=0.145 pd=1.29 as=0.145 ps=1.29 w=1 l=4
X993 a_n8609_2082# a_n15687_2040# vss vss sky130_fd_pr__nfet_g5v0d10v5 ad=0.145 pd=1.29 as=0.145 ps=1.29 w=1 l=4
X994 w_n8809_8685# a_n8609_2082# a_n8609_14110# w_n8809_8685# sky130_fd_pr__pfet_g5v0d10v5 ad=0.2175 pd=1.79 as=0.2175 ps=1.79 w=1.5 l=4
X995 vss a_n15687_2040# a_n8609_2082# vss sky130_fd_pr__nfet_g5v0d10v5 ad=0.145 pd=1.29 as=0.145 ps=1.29 w=1 l=4
X996 a_n8581_n15597# vss sky130_fd_pr__cap_mim_m3_1 l=22.2 w=22.2
X997 quiet a_n8609_14110# a_n8639_n20509# vss sky130_fd_pr__nfet_05v0_nvt ad=1.45 pd=10.29 as=1.45 ps=10.29 w=10 l=0.9
X998 quiet a_n8609_14110# a_n8639_n20509# vss sky130_fd_pr__nfet_05v0_nvt ad=1.45 pd=10.29 as=1.45 ps=10.29 w=10 l=0.9
X999 a_n8609_14110# a_n8609_2082# w_n8809_8685# w_n8809_8685# sky130_fd_pr__pfet_g5v0d10v5 ad=0.2175 pd=1.79 as=0.2175 ps=1.79 w=1.5 l=4
X1000 w_n8809_8685# vss sky130_fd_pr__cap_mim_m3_1 l=22.2 w=22.2
X1001 a_n8639_n20509# a_n8609_14110# quiet vss sky130_fd_pr__nfet_05v0_nvt ad=1.45 pd=10.29 as=1.45 ps=10.29 w=10 l=0.9
X1002 w_n8809_8685# a_n8609_2082# a_n8609_2082# w_n8809_8685# sky130_fd_pr__pfet_g5v0d10v5 ad=0.2175 pd=1.79 as=0.435 ps=3.58 w=1.5 l=4
X1003 w_n8809_8685# a_n8609_2082# a_n8609_11046# w_n8809_8685# sky130_fd_pr__pfet_g5v0d10v5 ad=0.2175 pd=1.79 as=0.2175 ps=1.79 w=1.5 l=4
X1004 vss a_n8609_4082# a_n8609_6082# vss sky130_fd_pr__nfet_g5v0d10v5 ad=0.145 pd=1.29 as=0.145 ps=1.29 w=1 l=4
X1005 a_n8609_2082# a_n15687_2040# vss vss sky130_fd_pr__nfet_g5v0d10v5 ad=0.145 pd=1.29 as=0.145 ps=1.29 w=1 l=4
X1006 w_n8809_8685# a_n8609_2082# a_n8609_14110# w_n8809_8685# sky130_fd_pr__pfet_g5v0d10v5 ad=0.2175 pd=1.79 as=0.2175 ps=1.79 w=1.5 l=4
X1007 a_n8609_14110# a_n8609_2082# w_n8809_8685# w_n8809_8685# sky130_fd_pr__pfet_g5v0d10v5 ad=0.2175 pd=1.79 as=0.2175 ps=1.79 w=1.5 l=4
X1008 quiet a_n8609_14110# a_n8639_n20509# vss sky130_fd_pr__nfet_05v0_nvt ad=1.45 pd=10.29 as=1.45 ps=10.29 w=10 l=0.9
X1009 quiet a_n8609_14110# a_n8639_n20509# vss sky130_fd_pr__nfet_05v0_nvt ad=1.45 pd=10.29 as=1.45 ps=10.29 w=10 l=0.9
X1010 vss a_n15687_2040# a_n15687_2040# vss sky130_fd_pr__nfet_g5v0d10v5 ad=0.145 pd=1.29 as=0.145 ps=1.29 w=1 l=4
X1011 a_n15687_2040# a_n15687_2040# vss vss sky130_fd_pr__nfet_g5v0d10v5 ad=0.145 pd=1.29 as=0.145 ps=1.29 w=1 l=4
X1012 vss a_n8609_4082# a_n8609_6082# vss sky130_fd_pr__nfet_g5v0d10v5 ad=0.145 pd=1.29 as=0.145 ps=1.29 w=1 l=4
X1013 a_n8639_n20509# a_n8609_14110# quiet vss sky130_fd_pr__nfet_05v0_nvt ad=1.45 pd=10.29 as=1.45 ps=10.29 w=10 l=0.9
X1014 a_n8609_2082# a_n15687_2040# vss vss sky130_fd_pr__nfet_g5v0d10v5 ad=0.145 pd=1.29 as=0.145 ps=1.29 w=1 l=4
X1015 a_n24073_2440# vss sky130_fd_pr__cap_mim_m3_1 l=22.2 w=22.2
X1016 a_n25621_6140# a_n27821_6140# vss sky130_fd_pr__res_high_po w=1 l=5.12
X1017 a_n8609_14110# a_n8609_2082# w_n8809_8685# w_n8809_8685# sky130_fd_pr__pfet_g5v0d10v5 ad=0.2175 pd=1.79 as=0.2175 ps=1.79 w=1.5 l=4
X1018 a_n8609_14110# a_n8609_2082# w_n8809_8685# w_n8809_8685# sky130_fd_pr__pfet_g5v0d10v5 ad=0.2175 pd=1.79 as=0.2175 ps=1.79 w=1.5 l=4
X1019 vss a_47548_n18673# vss sky130_fd_pr__res_high_po w=1 l=78.57
X1020 a_n8609_6082# a_n8609_4082# vss vss sky130_fd_pr__nfet_g5v0d10v5 ad=0.145 pd=1.29 as=0.145 ps=1.29 w=1 l=4
X1021 a_n8609_4082# a_n8609_4082# vss vss sky130_fd_pr__nfet_g5v0d10v5 ad=0.145 pd=1.29 as=0.145 ps=1.29 w=1 l=4
X1022 quiet a_n8609_14110# a_n8639_n20509# vss sky130_fd_pr__nfet_05v0_nvt ad=1.45 pd=10.29 as=1.45 ps=10.29 w=10 l=0.9
X1023 vin a_n8581_n15597# a_n8639_n20509# vss sky130_fd_pr__nfet_05v0_nvt ad=1.45 pd=10.29 as=1.45 ps=10.29 w=10 l=0.9
X1024 w_n8809_8685# a_n8609_2082# a_n8609_11046# w_n8809_8685# sky130_fd_pr__pfet_g5v0d10v5 ad=0.2175 pd=1.79 as=0.2175 ps=1.79 w=1.5 l=4
X1025 w_n8809_8685# a_n8609_2082# a_n8609_11046# w_n8809_8685# sky130_fd_pr__pfet_g5v0d10v5 ad=0.2175 pd=1.79 as=0.2175 ps=1.79 w=1.5 l=4
X1026 w_n8809_8685# a_n8609_2082# a_n8609_11046# w_n8809_8685# sky130_fd_pr__pfet_g5v0d10v5 ad=0.2175 pd=1.79 as=0.2175 ps=1.79 w=1.5 l=4
X1027 a_n8609_4082# a_n8609_4082# vss vss sky130_fd_pr__nfet_g5v0d10v5 ad=0.145 pd=1.29 as=0.145 ps=1.29 w=1 l=4
X1028 quiet a_n8609_14110# a_n8639_n20509# vss sky130_fd_pr__nfet_05v0_nvt ad=1.45 pd=10.29 as=1.45 ps=10.29 w=10 l=0.9
X1029 w_n8809_8685# a_n8609_2082# a_n8609_14110# w_n8809_8685# sky130_fd_pr__pfet_g5v0d10v5 ad=0.2175 pd=1.79 as=0.435 ps=3.58 w=1.5 l=4
X1030 a_n8609_14110# a_n8609_2082# w_n8809_8685# w_n8809_8685# sky130_fd_pr__pfet_g5v0d10v5 ad=0.2175 pd=1.79 as=0.2175 ps=1.79 w=1.5 l=4
X1031 w_n8809_8685# vss sky130_fd_pr__cap_mim_m3_1 l=22.2 w=22.2
X1032 w_n8809_8685# a_n8609_2082# a_n8609_2082# w_n8809_8685# sky130_fd_pr__pfet_g5v0d10v5 ad=0.2175 pd=1.79 as=0.2175 ps=1.79 w=1.5 l=4
X1033 a_n8639_n20509# a_n8609_14110# quiet vss sky130_fd_pr__nfet_05v0_nvt ad=1.45 pd=10.29 as=1.45 ps=10.29 w=10 l=0.9
X1034 w_n8809_8685# a_n8609_2082# a_n8609_11046# w_n8809_8685# sky130_fd_pr__pfet_g5v0d10v5 ad=0.2175 pd=1.79 as=0.2175 ps=1.79 w=1.5 l=4
X1035 a_n8609_4082# a_n8609_4082# vss vss sky130_fd_pr__nfet_g5v0d10v5 ad=0.145 pd=1.29 as=0.145 ps=1.29 w=1 l=4
X1036 w_n8809_8685# a_n8609_2082# a_n8609_14110# w_n8809_8685# sky130_fd_pr__pfet_g5v0d10v5 ad=0.2175 pd=1.79 as=0.2175 ps=1.79 w=1.5 l=4
X1037 w_n8809_8685# a_n8609_2082# a_n8609_14110# w_n8809_8685# sky130_fd_pr__pfet_g5v0d10v5 ad=0.2175 pd=1.79 as=0.2175 ps=1.79 w=1.5 l=4
X1038 a_n8609_14110# a_n8609_2082# w_n8809_8685# w_n8809_8685# sky130_fd_pr__pfet_g5v0d10v5 ad=0.2175 pd=1.79 as=0.2175 ps=1.79 w=1.5 l=4
X1039 quiet a_n8609_14110# a_n8639_n20509# vss sky130_fd_pr__nfet_05v0_nvt ad=1.45 pd=10.29 as=1.45 ps=10.29 w=10 l=0.9
X1040 vin a_n8581_n15597# a_n8639_n20509# vss sky130_fd_pr__nfet_05v0_nvt ad=1.45 pd=10.29 as=1.45 ps=10.29 w=10 l=0.9
X1041 vss a_n15687_2040# a_n15687_2040# vss sky130_fd_pr__nfet_g5v0d10v5 ad=0.145 pd=1.29 as=0.29 ps=2.58 w=1 l=4
X1042 quiet a_n8609_14110# a_n8639_n20509# vss sky130_fd_pr__nfet_05v0_nvt ad=1.45 pd=10.29 as=1.45 ps=10.29 w=10 l=0.9
X1043 a_n16821_6140# t5 a_n19021_6140# vss sky130_fd_pr__nfet_01v8 ad=1.55 pd=10.62 as=0.825 ps=5.33 w=5 l=0.15
X1044 w_n8809_8685# a_n8609_2082# a_n8609_14110# w_n8809_8685# sky130_fd_pr__pfet_g5v0d10v5 ad=0.2175 pd=1.79 as=0.2175 ps=1.79 w=1.5 l=4
X1045 a_n8609_2082# a_n8609_2082# w_n8809_8685# w_n8809_8685# sky130_fd_pr__pfet_g5v0d10v5 ad=0.2175 pd=1.79 as=0.2175 ps=1.79 w=1.5 l=4
X1046 a_n8639_n20509# a_n8581_n15597# vin vss sky130_fd_pr__nfet_05v0_nvt ad=1.45 pd=10.29 as=1.45 ps=10.29 w=10 l=0.9
X1047 w_n8809_8685# a_n8609_2082# a_n8609_14110# w_n8809_8685# sky130_fd_pr__pfet_g5v0d10v5 ad=0.2175 pd=1.79 as=0.2175 ps=1.79 w=1.5 l=4
X1048 vss a_n8609_4082# a_n8609_4082# vss sky130_fd_pr__nfet_g5v0d10v5 ad=0.145 pd=1.29 as=0.145 ps=1.29 w=1 l=4
X1049 w_n8809_8685# vss sky130_fd_pr__cap_mim_m3_1 l=22.2 w=22.2
X1050 host enable a_n25673_2540# host sky130_fd_pr__pfet_01v8 ad=0.58 pd=4.58 as=0.58 ps=4.58 w=2 l=0.15
X1051 a_n23016_n717# a_n23312_n20595# vss sky130_fd_pr__res_high_po w=1 l=97.39
X1052 a_n8609_14110# a_n8609_2082# w_n8809_8685# w_n8809_8685# sky130_fd_pr__pfet_g5v0d10v5 ad=0.2175 pd=1.79 as=0.2175 ps=1.79 w=1.5 l=4
X1053 a_n8609_6082# a_n8609_4082# vss vss sky130_fd_pr__nfet_g5v0d10v5 ad=0.145 pd=1.29 as=0.145 ps=1.29 w=1 l=4
X1054 quiet a_n8609_14110# a_n8639_n20509# vss sky130_fd_pr__nfet_05v0_nvt ad=1.45 pd=10.29 as=1.45 ps=10.29 w=10 l=0.9
X1055 a_n8639_n20509# a_n8581_n15597# vin vss sky130_fd_pr__nfet_05v0_nvt ad=1.45 pd=10.29 as=1.45 ps=10.29 w=10 l=0.9
X1056 w_n8809_8685# a_n8609_2082# a_n8609_14110# w_n8809_8685# sky130_fd_pr__pfet_g5v0d10v5 ad=0.2175 pd=1.79 as=0.2175 ps=1.79 w=1.5 l=4
X1057 a_n8609_4082# a_n8609_4082# vss vss sky130_fd_pr__nfet_g5v0d10v5 ad=0.145 pd=1.29 as=0.145 ps=1.29 w=1 l=4
X1058 vss a_n8609_4082# a_n8609_6082# vss sky130_fd_pr__nfet_g5v0d10v5 ad=0.145 pd=1.29 as=0.29 ps=2.58 w=1 l=4
X1059 vss a_n15687_2040# a_n8609_2082# vss sky130_fd_pr__nfet_g5v0d10v5 ad=0.145 pd=1.29 as=0.145 ps=1.29 w=1 l=4
X1060 vss a_n15687_2040# a_n15687_2040# vss sky130_fd_pr__nfet_g5v0d10v5 ad=0.145 pd=1.29 as=0.145 ps=1.29 w=1 l=4
X1061 a_n8609_14110# a_n8609_2082# w_n8809_8685# w_n8809_8685# sky130_fd_pr__pfet_g5v0d10v5 ad=0.435 pd=3.58 as=0.2175 ps=1.79 w=1.5 l=4
X1062 a_n8609_2082# a_n15687_2040# vss vss sky130_fd_pr__nfet_g5v0d10v5 ad=0.145 pd=1.29 as=0.145 ps=1.29 w=1 l=4
X1063 quiet vss sky130_fd_pr__cap_mim_m3_1 l=22.2 w=22.2
X1064 a_n8639_n20509# a_n8609_14110# quiet vss sky130_fd_pr__nfet_05v0_nvt ad=1.45 pd=10.29 as=1.45 ps=10.29 w=10 l=0.9
C0 bg a_n24073_2440# 0.09098f
C1 a_n19168_n20595# a_n24073_2440# 0.01941f
C2 quiet a_4700_n3568# 0.16158f
C3 a_n8609_6082# a_n8609_11046# 1.18819f
C4 t3 a_n23421_6140# 0.43f
C5 host a_n24073_2440# 0.22263f
C6 a_n14744_18586# a_n14152_18586# 0.15377f
C7 a_n8609_6082# a_n15687_2040# 4.34195f
C8 a_n17984_n20595# a_n18576_n20595# 0.15377f
C9 a_n21221_6140# a_n23421_6140# 1.91649f
C10 a_n19021_6140# t5 0.43007f
C11 a_n21240_n717# a_n24073_2440# 0.07982f
C12 a_n8581_n15597# a_n8609_11046# 0.0107f
C13 a_n22424_n717# a_n27185_2440# 0
C14 a_n24073_2440# w_n8809_8685# 0.75453f
C15 a_n8581_n15597# a_n15687_2040# 0.00596f
C16 a_n19760_n20595# a_n24073_2440# 0.01941f
C17 quiet a_n8609_6082# 0.01683f
C18 a_n8609_14110# a_n24073_2440# 0.13954f
C19 quiet a_n8581_n15597# 0.20572f
C20 a_n13856_8466# a_n24073_2440# 1.32246f
C21 vin a_4700_n3568# 0.25868f
C22 a_n22424_n717# a_n24073_2440# 0.08812f
C23 enable a_n27185_2440# 0.07873f
C24 vgi a_n24073_2440# 0.02365f
C25 a_n21832_n717# a_n27185_2440# 0
C26 a_n13856_8466# a_n14448_8466# 0.16074f
C27 a_n8609_4082# a_n8609_2082# 1.98831f
C28 w_n8809_8685# a_4700_n3568# 0.17799f
C29 a_n20352_n20595# a_n24073_2440# 0.01239f
C30 a_n13856_8466# a_n16821_6140# 0.00316f
C31 a_n8581_n15597# vin 0.15932p
C32 enable a_n24073_2440# 0.00754f
C33 t5 a_n16821_6140# 0.43737f
C34 a_n8609_14110# a_4700_n3568# 87.6491f
C35 a_n21832_n717# a_n24073_2440# 0.08622f
C36 a_n8609_6082# w_n8809_8685# 2.56643f
C37 a_n24200_n717# a_n27185_2440# 0.00144f
C38 a_n17096_n717# a_n17688_n717# 0.15377f
C39 a_n8609_6082# a_n8609_14110# 3.404f
C40 a_n8581_n15597# w_n8809_8685# 1.52739f
C41 a_n8609_6082# a_n13856_8466# 0.15103f
C42 a_n23904_n20595# a_n23312_n20595# 0.15377f
C43 a_n24073_2440# a_n20648_n717# 0.07291f
C44 a_n8581_n15597# a_n8609_14110# 7.73457f
C45 a_n15687_2040# a_n25673_2540# 1.37429f
C46 a_n24200_n717# a_n24073_2440# 0.0882f
C47 a_n16800_n20595# a_n16208_n20595# 0.15377f
C48 a_n16800_n20595# a_n24073_2440# 0.01941f
C49 quiet a_n8639_n20509# 58.628f
C50 t2 a_n25621_6140# 0.43f
C51 a_n24496_n20595# a_n24073_2440# 0.01941f
C52 quiet a_n25673_2540# 0.92645f
C53 a_n19021_6140# a_n16848_18842# 0.00769f
C54 a_n23608_n717# bg 0
C55 a_n8609_11046# a_n15687_2040# 1.23231f
C56 a_n22720_n20595# a_n24073_2440# 0.01941f
C57 a_n17688_n717# a_n18280_n717# 0.15377f
C58 a_n23016_n717# a_n27185_2440# 0
C59 a_n8639_n20509# vin 0.13231p
C60 quiet a_n15687_2040# 0.19053f
C61 a_n21536_n20595# a_n20944_n20595# 0.15377f
C62 bg a_n25673_2540# 0.09676f
C63 a_n23016_n717# a_n24073_2440# 0.09349f
C64 a_n22720_n20595# a_n22128_n20595# 0.15377f
C65 t1 a_n25621_6140# 0.43932f
C66 host a_n25673_2540# 0.80084f
C67 vin a_n8609_11046# 0.00194f
C68 vin a_n15687_2040# 0.01188f
C69 a_n24073_2440# a_n20944_n20595# 0.00241f
C70 a_n8609_14110# a_n8639_n20509# 79.1501f
C71 a_n24073_2440# a_n8609_4082# 0.10936f
C72 a_n24496_n20595# a_n25088_n20595# 0.15377f
C73 a_n16504_n717# a_n24073_2440# 0.26482f
C74 a_n8609_14110# a_n25673_2540# 0.51514f
C75 quiet vin 0.14293f
C76 host a_n15687_2040# 1.58329f
C77 a_n8609_6082# a_n8609_2082# 1.24343f
C78 a_n13856_8466# a_n25673_2540# 0.32552f
C79 a_n8609_11046# w_n8809_8685# 18.4493f
C80 a_n15687_2040# w_n8809_8685# 3.79415f
C81 a_n20648_n717# a_n20056_n717# 0.15377f
C82 a_n8581_n15597# a_n8609_2082# 0.29664f
C83 a_n24792_n717# bg 0
C84 a_n8609_14110# a_n8609_11046# 0.21921f
C85 vgi a_n25673_2540# 0.41284f
C86 a_n8609_14110# a_n15687_2040# 1.51422f
C87 a_n13856_8466# a_n8609_11046# 1.01693f
C88 a_n13856_8466# a_n15687_2040# 0.42015f
C89 a_n19021_6140# a_n21221_6140# 1.91649f
C90 a_n21536_n20595# a_n24073_2440# 0.01941f
C91 a_n19168_n20595# a_n18576_n20595# 0.15377f
C92 a_n24073_2440# a_n27185_2440# 0.60655f
C93 quiet a_n8609_14110# 72.068f
C94 enable a_n25673_2540# 1.56749f
C95 a_n18872_n717# a_n24073_2440# 0.08977f
C96 quiet a_n13856_8466# 0.47845f
C97 vgi a_n15687_2040# 2.77572f
C98 a_n23608_n717# a_n24200_n717# 0.15377f
C99 a_n25621_6140# a_n27821_6140# 1.93071f
C100 a_n8609_6082# a_n8609_4082# 20.8688f
C101 host bg 0.36873f
C102 t1 a_n27821_6140# 0.43f
C103 a_n16800_n20595# a_n17392_n20595# 0.15377f
C104 t0 a_n27821_6140# 0.44139f
C105 a_n19021_6140# a_n16821_6140# 2.07298f
C106 vin w_n8809_8685# 0.68395f
C107 a_n16208_n20595# a_n24073_2440# 0.01352f
C108 a_n21221_6140# t3 0.43932f
C109 a_n8581_n15597# a_n8609_4082# 0.00596f
C110 a_n21536_n20595# a_n22128_n20595# 0.15377f
C111 a_n19760_n20595# a_n19168_n20595# 0.15377f
C112 a_n8609_14110# vin 4.79646f
C113 a_n13856_8466# vin 0
C114 a_n22720_n20595# a_n23312_n20595# 0.15377f
C115 a_n17984_n20595# a_n24073_2440# 0.01965f
C116 a_n22424_n717# bg 0
C117 a_n22128_n20595# a_n24073_2440# 0.01941f
C118 a_n8609_14110# w_n8809_8685# 39.3225f
C119 a_n23608_n717# a_n23016_n717# 0.15377f
C120 a_n13856_8466# w_n8809_8685# 0.66943f
C121 a_n25673_2540# a_n8609_2082# 0.0021f
C122 host vgi 9.58983f
C123 a_n19464_n717# a_n18872_n717# 0.15377f
C124 bg enable 0.0773f
C125 a_n8609_14110# a_n13856_8466# 0.20883f
C126 a_n16504_n717# a_n17096_n717# 0.15377f
C127 a_n14448_8466# a_n16821_6140# 0.16061f
C128 host enable 0.42454f
C129 a_n8609_6082# a_n24073_2440# 1.29894f
C130 bg a_n21832_n717# 0
C131 a_n25088_n20595# a_n24073_2440# 0.01941f
C132 a_n8609_11046# a_n8609_2082# 27.7727f
C133 a_n24496_n20595# a_n23904_n20595# 0.15377f
C134 a_n15687_2040# a_n8609_2082# 16.6035f
C135 a_n24792_n717# a_n24200_n717# 0.15377f
C136 a_n19760_n20595# a_n20352_n20595# 0.15377f
C137 a_n19464_n717# a_n24073_2440# 0.087f
C138 quiet a_n8609_2082# 0.01683f
C139 a_n21240_n717# a_n21832_n717# 0.15377f
C140 bg a_n24200_n717# 0
C141 a_n24073_2440# a_n20056_n717# 0.08532f
C142 a_n23608_n717# a_n27185_2440# 0
C143 a_n8609_6082# a_4700_n3568# 0.00724f
C144 a_n21240_n717# a_n20648_n717# 0.15377f
C145 a_n22424_n717# a_n21832_n717# 0.15377f
C146 a_n8609_11046# a_n8609_4082# 2.04588f
C147 a_n17096_n717# a_n24073_2440# 0.09467f
C148 a_46956_n18673# a_47548_n18673# 0.15377f
C149 a_n15687_2040# a_n8609_4082# 2.02834f
C150 a_n8581_n15597# a_4700_n3568# 0.27563f
C151 quiet a_47252_n2559# 0.16023f
C152 a_n23608_n717# a_n24073_2440# 0.09391f
C153 quiet a_n8609_4082# 0.08132f
C154 a_n17392_n20595# a_n24073_2440# 0.01941f
C155 a_n8581_n15597# a_n8609_6082# 0.00341f
C156 a_n27185_2440# a_n25673_2540# 0.09602f
C157 a_n8609_2082# w_n8809_8685# 0.52003p
C158 a_n18872_n717# a_n18280_n717# 0.15377f
C159 a_n24073_2440# a_n23312_n20595# 0.02037f
C160 a_n23016_n717# bg 0
C161 a_n8609_14110# a_n8609_2082# 82.5728f
C162 a_n13856_8466# a_n8609_2082# 0.02674f
C163 a_n17392_n20595# a_n17984_n20595# 0.15377f
C164 t2 a_n23421_6140# 0.43932f
C165 a_n24073_2440# a_n25673_2540# 0.32277f
C166 a_n24073_2440# a_n18280_n717# 0.09916f
C167 a_n19021_6140# t4 0.43932f
C168 a_n19464_n717# a_n20056_n717# 0.15377f
C169 a_n24073_2440# a_n8609_11046# 1.19278f
C170 a_n24792_n717# a_n27185_2440# 0.16309f
C171 a_n24073_2440# a_n15687_2040# 0.31672f
C172 a_n8609_4082# w_n8809_8685# 4.97777f
C173 a_n22424_n717# a_n23016_n717# 0.15377f
C174 a_n8639_n20509# a_4700_n3568# 0.06798f
C175 a_n23904_n20595# a_n24073_2440# 0.01941f
C176 t4 a_n21221_6140# 0.43f
C177 a_n8609_14110# a_n8609_4082# 1.50247f
C178 quiet a_n24073_2440# 0.34841f
C179 a_n25621_6140# a_n23421_6140# 1.91649f
C180 a_n13856_8466# a_n8609_4082# 1.41919f
C181 a_n24792_n717# a_n24073_2440# 0.07934f
C182 bg a_n27185_2440# 1.45579f
C183 a_n24073_2440# a_n17688_n717# 0.09198f
C184 host a_n27185_2440# 0.45593f
C185 a_n24073_2440# a_n18576_n20595# 0.01941f
C186 a_n8581_n15597# a_n8639_n20509# 0.15563p
C187 a_n20352_n20595# a_n20944_n20595# 0.15377f
C188 vin a_n24073_2440# 0
C189 a_n21240_n717# a_n27185_2440# 0
C190 vin vss 55.7777f
C191 vgi vss 1.63608f
C192 bg vss 3.07306f
C193 enable vss 3.85058f
C194 t5 vss 1.06072f
C195 t4 vss 1.15327f
C196 t3 vss 1.15327f
C197 t2 vss 1.15327f
C198 t1 vss 1.15327f
C199 t0 vss 1.62191f
C200 quiet vss 0.24315p
C201 host vss 24.3692f
C202 a_47548_n18673# vss 0.9153f
C203 a_47252_n2559# vss 0.81257f
C204 a_46956_n18673# vss 0.79505f
C205 a_n8639_n20509# vss 5.0087f
C206 a_n8581_n15597# vss 0.83485p
C207 a_4700_n3568# vss 6.72849f
C208 a_n16208_n20595# vss 1.03394f
C209 a_n16504_n717# vss 0.70824f
C210 a_n16800_n20595# vss 0.86548f
C211 a_n17096_n717# vss 0.7057f
C212 a_n17392_n20595# vss 0.86358f
C213 a_n17688_n717# vss 0.70566f
C214 a_n17984_n20595# vss 0.86285f
C215 a_n18280_n717# vss 0.70566f
C216 a_n18576_n20595# vss 0.86285f
C217 a_n18872_n717# vss 0.70566f
C218 a_n19168_n20595# vss 0.86518f
C219 a_n19464_n717# vss 0.70566f
C220 a_n19760_n20595# vss 0.87038f
C221 a_n20056_n717# vss 0.70566f
C222 a_n20352_n20595# vss 0.89518f
C223 a_n20648_n717# vss 0.68835f
C224 a_n20944_n20595# vss 0.90775f
C225 a_n21240_n717# vss 0.70566f
C226 a_n21536_n20595# vss 0.87191f
C227 a_n21832_n717# vss 0.70566f
C228 a_n22128_n20595# vss 0.86627f
C229 a_n22424_n717# vss 0.70566f
C230 a_n22720_n20595# vss 0.86285f
C231 a_n23016_n717# vss 0.70566f
C232 a_n23312_n20595# vss 0.86285f
C233 a_n23608_n717# vss 0.70566f
C234 a_n23904_n20595# vss 0.86286f
C235 a_n24200_n717# vss 0.7057f
C236 a_n24496_n20595# vss 0.86456f
C237 a_n24792_n717# vss 0.70824f
C238 a_n25088_n20595# vss 1.0277f
C239 a_n15687_2040# vss 0.15016p
C240 a_n24073_2440# vss 0.71056p
C241 a_n25673_2540# vss 12.2226f
C242 a_n27185_2440# vss 3.56439f
C243 a_n8609_6082# vss 20.1955f
C244 a_n8609_4082# vss 0.14536p
C245 a_n8609_11046# vss 7.65766f
C246 a_n8609_14110# vss 80.3219f
C247 a_n12048_20734# vss 0.94225f
C248 a_n13856_8466# vss 8.23167f
C249 a_n14152_18586# vss 0.79459f
C250 a_n14448_8466# vss 0.76825f
C251 a_n14744_18586# vss 0.79459f
C252 a_n16821_6140# vss 3.79253f
C253 a_n16848_18842# vss 0.94208f
C254 a_n19021_6140# vss 9.08249f
C255 a_n21221_6140# vss 7.06911f
C256 a_n23421_6140# vss 5.95789f
C257 a_n25621_6140# vss 5.37992f
C258 a_n27821_6140# vss 7.41946f
C259 w_n8809_8685# vss 2.07855p
.ends
