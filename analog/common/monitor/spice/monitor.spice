* Monitor toolkit (2026-11-09): slow continuous-time comparator and current x resistor threshold ladders.
* Generic cells; a user (e.g. the PLL Vctrl window) instantiates them with its own codes and currents.
* Needs devices/spice/sky130_primitives.spice, sky130_pfet_lvt.spice, cmos_logic.spice.
*
* serdes_cmp: out = 1 when inp > inn (CMOS levels).  Two stages + two inverters.
*   First stage: LVT NMOS pair (diode side gate inn, output side gate inp) with an LVT PMOS mirror; the pair
*   sits in weak inversion and the mirror in moderate inversion, so the mirror's mismatch (pfet_lvt A_VT is
*   ~20 mV um against ~8 for nfet_lvt) enters the input offset scaled by gm_p / gm_n ~ 1/3.
*   Second stage: LVT PMOS common source on o1, W ratioed to the mirror (m2 * ib against ib / 2 per side), so
*   the balanced first-stage voltage gives exactly the sink current: no systematic offset.  NMOS sink.
*   Input range: NMOS pair -> the low end is set by the tail headroom (Vin - Vgs >= ~0.1 V), the high end by
*   the pair staying saturated (Vin - o1 < Vth; o1 ~ VDD - |Vgs| of the LVT mirror).
*   Bias: ib is a sink-current input (nominal 2.5 uA, one serdes_bias_pcopy finger); tail = ib, second
*   stage = m2 * ib.  Static ~ (1 + m2 + 1) * ib from vdd (diode, tail, second stage).
.subckt serdes_cmp inp inn out ib vdd vss
+ params: win=16 lin=2 wl=8 ll=8 wb=4 lb=2 m2=1 wi=1
Xbd ib ib vss vss serdes_nfet w={wb} l={lb}
Xt tail ib vss vss serdes_nfet w={wb} l={lb}
Xa da inn tail vss serdes_nfet_lvt w={win} l={lin}
Xb o1 inp tail vss serdes_nfet_lvt w={win} l={lin}
Xla da da vdd vdd serdes_pfet_lvt w={wl} l={ll}
Xlb o1 da vdd vdd serdes_pfet_lvt w={wl} l={ll}
* second stage: PMOS width 2 * m2 * wl carries m2 * ib at the balanced o1; inp > inn pulls o1 down -> o2 high
Xp2 o2 o1 vdd vdd serdes_pfet_lvt w={2*m2*wl} l={ll} nf=2
Xn2 o2 ib vss vss serdes_nfet w={m2*wb} l={lb}
Xi1 o2 o2b vdd vss serdes_cmos_inv wn={wi} wp={2*wi}
Xi2 o2b out vdd vss serdes_cmos_inv wn={wi} wp={2*wi}
.ends serdes_cmp

* serdes_cmp_hv: serdes_cmp for inputs near VDD (the PLL window's upper threshold VDD - 0.32 .. 0.77 V).  At an input
* of VDD - 0.35 V the LVT pair of serdes_cmp enters triode at SF 1.65 V -40 C (MC sigma 12.6 mV, one sample without a
* trip in +-30 mV; cmp_mc 20261109T144617Z).  Here the pair is a regular nfet (Vth ~0.15-0.2 V above LVT: the pair
* stays saturated up to a higher input; A_VT 5.4 against 7.9 mV um) and the LVT mirror is twice as wide (smaller
* |Vgs|, o1 sits higher).  The low end of the input range moves up to ~0.8 V.  Same ports and bias.
.subckt serdes_cmp_hv inp inn out ib vdd vss
+ params: win=16 lin=2 wl=16 ll=8 wb=4 lb=2 m2=1 wi=1
Xbd ib ib vss vss serdes_nfet w={wb} l={lb}
Xt tail ib vss vss serdes_nfet w={wb} l={lb}
Xa da inn tail vss serdes_nfet w={win} l={lin}
Xb o1 inp tail vss serdes_nfet w={win} l={lin}
Xla da da vdd vdd serdes_pfet_lvt w={wl} l={ll}
Xlb o1 da vdd vdd serdes_pfet_lvt w={wl} l={ll}
Xp2 o2 o1 vdd vdd serdes_pfet_lvt w={2*m2*wl} l={ll} nf=2
Xn2 o2 ib vss vss serdes_nfet w={m2*wb} l={lb}
Xi1 o2 o2b vdd vss serdes_cmos_inv wn={wi} wp={2*wi}
Xi2 o2b out vdd vss serdes_cmos_inv wn={wi} wp={2*wi}
.ends serdes_cmp_hv

* serdes_vref_gnd: out = I(iin) x R(code) to vss.  iin is a sourced current (a bandgap copy); the high_po string
* r0 + code * rstep (code 0..15) is the same resistor type as the bandgap's r_ref, so out = vbg x R / r_ref x
* (copy ratio) holds over resistor corners.  Taps reach out through a 16:1 transmission-gate mux (gate loads
* only, no DC current); the decode of the static code parameter is behavioural.
.subckt serdes_vref_gnd iin out vdd vss params: code=8 r0=160k rstep=2.667k
Xr0 t0 vss vss sky130_fd_pr__res_high_po w=1 l={(r0-378)/317}
Xr1 t1 t0 vss sky130_fd_pr__res_high_po w=1 l={(rstep-378)/317}
Xr2 t2 t1 vss sky130_fd_pr__res_high_po w=1 l={(rstep-378)/317}
Xr3 t3 t2 vss sky130_fd_pr__res_high_po w=1 l={(rstep-378)/317}
Xr4 t4 t3 vss sky130_fd_pr__res_high_po w=1 l={(rstep-378)/317}
Xr5 t5 t4 vss sky130_fd_pr__res_high_po w=1 l={(rstep-378)/317}
Xr6 t6 t5 vss sky130_fd_pr__res_high_po w=1 l={(rstep-378)/317}
Xr7 t7 t6 vss sky130_fd_pr__res_high_po w=1 l={(rstep-378)/317}
Xr8 t8 t7 vss sky130_fd_pr__res_high_po w=1 l={(rstep-378)/317}
Xr9 t9 t8 vss sky130_fd_pr__res_high_po w=1 l={(rstep-378)/317}
Xr10 t10 t9 vss sky130_fd_pr__res_high_po w=1 l={(rstep-378)/317}
Xr11 t11 t10 vss sky130_fd_pr__res_high_po w=1 l={(rstep-378)/317}
Xr12 t12 t11 vss sky130_fd_pr__res_high_po w=1 l={(rstep-378)/317}
Xr13 t13 t12 vss sky130_fd_pr__res_high_po w=1 l={(rstep-378)/317}
Xr14 t14 t13 vss sky130_fd_pr__res_high_po w=1 l={(rstep-378)/317}
Xr15 iin t14 vss sky130_fd_pr__res_high_po w=1 l={(rstep-378)/317}
Vt15 iin t15 0
Xmux t0 t1 t2 t3 t4 t5 t6 t7 t8 t9 t10 t11 t12 t13 t14 t15 out vdd vss serdes_tap_mux16 code={code}
.ends serdes_vref_gnd

* serdes_vref_vdd: out = vdd - I(iin) x R(code).  iin (sourced) sets an NMOS diode; the mirror sinks the same
* current through a high_po string from vdd (top segment r0, then 15 x rstep down to the sink).  Same tap mux.
* The sink needs out - I x R... >= ~0.2 V: at the bottom of the string the voltage is vdd - I (r0 + 15 rstep).
.subckt serdes_vref_vdd iin out vdd vss params: code=8 r0=66k rstep=2k wsn=4 lsn=4
Xd iin iin vss vss serdes_nfet w={wsn} l={lsn}
Xs t15 iin vss vss serdes_nfet w={wsn} l={lsn}
Xr0 vdd t0 vss sky130_fd_pr__res_high_po w=1 l={(r0-378)/317}
Xr1 t0 t1 vss sky130_fd_pr__res_high_po w=1 l={(rstep-378)/317}
Xr2 t1 t2 vss sky130_fd_pr__res_high_po w=1 l={(rstep-378)/317}
Xr3 t2 t3 vss sky130_fd_pr__res_high_po w=1 l={(rstep-378)/317}
Xr4 t3 t4 vss sky130_fd_pr__res_high_po w=1 l={(rstep-378)/317}
Xr5 t4 t5 vss sky130_fd_pr__res_high_po w=1 l={(rstep-378)/317}
Xr6 t5 t6 vss sky130_fd_pr__res_high_po w=1 l={(rstep-378)/317}
Xr7 t6 t7 vss sky130_fd_pr__res_high_po w=1 l={(rstep-378)/317}
Xr8 t7 t8 vss sky130_fd_pr__res_high_po w=1 l={(rstep-378)/317}
Xr9 t8 t9 vss sky130_fd_pr__res_high_po w=1 l={(rstep-378)/317}
Xr10 t9 t10 vss sky130_fd_pr__res_high_po w=1 l={(rstep-378)/317}
Xr11 t10 t11 vss sky130_fd_pr__res_high_po w=1 l={(rstep-378)/317}
Xr12 t11 t12 vss sky130_fd_pr__res_high_po w=1 l={(rstep-378)/317}
Xr13 t12 t13 vss sky130_fd_pr__res_high_po w=1 l={(rstep-378)/317}
Xr14 t13 t14 vss sky130_fd_pr__res_high_po w=1 l={(rstep-378)/317}
Xr15 t14 t15 vss sky130_fd_pr__res_high_po w=1 l={(rstep-378)/317}
Xmux t0 t1 t2 t3 t4 t5 t6 t7 t8 t9 t10 t11 t12 t13 t14 t15 out vdd vss serdes_tap_mux16 code={code}
.ends serdes_vref_vdd

* 16:1 transmission-gate mux, static code (behavioural decode, one select at vdd).
.subckt serdes_tap_mux16 t0 t1 t2 t3 t4 t5 t6 t7 t8 t9 t10 t11 t12 t13 t14 t15 out vdd vss params: code=8
Bs0 s0 vss V=(abs(code-0)<0.5)*v(vdd)
Bs1 s1 vss V=(abs(code-1)<0.5)*v(vdd)
Bs2 s2 vss V=(abs(code-2)<0.5)*v(vdd)
Bs3 s3 vss V=(abs(code-3)<0.5)*v(vdd)
Bs4 s4 vss V=(abs(code-4)<0.5)*v(vdd)
Bs5 s5 vss V=(abs(code-5)<0.5)*v(vdd)
Bs6 s6 vss V=(abs(code-6)<0.5)*v(vdd)
Bs7 s7 vss V=(abs(code-7)<0.5)*v(vdd)
Bs8 s8 vss V=(abs(code-8)<0.5)*v(vdd)
Bs9 s9 vss V=(abs(code-9)<0.5)*v(vdd)
Bs10 s10 vss V=(abs(code-10)<0.5)*v(vdd)
Bs11 s11 vss V=(abs(code-11)<0.5)*v(vdd)
Bs12 s12 vss V=(abs(code-12)<0.5)*v(vdd)
Bs13 s13 vss V=(abs(code-13)<0.5)*v(vdd)
Bs14 s14 vss V=(abs(code-14)<0.5)*v(vdd)
Bs15 s15 vss V=(abs(code-15)<0.5)*v(vdd)
Xi0 s0 sb0 vdd vss serdes_cmos_inv
Xi1 s1 sb1 vdd vss serdes_cmos_inv
Xi2 s2 sb2 vdd vss serdes_cmos_inv
Xi3 s3 sb3 vdd vss serdes_cmos_inv
Xi4 s4 sb4 vdd vss serdes_cmos_inv
Xi5 s5 sb5 vdd vss serdes_cmos_inv
Xi6 s6 sb6 vdd vss serdes_cmos_inv
Xi7 s7 sb7 vdd vss serdes_cmos_inv
Xi8 s8 sb8 vdd vss serdes_cmos_inv
Xi9 s9 sb9 vdd vss serdes_cmos_inv
Xi10 s10 sb10 vdd vss serdes_cmos_inv
Xi11 s11 sb11 vdd vss serdes_cmos_inv
Xi12 s12 sb12 vdd vss serdes_cmos_inv
Xi13 s13 sb13 vdd vss serdes_cmos_inv
Xi14 s14 sb14 vdd vss serdes_cmos_inv
Xi15 s15 sb15 vdd vss serdes_cmos_inv
Xg0 t0 out s0 sb0 vdd vss serdes_cmos_tgate
Xg1 t1 out s1 sb1 vdd vss serdes_cmos_tgate
Xg2 t2 out s2 sb2 vdd vss serdes_cmos_tgate
Xg3 t3 out s3 sb3 vdd vss serdes_cmos_tgate
Xg4 t4 out s4 sb4 vdd vss serdes_cmos_tgate
Xg5 t5 out s5 sb5 vdd vss serdes_cmos_tgate
Xg6 t6 out s6 sb6 vdd vss serdes_cmos_tgate
Xg7 t7 out s7 sb7 vdd vss serdes_cmos_tgate
Xg8 t8 out s8 sb8 vdd vss serdes_cmos_tgate
Xg9 t9 out s9 sb9 vdd vss serdes_cmos_tgate
Xg10 t10 out s10 sb10 vdd vss serdes_cmos_tgate
Xg11 t11 out s11 sb11 vdd vss serdes_cmos_tgate
Xg12 t12 out s12 sb12 vdd vss serdes_cmos_tgate
Xg13 t13 out s13 sb13 vdd vss serdes_cmos_tgate
Xg14 t14 out s14 sb14 vdd vss serdes_cmos_tgate
Xg15 t15 out s15 sb15 vdd vss serdes_cmos_tgate
.ends serdes_tap_mux16

* serdes_window_cmp: hi = 1 when in > vhi, lo = 1 when in < vlo.  Two serdes_cmp, each with its own bias input
* (separate copies keep one comparator's switching off the other's bias).
.subckt serdes_window_cmp in vlo vhi hi lo ibh ibl vdd vss
Xh in vhi hi ibh vdd vss serdes_cmp
Xl vlo in lo ibl vdd vss serdes_cmp
.ends serdes_window_cmp

* serdes_tsense_vbe: temperature-sensing voltage out = VBE(Q, I) + I x rs, with I the current sourced into out (a
* bandgap copy, nominal 10 uA = four serdes_bias_pcopy fingers).  Q is the bandgap's PNP type (collector and base at
* vss); rs (high_po) lifts the level into serdes_cmp's input range.  out falls ~1.8 mV/K (VBE); I x rs = vbg x rs /
* r_ref is a ratio and flat over resistor corners.  Compared against serdes_vref_gnd (same current, a ladder) the
* trip temperature of each ladder code depends on VBE's process spread, the copy ratio and the comparator offset,
* not on the resistor corner.  The bias block is not touched (no PTAT tap on its core loop).
.subckt serdes_tsense_vbe out vss params: rs=23k m=1
Xrs out e vss sky130_fd_pr__res_high_po w=1 l={(rs-378)/317}
Xq vss vss e sky130_fd_pr__pnp_05v5_W3p40L3p40 m={m}
.ends serdes_tsense_vbe
