* Real-PDK Static CMOS Monitor Toolkit (Zero B-sources, Zero Ideal Probes)
* Isolated tapeout-clean companion to analog/common/monitor/spice/monitor.spice.
* Dependencies:
*   analog/common/devices/spice/sky130_primitives.spice
*   analog/common/devices/spice/sky130_pfet_lvt.spice
*   analog/common/devices/spice/cmos_logic.spice
*   analog/common/monitor/spice/monitor.spice (for serdes_cmp, serdes_cmp_hv, serdes_tsense_vbe)
*
* Replaces the 16 behavioral B-sources in `serdes_tap_mux16` with a static CMOS
* 2+2 pre-decoded 4->16 one-hot decoder driving 16 real transmission gates.

.subckt serdes_tap_mux16_cmos
+ t0 t1 t2 t3 t4 t5 t6 t7 t8 t9 t10 t11 t12 t13 t14 t15
+ c3 c2 c1 c0 out vdd vss
* Complement code bits
Xinv0 c0 c0b vdd vss serdes_cmos_inv
Xinv1 c1 c1b vdd vss serdes_cmos_inv
Xinv2 c2 c2b vdd vss serdes_cmos_inv
Xinv3 c3 c3b vdd vss serdes_cmos_inv
* 2-bit low pre-decode (l0..l3 active high)
Xlo0 c1b c0b l0 vdd vss serdes_cmos_and2
Xlo1 c1b c0  l1 vdd vss serdes_cmos_and2
Xlo2 c1  c0b l2 vdd vss serdes_cmos_and2
Xlo3 c1  c0  l3 vdd vss serdes_cmos_and2
* 2-bit high pre-decode (h0..h3 active high)
Xhi0 c3b c2b h0 vdd vss serdes_cmos_and2
Xhi1 c3b c2  h1 vdd vss serdes_cmos_and2
Xhi2 c3  c2b h2 vdd vss serdes_cmos_and2
Xhi3 c3  c2  h3 vdd vss serdes_cmos_and2
* 16 one-hot select pairs (sb_k active low from NAND2, s_k active high from INV)
Xdn0  h0 l0 sb0  vdd vss serdes_cmos_nand2
Xdn1  h0 l1 sb1  vdd vss serdes_cmos_nand2
Xdn2  h0 l2 sb2  vdd vss serdes_cmos_nand2
Xdn3  h0 l3 sb3  vdd vss serdes_cmos_nand2
Xdn4  h1 l0 sb4  vdd vss serdes_cmos_nand2
Xdn5  h1 l1 sb5  vdd vss serdes_cmos_nand2
Xdn6  h1 l2 sb6  vdd vss serdes_cmos_nand2
Xdn7  h1 l3 sb7  vdd vss serdes_cmos_nand2
Xdn8  h2 l0 sb8  vdd vss serdes_cmos_nand2
Xdn9  h2 l1 sb9  vdd vss serdes_cmos_nand2
Xdn10 h2 l2 sb10 vdd vss serdes_cmos_nand2
Xdn11 h2 l3 sb11 vdd vss serdes_cmos_nand2
Xdn12 h3 l0 sb12 vdd vss serdes_cmos_nand2
Xdn13 h3 l1 sb13 vdd vss serdes_cmos_nand2
Xdn14 h3 l2 sb14 vdd vss serdes_cmos_nand2
Xdn15 h3 l3 sb15 vdd vss serdes_cmos_nand2
Xdi0  sb0  s0  vdd vss serdes_cmos_inv
Xdi1  sb1  s1  vdd vss serdes_cmos_inv
Xdi2  sb2  s2  vdd vss serdes_cmos_inv
Xdi3  sb3  s3  vdd vss serdes_cmos_inv
Xdi4  sb4  s4  vdd vss serdes_cmos_inv
Xdi5  sb5  s5  vdd vss serdes_cmos_inv
Xdi6  sb6  s6  vdd vss serdes_cmos_inv
Xdi7  sb7  s7  vdd vss serdes_cmos_inv
Xdi8  sb8  s8  vdd vss serdes_cmos_inv
Xdi9  sb9  s9  vdd vss serdes_cmos_inv
Xdi10 sb10 s10 vdd vss serdes_cmos_inv
Xdi11 sb11 s11 vdd vss serdes_cmos_inv
Xdi12 sb12 s12 vdd vss serdes_cmos_inv
Xdi13 sb13 s13 vdd vss serdes_cmos_inv
Xdi14 sb14 s14 vdd vss serdes_cmos_inv
Xdi15 sb15 s15 vdd vss serdes_cmos_inv
* 16 CMOS transmission gates
Xg0  t0  out s0  sb0  vdd vss serdes_cmos_tgate
Xg1  t1  out s1  sb1  vdd vss serdes_cmos_tgate
Xg2  t2  out s2  sb2  vdd vss serdes_cmos_tgate
Xg3  t3  out s3  sb3  vdd vss serdes_cmos_tgate
Xg4  t4  out s4  sb4  vdd vss serdes_cmos_tgate
Xg5  t5  out s5  sb5  vdd vss serdes_cmos_tgate
Xg6  t6  out s6  sb6  vdd vss serdes_cmos_tgate
Xg7  t7  out s7  sb7  vdd vss serdes_cmos_tgate
Xg8  t8  out s8  sb8  vdd vss serdes_cmos_tgate
Xg9  t9  out s9  sb9  vdd vss serdes_cmos_tgate
Xg10 t10 out s10 sb10 vdd vss serdes_cmos_tgate
Xg11 t11 out s11 sb11 vdd vss serdes_cmos_tgate
Xg12 t12 out s12 sb12 vdd vss serdes_cmos_tgate
Xg13 t13 out s13 sb13 vdd vss serdes_cmos_tgate
Xg14 t14 out s14 sb14 vdd vss serdes_cmos_tgate
Xg15 t15 out s15 sb15 vdd vss serdes_cmos_tgate
.ends serdes_tap_mux16_cmos

* Ground-referenced high_po resistor ladder with real 4-bit CMOS select (no B-sources, no 0V probe)
.subckt serdes_vref_gnd_cmos iin c3 c2 c1 c0 out vdd vss params: r0=160k rstep=4k
Xr0  t0  vss vss sky130_fd_pr__res_high_po w=1 l={(r0-378)/317}
Xr1  t1  t0  vss sky130_fd_pr__res_high_po w=1 l={(rstep-378)/317}
Xr2  t2  t1  vss sky130_fd_pr__res_high_po w=1 l={(rstep-378)/317}
Xr3  t3  t2  vss sky130_fd_pr__res_high_po w=1 l={(rstep-378)/317}
Xr4  t4  t3  vss sky130_fd_pr__res_high_po w=1 l={(rstep-378)/317}
Xr5  t5  t4  vss sky130_fd_pr__res_high_po w=1 l={(rstep-378)/317}
Xr6  t6  t5  vss sky130_fd_pr__res_high_po w=1 l={(rstep-378)/317}
Xr7  t7  t6  vss sky130_fd_pr__res_high_po w=1 l={(rstep-378)/317}
Xr8  t8  t7  vss sky130_fd_pr__res_high_po w=1 l={(rstep-378)/317}
Xr9  t9  t8  vss sky130_fd_pr__res_high_po w=1 l={(rstep-378)/317}
Xr10 t10 t9  vss sky130_fd_pr__res_high_po w=1 l={(rstep-378)/317}
Xr11 t11 t10 vss sky130_fd_pr__res_high_po w=1 l={(rstep-378)/317}
Xr12 t12 t11 vss sky130_fd_pr__res_high_po w=1 l={(rstep-378)/317}
Xr13 t13 t12 vss sky130_fd_pr__res_high_po w=1 l={(rstep-378)/317}
Xr14 t14 t13 vss sky130_fd_pr__res_high_po w=1 l={(rstep-378)/317}
Xr15 iin t14 vss sky130_fd_pr__res_high_po w=1 l={(rstep-378)/317}
Xmux t0 t1 t2 t3 t4 t5 t6 t7 t8 t9 t10 t11 t12 t13 t14 iin c3 c2 c1 c0 out vdd vss serdes_tap_mux16_cmos
.ends serdes_vref_gnd_cmos

* VDD-referenced high_po resistor ladder with real 4-bit CMOS select (no B-sources)
.subckt serdes_vref_vdd_cmos iin c3 c2 c1 c0 out vdd vss params: r0=64k rstep=6k wsn=4 lsn=4
Xd   iin iin vss vss serdes_nfet w={wsn} l={lsn}
Xs   t15 iin vss vss serdes_nfet w={wsn} l={lsn}
Xr0  vdd t0  vss sky130_fd_pr__res_high_po w=1 l={(r0-378)/317}
Xr1  t0  t1  vss sky130_fd_pr__res_high_po w=1 l={(rstep-378)/317}
Xr2  t1  t2  vss sky130_fd_pr__res_high_po w=1 l={(rstep-378)/317}
Xr3  t2  t3  vss sky130_fd_pr__res_high_po w=1 l={(rstep-378)/317}
Xr4  t3  t4  vss sky130_fd_pr__res_high_po w=1 l={(rstep-378)/317}
Xr5  t4  t5  vss sky130_fd_pr__res_high_po w=1 l={(rstep-378)/317}
Xr6  t5  t6  vss sky130_fd_pr__res_high_po w=1 l={(rstep-378)/317}
Xr7  t6  t7  vss sky130_fd_pr__res_high_po w=1 l={(rstep-378)/317}
Xr8  t7  t8  vss sky130_fd_pr__res_high_po w=1 l={(rstep-378)/317}
Xr9  t8  t9  vss sky130_fd_pr__res_high_po w=1 l={(rstep-378)/317}
Xr10 t9  t10 vss sky130_fd_pr__res_high_po w=1 l={(rstep-378)/317}
Xr11 t10 t11 vss sky130_fd_pr__res_high_po w=1 l={(rstep-378)/317}
Xr12 t11 t12 vss sky130_fd_pr__res_high_po w=1 l={(rstep-378)/317}
Xr13 t12 t13 vss sky130_fd_pr__res_high_po w=1 l={(rstep-378)/317}
Xr14 t13 t14 vss sky130_fd_pr__res_high_po w=1 l={(rstep-378)/317}
Xr15 t14 t15 vss sky130_fd_pr__res_high_po w=1 l={(rstep-378)/317}
Xmux t0 t1 t2 t3 t4 t5 t6 t7 t8 t9 t10 t11 t12 t13 t14 t15 c3 c2 c1 c0 out vdd vss serdes_tap_mux16_cmos
.ends serdes_vref_vdd_cmos
