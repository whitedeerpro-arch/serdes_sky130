* NGSPICE file created from serdes_pll_supply_hv18_v2_cur_pdk.ext - technology: sky130A

.subckt serdes_pll_supply_hv18_v2_cur_pdk vin host quiet bg i_ldo enable t0 t1 t2
+ t3 t4 t5 vss
X0 a_51034_n9809# a_1464_8048# vin vss sky130_fd_pr__nfet_05v0_nvt ad=1.45 pd=10.29 as=1.45 ps=10.29 w=10 l=0.9
X1 vss i_ldo a_42634_n375# vss sky130_fd_pr__nfet_g5v0d10v5 ad=0.725 pd=5.29 as=0.725 ps=5.29 w=5 l=2
X2 a_17536_8048# a_17340_n7480# vss sky130_fd_pr__res_high_po w=0.5 l=75.64
X3 w_42120_n8480# a_42634_n375# a_23713_n11140# w_42120_n8480# sky130_fd_pr__pfet_g5v0d10v5 ad=0.725 pd=5.29 as=0.725 ps=5.29 w=5 l=2
X4 w_42120_n8480# a_42634_n375# a_42523_n6500# w_42120_n8480# sky130_fd_pr__pfet_g5v0d10v5 ad=0.725 pd=5.29 as=1.45 ps=10.58 w=5 l=2
X5 w_42120_n8480# a_22436_8048# vin vin sky130_fd_pr__pfet_g5v0d10v5 ad=0.725 pd=5.29 as=0.725 ps=5.29 w=5 l=2
X6 vin a_1464_8048# a_51034_n9809# vss sky130_fd_pr__nfet_05v0_nvt ad=1.45 pd=10.29 as=1.45 ps=10.29 w=10 l=0.9
X7 a_32800_3942# a_29900_878# quiet quiet sky130_fd_pr__pfet_01v8 ad=0.99 pd=6.33 as=0.99 ps=6.33 w=6 l=0.15
X8 quiet a_32800_3942# vss vss sky130_fd_pr__nfet_01v8 ad=0.66 pd=4.33 as=0.66 ps=4.33 w=4 l=0.15
X9 a_17536_8048# a_17732_n7480# vss sky130_fd_pr__res_high_po w=0.5 l=75.64
X10 a_51034_n9809# a_23713_n11140# quiet vss sky130_fd_pr__nfet_05v0_nvt ad=1.45 pd=10.29 as=1.45 ps=10.29 w=10 l=0.9
X11 w_42120_n8480# a_42634_n375# a_23713_n11140# w_42120_n8480# sky130_fd_pr__pfet_g5v0d10v5 ad=0.725 pd=5.29 as=0.725 ps=5.29 w=5 l=2
X12 w_42120_n8480# a_42634_n375# a_42634_n375# w_42120_n8480# sky130_fd_pr__pfet_g5v0d10v5 ad=0.725 pd=5.29 as=1.45 ps=10.58 w=5 l=2
X13 a_32008_n6273# t4 a_33192_n6273# vss sky130_fd_pr__nfet_01v8 ad=0.825 pd=5.33 as=0.825 ps=5.33 w=5 l=0.15
X14 a_32800_3942# vss vss sky130_fd_pr__res_high_po w=1 l=14.58
X15 a_42634_n375# a_42634_n375# w_42120_n8480# w_42120_n8480# sky130_fd_pr__pfet_g5v0d10v5 ad=0.725 pd=5.29 as=0.725 ps=5.29 w=5 l=2
X16 a_23713_n11140# a_24907_n11228# vss vss sky130_fd_pr__nfet_g5v0d10v5 ad=0.725 pd=5.29 as=0.725 ps=5.29 w=5 l=0.5
X17 quiet a_23713_n11140# a_51034_n9809# vss sky130_fd_pr__nfet_05v0_nvt ad=1.45 pd=10.29 as=1.45 ps=10.29 w=10 l=0.9
X18 a_5708_8048# a_5512_n7480# vss sky130_fd_pr__res_high_po w=0.5 l=75.64
X19 a_24907_n11228# a_7527_n10700# a_42523_n6500# w_42120_n8480# sky130_fd_pr__pfet_g5v0d10v5 ad=0.725 pd=5.29 as=0.725 ps=5.29 w=5 l=1
X20 quiet a_23713_n11140# a_51034_n9809# vss sky130_fd_pr__nfet_05v0_nvt ad=1.45 pd=10.29 as=1.45 ps=10.29 w=10 l=0.9
X21 vin a_1464_8048# a_51034_n9809# vss sky130_fd_pr__nfet_05v0_nvt ad=1.45 pd=10.29 as=1.45 ps=10.29 w=10 l=0.9
X22 quiet a_23713_n11140# a_51034_n9809# vss sky130_fd_pr__nfet_05v0_nvt ad=1.45 pd=10.29 as=1.45 ps=10.29 w=10 l=0.9
X23 a_42633_n11868# a_36004_n3859# a_42523_n6500# w_42120_n8480# sky130_fd_pr__pfet_g5v0d10v5 ad=0.725 pd=5.29 as=0.725 ps=5.29 w=5 l=1
X24 a_51034_n9809# a_1464_8048# vin vss sky130_fd_pr__nfet_05v0_nvt ad=1.45 pd=10.29 as=1.45 ps=10.29 w=10 l=0.9
X25 a_51034_n9809# a_1464_8048# vin vss sky130_fd_pr__nfet_05v0_nvt ad=1.45 pd=10.29 as=1.45 ps=10.29 w=10 l=0.9
X26 a_42523_n6500# a_42634_n375# w_42120_n8480# w_42120_n8480# sky130_fd_pr__pfet_g5v0d10v5 ad=0.725 pd=5.29 as=0.725 ps=5.29 w=5 l=2
X27 w_42120_n8480# a_42634_n375# a_42523_n6500# w_42120_n8480# sky130_fd_pr__pfet_g5v0d10v5 ad=0.725 pd=5.29 as=0.725 ps=5.29 w=5 l=2
X28 a_42523_n6500# a_36004_n3859# a_42633_n11868# w_42120_n8480# sky130_fd_pr__pfet_g5v0d10v5 ad=0.725 pd=5.29 as=0.725 ps=5.29 w=5 l=1
X29 a_24907_n11228# a_7527_n10700# a_42523_n6500# w_42120_n8480# sky130_fd_pr__pfet_g5v0d10v5 ad=0.725 pd=5.29 as=0.725 ps=5.29 w=5 l=1
X30 i_ldo i_ldo vss vss sky130_fd_pr__nfet_g5v0d10v5 ad=1.45 pd=10.58 as=0.725 ps=5.29 w=5 l=2
X31 a_5708_8048# a_5904_n7480# vss sky130_fd_pr__res_high_po w=0.5 l=75.64
X32 quiet a_32800_3942# vss vss sky130_fd_pr__nfet_01v8 ad=0.66 pd=4.33 as=0.66 ps=4.33 w=4 l=0.15
X33 a_11196_8048# a_11000_n7480# vss sky130_fd_pr__res_high_po w=0.5 l=75.64
X34 vin a_22436_8048# w_42120_n8480# vin sky130_fd_pr__pfet_g5v0d10v5 ad=0.725 pd=5.29 as=1.45 ps=10.58 w=5 l=2
X35 w_42120_n8480# a_19104_8048# a_19104_8048# w_42120_n8480# sky130_fd_pr__pfet_g5v0d10v5 ad=0.725 pd=5.29 as=0.725 ps=5.29 w=5 l=2
X36 a_51034_n9809# a_23713_n11140# quiet vss sky130_fd_pr__nfet_05v0_nvt ad=1.45 pd=10.29 as=1.45 ps=10.29 w=10 l=0.9
X37 vss a_7527_n10700# sky130_fd_pr__cap_mim_m3_2 l=29.42 w=29.42
X38 a_42523_n6500# a_36004_n3859# a_42633_n11868# w_42120_n8480# sky130_fd_pr__pfet_g5v0d10v5 ad=0.725 pd=5.29 as=0.725 ps=5.29 w=5 l=1
X39 a_51034_n9809# a_23713_n11140# quiet vss sky130_fd_pr__nfet_05v0_nvt ad=1.45 pd=10.29 as=1.45 ps=10.29 w=10 l=0.9
X40 a_42634_n375# a_42634_n375# w_42120_n8480# w_42120_n8480# sky130_fd_pr__pfet_g5v0d10v5 ad=0.725 pd=5.29 as=0.725 ps=5.29 w=5 l=2
X41 vin a_1464_8048# a_51034_n9809# vss sky130_fd_pr__nfet_05v0_nvt ad=1.45 pd=10.29 as=1.45 ps=10.29 w=10 l=0.9
X42 vin a_22436_8048# w_42120_n8480# vin sky130_fd_pr__pfet_g5v0d10v5 ad=1.45 pd=10.58 as=0.725 ps=5.29 w=5 l=2
X43 a_1464_8048# vss sky130_fd_pr__cap_mim_m3_1 l=29.42 w=29.42
X44 a_19104_8048# a_19104_8048# w_42120_n8480# w_42120_n8480# sky130_fd_pr__pfet_g5v0d10v5 ad=0.725 pd=5.29 as=0.725 ps=5.29 w=5 l=2
X45 vss a_1464_8048# sky130_fd_pr__cap_mim_m3_2 l=29.42 w=29.42
X46 quiet a_23713_n11140# a_51034_n9809# vss sky130_fd_pr__nfet_05v0_nvt ad=1.45 pd=10.29 as=1.45 ps=10.29 w=10 l=0.9
X47 a_11196_8048# a_11392_n7480# vss sky130_fd_pr__res_high_po w=0.5 l=75.64
X48 w_42120_n8480# a_42634_n375# a_23713_n11140# w_42120_n8480# sky130_fd_pr__pfet_g5v0d10v5 ad=0.725 pd=5.29 as=0.725 ps=5.29 w=5 l=2
X49 vss a_42633_n11868# a_42633_n11868# vss sky130_fd_pr__nfet_g5v0d10v5 ad=0.725 pd=5.29 as=0.725 ps=5.29 w=5 l=2
X50 a_1015_n10700# enable bg vss sky130_fd_pr__nfet_01v8 ad=0.58 pd=4.58 as=0.58 ps=4.58 w=2 l=0.15
X51 a_51034_n9809# a_1464_8048# vin vss sky130_fd_pr__nfet_05v0_nvt ad=1.45 pd=10.29 as=1.45 ps=10.29 w=10 l=0.9
X52 a_6884_8048# a_7080_n7480# vss sky130_fd_pr__res_high_po w=0.5 l=75.64
X53 vss a_32800_3942# quiet vss sky130_fd_pr__nfet_01v8 ad=0.66 pd=4.33 as=0.66 ps=4.33 w=4 l=0.15
X54 a_51034_n9809# a_1464_8048# vin vss sky130_fd_pr__nfet_05v0_nvt ad=1.45 pd=10.29 as=1.45 ps=10.29 w=10 l=0.9
X55 a_1464_8048# vss sky130_fd_pr__cap_mim_m3_1 l=29.42 w=29.42
X56 a_33192_n6273# t4 a_32008_n6273# vss sky130_fd_pr__nfet_01v8 ad=0.825 pd=5.33 as=0.825 ps=5.33 w=5 l=0.15
X57 a_42523_n6500# a_36004_n3859# a_42633_n11868# w_42120_n8480# sky130_fd_pr__pfet_g5v0d10v5 ad=0.725 pd=5.29 as=0.725 ps=5.29 w=5 l=1
X58 a_51034_n9809# a_1464_8048# vin vss sky130_fd_pr__nfet_05v0_nvt ad=1.45 pd=10.29 as=1.45 ps=10.29 w=10 l=0.9
X59 a_51034_n9809# a_1464_8048# vin vss sky130_fd_pr__nfet_05v0_nvt ad=1.45 pd=10.29 as=1.45 ps=10.29 w=10 l=0.9
X60 a_51034_n9809# a_1464_8048# vin vss sky130_fd_pr__nfet_05v0_nvt ad=1.45 pd=10.29 as=1.45 ps=10.29 w=10 l=0.9
X61 a_51034_n9809# a_23713_n11140# quiet vss sky130_fd_pr__nfet_05v0_nvt ad=1.45 pd=10.29 as=1.45 ps=10.29 w=10 l=0.9
X62 a_8452_8048# a_8648_n7480# vss sky130_fd_pr__res_high_po w=0.5 l=75.64
X63 a_15576_8048# a_15380_n7480# vss sky130_fd_pr__res_high_po w=0.5 l=75.64
X64 a_42523_n6500# w_42120_n8480# w_42120_n8480# w_42120_n8480# sky130_fd_pr__pfet_g5v0d10v5 ad=0.725 pd=5.29 as=1.45 ps=10.58 w=5 l=1
X65 vss a_24907_n11228# a_23713_n11140# vss sky130_fd_pr__nfet_g5v0d10v5 ad=0.725 pd=5.29 as=0.725 ps=5.29 w=5 l=0.5
X66 vin a_1464_8048# a_51034_n9809# vss sky130_fd_pr__nfet_05v0_nvt ad=1.45 pd=10.29 as=1.45 ps=10.29 w=10 l=0.9
X67 a_23713_n11140# a_42634_n375# w_42120_n8480# w_42120_n8480# sky130_fd_pr__pfet_g5v0d10v5 ad=0.725 pd=5.29 as=0.725 ps=5.29 w=5 l=2
X68 a_29900_878# a_25242_n7480# vss vss sky130_fd_pr__nfet_01v8 ad=0.66 pd=4.33 as=0.66 ps=4.33 w=4 l=0.15
X69 vin a_22436_8048# w_42120_n8480# vin sky130_fd_pr__pfet_g5v0d10v5 ad=0.725 pd=5.29 as=0.725 ps=5.29 w=5 l=2
X70 vss a_24907_n11228# a_23713_n11140# vss sky130_fd_pr__nfet_g5v0d10v5 ad=0.725 pd=5.29 as=0.725 ps=5.29 w=5 l=0.5
X71 vss w_42120_n8480# sky130_fd_pr__cap_mim_m3_2 l=29.42 w=29.42
X72 vin a_1464_8048# a_51034_n9809# vss sky130_fd_pr__nfet_05v0_nvt ad=1.45 pd=10.29 as=1.45 ps=10.29 w=10 l=0.9
X73 w_42120_n8480# a_19104_8048# a_19104_8048# w_42120_n8480# sky130_fd_pr__pfet_g5v0d10v5 ad=0.725 pd=5.29 as=0.725 ps=5.29 w=5 l=2
X74 a_51034_n9809# a_1464_8048# vin vss sky130_fd_pr__nfet_05v0_nvt ad=1.45 pd=10.29 as=2.9 ps=20.58 w=10 l=0.9
X75 a_42633_n11868# a_36004_n3859# a_42523_n6500# w_42120_n8480# sky130_fd_pr__pfet_g5v0d10v5 ad=0.725 pd=5.29 as=0.725 ps=5.29 w=5 l=1
X76 vss enable a_2667_n10997# vss sky130_fd_pr__nfet_01v8 ad=0.29 pd=2.58 as=0.29 ps=2.58 w=1 l=0.15
X77 a_8844_8048# a_8648_n7480# vss sky130_fd_pr__res_high_po w=0.5 l=75.64
X78 a_15576_8048# a_15772_n7480# vss sky130_fd_pr__res_high_po w=0.5 l=75.64
X79 vss vss vss vss sky130_fd_pr__nfet_g5v0d10v5 ad=1.45 pd=10.58 as=40.89 ps=298.82001 w=5 l=2
X80 a_19104_8048# a_19104_8048# w_42120_n8480# w_42120_n8480# sky130_fd_pr__pfet_g5v0d10v5 ad=0.725 pd=5.29 as=0.725 ps=5.29 w=5 l=2
X81 a_51034_n9809# a_23713_n11140# quiet vss sky130_fd_pr__nfet_05v0_nvt ad=1.45 pd=10.29 as=1.45 ps=10.29 w=10 l=0.9
X82 vss i_ldo a_19104_8048# vss sky130_fd_pr__nfet_g5v0d10v5 ad=0.435 pd=3.29 as=0.87 ps=6.58 w=3 l=2
X83 vss a_32800_3942# quiet vss sky130_fd_pr__nfet_01v8 ad=0.66 pd=4.33 as=0.66 ps=4.33 w=4 l=0.15
X84 a_24907_n11228# a_7527_n10700# a_42523_n6500# w_42120_n8480# sky130_fd_pr__pfet_g5v0d10v5 ad=0.725 pd=5.29 as=0.725 ps=5.29 w=5 l=1
X85 a_23713_n11140# a_42634_n375# w_42120_n8480# w_42120_n8480# sky130_fd_pr__pfet_g5v0d10v5 ad=0.725 pd=5.29 as=0.725 ps=5.29 w=5 l=2
X86 a_42633_n11868# a_36004_n3859# a_42523_n6500# w_42120_n8480# sky130_fd_pr__pfet_g5v0d10v5 ad=0.725 pd=5.29 as=0.725 ps=5.29 w=5 l=1
X87 a_51034_n9809# a_1464_8048# vin vss sky130_fd_pr__nfet_05v0_nvt ad=1.45 pd=10.29 as=1.45 ps=10.29 w=10 l=0.9
X88 a_51034_n9809# a_1464_8048# vin vss sky130_fd_pr__nfet_05v0_nvt ad=1.45 pd=10.29 as=1.45 ps=10.29 w=10 l=0.9
X89 vin a_1464_8048# a_51034_n9809# vss sky130_fd_pr__nfet_05v0_nvt ad=1.45 pd=10.29 as=1.45 ps=10.29 w=10 l=0.9
X90 vss a_25242_n7480# a_29900_878# vss sky130_fd_pr__nfet_01v8 ad=0.66 pd=4.33 as=0.66 ps=4.33 w=4 l=0.15
X91 vss a_42633_n11868# a_24907_n11228# vss sky130_fd_pr__nfet_g5v0d10v5 ad=0.725 pd=5.29 as=0.725 ps=5.29 w=5 l=2
X92 a_51034_n9809# a_1464_8048# vin vss sky130_fd_pr__nfet_05v0_nvt ad=2.9 pd=20.58 as=1.45 ps=10.29 w=10 l=0.9
X93 vin a_1464_8048# a_51034_n9809# vss sky130_fd_pr__nfet_05v0_nvt ad=1.45 pd=10.29 as=1.45 ps=10.29 w=10 l=0.9
X94 w_42120_n8480# a_42634_n375# a_23713_n11140# w_42120_n8480# sky130_fd_pr__pfet_g5v0d10v5 ad=0.725 pd=5.29 as=0.725 ps=5.29 w=5 l=2
X95 a_29179_n11180# t1 a_30379_n11180# vss sky130_fd_pr__nfet_01v8 ad=0.825 pd=5.33 as=0.825 ps=5.33 w=5 l=0.15
X96 quiet a_23713_n11140# a_51034_n9809# vss sky130_fd_pr__nfet_05v0_nvt ad=1.45 pd=10.29 as=1.45 ps=10.29 w=10 l=0.9
X97 a_10804_8048# a_11000_n7480# vss sky130_fd_pr__res_high_po w=0.5 l=75.64
X98 a_51034_n9809# a_23713_n11140# quiet vss sky130_fd_pr__nfet_05v0_nvt ad=1.45 pd=10.29 as=1.45 ps=10.29 w=10 l=0.9
X99 vin a_1464_8048# a_51034_n9809# vss sky130_fd_pr__nfet_05v0_nvt ad=1.45 pd=10.29 as=1.45 ps=10.29 w=10 l=0.9
X100 a_42523_n6500# a_36004_n3859# a_42633_n11868# w_42120_n8480# sky130_fd_pr__pfet_g5v0d10v5 ad=0.725 pd=5.29 as=0.725 ps=5.29 w=5 l=1
X101 vss a_32800_3942# quiet vss sky130_fd_pr__nfet_01v8 ad=0.66 pd=4.33 as=0.66 ps=4.33 w=4 l=0.15
X102 quiet a_29900_878# a_32800_3942# quiet sky130_fd_pr__pfet_01v8 ad=0.99 pd=6.33 as=0.99 ps=6.33 w=6 l=0.15
X103 a_51034_n9809# a_23713_n11140# quiet vss sky130_fd_pr__nfet_05v0_nvt ad=1.45 pd=10.29 as=1.45 ps=10.29 w=10 l=0.9
X104 a_1464_8048# a_1464_n7480# vss sky130_fd_pr__res_high_po w=0.5 l=75.64
X105 vss a_32800_3942# quiet vss sky130_fd_pr__nfet_01v8 ad=0.66 pd=4.33 as=1.24 ps=8.62 w=4 l=0.15
X106 w_42120_n8480# a_22436_8048# vin vin sky130_fd_pr__pfet_g5v0d10v5 ad=0.725 pd=5.29 as=0.725 ps=5.29 w=5 l=2
X107 a_22044_8048# a_21848_n7480# vss sky130_fd_pr__res_high_po w=0.5 l=75.64
X108 a_23713_n11140# a_24907_n11228# vss vss sky130_fd_pr__nfet_g5v0d10v5 ad=0.725 pd=5.29 as=0.725 ps=5.29 w=5 l=0.5
X109 a_42523_n6500# a_7527_n10700# a_24907_n11228# w_42120_n8480# sky130_fd_pr__pfet_g5v0d10v5 ad=0.725 pd=5.29 as=0.725 ps=5.29 w=5 l=1
X110 w_42120_n8480# a_42634_n375# a_42634_n375# w_42120_n8480# sky130_fd_pr__pfet_g5v0d10v5 ad=0.725 pd=5.29 as=0.725 ps=5.29 w=5 l=2
X111 a_51034_n9809# a_1464_8048# vin vss sky130_fd_pr__nfet_05v0_nvt ad=1.45 pd=10.29 as=1.45 ps=10.29 w=10 l=0.9
X112 quiet a_23713_n11140# a_51034_n9809# vss sky130_fd_pr__nfet_05v0_nvt ad=2.9 pd=20.58 as=1.45 ps=10.29 w=10 l=0.9
X113 a_1660_8048# a_1464_n7480# vss sky130_fd_pr__res_high_po w=0.5 l=75.64
X114 quiet a_23713_n11140# a_51034_n9809# vss sky130_fd_pr__nfet_05v0_nvt ad=1.45 pd=10.29 as=1.45 ps=10.29 w=10 l=0.9
X115 a_51034_n9809# a_1464_8048# vin vss sky130_fd_pr__nfet_05v0_nvt ad=2.9 pd=20.58 as=1.45 ps=10.29 w=10 l=0.9
X116 a_51034_n9809# a_1464_8048# vin vss sky130_fd_pr__nfet_05v0_nvt ad=1.45 pd=10.29 as=1.45 ps=10.29 w=10 l=0.9
X117 a_42523_n6500# w_42120_n8480# w_42120_n8480# w_42120_n8480# sky130_fd_pr__pfet_g5v0d10v5 ad=0.725 pd=5.29 as=1.45 ps=10.58 w=5 l=1
X118 quiet a_23713_n11140# a_51034_n9809# vss sky130_fd_pr__nfet_05v0_nvt ad=1.45 pd=10.29 as=1.45 ps=10.29 w=10 l=0.9
X119 a_22044_8048# a_22240_n7480# vss sky130_fd_pr__res_high_po w=0.5 l=75.64
X120 a_51034_n9809# a_1464_8048# vin vss sky130_fd_pr__nfet_05v0_nvt ad=1.45 pd=10.29 as=1.45 ps=10.29 w=10 l=0.9
X121 a_51034_n9809# a_1464_8048# vin vss sky130_fd_pr__nfet_05v0_nvt ad=1.45 pd=10.29 as=1.45 ps=10.29 w=10 l=0.9
X122 quiet a_32800_3942# vss vss sky130_fd_pr__nfet_01v8 ad=0.66 pd=4.33 as=0.66 ps=4.33 w=4 l=0.15
X123 w_42120_n8480# a_19104_8048# a_19104_8048# w_42120_n8480# sky130_fd_pr__pfet_g5v0d10v5 ad=0.725 pd=5.29 as=0.725 ps=5.29 w=5 l=2
X124 quiet a_23713_n11140# a_51034_n9809# vss sky130_fd_pr__nfet_05v0_nvt ad=1.45 pd=10.29 as=1.45 ps=10.29 w=10 l=0.9
X125 a_6492_8048# a_6688_n7480# vss sky130_fd_pr__res_high_po w=0.5 l=75.64
X126 a_32800_3942# a_29900_878# quiet quiet sky130_fd_pr__pfet_01v8 ad=0.99 pd=6.33 as=0.99 ps=6.33 w=6 l=0.15
X127 a_51034_n9809# a_1464_8048# vin vss sky130_fd_pr__nfet_05v0_nvt ad=1.45 pd=10.29 as=1.45 ps=10.29 w=10 l=0.9
X128 a_19104_8048# a_19104_8048# w_42120_n8480# w_42120_n8480# sky130_fd_pr__pfet_g5v0d10v5 ad=0.725 pd=5.29 as=0.725 ps=5.29 w=5 l=2
X129 vss vss vss sky130_fd_pr__res_high_po w=1 l=11.43
X130 a_7527_n10700# vss sky130_fd_pr__cap_mim_m3_1 l=29.42 w=29.42
X131 vin a_22436_8048# w_42120_n8480# vin sky130_fd_pr__pfet_g5v0d10v5 ad=0.725 pd=5.29 as=0.725 ps=5.29 w=5 l=2
X132 a_19104_8048# a_19104_8048# w_42120_n8480# w_42120_n8480# sky130_fd_pr__pfet_g5v0d10v5 ad=0.725 pd=5.29 as=0.725 ps=5.29 w=5 l=2
X133 a_42633_n11868# a_36004_n3859# a_42523_n6500# w_42120_n8480# sky130_fd_pr__pfet_g5v0d10v5 ad=0.725 pd=5.29 as=0.725 ps=5.29 w=5 l=1
X134 quiet a_23713_n11140# a_51034_n9809# vss sky130_fd_pr__nfet_05v0_nvt ad=2.9 pd=20.58 as=1.45 ps=10.29 w=10 l=0.9
X135 vin a_1464_8048# a_51034_n9809# vss sky130_fd_pr__nfet_05v0_nvt ad=1.45 pd=10.29 as=1.45 ps=10.29 w=10 l=0.9
X136 a_6884_8048# a_6688_n7480# vss sky130_fd_pr__res_high_po w=0.5 l=75.64
X137 a_23713_n11140# a_24907_n11228# vss vss sky130_fd_pr__nfet_g5v0d10v5 ad=0.725 pd=5.29 as=0.725 ps=5.29 w=5 l=0.5
X138 a_30379_n11180# t1 a_29179_n11180# vss sky130_fd_pr__nfet_01v8 ad=0.825 pd=5.33 as=0.825 ps=5.33 w=5 l=0.15
X139 w_42120_n8480# a_42634_n375# a_42634_n375# w_42120_n8480# sky130_fd_pr__pfet_g5v0d10v5 ad=0.725 pd=5.29 as=0.725 ps=5.29 w=5 l=2
X140 a_1464_8048# vss sky130_fd_pr__cap_mim_m3_1 l=29.42 w=29.42
X141 quiet a_23713_n11140# a_51034_n9809# vss sky130_fd_pr__nfet_05v0_nvt ad=2.9 pd=20.58 as=1.45 ps=10.29 w=10 l=0.9
X142 a_51034_n9809# a_1464_8048# vin vss sky130_fd_pr__nfet_05v0_nvt ad=1.45 pd=10.29 as=1.45 ps=10.29 w=10 l=0.9
X143 a_29196_n1173# a_29492_n3859# vss sky130_fd_pr__res_high_po w=1 l=11.43
X144 a_42633_n11868# a_36004_n3859# a_42523_n6500# w_42120_n8480# sky130_fd_pr__pfet_g5v0d10v5 ad=0.725 pd=5.29 as=0.725 ps=5.29 w=5 l=1
X145 quiet a_23713_n11140# a_51034_n9809# vss sky130_fd_pr__nfet_05v0_nvt ad=1.45 pd=10.29 as=1.45 ps=10.29 w=10 l=0.9
X146 a_33192_n6273# t5 a_29196_n3859# vss sky130_fd_pr__nfet_01v8 ad=0.825 pd=5.33 as=0.825 ps=5.33 w=5 l=0.15
X147 a_51034_n9809# a_1464_8048# vin vss sky130_fd_pr__nfet_05v0_nvt ad=1.45 pd=10.29 as=1.45 ps=10.29 w=10 l=0.9
X148 a_51034_n9809# a_1464_8048# vin vss sky130_fd_pr__nfet_05v0_nvt ad=1.45 pd=10.29 as=1.45 ps=10.29 w=10 l=0.9
X149 a_51034_n9809# a_23713_n11140# quiet vss sky130_fd_pr__nfet_05v0_nvt ad=1.45 pd=10.29 as=1.45 ps=10.29 w=10 l=0.9
X150 a_23713_n11140# a_42634_n375# w_42120_n8480# w_42120_n8480# sky130_fd_pr__pfet_g5v0d10v5 ad=0.725 pd=5.29 as=0.725 ps=5.29 w=5 l=2
X151 vin a_1464_8048# a_51034_n9809# vss sky130_fd_pr__nfet_05v0_nvt ad=1.45 pd=10.29 as=1.45 ps=10.29 w=10 l=0.9
X152 quiet a_36004_n3859# sky130_fd_pr__cap_mim_m3_2 l=13.5 w=13.5
X153 a_17928_8048# a_18124_n7480# vss sky130_fd_pr__res_high_po w=0.5 l=75.64
X154 a_23713_n11140# a_42634_n375# w_42120_n8480# w_42120_n8480# sky130_fd_pr__pfet_g5v0d10v5 ad=0.725 pd=5.29 as=0.725 ps=5.29 w=5 l=2
X155 a_42523_n6500# a_7527_n10700# a_24907_n11228# w_42120_n8480# sky130_fd_pr__pfet_g5v0d10v5 ad=0.725 pd=5.29 as=0.725 ps=5.29 w=5 l=1
X156 vss i_ldo i_ldo vss sky130_fd_pr__nfet_g5v0d10v5 ad=0.725 pd=5.29 as=0.725 ps=5.29 w=5 l=2
X157 a_29900_878# a_25242_n7480# vss vss sky130_fd_pr__nfet_01v8 ad=0.66 pd=4.33 as=0.66 ps=4.33 w=4 l=0.15
X158 vin a_1464_8048# a_51034_n9809# vss sky130_fd_pr__nfet_05v0_nvt ad=1.45 pd=10.29 as=1.45 ps=10.29 w=10 l=0.9
X159 w_42120_n8480# a_19104_8048# a_19104_8048# w_42120_n8480# sky130_fd_pr__pfet_g5v0d10v5 ad=0.725 pd=5.29 as=0.725 ps=5.29 w=5 l=2
X160 a_51034_n9809# a_1464_8048# vin vss sky130_fd_pr__nfet_05v0_nvt ad=1.45 pd=10.29 as=1.45 ps=10.29 w=10 l=0.9
X161 w_42120_n8480# a_22436_8048# vin vin sky130_fd_pr__pfet_g5v0d10v5 ad=0.725 pd=5.29 as=0.725 ps=5.29 w=5 l=2
X162 w_42120_n8480# vss sky130_fd_pr__cap_mim_m3_1 l=29.42 w=29.42
X163 a_19104_8048# a_19104_8048# w_42120_n8480# w_42120_n8480# sky130_fd_pr__pfet_g5v0d10v5 ad=0.725 pd=5.29 as=0.725 ps=5.29 w=5 l=2
X164 a_10412_8048# a_10608_n7480# vss sky130_fd_pr__res_high_po w=0.5 l=75.64
X165 vin a_22436_8048# w_42120_n8480# vin sky130_fd_pr__pfet_g5v0d10v5 ad=0.725 pd=5.29 as=0.725 ps=5.29 w=5 l=2
X166 a_51034_n9809# a_23713_n11140# quiet vss sky130_fd_pr__nfet_05v0_nvt ad=1.45 pd=10.29 as=1.45 ps=10.29 w=10 l=0.9
X167 vin a_1464_8048# a_51034_n9809# vss sky130_fd_pr__nfet_05v0_nvt ad=1.45 pd=10.29 as=1.45 ps=10.29 w=10 l=0.9
X168 a_51034_n9809# a_23713_n11140# quiet vss sky130_fd_pr__nfet_05v0_nvt ad=1.45 pd=10.29 as=1.45 ps=10.29 w=10 l=0.9
X169 a_18320_8048# a_18124_n7480# vss sky130_fd_pr__res_high_po w=0.5 l=75.64
X170 vss w_42120_n8480# sky130_fd_pr__cap_mim_m3_2 l=29.42 w=29.42
X171 a_51034_n9809# a_23713_n11140# quiet vss sky130_fd_pr__nfet_05v0_nvt ad=1.45 pd=10.29 as=1.45 ps=10.29 w=10 l=0.9
X172 vin a_1464_8048# a_51034_n9809# vss sky130_fd_pr__nfet_05v0_nvt ad=1.45 pd=10.29 as=1.45 ps=10.29 w=10 l=0.9
X173 quiet a_32800_3942# vss vss sky130_fd_pr__nfet_01v8 ad=0.66 pd=4.33 as=0.66 ps=4.33 w=4 l=0.15
X174 a_33784_n6273# a_34080_n8959# vss sky130_fd_pr__res_high_po w=1 l=11.43
X175 vss a_24907_n11228# a_23713_n11140# vss sky130_fd_pr__nfet_g5v0d10v5 ad=0.725 pd=5.29 as=0.725 ps=5.29 w=5 l=0.5
X176 vin a_1464_8048# a_51034_n9809# vss sky130_fd_pr__nfet_05v0_nvt ad=1.45 pd=10.29 as=1.45 ps=10.29 w=10 l=0.9
X177 a_51034_n9809# a_23713_n11140# quiet vss sky130_fd_pr__nfet_05v0_nvt ad=1.45 pd=10.29 as=1.45 ps=10.29 w=10 l=0.9
X178 vin a_1464_8048# a_51034_n9809# vss sky130_fd_pr__nfet_05v0_nvt ad=1.45 pd=10.29 as=1.45 ps=10.29 w=10 l=0.9
X179 a_10804_8048# a_10608_n7480# vss sky130_fd_pr__res_high_po w=0.5 l=75.64
X180 a_42523_n6500# a_36004_n3859# a_42633_n11868# w_42120_n8480# sky130_fd_pr__pfet_g5v0d10v5 ad=0.725 pd=5.29 as=0.725 ps=5.29 w=5 l=1
X181 a_51034_n9809# a_23713_n11140# quiet vss sky130_fd_pr__nfet_05v0_nvt ad=1.45 pd=10.29 as=1.45 ps=10.29 w=10 l=0.9
X182 vin a_1464_8048# a_51034_n9809# vss sky130_fd_pr__nfet_05v0_nvt ad=1.45 pd=10.29 as=1.45 ps=10.29 w=10 l=0.9
X183 a_29196_n3859# a_35264_n8959# vss sky130_fd_pr__res_high_po w=1 l=11.43
X184 w_42120_n8480# a_42634_n375# a_23713_n11140# w_42120_n8480# sky130_fd_pr__pfet_g5v0d10v5 ad=0.725 pd=5.29 as=1.45 ps=10.58 w=5 l=2
X185 a_51034_n9809# a_23713_n11140# quiet vss sky130_fd_pr__nfet_05v0_nvt ad=1.45 pd=10.29 as=1.45 ps=10.29 w=10 l=0.9
X186 a_42633_n11868# a_42633_n11868# vss vss sky130_fd_pr__nfet_g5v0d10v5 ad=0.725 pd=5.29 as=0.725 ps=5.29 w=5 l=2
X187 w_42120_n8480# a_22436_8048# vin vin sky130_fd_pr__pfet_g5v0d10v5 ad=0.725 pd=5.29 as=0.725 ps=5.29 w=5 l=2
X188 w_42120_n8480# a_42634_n375# a_42523_n6500# w_42120_n8480# sky130_fd_pr__pfet_g5v0d10v5 ad=0.725 pd=5.29 as=0.725 ps=5.29 w=5 l=2
X189 a_21652_8048# a_21848_n7480# vss sky130_fd_pr__res_high_po w=0.5 l=75.64
X190 a_24907_n11228# a_7527_n10700# a_42523_n6500# w_42120_n8480# sky130_fd_pr__pfet_g5v0d10v5 ad=0.725 pd=5.29 as=0.725 ps=5.29 w=5 l=1
X191 w_42120_n8480# a_42634_n375# a_23713_n11140# w_42120_n8480# sky130_fd_pr__pfet_g5v0d10v5 ad=0.725 pd=5.29 as=0.725 ps=5.29 w=5 l=2
X192 a_23713_n11140# a_42634_n375# w_42120_n8480# w_42120_n8480# sky130_fd_pr__pfet_g5v0d10v5 ad=0.725 pd=5.29 as=0.725 ps=5.29 w=5 l=2
X193 w_42120_n8480# a_42634_n375# a_23713_n11140# w_42120_n8480# sky130_fd_pr__pfet_g5v0d10v5 ad=1.45 pd=10.58 as=0.725 ps=5.29 w=5 l=2
X194 a_42523_n6500# a_42634_n375# w_42120_n8480# w_42120_n8480# sky130_fd_pr__pfet_g5v0d10v5 ad=0.725 pd=5.29 as=0.725 ps=5.29 w=5 l=2
X195 a_29196_n3859# t5 a_33192_n6273# vss sky130_fd_pr__nfet_01v8 ad=0.825 pd=5.33 as=0.825 ps=5.33 w=5 l=0.15
X196 vss a_32800_3942# quiet vss sky130_fd_pr__nfet_01v8 ad=0.66 pd=4.33 as=0.66 ps=4.33 w=4 l=0.15
X197 quiet a_29900_878# a_32800_3942# quiet sky130_fd_pr__pfet_01v8 ad=0.99 pd=6.33 as=0.99 ps=6.33 w=6 l=0.15
X198 a_51034_n9809# a_23713_n11140# quiet vss sky130_fd_pr__nfet_05v0_nvt ad=1.45 pd=10.29 as=1.45 ps=10.29 w=10 l=0.9
X199 vss a_32800_3942# quiet vss sky130_fd_pr__nfet_01v8 ad=0.66 pd=4.33 as=0.66 ps=4.33 w=4 l=0.15
X200 a_51034_n9809# a_23713_n11140# quiet vss sky130_fd_pr__nfet_05v0_nvt ad=1.45 pd=10.29 as=1.45 ps=10.29 w=10 l=0.9
X201 vin a_1464_8048# a_51034_n9809# vss sky130_fd_pr__nfet_05v0_nvt ad=1.45 pd=10.29 as=1.45 ps=10.29 w=10 l=0.9
X202 a_24907_n11228# a_7527_n10700# a_42523_n6500# w_42120_n8480# sky130_fd_pr__pfet_g5v0d10v5 ad=0.725 pd=5.29 as=0.725 ps=5.29 w=5 l=1
X203 a_51034_n9809# a_23713_n11140# quiet vss sky130_fd_pr__nfet_05v0_nvt ad=1.45 pd=10.29 as=1.45 ps=10.29 w=10 l=0.9
X204 a_51034_n9809# a_23713_n11140# quiet vss sky130_fd_pr__nfet_05v0_nvt ad=1.45 pd=10.29 as=1.45 ps=10.29 w=10 l=0.9
X205 vin a_1464_8048# a_51034_n9809# vss sky130_fd_pr__nfet_05v0_nvt ad=1.45 pd=10.29 as=1.45 ps=10.29 w=10 l=0.9
X206 a_51034_n9809# a_23713_n11140# quiet vss sky130_fd_pr__nfet_05v0_nvt ad=1.45 pd=10.29 as=1.45 ps=10.29 w=10 l=0.9
X207 w_42120_n8480# a_19104_8048# a_19104_8048# w_42120_n8480# sky130_fd_pr__pfet_g5v0d10v5 ad=0.725 pd=5.29 as=0.725 ps=5.29 w=5 l=2
X208 vin a_1464_8048# a_51034_n9809# vss sky130_fd_pr__nfet_05v0_nvt ad=1.45 pd=10.29 as=1.45 ps=10.29 w=10 l=0.9
X209 vss a_2667_n10997# i_ldo vss sky130_fd_pr__nfet_g5v0d10v5 ad=0.725 pd=5.29 as=1.45 ps=10.58 w=5 l=0.5
X210 a_51034_n9809# a_1464_8048# vin vss sky130_fd_pr__nfet_05v0_nvt ad=2.9 pd=20.58 as=1.45 ps=10.29 w=10 l=0.9
X211 vin a_1464_8048# a_51034_n9809# vss sky130_fd_pr__nfet_05v0_nvt ad=1.45 pd=10.29 as=1.45 ps=10.29 w=10 l=0.9
X212 a_29196_n1173# a_29196_n3859# vss sky130_fd_pr__res_high_po w=1 l=11.43
X213 vin a_1464_8048# a_51034_n9809# vss sky130_fd_pr__nfet_05v0_nvt ad=1.45 pd=10.29 as=1.45 ps=10.29 w=10 l=0.9
X214 a_51034_n9809# a_1464_8048# vin vss sky130_fd_pr__nfet_05v0_nvt ad=1.45 pd=10.29 as=2.9 ps=20.58 w=10 l=0.9
X215 quiet a_23713_n11140# a_51034_n9809# vss sky130_fd_pr__nfet_05v0_nvt ad=1.45 pd=10.29 as=1.45 ps=10.29 w=10 l=0.9
X216 a_51034_n9809# a_1464_8048# vin vss sky130_fd_pr__nfet_05v0_nvt ad=1.45 pd=10.29 as=1.45 ps=10.29 w=10 l=0.9
X217 vin a_1464_8048# a_51034_n9809# vss sky130_fd_pr__nfet_05v0_nvt ad=1.45 pd=10.29 as=1.45 ps=10.29 w=10 l=0.9
X218 a_51034_n9809# a_23713_n11140# quiet vss sky130_fd_pr__nfet_05v0_nvt ad=1.45 pd=10.29 as=1.45 ps=10.29 w=10 l=0.9
X219 a_51034_n9809# a_1464_8048# vin vss sky130_fd_pr__nfet_05v0_nvt ad=2.9 pd=20.58 as=1.45 ps=10.29 w=10 l=0.9
X220 quiet a_23713_n11140# a_51034_n9809# vss sky130_fd_pr__nfet_05v0_nvt ad=1.45 pd=10.29 as=1.45 ps=10.29 w=10 l=0.9
X221 a_51034_n9809# a_1464_8048# vin vss sky130_fd_pr__nfet_05v0_nvt ad=1.45 pd=10.29 as=1.45 ps=10.29 w=10 l=0.9
X222 a_42523_n6500# a_42634_n375# w_42120_n8480# w_42120_n8480# sky130_fd_pr__pfet_g5v0d10v5 ad=1.45 pd=10.58 as=0.725 ps=5.29 w=5 l=2
X223 a_9236_8048# a_9040_n7480# vss sky130_fd_pr__res_high_po w=0.5 l=75.64
X224 a_15968_8048# a_16164_n7480# vss sky130_fd_pr__res_high_po w=0.5 l=75.64
X225 vss a_32800_3942# quiet vss sky130_fd_pr__nfet_01v8 ad=0.66 pd=4.33 as=1.24 ps=8.62 w=4 l=0.15
X226 a_19104_8048# a_19104_8048# w_42120_n8480# w_42120_n8480# sky130_fd_pr__pfet_g5v0d10v5 ad=0.725 pd=5.29 as=0.725 ps=5.29 w=5 l=2
X227 a_42634_n375# i_ldo vss vss sky130_fd_pr__nfet_g5v0d10v5 ad=0.725 pd=5.29 as=0.725 ps=5.29 w=5 l=2
X228 w_42120_n8480# a_19104_8048# a_19104_8048# w_42120_n8480# sky130_fd_pr__pfet_g5v0d10v5 ad=0.725 pd=5.29 as=0.725 ps=5.29 w=5 l=2
X229 a_51034_n9809# a_23713_n11140# quiet vss sky130_fd_pr__nfet_05v0_nvt ad=1.45 pd=10.29 as=1.45 ps=10.29 w=10 l=0.9
X230 a_51034_n9809# a_1464_8048# vin vss sky130_fd_pr__nfet_05v0_nvt ad=1.45 pd=10.29 as=1.45 ps=10.29 w=10 l=0.9
X231 a_16360_8048# a_16164_n7480# vss sky130_fd_pr__res_high_po w=0.5 l=75.64
X232 a_23713_n11140# a_24907_n11228# vss vss sky130_fd_pr__nfet_g5v0d10v5 ad=0.725 pd=5.29 as=0.725 ps=5.29 w=5 l=0.5
X233 a_30379_n11180# t2 a_31416_n6273# vss sky130_fd_pr__nfet_01v8 ad=0.825 pd=5.33 as=0.825 ps=5.33 w=5 l=0.15
X234 quiet a_23713_n11140# a_51034_n9809# vss sky130_fd_pr__nfet_05v0_nvt ad=1.45 pd=10.29 as=1.45 ps=10.29 w=10 l=0.9
X235 a_9236_8048# a_9432_n7480# vss sky130_fd_pr__res_high_po w=0.5 l=75.64
X236 vin a_1464_8048# a_51034_n9809# vss sky130_fd_pr__nfet_05v0_nvt ad=1.45 pd=10.29 as=1.45 ps=10.29 w=10 l=0.9
X237 a_42523_n6500# a_7527_n10700# a_24907_n11228# w_42120_n8480# sky130_fd_pr__pfet_g5v0d10v5 ad=0.725 pd=5.29 as=0.725 ps=5.29 w=5 l=1
X238 vss a_23713_n11140# sky130_fd_pr__cap_mim_m3_2 l=15.6 w=15.6
X239 vin a_1464_8048# a_51034_n9809# vss sky130_fd_pr__nfet_05v0_nvt ad=1.45 pd=10.29 as=1.45 ps=10.29 w=10 l=0.9
X240 a_24458_8048# a_24458_n7480# vss sky130_fd_pr__res_high_po w=0.5 l=75.64
X241 w_42120_n8480# a_19104_8048# a_19104_8048# w_42120_n8480# sky130_fd_pr__pfet_g5v0d10v5 ad=0.725 pd=5.29 as=0.725 ps=5.29 w=5 l=2
X242 vin a_1464_8048# a_51034_n9809# vss sky130_fd_pr__nfet_05v0_nvt ad=1.45 pd=10.29 as=1.45 ps=10.29 w=10 l=0.9
X243 a_17928_8048# a_17732_n7480# vss sky130_fd_pr__res_high_po w=0.5 l=75.64
X244 a_29900_878# a_25242_n7480# vss vss sky130_fd_pr__nfet_01v8 ad=0.66 pd=4.33 as=0.66 ps=4.33 w=4 l=0.15
X245 vin a_1464_8048# a_51034_n9809# vss sky130_fd_pr__nfet_05v0_nvt ad=1.45 pd=10.29 as=1.45 ps=10.29 w=10 l=0.9
X246 a_51034_n9809# a_1464_8048# vin vss sky130_fd_pr__nfet_05v0_nvt ad=1.45 pd=10.29 as=1.45 ps=10.29 w=10 l=0.9
X247 a_51034_n9809# a_1464_8048# vin vss sky130_fd_pr__nfet_05v0_nvt ad=1.45 pd=10.29 as=1.45 ps=10.29 w=10 l=0.9
X248 a_51034_n9809# a_1464_8048# vin vss sky130_fd_pr__nfet_05v0_nvt ad=1.45 pd=10.29 as=1.45 ps=10.29 w=10 l=0.9
X249 a_51034_n9809# a_1464_8048# vin vss sky130_fd_pr__nfet_05v0_nvt ad=1.45 pd=10.29 as=1.45 ps=10.29 w=10 l=0.9
X250 a_51034_n9809# a_1464_8048# vin vss sky130_fd_pr__nfet_05v0_nvt ad=1.45 pd=10.29 as=1.45 ps=10.29 w=10 l=0.9
X251 vin a_1464_8048# a_51034_n9809# vss sky130_fd_pr__nfet_05v0_nvt ad=1.45 pd=10.29 as=1.45 ps=10.29 w=10 l=0.9
X252 vin a_1464_8048# a_51034_n9809# vss sky130_fd_pr__nfet_05v0_nvt ad=1.45 pd=10.29 as=1.45 ps=10.29 w=10 l=0.9
X253 quiet a_23713_n11140# a_51034_n9809# vss sky130_fd_pr__nfet_05v0_nvt ad=1.45 pd=10.29 as=1.45 ps=10.29 w=10 l=0.9
X254 a_34968_n6273# a_35264_n8959# vss sky130_fd_pr__res_high_po w=1 l=11.43
X255 a_36004_n3859# quiet sky130_fd_pr__cap_mim_m3_1 l=13.5 w=13.5
X256 a_24654_8048# a_24458_n7480# vss sky130_fd_pr__res_high_po w=0.5 l=75.64
X257 w_42120_n8480# a_19104_8048# a_19104_8048# w_42120_n8480# sky130_fd_pr__pfet_g5v0d10v5 ad=0.725 pd=5.29 as=1.45 ps=10.58 w=5 l=2
X258 vin a_22436_8048# w_42120_n8480# vin sky130_fd_pr__pfet_g5v0d10v5 ad=0.725 pd=5.29 as=0.725 ps=5.29 w=5 l=2
X259 a_33192_n6273# a_32896_n8959# vss sky130_fd_pr__res_high_po w=1 l=11.43
X260 a_42523_n6500# a_42634_n375# w_42120_n8480# w_42120_n8480# sky130_fd_pr__pfet_g5v0d10v5 ad=0.725 pd=5.29 as=0.725 ps=5.29 w=5 l=2
X261 a_23713_n11140# a_42634_n375# w_42120_n8480# w_42120_n8480# sky130_fd_pr__pfet_g5v0d10v5 ad=0.725 pd=5.29 as=0.725 ps=5.29 w=5 l=2
X262 w_42120_n8480# a_42634_n375# a_42523_n6500# w_42120_n8480# sky130_fd_pr__pfet_g5v0d10v5 ad=0.725 pd=5.29 as=0.725 ps=5.29 w=5 l=2
X263 a_51034_n9809# a_23713_n11140# quiet vss sky130_fd_pr__nfet_05v0_nvt ad=1.45 pd=10.29 as=1.45 ps=10.29 w=10 l=0.9
X264 w_42120_n8480# a_19104_8048# a_19104_8048# w_42120_n8480# sky130_fd_pr__pfet_g5v0d10v5 ad=1.45 pd=10.58 as=0.725 ps=5.29 w=5 l=2
X265 a_34376_n6273# a_34672_n8959# vss sky130_fd_pr__res_high_po w=1 l=11.43
X266 a_42633_n11868# a_36004_n3859# a_42523_n6500# w_42120_n8480# sky130_fd_pr__pfet_g5v0d10v5 ad=0.725 pd=5.29 as=0.725 ps=5.29 w=5 l=1
X267 vin a_1464_8048# a_51034_n9809# vss sky130_fd_pr__nfet_05v0_nvt ad=1.45 pd=10.29 as=1.45 ps=10.29 w=10 l=0.9
X268 a_2052_8048# a_1856_n7480# vss sky130_fd_pr__res_high_po w=0.5 l=75.64
X269 a_24654_8048# a_24850_n7480# vss sky130_fd_pr__res_high_po w=0.5 l=75.64
X270 vin a_1464_8048# a_51034_n9809# vss sky130_fd_pr__nfet_05v0_nvt ad=1.45 pd=10.29 as=1.45 ps=10.29 w=10 l=0.9
X271 vin a_1464_8048# a_51034_n9809# vss sky130_fd_pr__nfet_05v0_nvt ad=1.45 pd=10.29 as=1.45 ps=10.29 w=10 l=0.9
X272 w_42120_n8480# vss sky130_fd_pr__cap_mim_m3_1 l=29.42 w=29.42
X273 quiet a_32800_3942# vss vss sky130_fd_pr__nfet_01v8 ad=0.66 pd=4.33 as=0.66 ps=4.33 w=4 l=0.15
X274 a_23713_n11140# a_42634_n375# w_42120_n8480# w_42120_n8480# sky130_fd_pr__pfet_g5v0d10v5 ad=0.725 pd=5.29 as=0.725 ps=5.29 w=5 l=2
X275 a_29179_n11180# vss vss sky130_fd_pr__res_high_po w=1 l=11.43
X276 a_35412_n1173# a_36004_n3859# vss sky130_fd_pr__res_high_po w=1 l=11.43
X277 a_51034_n9809# a_1464_8048# vin vss sky130_fd_pr__nfet_05v0_nvt ad=1.45 pd=10.29 as=1.45 ps=10.29 w=10 l=0.9
X278 a_51034_n9809# a_1464_8048# vin vss sky130_fd_pr__nfet_05v0_nvt ad=1.45 pd=10.29 as=1.45 ps=10.29 w=10 l=0.9
X279 vin a_1464_8048# a_51034_n9809# vss sky130_fd_pr__nfet_05v0_nvt ad=1.45 pd=10.29 as=1.45 ps=10.29 w=10 l=0.9
X280 vss i_ldo a_42634_n375# vss sky130_fd_pr__nfet_g5v0d10v5 ad=0.725 pd=5.29 as=0.725 ps=5.29 w=5 l=2
X281 a_7527_n10700# a_11392_n7480# vss sky130_fd_pr__res_high_po w=0.5 l=75.64
X282 a_31416_n6273# t2 a_30379_n11180# vss sky130_fd_pr__nfet_01v8 ad=0.825 pd=5.33 as=0.825 ps=5.33 w=5 l=0.15
X283 w_42120_n8480# a_22436_8048# vin vin sky130_fd_pr__pfet_g5v0d10v5 ad=0.725 pd=5.29 as=0.725 ps=5.29 w=5 l=2
X284 w_42120_n8480# w_42120_n8480# a_42523_n6500# w_42120_n8480# sky130_fd_pr__pfet_g5v0d10v5 ad=1.45 pd=10.58 as=0.725 ps=5.29 w=5 l=1
X285 vin a_1464_8048# a_51034_n9809# vss sky130_fd_pr__nfet_05v0_nvt ad=1.45 pd=10.29 as=1.45 ps=10.29 w=10 l=0.9
X286 quiet a_29900_878# a_32800_3942# quiet sky130_fd_pr__pfet_01v8 ad=0.99 pd=6.33 as=0.99 ps=6.33 w=6 l=0.15
X287 a_25242_n7480# a_2667_n10997# vss vss sky130_fd_pr__nfet_01v8 ad=0.62 pd=4.62 as=0.33 ps=2.33 w=2 l=0.15
X288 a_51034_n9809# a_1464_8048# vin vss sky130_fd_pr__nfet_05v0_nvt ad=1.45 pd=10.29 as=1.45 ps=10.29 w=10 l=0.9
X289 quiet a_23713_n11140# a_51034_n9809# vss sky130_fd_pr__nfet_05v0_nvt ad=1.45 pd=10.29 as=1.45 ps=10.29 w=10 l=0.9
X290 a_7276_8048# a_7080_n7480# vss sky130_fd_pr__res_high_po w=0.5 l=75.64
X291 a_51034_n9809# a_23713_n11140# quiet vss sky130_fd_pr__nfet_05v0_nvt ad=1.45 pd=10.29 as=1.45 ps=10.29 w=10 l=0.9
X292 w_42120_n8480# a_42634_n375# a_23713_n11140# w_42120_n8480# sky130_fd_pr__pfet_g5v0d10v5 ad=0.725 pd=5.29 as=0.725 ps=5.29 w=5 l=2
X293 w_42120_n8480# a_42634_n375# a_42523_n6500# w_42120_n8480# sky130_fd_pr__pfet_g5v0d10v5 ad=0.725 pd=5.29 as=0.725 ps=5.29 w=5 l=2
X294 vss a_2667_n10997# a_23713_n11140# vss sky130_fd_pr__nfet_g5v0d10v5 ad=0.725 pd=5.29 as=1.45 ps=10.58 w=5 l=0.5
X295 quiet a_32800_3942# vss vss sky130_fd_pr__nfet_01v8 ad=0.66 pd=4.33 as=0.66 ps=4.33 w=4 l=0.15
X296 w_42120_n8480# a_42634_n375# a_42523_n6500# w_42120_n8480# sky130_fd_pr__pfet_g5v0d10v5 ad=0.725 pd=5.29 as=0.725 ps=5.29 w=5 l=2
X297 vss a_2667_n10997# a_7527_n10700# vss sky130_fd_pr__nfet_01v8 ad=0.58 pd=4.58 as=0.58 ps=4.58 w=2 l=0.15
X298 a_7276_8048# a_7472_n7480# vss sky130_fd_pr__res_high_po w=0.5 l=75.64
X299 a_28900_n1173# a_29788_n3859# vss sky130_fd_pr__res_high_po w=1 l=11.43
X300 vin a_1464_8048# a_51034_n9809# vss sky130_fd_pr__nfet_05v0_nvt ad=1.45 pd=10.29 as=1.45 ps=10.29 w=10 l=0.9
X301 w_42120_n8480# a_19104_8048# a_19104_8048# w_42120_n8480# sky130_fd_pr__pfet_g5v0d10v5 ad=0.725 pd=5.29 as=0.725 ps=5.29 w=5 l=2
X302 a_51034_n9809# a_23713_n11140# quiet vss sky130_fd_pr__nfet_05v0_nvt ad=1.45 pd=10.29 as=1.45 ps=10.29 w=10 l=0.9
X303 a_15968_8048# a_15772_n7480# vss sky130_fd_pr__res_high_po w=0.5 l=75.64
X304 w_42120_n8480# a_42634_n375# a_23713_n11140# w_42120_n8480# sky130_fd_pr__pfet_g5v0d10v5 ad=0.725 pd=5.29 as=0.725 ps=5.29 w=5 l=2
X305 vin a_1464_8048# a_51034_n9809# vss sky130_fd_pr__nfet_05v0_nvt ad=1.45 pd=10.29 as=1.45 ps=10.29 w=10 l=0.9
X306 w_42120_n8480# a_19104_8048# a_19104_8048# w_42120_n8480# sky130_fd_pr__pfet_g5v0d10v5 ad=0.725 pd=5.29 as=0.725 ps=5.29 w=5 l=2
X307 vss t0 a_29179_n11180# vss sky130_fd_pr__nfet_01v8 ad=0.825 pd=5.33 as=0.825 ps=5.33 w=5 l=0.15
X308 vin a_1464_8048# a_51034_n9809# vss sky130_fd_pr__nfet_05v0_nvt ad=1.45 pd=10.29 as=1.45 ps=10.29 w=10 l=0.9
X309 quiet a_23713_n11140# a_51034_n9809# vss sky130_fd_pr__nfet_05v0_nvt ad=2.9 pd=20.58 as=1.45 ps=10.29 w=10 l=0.9
X310 vin a_1464_8048# a_51034_n9809# vss sky130_fd_pr__nfet_05v0_nvt ad=1.45 pd=10.29 as=1.45 ps=10.29 w=10 l=0.9
X311 a_51034_n9809# a_23713_n11140# quiet vss sky130_fd_pr__nfet_05v0_nvt ad=1.45 pd=10.29 as=1.45 ps=10.29 w=10 l=0.9
X312 quiet a_23713_n11140# a_51034_n9809# vss sky130_fd_pr__nfet_05v0_nvt ad=1.45 pd=10.29 as=1.45 ps=10.29 w=10 l=0.9
X313 vss a_32800_3942# quiet vss sky130_fd_pr__nfet_01v8 ad=0.66 pd=4.33 as=0.66 ps=4.33 w=4 l=0.15
X314 w_42120_n8480# a_22436_8048# vin vin sky130_fd_pr__pfet_g5v0d10v5 ad=0.725 pd=5.29 as=0.725 ps=5.29 w=5 l=2
X315 a_42523_n6500# a_7527_n10700# a_24907_n11228# w_42120_n8480# sky130_fd_pr__pfet_g5v0d10v5 ad=0.725 pd=5.29 as=0.725 ps=5.29 w=5 l=1
X316 vin a_1464_8048# a_51034_n9809# vss sky130_fd_pr__nfet_05v0_nvt ad=1.45 pd=10.29 as=1.45 ps=10.29 w=10 l=0.9
X317 a_23713_n11140# a_42634_n375# w_42120_n8480# w_42120_n8480# sky130_fd_pr__pfet_g5v0d10v5 ad=0.725 pd=5.29 as=0.725 ps=5.29 w=5 l=2
X318 a_24907_n11228# a_7527_n10700# a_42523_n6500# w_42120_n8480# sky130_fd_pr__pfet_g5v0d10v5 ad=0.725 pd=5.29 as=0.725 ps=5.29 w=5 l=1
X319 quiet a_23713_n11140# a_51034_n9809# vss sky130_fd_pr__nfet_05v0_nvt ad=1.45 pd=10.29 as=1.45 ps=10.29 w=10 l=0.9
X320 quiet a_23713_n11140# a_51034_n9809# vss sky130_fd_pr__nfet_05v0_nvt ad=1.45 pd=10.29 as=2.9 ps=20.58 w=10 l=0.9
X321 a_19104_8048# a_19104_8048# w_42120_n8480# w_42120_n8480# sky130_fd_pr__pfet_g5v0d10v5 ad=0.725 pd=5.29 as=0.725 ps=5.29 w=5 l=2
X322 a_42523_n6500# a_7527_n10700# a_24907_n11228# w_42120_n8480# sky130_fd_pr__pfet_g5v0d10v5 ad=0.725 pd=5.29 as=0.725 ps=5.29 w=5 l=1
X323 vin a_1464_8048# a_51034_n9809# vss sky130_fd_pr__nfet_05v0_nvt ad=1.45 pd=10.29 as=1.45 ps=10.29 w=10 l=0.9
X324 vin a_1464_8048# a_51034_n9809# vss sky130_fd_pr__nfet_05v0_nvt ad=1.45 pd=10.29 as=1.45 ps=10.29 w=10 l=0.9
X325 a_34376_n6273# a_34080_n8959# vss sky130_fd_pr__res_high_po w=1 l=11.43
X326 a_29900_878# a_25242_n7480# vss vss sky130_fd_pr__nfet_01v8 ad=0.66 pd=4.33 as=0.66 ps=4.33 w=4 l=0.15
X327 a_51034_n9809# a_23713_n11140# quiet vss sky130_fd_pr__nfet_05v0_nvt ad=1.45 pd=10.29 as=1.45 ps=10.29 w=10 l=0.9
X328 w_42120_n8480# a_19104_8048# a_19104_8048# w_42120_n8480# sky130_fd_pr__pfet_g5v0d10v5 ad=0.725 pd=5.29 as=0.725 ps=5.29 w=5 l=2
X329 a_51034_n9809# a_23713_n11140# quiet vss sky130_fd_pr__nfet_05v0_nvt ad=1.45 pd=10.29 as=1.45 ps=10.29 w=10 l=0.9
X330 vin a_1464_8048# a_51034_n9809# vss sky130_fd_pr__nfet_05v0_nvt ad=1.45 pd=10.29 as=1.45 ps=10.29 w=10 l=0.9
X331 w_42120_n8480# w_42120_n8480# a_42523_n6500# w_42120_n8480# sky130_fd_pr__pfet_g5v0d10v5 ad=1.45 pd=10.58 as=0.725 ps=5.29 w=5 l=1
X332 a_23713_n11140# vss sky130_fd_pr__cap_mim_m3_1 l=15.6 w=15.6
X333 vss vss vss sky130_fd_pr__res_high_po w=1 l=11.43
X334 vss vss vss sky130_fd_pr__res_high_po w=1 l=11.43
X335 a_23713_n11140# a_42634_n375# w_42120_n8480# w_42120_n8480# sky130_fd_pr__pfet_g5v0d10v5 ad=0.725 pd=5.29 as=0.725 ps=5.29 w=5 l=2
X336 a_35708_n1173# a_36004_n3859# vss sky130_fd_pr__res_high_po w=1 l=11.43
X337 a_33784_n6273# a_33488_n8959# vss sky130_fd_pr__res_high_po w=1 l=11.43
X338 vss a_7527_n10700# sky130_fd_pr__cap_mim_m3_2 l=29.42 w=29.42
X339 vin a_1464_8048# a_51034_n9809# vss sky130_fd_pr__nfet_05v0_nvt ad=1.45 pd=10.29 as=1.45 ps=10.29 w=10 l=0.9
X340 a_23713_n11140# a_42634_n375# w_42120_n8480# w_42120_n8480# sky130_fd_pr__pfet_g5v0d10v5 ad=0.725 pd=5.29 as=0.725 ps=5.29 w=5 l=2
X341 vss a_7527_n10700# sky130_fd_pr__cap_mim_m3_2 l=29.42 w=29.42
X342 a_51034_n9809# a_1464_8048# vin vss sky130_fd_pr__nfet_05v0_nvt ad=1.45 pd=10.29 as=1.45 ps=10.29 w=10 l=0.9
X343 vin a_22436_8048# w_42120_n8480# vin sky130_fd_pr__pfet_g5v0d10v5 ad=0.725 pd=5.29 as=0.725 ps=5.29 w=5 l=2
X344 quiet a_23713_n11140# a_51034_n9809# vss sky130_fd_pr__nfet_05v0_nvt ad=1.45 pd=10.29 as=2.9 ps=20.58 w=10 l=0.9
X345 a_51034_n9809# a_1464_8048# vin vss sky130_fd_pr__nfet_05v0_nvt ad=1.45 pd=10.29 as=1.45 ps=10.29 w=10 l=0.9
X346 quiet a_23713_n11140# a_51034_n9809# vss sky130_fd_pr__nfet_05v0_nvt ad=1.45 pd=10.29 as=1.45 ps=10.29 w=10 l=0.9
X347 a_51034_n9809# a_1464_8048# vin vss sky130_fd_pr__nfet_05v0_nvt ad=1.45 pd=10.29 as=1.45 ps=10.29 w=10 l=0.9
X348 quiet a_23713_n11140# a_51034_n9809# vss sky130_fd_pr__nfet_05v0_nvt ad=1.45 pd=10.29 as=2.9 ps=20.58 w=10 l=0.9
X349 quiet a_23713_n11140# a_51034_n9809# vss sky130_fd_pr__nfet_05v0_nvt ad=1.45 pd=10.29 as=2.9 ps=20.58 w=10 l=0.9
X350 a_1660_8048# a_1856_n7480# vss sky130_fd_pr__res_high_po w=0.5 l=75.64
X351 quiet a_23713_n11140# a_51034_n9809# vss sky130_fd_pr__nfet_05v0_nvt ad=1.45 pd=10.29 as=1.45 ps=10.29 w=10 l=0.9
X352 a_22436_8048# a_22240_n7480# vss sky130_fd_pr__res_high_po w=0.5 l=75.64
X353 quiet a_32800_3942# vss vss sky130_fd_pr__nfet_01v8 ad=0.66 pd=4.33 as=0.66 ps=4.33 w=4 l=0.15
X354 w_42120_n8480# a_19104_8048# a_19104_8048# w_42120_n8480# sky130_fd_pr__pfet_g5v0d10v5 ad=0.725 pd=5.29 as=0.725 ps=5.29 w=5 l=2
X355 a_35412_n1173# a_34820_n3859# vss sky130_fd_pr__res_high_po w=1 l=11.43
X356 a_29179_n11180# t0 vss vss sky130_fd_pr__nfet_01v8 ad=0.825 pd=5.33 as=0.825 ps=5.33 w=5 l=0.15
X357 a_31860_n1173# a_33340_n3859# vss sky130_fd_pr__res_high_po w=1 l=11.43
X358 a_42523_n6500# a_42634_n375# w_42120_n8480# w_42120_n8480# sky130_fd_pr__pfet_g5v0d10v5 ad=0.725 pd=5.29 as=0.725 ps=5.29 w=5 l=2
X359 vin a_1464_8048# a_51034_n9809# vss sky130_fd_pr__nfet_05v0_nvt ad=1.45 pd=10.29 as=1.45 ps=10.29 w=10 l=0.9
X360 a_24907_n11228# a_7527_n10700# a_42523_n6500# w_42120_n8480# sky130_fd_pr__pfet_g5v0d10v5 ad=0.725 pd=5.29 as=0.725 ps=5.29 w=5 l=1
X361 vin a_1464_8048# a_51034_n9809# vss sky130_fd_pr__nfet_05v0_nvt ad=1.45 pd=10.29 as=1.45 ps=10.29 w=10 l=0.9
X362 vss i_ldo a_42634_n375# vss sky130_fd_pr__nfet_g5v0d10v5 ad=0.725 pd=5.29 as=1.45 ps=10.58 w=5 l=2
X363 a_33932_n1173# a_34820_n3859# vss sky130_fd_pr__res_high_po w=1 l=11.43
X364 quiet a_29900_878# a_32800_3942# quiet sky130_fd_pr__pfet_01v8 ad=0.99 pd=6.33 as=0.99 ps=6.33 w=6 l=0.15
X365 a_24907_n11228# a_7527_n10700# a_42523_n6500# w_42120_n8480# sky130_fd_pr__pfet_g5v0d10v5 ad=0.725 pd=5.29 as=0.725 ps=5.29 w=5 l=1
X366 w_42120_n8480# a_22436_8048# vin vin sky130_fd_pr__pfet_g5v0d10v5 ad=0.725 pd=5.29 as=0.725 ps=5.29 w=5 l=2
X367 a_19104_8048# a_19104_8048# w_42120_n8480# w_42120_n8480# sky130_fd_pr__pfet_g5v0d10v5 ad=0.725 pd=5.29 as=0.725 ps=5.29 w=5 l=2
X368 a_42523_n6500# a_36004_n3859# a_42633_n11868# w_42120_n8480# sky130_fd_pr__pfet_g5v0d10v5 ad=0.725 pd=5.29 as=0.725 ps=5.29 w=5 l=1
X369 vss w_42120_n8480# sky130_fd_pr__cap_mim_m3_2 l=29.42 w=29.42
X370 a_51034_n9809# a_1464_8048# vin vss sky130_fd_pr__nfet_05v0_nvt ad=1.45 pd=10.29 as=1.45 ps=10.29 w=10 l=0.9
X371 quiet a_23713_n11140# a_51034_n9809# vss sky130_fd_pr__nfet_05v0_nvt ad=1.45 pd=10.29 as=1.45 ps=10.29 w=10 l=0.9
X372 vin a_1464_8048# a_51034_n9809# vss sky130_fd_pr__nfet_05v0_nvt ad=1.45 pd=10.29 as=1.45 ps=10.29 w=10 l=0.9
X373 a_51034_n9809# a_1464_8048# vin vss sky130_fd_pr__nfet_05v0_nvt ad=1.45 pd=10.29 as=2.9 ps=20.58 w=10 l=0.9
X374 a_51034_n9809# a_23713_n11140# quiet vss sky130_fd_pr__nfet_05v0_nvt ad=1.45 pd=10.29 as=1.45 ps=10.29 w=10 l=0.9
X375 vin a_1464_8048# a_51034_n9809# vss sky130_fd_pr__nfet_05v0_nvt ad=1.45 pd=10.29 as=1.45 ps=10.29 w=10 l=0.9
X376 quiet a_23713_n11140# a_51034_n9809# vss sky130_fd_pr__nfet_05v0_nvt ad=1.45 pd=10.29 as=1.45 ps=10.29 w=10 l=0.9
X377 a_51034_n9809# a_1464_8048# vin vss sky130_fd_pr__nfet_05v0_nvt ad=1.45 pd=10.29 as=1.45 ps=10.29 w=10 l=0.9
X378 a_42523_n6500# a_36004_n3859# a_42633_n11868# w_42120_n8480# sky130_fd_pr__pfet_g5v0d10v5 ad=0.725 pd=5.29 as=0.725 ps=5.29 w=5 l=1
X379 vin a_1464_8048# a_51034_n9809# vss sky130_fd_pr__nfet_05v0_nvt ad=1.45 pd=10.29 as=1.45 ps=10.29 w=10 l=0.9
X380 a_19104_8048# a_19104_8048# w_42120_n8480# w_42120_n8480# sky130_fd_pr__pfet_g5v0d10v5 ad=0.725 pd=5.29 as=0.725 ps=5.29 w=5 l=2
X381 a_51034_n9809# a_23713_n11140# quiet vss sky130_fd_pr__nfet_05v0_nvt ad=1.45 pd=10.29 as=1.45 ps=10.29 w=10 l=0.9
X382 quiet a_32800_3942# vss vss sky130_fd_pr__nfet_01v8 ad=0.66 pd=4.33 as=0.66 ps=4.33 w=4 l=0.15
X383 a_42523_n6500# a_42634_n375# w_42120_n8480# w_42120_n8480# sky130_fd_pr__pfet_g5v0d10v5 ad=0.725 pd=5.29 as=0.725 ps=5.29 w=5 l=2
X384 i_ldo i_ldo vss vss sky130_fd_pr__nfet_g5v0d10v5 ad=0.725 pd=5.29 as=0.725 ps=5.29 w=5 l=2
X385 quiet a_23713_n11140# a_51034_n9809# vss sky130_fd_pr__nfet_05v0_nvt ad=1.45 pd=10.29 as=1.45 ps=10.29 w=10 l=0.9
X386 a_32008_n6273# t4 a_33192_n6273# vss sky130_fd_pr__nfet_01v8 ad=0.825 pd=5.33 as=1.55 ps=10.62 w=5 l=0.15
X387 a_24907_n11228# a_40600_n6374# vss sky130_fd_pr__res_high_po w=1 l=14.58
X388 a_25046_8048# a_24850_n7480# vss sky130_fd_pr__res_high_po w=0.5 l=75.64
X389 a_18320_8048# a_18516_n7480# vss sky130_fd_pr__res_high_po w=0.5 l=75.64
X390 w_42120_n8480# a_19104_8048# a_19104_8048# w_42120_n8480# sky130_fd_pr__pfet_g5v0d10v5 ad=0.725 pd=5.29 as=0.725 ps=5.29 w=5 l=2
X391 w_42120_n8480# a_19104_8048# a_19104_8048# w_42120_n8480# sky130_fd_pr__pfet_g5v0d10v5 ad=0.725 pd=5.29 as=0.725 ps=5.29 w=5 l=2
X392 vss a_24907_n11228# a_23713_n11140# vss sky130_fd_pr__nfet_g5v0d10v5 ad=0.725 pd=5.29 as=0.725 ps=5.29 w=5 l=0.5
X393 a_42523_n6500# a_36004_n3859# a_42633_n11868# w_42120_n8480# sky130_fd_pr__pfet_g5v0d10v5 ad=0.725 pd=5.29 as=0.725 ps=5.29 w=5 l=1
X394 a_32008_n6273# t3 a_31416_n6273# vss sky130_fd_pr__nfet_01v8 ad=1.55 pd=10.62 as=0.825 ps=5.33 w=5 l=0.15
X395 a_51034_n9809# a_1464_8048# vin vss sky130_fd_pr__nfet_05v0_nvt ad=1.45 pd=10.29 as=2.9 ps=20.58 w=10 l=0.9
X396 w_42120_n8480# a_22436_8048# vin vin sky130_fd_pr__pfet_g5v0d10v5 ad=0.725 pd=5.29 as=0.725 ps=5.29 w=5 l=2
X397 a_33192_n6273# a_33488_n8959# vss sky130_fd_pr__res_high_po w=1 l=11.43
X398 a_19104_8048# a_19104_8048# w_42120_n8480# w_42120_n8480# sky130_fd_pr__pfet_g5v0d10v5 ad=0.725 pd=5.29 as=0.725 ps=5.29 w=5 l=2
X399 vin a_1464_8048# a_51034_n9809# vss sky130_fd_pr__nfet_05v0_nvt ad=1.45 pd=10.29 as=1.45 ps=10.29 w=10 l=0.9
X400 a_51034_n9809# a_1464_8048# vin vss sky130_fd_pr__nfet_05v0_nvt ad=1.45 pd=10.29 as=1.45 ps=10.29 w=10 l=0.9
X401 a_25046_8048# a_25242_n7480# vss sky130_fd_pr__res_high_po w=0.5 l=75.64
X402 quiet a_23713_n11140# a_51034_n9809# vss sky130_fd_pr__nfet_05v0_nvt ad=1.45 pd=10.29 as=1.45 ps=10.29 w=10 l=0.9
X403 a_51034_n9809# a_1464_8048# vin vss sky130_fd_pr__nfet_05v0_nvt ad=1.45 pd=10.29 as=1.45 ps=10.29 w=10 l=0.9
X404 a_51034_n9809# a_1464_8048# vin vss sky130_fd_pr__nfet_05v0_nvt ad=1.45 pd=10.29 as=1.45 ps=10.29 w=10 l=0.9
X405 a_51034_n9809# a_1464_8048# vin vss sky130_fd_pr__nfet_05v0_nvt ad=1.45 pd=10.29 as=1.45 ps=10.29 w=10 l=0.9
X406 quiet a_23713_n11140# a_51034_n9809# vss sky130_fd_pr__nfet_05v0_nvt ad=1.45 pd=10.29 as=1.45 ps=10.29 w=10 l=0.9
X407 vss vss vss vss sky130_fd_pr__nfet_g5v0d10v5 ad=1.45 pd=10.58 as=0 ps=0 w=5 l=2
X408 a_18712_8048# a_18516_n7480# vss sky130_fd_pr__res_high_po w=0.5 l=75.64
X409 a_34968_n6273# a_34672_n8959# vss sky130_fd_pr__res_high_po w=1 l=11.43
X410 a_32008_n6273# t3 a_31416_n6273# vss sky130_fd_pr__nfet_01v8 ad=0.825 pd=5.33 as=0.825 ps=5.33 w=5 l=0.15
X411 a_51034_n9809# a_1464_8048# vin vss sky130_fd_pr__nfet_05v0_nvt ad=1.45 pd=10.29 as=1.45 ps=10.29 w=10 l=0.9
X412 a_42633_n11868# a_36004_n3859# a_42523_n6500# w_42120_n8480# sky130_fd_pr__pfet_g5v0d10v5 ad=0.725 pd=5.29 as=0.725 ps=5.29 w=5 l=1
X413 quiet a_23713_n11140# a_51034_n9809# vss sky130_fd_pr__nfet_05v0_nvt ad=1.45 pd=10.29 as=1.45 ps=10.29 w=10 l=0.9
X414 a_34524_n1173# a_35116_n3859# vss sky130_fd_pr__res_high_po w=1 l=11.43
X415 a_32600_n6273# a_32896_n8959# vss sky130_fd_pr__res_high_po w=1 l=11.43
X416 a_29900_878# a_25242_n7480# vss vss sky130_fd_pr__nfet_01v8 ad=1.24 pd=8.62 as=0.66 ps=4.33 w=4 l=0.15
X417 a_32748_n1173# a_33044_n3859# vss sky130_fd_pr__res_high_po w=1 l=11.43
X418 w_42120_n8480# a_42634_n375# a_42523_n6500# w_42120_n8480# sky130_fd_pr__pfet_g5v0d10v5 ad=0.725 pd=5.29 as=1.45 ps=10.58 w=5 l=2
X419 quiet a_25242_n7480# sky130_fd_pr__cap_mim_m3_2 l=22.2 w=22.2
X420 a_51034_n9809# a_1464_8048# vin vss sky130_fd_pr__nfet_05v0_nvt ad=1.45 pd=10.29 as=1.45 ps=10.29 w=10 l=0.9
X421 a_29179_n11180# vss vss sky130_fd_pr__res_high_po w=1 l=11.43
X422 a_42633_n11868# a_36004_n3859# a_42523_n6500# w_42120_n8480# sky130_fd_pr__pfet_g5v0d10v5 ad=0.725 pd=5.29 as=0.725 ps=5.29 w=5 l=1
X423 a_1015_n10700# a_2667_n10997# bg host sky130_fd_pr__pfet_01v8 ad=1.16 pd=8.58 as=1.16 ps=8.58 w=4 l=0.15
X424 vin a_1464_8048# a_51034_n9809# vss sky130_fd_pr__nfet_05v0_nvt ad=1.45 pd=10.29 as=1.45 ps=10.29 w=10 l=0.9
X425 vss a_42633_n11868# a_42633_n11868# vss sky130_fd_pr__nfet_g5v0d10v5 ad=0.725 pd=5.29 as=0.725 ps=5.29 w=5 l=2
X426 w_42120_n8480# a_19104_8048# a_19104_8048# w_42120_n8480# sky130_fd_pr__pfet_g5v0d10v5 ad=0.725 pd=5.29 as=0.725 ps=5.29 w=5 l=2
X427 a_23713_n11140# a_42634_n375# w_42120_n8480# w_42120_n8480# sky130_fd_pr__pfet_g5v0d10v5 ad=0.725 pd=5.29 as=0.725 ps=5.29 w=5 l=2
X428 a_34524_n1173# a_34228_n3859# vss sky130_fd_pr__res_high_po w=1 l=11.43
X429 vss a_25242_n7480# a_29900_878# vss sky130_fd_pr__nfet_01v8 ad=0.66 pd=4.33 as=0.66 ps=4.33 w=4 l=0.15
X430 a_32156_n1173# a_32452_n3859# vss sky130_fd_pr__res_high_po w=1 l=11.43
X431 a_24907_n11228# a_42633_n11868# vss vss sky130_fd_pr__nfet_g5v0d10v5 ad=0.725 pd=5.29 as=0.725 ps=5.29 w=5 l=2
X432 vin a_22436_8048# w_42120_n8480# vin sky130_fd_pr__pfet_g5v0d10v5 ad=0.725 pd=5.29 as=1.45 ps=10.58 w=5 l=2
X433 a_7527_n10700# vss sky130_fd_pr__cap_mim_m3_1 l=29.42 w=29.42
X434 quiet a_23713_n11140# a_51034_n9809# vss sky130_fd_pr__nfet_05v0_nvt ad=1.45 pd=10.29 as=1.45 ps=10.29 w=10 l=0.9
X435 vss i_ldo i_ldo vss sky130_fd_pr__nfet_g5v0d10v5 ad=0.725 pd=5.29 as=0.725 ps=5.29 w=5 l=2
X436 a_7527_n10700# vss sky130_fd_pr__cap_mim_m3_1 l=29.42 w=29.42
X437 quiet a_32800_3942# vss vss sky130_fd_pr__nfet_01v8 ad=0.66 pd=4.33 as=0.66 ps=4.33 w=4 l=0.15
X438 a_30380_n1173# a_29788_n3859# vss sky130_fd_pr__res_high_po w=1 l=11.43
X439 a_51034_n9809# a_1464_8048# vin vss sky130_fd_pr__nfet_05v0_nvt ad=1.45 pd=10.29 as=1.45 ps=10.29 w=10 l=0.9
X440 vin a_1464_8048# a_51034_n9809# vss sky130_fd_pr__nfet_05v0_nvt ad=1.45 pd=10.29 as=1.45 ps=10.29 w=10 l=0.9
X441 vin a_22436_8048# w_42120_n8480# vin sky130_fd_pr__pfet_g5v0d10v5 ad=0.725 pd=5.29 as=0.725 ps=5.29 w=5 l=2
X442 a_33932_n1173# a_33340_n3859# vss sky130_fd_pr__res_high_po w=1 l=11.43
X443 a_42523_n6500# a_36004_n3859# a_42633_n11868# w_42120_n8480# sky130_fd_pr__pfet_g5v0d10v5 ad=0.725 pd=5.29 as=0.725 ps=5.29 w=5 l=1
X444 quiet a_23713_n11140# a_51034_n9809# vss sky130_fd_pr__nfet_05v0_nvt ad=1.45 pd=10.29 as=1.45 ps=10.29 w=10 l=0.9
X445 a_51034_n9809# a_1464_8048# vin vss sky130_fd_pr__nfet_05v0_nvt ad=1.45 pd=10.29 as=1.45 ps=10.29 w=10 l=0.9
X446 quiet a_32800_3942# vss vss sky130_fd_pr__nfet_01v8 ad=1.24 pd=8.62 as=0.66 ps=4.33 w=4 l=0.15
X447 vin a_22436_8048# w_42120_n8480# vin sky130_fd_pr__pfet_g5v0d10v5 ad=1.45 pd=10.58 as=0.725 ps=5.29 w=5 l=2
X448 a_31860_n1173# a_31268_n3859# vss sky130_fd_pr__res_high_po w=1 l=11.43
X449 a_51034_n9809# a_1464_8048# vin vss sky130_fd_pr__nfet_05v0_nvt ad=1.45 pd=10.29 as=1.45 ps=10.29 w=10 l=0.9
X450 a_42523_n6500# a_42634_n375# w_42120_n8480# w_42120_n8480# sky130_fd_pr__pfet_g5v0d10v5 ad=0.725 pd=5.29 as=0.725 ps=5.29 w=5 l=2
X451 vss vss vss vss sky130_fd_pr__nfet_g5v0d10v5 ad=0.725 pd=5.29 as=0 ps=0 w=5 l=2
X452 w_42120_n8480# a_42634_n375# a_42523_n6500# w_42120_n8480# sky130_fd_pr__pfet_g5v0d10v5 ad=0.725 pd=5.29 as=0.725 ps=5.29 w=5 l=2
X453 a_42633_n11868# a_36004_n3859# a_42523_n6500# w_42120_n8480# sky130_fd_pr__pfet_g5v0d10v5 ad=0.725 pd=5.29 as=0.725 ps=5.29 w=5 l=1
X454 w_42120_n8480# a_42634_n375# a_23713_n11140# w_42120_n8480# sky130_fd_pr__pfet_g5v0d10v5 ad=0.725 pd=5.29 as=1.45 ps=10.58 w=5 l=2
X455 a_28900_n1173# quiet vss sky130_fd_pr__res_high_po w=1 l=11.43
X456 a_8060_8048# a_7864_n7480# vss sky130_fd_pr__res_high_po w=0.5 l=75.64
X457 vin a_1464_8048# a_51034_n9809# vss sky130_fd_pr__nfet_05v0_nvt ad=1.45 pd=10.29 as=1.45 ps=10.29 w=10 l=0.9
X458 a_23713_n11140# a_24907_n11228# vss vss sky130_fd_pr__nfet_g5v0d10v5 ad=1.45 pd=10.58 as=0.725 ps=5.29 w=5 l=0.5
X459 a_51034_n9809# a_23713_n11140# quiet vss sky130_fd_pr__nfet_05v0_nvt ad=1.45 pd=10.29 as=1.45 ps=10.29 w=10 l=0.9
X460 quiet a_29900_878# a_32800_3942# quiet sky130_fd_pr__pfet_01v8 ad=0.99 pd=6.33 as=0.99 ps=6.33 w=6 l=0.15
X461 a_42523_n6500# a_7527_n10700# a_24907_n11228# w_42120_n8480# sky130_fd_pr__pfet_g5v0d10v5 ad=0.725 pd=5.29 as=0.725 ps=5.29 w=5 l=1
X462 a_19104_8048# a_19104_8048# w_42120_n8480# w_42120_n8480# sky130_fd_pr__pfet_g5v0d10v5 ad=0.725 pd=5.29 as=0.725 ps=5.29 w=5 l=2
X463 a_16360_8048# a_16556_n7480# vss sky130_fd_pr__res_high_po w=0.5 l=75.64
X464 a_9628_8048# a_9432_n7480# vss sky130_fd_pr__res_high_po w=0.5 l=75.64
X465 quiet a_23713_n11140# a_51034_n9809# vss sky130_fd_pr__nfet_05v0_nvt ad=1.45 pd=10.29 as=1.45 ps=10.29 w=10 l=0.9
X466 quiet a_32800_3942# vss vss sky130_fd_pr__nfet_01v8 ad=0.66 pd=4.33 as=0.66 ps=4.33 w=4 l=0.15
X467 a_32800_3942# a_29900_878# quiet quiet sky130_fd_pr__pfet_01v8 ad=0.99 pd=6.33 as=0.99 ps=6.33 w=6 l=0.15
X468 a_51034_n9809# a_1464_8048# vin vss sky130_fd_pr__nfet_05v0_nvt ad=1.45 pd=10.29 as=1.45 ps=10.29 w=10 l=0.9
X469 w_42120_n8480# vss sky130_fd_pr__cap_mim_m3_1 l=29.42 w=29.42
X470 vss a_2667_n10997# a_25242_n7480# vss sky130_fd_pr__nfet_01v8 ad=0.33 pd=2.33 as=0.62 ps=4.62 w=2 l=0.15
X471 quiet a_23713_n11140# a_51034_n9809# vss sky130_fd_pr__nfet_05v0_nvt ad=1.45 pd=10.29 as=1.45 ps=10.29 w=10 l=0.9
X472 a_23713_n11140# a_24907_n11228# vss vss sky130_fd_pr__nfet_g5v0d10v5 ad=0.725 pd=5.29 as=0.725 ps=5.29 w=5 l=0.5
X473 a_51034_n9809# a_1464_8048# vin vss sky130_fd_pr__nfet_05v0_nvt ad=1.45 pd=10.29 as=1.45 ps=10.29 w=10 l=0.9
X474 vin a_1464_8048# a_51034_n9809# vss sky130_fd_pr__nfet_05v0_nvt ad=1.45 pd=10.29 as=1.45 ps=10.29 w=10 l=0.9
X475 a_51034_n9809# a_1464_8048# vin vss sky130_fd_pr__nfet_05v0_nvt ad=1.45 pd=10.29 as=1.45 ps=10.29 w=10 l=0.9
X476 a_51034_n9809# a_1464_8048# vin vss sky130_fd_pr__nfet_05v0_nvt ad=1.45 pd=10.29 as=1.45 ps=10.29 w=10 l=0.9
X477 a_9628_8048# a_9824_n7480# vss sky130_fd_pr__res_high_po w=0.5 l=75.64
X478 a_16752_8048# a_16556_n7480# vss sky130_fd_pr__res_high_po w=0.5 l=75.64
X479 a_29179_n11180# t1 a_30379_n11180# vss sky130_fd_pr__nfet_01v8 ad=0.825 pd=5.33 as=1.55 ps=10.62 w=5 l=0.15
X480 a_51034_n9809# a_23713_n11140# quiet vss sky130_fd_pr__nfet_05v0_nvt ad=1.45 pd=10.29 as=1.45 ps=10.29 w=10 l=0.9
X481 vss w_42120_n8480# sky130_fd_pr__cap_mim_m3_2 l=29.42 w=29.42
X482 a_51034_n9809# a_1464_8048# vin vss sky130_fd_pr__nfet_05v0_nvt ad=1.45 pd=10.29 as=1.45 ps=10.29 w=10 l=0.9
X483 vss a_25242_n7480# a_29900_878# vss sky130_fd_pr__nfet_01v8 ad=0.66 pd=4.33 as=1.24 ps=8.62 w=4 l=0.15
X484 a_51034_n9809# a_23713_n11140# quiet vss sky130_fd_pr__nfet_05v0_nvt ad=1.45 pd=10.29 as=1.45 ps=10.29 w=10 l=0.9
X485 vin a_22436_8048# sky130_fd_pr__cap_mim_m3_2 l=22.2 w=22.2
X486 w_42120_n8480# a_19104_8048# a_19104_8048# w_42120_n8480# sky130_fd_pr__pfet_g5v0d10v5 ad=0.725 pd=5.29 as=0.725 ps=5.29 w=5 l=2
X487 a_42523_n6500# w_42120_n8480# w_42120_n8480# w_42120_n8480# sky130_fd_pr__pfet_g5v0d10v5 ad=0.725 pd=5.29 as=1.45 ps=10.58 w=5 l=1
X488 vss quiet sky130_fd_pr__cap_mim_m3_2 l=29.42 w=29.42
X489 vin a_1464_8048# a_51034_n9809# vss sky130_fd_pr__nfet_05v0_nvt ad=1.45 pd=10.29 as=1.45 ps=10.29 w=10 l=0.9
X490 w_42120_n8480# a_19104_8048# a_19104_8048# w_42120_n8480# sky130_fd_pr__pfet_g5v0d10v5 ad=0.725 pd=5.29 as=1.45 ps=10.58 w=5 l=2
X491 a_2052_8048# a_2248_n7480# vss sky130_fd_pr__res_high_po w=0.5 l=75.64
X492 a_19104_8048# a_19104_8048# w_42120_n8480# w_42120_n8480# sky130_fd_pr__pfet_g5v0d10v5 ad=0.725 pd=5.29 as=0.725 ps=5.29 w=5 l=2
X493 a_33636_n1173# a_34228_n3859# vss sky130_fd_pr__res_high_po w=1 l=11.43
X494 a_42523_n6500# a_7527_n10700# a_24907_n11228# w_42120_n8480# sky130_fd_pr__pfet_g5v0d10v5 ad=0.725 pd=5.29 as=0.725 ps=5.29 w=5 l=1
X495 w_42120_n8480# a_19104_8048# a_19104_8048# w_42120_n8480# sky130_fd_pr__pfet_g5v0d10v5 ad=1.45 pd=10.58 as=0.725 ps=5.29 w=5 l=2
X496 a_32156_n1173# a_31564_n3859# vss sky130_fd_pr__res_high_po w=1 l=11.43
X497 a_42523_n6500# a_7527_n10700# a_24907_n11228# w_42120_n8480# sky130_fd_pr__pfet_g5v0d10v5 ad=0.725 pd=5.29 as=0.725 ps=5.29 w=5 l=1
X498 a_51034_n9809# a_1464_8048# vin vss sky130_fd_pr__nfet_05v0_nvt ad=1.45 pd=10.29 as=1.45 ps=10.29 w=10 l=0.9
X499 a_29900_878# a_25242_n7480# vss vss sky130_fd_pr__nfet_01v8 ad=0.66 pd=4.33 as=0.66 ps=4.33 w=4 l=0.15
X500 a_35708_n1173# a_35116_n3859# vss sky130_fd_pr__res_high_po w=1 l=11.43
X501 a_51034_n9809# a_1464_8048# vin vss sky130_fd_pr__nfet_05v0_nvt ad=1.45 pd=10.29 as=1.45 ps=10.29 w=10 l=0.9
X502 a_42634_n375# i_ldo vss vss sky130_fd_pr__nfet_g5v0d10v5 ad=0.725 pd=5.29 as=0.725 ps=5.29 w=5 l=2
X503 a_30084_n1173# a_29492_n3859# vss sky130_fd_pr__res_high_po w=1 l=11.43
X504 a_24907_n11228# a_7527_n10700# a_42523_n6500# w_42120_n8480# sky130_fd_pr__pfet_g5v0d10v5 ad=0.725 pd=5.29 as=0.725 ps=5.29 w=5 l=1
X505 a_2444_8048# a_2248_n7480# vss sky130_fd_pr__res_high_po w=0.5 l=75.64
X506 a_51034_n9809# a_1464_8048# vin vss sky130_fd_pr__nfet_05v0_nvt ad=1.45 pd=10.29 as=1.45 ps=10.29 w=10 l=0.9
X507 w_42120_n8480# a_22436_8048# vin vin sky130_fd_pr__pfet_g5v0d10v5 ad=0.725 pd=5.29 as=0.725 ps=5.29 w=5 l=2
X508 a_33636_n1173# a_33044_n3859# vss sky130_fd_pr__res_high_po w=1 l=11.43
X509 vin a_1464_8048# a_51034_n9809# vss sky130_fd_pr__nfet_05v0_nvt ad=1.45 pd=10.29 as=1.45 ps=10.29 w=10 l=0.9
X510 a_30972_n1173# a_31564_n3859# vss sky130_fd_pr__res_high_po w=1 l=11.43
X511 w_42120_n8480# a_19104_8048# a_19104_8048# w_42120_n8480# sky130_fd_pr__pfet_g5v0d10v5 ad=0.725 pd=5.29 as=0.725 ps=5.29 w=5 l=2
X512 a_25242_n7480# quiet sky130_fd_pr__cap_mim_m3_1 l=22.2 w=22.2
X513 vss vss vss sky130_fd_pr__res_high_po w=1 l=11.43
X514 vin a_1464_8048# a_51034_n9809# vss sky130_fd_pr__nfet_05v0_nvt ad=1.45 pd=10.29 as=1.45 ps=10.29 w=10 l=0.9
X515 a_2444_8048# a_2640_n7480# vss sky130_fd_pr__res_high_po w=0.5 l=75.64
X516 a_32800_3942# a_29900_878# quiet quiet sky130_fd_pr__pfet_01v8 ad=0.99 pd=6.33 as=0.99 ps=6.33 w=6 l=0.15
X517 vss i_ldo i_ldo vss sky130_fd_pr__nfet_g5v0d10v5 ad=0.725 pd=5.29 as=1.45 ps=10.58 w=5 l=2
X518 vin a_1464_8048# a_51034_n9809# vss sky130_fd_pr__nfet_05v0_nvt ad=1.45 pd=10.29 as=1.45 ps=10.29 w=10 l=0.9
X519 a_23713_n11140# a_42634_n375# w_42120_n8480# w_42120_n8480# sky130_fd_pr__pfet_g5v0d10v5 ad=0.725 pd=5.29 as=0.725 ps=5.29 w=5 l=2
X520 a_51034_n9809# a_23713_n11140# quiet vss sky130_fd_pr__nfet_05v0_nvt ad=1.45 pd=10.29 as=1.45 ps=10.29 w=10 l=0.9
X521 a_30972_n1173# a_30676_n3859# vss sky130_fd_pr__res_high_po w=1 l=11.43
X522 a_7668_8048# a_7472_n7480# vss sky130_fd_pr__res_high_po w=0.5 l=75.64
X523 vin a_14596_n7480# vss sky130_fd_pr__res_high_po w=0.5 l=75.64
X524 vss a_24907_n11228# a_23713_n11140# vss sky130_fd_pr__nfet_g5v0d10v5 ad=0.725 pd=5.29 as=0.725 ps=5.29 w=5 l=0.5
X525 a_51034_n9809# a_1464_8048# vin vss sky130_fd_pr__nfet_05v0_nvt ad=1.45 pd=10.29 as=1.45 ps=10.29 w=10 l=0.9
X526 quiet a_32800_3942# vss vss sky130_fd_pr__nfet_01v8 ad=0.66 pd=4.33 as=0.66 ps=4.33 w=4 l=0.15
X527 a_33192_n6273# t5 a_29196_n3859# vss sky130_fd_pr__nfet_01v8 ad=0.825 pd=5.33 as=1.55 ps=10.62 w=5 l=0.15
X528 vin a_22436_8048# w_42120_n8480# vin sky130_fd_pr__pfet_g5v0d10v5 ad=0.725 pd=5.29 as=0.725 ps=5.29 w=5 l=2
X529 vin a_22436_8048# w_42120_n8480# vin sky130_fd_pr__pfet_g5v0d10v5 ad=0.725 pd=5.29 as=0.725 ps=5.29 w=5 l=2
X530 a_51034_n9809# a_1464_8048# vin vss sky130_fd_pr__nfet_05v0_nvt ad=2.9 pd=20.58 as=1.45 ps=10.29 w=10 l=0.9
X531 vin a_1464_8048# a_51034_n9809# vss sky130_fd_pr__nfet_05v0_nvt ad=1.45 pd=10.29 as=1.45 ps=10.29 w=10 l=0.9
X532 a_14792_8048# a_14596_n7480# vss sky130_fd_pr__res_high_po w=0.5 l=75.64
X533 a_51034_n9809# a_1464_8048# vin vss sky130_fd_pr__nfet_05v0_nvt ad=2.9 pd=20.58 as=1.45 ps=10.29 w=10 l=0.9
X534 a_51034_n9809# a_1464_8048# vin vss sky130_fd_pr__nfet_05v0_nvt ad=1.45 pd=10.29 as=1.45 ps=10.29 w=10 l=0.9
X535 a_7668_8048# a_7864_n7480# vss sky130_fd_pr__res_high_po w=0.5 l=75.64
X536 quiet a_29900_878# a_32800_3942# quiet sky130_fd_pr__pfet_01v8 ad=0.99 pd=6.33 as=0.99 ps=6.33 w=6 l=0.15
X537 a_42523_n6500# w_42120_n8480# w_42120_n8480# w_42120_n8480# sky130_fd_pr__pfet_g5v0d10v5 ad=0.725 pd=5.29 as=1.45 ps=10.58 w=5 l=1
X538 a_33192_n6273# t4 a_32008_n6273# vss sky130_fd_pr__nfet_01v8 ad=1.55 pd=10.62 as=0.825 ps=5.33 w=5 l=0.15
X539 quiet a_23713_n11140# a_51034_n9809# vss sky130_fd_pr__nfet_05v0_nvt ad=1.45 pd=10.29 as=1.45 ps=10.29 w=10 l=0.9
X540 vss a_32800_3942# quiet vss sky130_fd_pr__nfet_01v8 ad=0.66 pd=4.33 as=0.66 ps=4.33 w=4 l=0.15
X541 a_51034_n9809# a_1464_8048# vin vss sky130_fd_pr__nfet_05v0_nvt ad=1.45 pd=10.29 as=1.45 ps=10.29 w=10 l=0.9
X542 a_51034_n9809# a_1464_8048# vin vss sky130_fd_pr__nfet_05v0_nvt ad=1.45 pd=10.29 as=1.45 ps=10.29 w=10 l=0.9
X543 a_19104_8048# a_19104_8048# w_42120_n8480# w_42120_n8480# sky130_fd_pr__pfet_g5v0d10v5 ad=0.725 pd=5.29 as=0.725 ps=5.29 w=5 l=2
X544 quiet a_23713_n11140# a_51034_n9809# vss sky130_fd_pr__nfet_05v0_nvt ad=1.45 pd=10.29 as=1.45 ps=10.29 w=10 l=0.9
X545 vin a_1464_8048# a_51034_n9809# vss sky130_fd_pr__nfet_05v0_nvt ad=1.45 pd=10.29 as=1.45 ps=10.29 w=10 l=0.9
X546 a_23713_n11140# a_40600_n6374# sky130_fd_pr__cap_mim_m3_2 l=15.6 w=15.6
X547 vin a_1464_8048# a_51034_n9809# vss sky130_fd_pr__nfet_05v0_nvt ad=1.45 pd=10.29 as=1.45 ps=10.29 w=10 l=0.9
X548 a_29179_n11180# a_30379_n11180# vss sky130_fd_pr__res_high_po w=1 l=11.43
X549 quiet a_32800_3942# vss vss sky130_fd_pr__nfet_01v8 ad=0.66 pd=4.33 as=0.66 ps=4.33 w=4 l=0.15
X550 a_42523_n6500# a_36004_n3859# a_42633_n11868# w_42120_n8480# sky130_fd_pr__pfet_g5v0d10v5 ad=0.725 pd=5.29 as=0.725 ps=5.29 w=5 l=1
X551 quiet a_23713_n11140# a_51034_n9809# vss sky130_fd_pr__nfet_05v0_nvt ad=2.9 pd=20.58 as=1.45 ps=10.29 w=10 l=0.9
X552 vin a_1464_8048# a_51034_n9809# vss sky130_fd_pr__nfet_05v0_nvt ad=1.45 pd=10.29 as=1.45 ps=10.29 w=10 l=0.9
X553 a_19104_8048# a_18908_n7480# vss sky130_fd_pr__res_high_po w=0.5 l=75.64
X554 quiet a_32800_3942# vss vss sky130_fd_pr__nfet_01v8 ad=1.24 pd=8.62 as=0.66 ps=4.33 w=4 l=0.15
X555 a_32600_n6273# a_32304_n8959# vss sky130_fd_pr__res_high_po w=1 l=11.43
X556 a_10020_8048# a_9824_n7480# vss sky130_fd_pr__res_high_po w=0.5 l=75.64
X557 a_32800_3942# a_29900_878# quiet quiet sky130_fd_pr__pfet_01v8 ad=1.86 pd=12.62 as=0.99 ps=6.33 w=6 l=0.15
X558 a_19104_8048# a_19104_8048# w_42120_n8480# w_42120_n8480# sky130_fd_pr__pfet_g5v0d10v5 ad=0.725 pd=5.29 as=0.725 ps=5.29 w=5 l=2
X559 host enable a_2667_n10997# host sky130_fd_pr__pfet_01v8 ad=0.58 pd=4.58 as=0.58 ps=4.58 w=2 l=0.15
X560 quiet a_23713_n11140# a_51034_n9809# vss sky130_fd_pr__nfet_05v0_nvt ad=1.45 pd=10.29 as=1.45 ps=10.29 w=10 l=0.9
X561 w_42120_n8480# a_22436_8048# vin vin sky130_fd_pr__pfet_g5v0d10v5 ad=0.725 pd=5.29 as=0.725 ps=5.29 w=5 l=2
X562 a_51034_n9809# a_1464_8048# vin vss sky130_fd_pr__nfet_05v0_nvt ad=1.45 pd=10.29 as=1.45 ps=10.29 w=10 l=0.9
X563 a_51034_n9809# a_1464_8048# vin vss sky130_fd_pr__nfet_05v0_nvt ad=1.45 pd=10.29 as=1.45 ps=10.29 w=10 l=0.9
X564 quiet a_23713_n11140# a_51034_n9809# vss sky130_fd_pr__nfet_05v0_nvt ad=1.45 pd=10.29 as=1.45 ps=10.29 w=10 l=0.9
X565 a_51034_n9809# a_1464_8048# vin vss sky130_fd_pr__nfet_05v0_nvt ad=1.45 pd=10.29 as=1.45 ps=10.29 w=10 l=0.9
X566 a_51034_n9809# a_1464_8048# vin vss sky130_fd_pr__nfet_05v0_nvt ad=1.45 pd=10.29 as=1.45 ps=10.29 w=10 l=0.9
X567 a_51034_n9809# a_1464_8048# vin vss sky130_fd_pr__nfet_05v0_nvt ad=1.45 pd=10.29 as=1.45 ps=10.29 w=10 l=0.9
X568 a_51034_n9809# a_1464_8048# vin vss sky130_fd_pr__nfet_05v0_nvt ad=1.45 pd=10.29 as=1.45 ps=10.29 w=10 l=0.9
X569 a_19104_8048# a_21064_n7480# vss sky130_fd_pr__res_high_po w=0.5 l=75.64
X570 quiet a_23713_n11140# a_51034_n9809# vss sky130_fd_pr__nfet_05v0_nvt ad=1.45 pd=10.29 as=1.45 ps=10.29 w=10 l=0.9
X571 vss a_25242_n7480# a_29900_878# vss sky130_fd_pr__nfet_01v8 ad=0.66 pd=4.33 as=0.66 ps=4.33 w=4 l=0.15
X572 w_42120_n8480# vss sky130_fd_pr__cap_mim_m3_1 l=29.42 w=29.42
X573 a_19104_8048# a_19104_8048# w_42120_n8480# w_42120_n8480# sky130_fd_pr__pfet_g5v0d10v5 ad=0.725 pd=5.29 as=0.725 ps=5.29 w=5 l=2
X574 w_42120_n8480# a_19104_8048# a_19104_8048# w_42120_n8480# sky130_fd_pr__pfet_g5v0d10v5 ad=0.725 pd=5.29 as=0.725 ps=5.29 w=5 l=2
X575 vss a_1464_8048# sky130_fd_pr__cap_mim_m3_2 l=29.42 w=29.42
X576 vin a_1464_8048# a_51034_n9809# vss sky130_fd_pr__nfet_05v0_nvt ad=1.45 pd=10.29 as=1.45 ps=10.29 w=10 l=0.9
X577 a_30380_n1173# a_31268_n3859# vss sky130_fd_pr__res_high_po w=1 l=11.43
X578 vss a_42633_n11868# a_24907_n11228# vss sky130_fd_pr__nfet_g5v0d10v5 ad=0.725 pd=5.29 as=0.725 ps=5.29 w=5 l=2
X579 a_22436_8048# vin sky130_fd_pr__cap_mim_m3_1 l=22.2 w=22.2
X580 a_24907_n11228# a_7527_n10700# a_42523_n6500# w_42120_n8480# sky130_fd_pr__pfet_g5v0d10v5 ad=0.725 pd=5.29 as=0.725 ps=5.29 w=5 l=1
X581 vss a_24907_n11228# a_23713_n11140# vss sky130_fd_pr__nfet_g5v0d10v5 ad=0.725 pd=5.29 as=1.45 ps=10.58 w=5 l=0.5
X582 quiet vss sky130_fd_pr__cap_mim_m3_1 l=29.42 w=29.42
X583 a_21260_8048# a_21064_n7480# vss sky130_fd_pr__res_high_po w=0.5 l=75.64
X584 a_32748_n1173# a_32452_n3859# vss sky130_fd_pr__res_high_po w=1 l=11.43
X585 quiet a_23713_n11140# a_51034_n9809# vss sky130_fd_pr__nfet_05v0_nvt ad=2.9 pd=20.58 as=1.45 ps=10.29 w=10 l=0.9
X586 vin a_1464_8048# a_51034_n9809# vss sky130_fd_pr__nfet_05v0_nvt ad=1.45 pd=10.29 as=1.45 ps=10.29 w=10 l=0.9
X587 a_19104_8048# a_19104_8048# w_42120_n8480# w_42120_n8480# sky130_fd_pr__pfet_g5v0d10v5 ad=0.725 pd=5.29 as=0.725 ps=5.29 w=5 l=2
X588 w_42120_n8480# a_22436_8048# vin vin sky130_fd_pr__pfet_g5v0d10v5 ad=0.725 pd=5.29 as=0.725 ps=5.29 w=5 l=2
X589 vin a_1464_8048# a_51034_n9809# vss sky130_fd_pr__nfet_05v0_nvt ad=1.45 pd=10.29 as=1.45 ps=10.29 w=10 l=0.9
X590 w_42120_n8480# a_19104_8048# a_19104_8048# w_42120_n8480# sky130_fd_pr__pfet_g5v0d10v5 ad=0.725 pd=5.29 as=0.725 ps=5.29 w=5 l=2
X591 a_30084_n1173# a_30676_n3859# vss sky130_fd_pr__res_high_po w=1 l=11.43
X592 a_51034_n9809# a_23713_n11140# quiet vss sky130_fd_pr__nfet_05v0_nvt ad=1.45 pd=10.29 as=1.45 ps=10.29 w=10 l=0.9
X593 vss a_32800_3942# quiet vss sky130_fd_pr__nfet_01v8 ad=0.66 pd=4.33 as=0.66 ps=4.33 w=4 l=0.15
X594 a_51034_n9809# a_1464_8048# vin vss sky130_fd_pr__nfet_05v0_nvt ad=1.45 pd=10.29 as=1.45 ps=10.29 w=10 l=0.9
X595 w_42120_n8480# a_42634_n375# a_23713_n11140# w_42120_n8480# sky130_fd_pr__pfet_g5v0d10v5 ad=0.725 pd=5.29 as=0.725 ps=5.29 w=5 l=2
X596 a_51034_n9809# a_23713_n11140# quiet vss sky130_fd_pr__nfet_05v0_nvt ad=1.45 pd=10.29 as=1.45 ps=10.29 w=10 l=0.9
X597 vin a_1464_8048# a_51034_n9809# vss sky130_fd_pr__nfet_05v0_nvt ad=1.45 pd=10.29 as=1.45 ps=10.29 w=10 l=0.9
X598 a_51034_n9809# a_1464_8048# vin vss sky130_fd_pr__nfet_05v0_nvt ad=1.45 pd=10.29 as=1.45 ps=10.29 w=10 l=0.9
X599 a_51034_n9809# a_23713_n11140# quiet vss sky130_fd_pr__nfet_05v0_nvt ad=1.45 pd=10.29 as=1.45 ps=10.29 w=10 l=0.9
X600 vin a_1464_8048# a_51034_n9809# vss sky130_fd_pr__nfet_05v0_nvt ad=1.45 pd=10.29 as=1.45 ps=10.29 w=10 l=0.9
X601 a_51034_n9809# a_23713_n11140# quiet vss sky130_fd_pr__nfet_05v0_nvt ad=1.45 pd=10.29 as=1.45 ps=10.29 w=10 l=0.9
X602 w_42120_n8480# a_19104_8048# a_19104_8048# w_42120_n8480# sky130_fd_pr__pfet_g5v0d10v5 ad=0.725 pd=5.29 as=0.725 ps=5.29 w=5 l=2
X603 a_32800_3942# a_29900_878# quiet quiet sky130_fd_pr__pfet_01v8 ad=0.99 pd=6.33 as=0.99 ps=6.33 w=6 l=0.15
X604 quiet a_32800_3942# vss vss sky130_fd_pr__nfet_01v8 ad=0.66 pd=4.33 as=0.66 ps=4.33 w=4 l=0.15
X605 a_51034_n9809# a_23713_n11140# quiet vss sky130_fd_pr__nfet_05v0_nvt ad=1.45 pd=10.29 as=1.45 ps=10.29 w=10 l=0.9
X606 i_ldo a_2667_n10997# vss vss sky130_fd_pr__nfet_g5v0d10v5 ad=1.45 pd=10.58 as=0.725 ps=5.29 w=5 l=0.5
X607 a_30379_n11180# t2 a_31416_n6273# vss sky130_fd_pr__nfet_01v8 ad=0.825 pd=5.33 as=1.55 ps=10.62 w=5 l=0.15
X608 a_51034_n9809# a_23713_n11140# quiet vss sky130_fd_pr__nfet_05v0_nvt ad=1.45 pd=10.29 as=1.45 ps=10.29 w=10 l=0.9
X609 a_51034_n9809# a_23713_n11140# quiet vss sky130_fd_pr__nfet_05v0_nvt ad=1.45 pd=10.29 as=1.45 ps=10.29 w=10 l=0.9
X610 vin a_1464_8048# a_51034_n9809# vss sky130_fd_pr__nfet_05v0_nvt ad=1.45 pd=10.29 as=1.45 ps=10.29 w=10 l=0.9
X611 w_42120_n8480# a_42634_n375# a_23713_n11140# w_42120_n8480# sky130_fd_pr__pfet_g5v0d10v5 ad=1.45 pd=10.58 as=0.725 ps=5.29 w=5 l=2
X612 a_17144_8048# a_16948_n7480# vss sky130_fd_pr__res_high_po w=0.5 l=75.64
X613 a_19104_8048# a_19104_8048# w_42120_n8480# w_42120_n8480# sky130_fd_pr__pfet_g5v0d10v5 ad=0.725 pd=5.29 as=0.725 ps=5.29 w=5 l=2
X614 a_51034_n9809# a_23713_n11140# quiet vss sky130_fd_pr__nfet_05v0_nvt ad=1.45 pd=10.29 as=1.45 ps=10.29 w=10 l=0.9
X615 a_51034_n9809# a_23713_n11140# quiet vss sky130_fd_pr__nfet_05v0_nvt ad=1.45 pd=10.29 as=1.45 ps=10.29 w=10 l=0.9
X616 a_32008_n6273# a_32304_n8959# vss sky130_fd_pr__res_high_po w=1 l=11.43
X617 a_30379_n11180# t1 a_29179_n11180# vss sky130_fd_pr__nfet_01v8 ad=1.55 pd=10.62 as=0.825 ps=5.33 w=5 l=0.15
X618 a_42523_n6500# a_7527_n10700# a_24907_n11228# w_42120_n8480# sky130_fd_pr__pfet_g5v0d10v5 ad=0.725 pd=5.29 as=0.725 ps=5.29 w=5 l=1
X619 vin a_1464_8048# a_51034_n9809# vss sky130_fd_pr__nfet_05v0_nvt ad=1.45 pd=10.29 as=1.45 ps=10.29 w=10 l=0.9
X620 a_51034_n9809# a_23713_n11140# quiet vss sky130_fd_pr__nfet_05v0_nvt ad=1.45 pd=10.29 as=1.45 ps=10.29 w=10 l=0.9
X621 a_29179_n11180# vss vss sky130_fd_pr__res_high_po w=1 l=11.43
X622 vin a_1464_8048# a_51034_n9809# vss sky130_fd_pr__nfet_05v0_nvt ad=1.45 pd=10.29 as=1.45 ps=10.29 w=10 l=0.9
X623 a_51034_n9809# a_1464_8048# vin vss sky130_fd_pr__nfet_05v0_nvt ad=2.9 pd=20.58 as=1.45 ps=10.29 w=10 l=0.9
X624 vss a_32800_3942# quiet vss sky130_fd_pr__nfet_01v8 ad=0.66 pd=4.33 as=0.66 ps=4.33 w=4 l=0.15
X625 vin a_22436_8048# w_42120_n8480# vin sky130_fd_pr__pfet_g5v0d10v5 ad=0.725 pd=5.29 as=0.725 ps=5.29 w=5 l=2
X626 a_51034_n9809# a_1464_8048# vin vss sky130_fd_pr__nfet_05v0_nvt ad=1.45 pd=10.29 as=2.9 ps=20.58 w=10 l=0.9
X627 a_17144_8048# a_17340_n7480# vss sky130_fd_pr__res_high_po w=0.5 l=75.64
X628 w_42120_n8480# a_42634_n375# a_42523_n6500# w_42120_n8480# sky130_fd_pr__pfet_g5v0d10v5 ad=0.725 pd=5.29 as=0.725 ps=5.29 w=5 l=2
X629 quiet a_23713_n11140# a_51034_n9809# vss sky130_fd_pr__nfet_05v0_nvt ad=1.45 pd=10.29 as=1.45 ps=10.29 w=10 l=0.9
X630 a_19104_8048# a_19104_8048# w_42120_n8480# w_42120_n8480# sky130_fd_pr__pfet_g5v0d10v5 ad=0.725 pd=5.29 as=0.725 ps=5.29 w=5 l=2
X631 a_42633_n11868# a_36004_n3859# a_42523_n6500# w_42120_n8480# sky130_fd_pr__pfet_g5v0d10v5 ad=0.725 pd=5.29 as=0.725 ps=5.29 w=5 l=1
X632 a_31416_n6273# a_31712_n8959# vss sky130_fd_pr__res_high_po w=1 l=11.43
X633 a_42523_n6500# a_42634_n375# w_42120_n8480# w_42120_n8480# sky130_fd_pr__pfet_g5v0d10v5 ad=0.725 pd=5.29 as=0.725 ps=5.29 w=5 l=2
X634 a_23713_n11140# a_24907_n11228# vss vss sky130_fd_pr__nfet_g5v0d10v5 ad=0.725 pd=5.29 as=0.725 ps=5.29 w=5 l=0.5
X635 a_18712_8048# a_18908_n7480# vss sky130_fd_pr__res_high_po w=0.5 l=75.64
X636 a_40600_n6374# a_23713_n11140# sky130_fd_pr__cap_mim_m3_1 l=15.6 w=15.6
X637 quiet a_29900_878# vss sky130_fd_pr__res_high_po w=1 l=36.66
X638 quiet a_32800_3942# vss vss sky130_fd_pr__nfet_01v8 ad=0.66 pd=4.33 as=0.66 ps=4.33 w=4 l=0.15
X639 a_19104_8048# a_19104_8048# w_42120_n8480# w_42120_n8480# sky130_fd_pr__pfet_g5v0d10v5 ad=0.725 pd=5.29 as=0.725 ps=5.29 w=5 l=2
X640 a_51034_n9809# a_23713_n11140# quiet vss sky130_fd_pr__nfet_05v0_nvt ad=1.45 pd=10.29 as=1.45 ps=10.29 w=10 l=0.9
X641 a_24458_8048# a_2667_n10997# quiet quiet sky130_fd_pr__pfet_01v8 ad=0.62 pd=4.62 as=0.33 ps=2.33 w=2 l=0.15
X642 vss a_1464_8048# sky130_fd_pr__cap_mim_m3_2 l=29.42 w=29.42
X643 vin a_1464_8048# a_51034_n9809# vss sky130_fd_pr__nfet_05v0_nvt ad=1.45 pd=10.29 as=1.45 ps=10.29 w=10 l=0.9
X644 a_51034_n9809# a_23713_n11140# quiet vss sky130_fd_pr__nfet_05v0_nvt ad=1.45 pd=10.29 as=1.45 ps=10.29 w=10 l=0.9
X645 a_1015_n10700# a_5512_n7480# vss sky130_fd_pr__res_high_po w=0.5 l=75.64
X646 vin a_1464_8048# a_51034_n9809# vss sky130_fd_pr__nfet_05v0_nvt ad=1.45 pd=10.29 as=1.45 ps=10.29 w=10 l=0.9
X647 vss a_32800_3942# quiet vss sky130_fd_pr__nfet_01v8 ad=0.66 pd=4.33 as=0.66 ps=4.33 w=4 l=0.15
X648 vin a_1464_8048# a_51034_n9809# vss sky130_fd_pr__nfet_05v0_nvt ad=1.45 pd=10.29 as=1.45 ps=10.29 w=10 l=0.9
X649 a_51034_n9809# a_1464_8048# vin vss sky130_fd_pr__nfet_05v0_nvt ad=1.45 pd=10.29 as=1.45 ps=10.29 w=10 l=0.9
X650 w_42120_n8480# a_19104_8048# a_19104_8048# w_42120_n8480# sky130_fd_pr__pfet_g5v0d10v5 ad=0.725 pd=5.29 as=0.725 ps=5.29 w=5 l=2
X651 a_51034_n9809# a_1464_8048# vin vss sky130_fd_pr__nfet_05v0_nvt ad=2.9 pd=20.58 as=1.45 ps=10.29 w=10 l=0.9
X652 vin a_1464_8048# a_51034_n9809# vss sky130_fd_pr__nfet_05v0_nvt ad=1.45 pd=10.29 as=1.45 ps=10.29 w=10 l=0.9
X653 a_51034_n9809# a_1464_8048# vin vss sky130_fd_pr__nfet_05v0_nvt ad=1.45 pd=10.29 as=1.45 ps=10.29 w=10 l=0.9
X654 quiet a_23713_n11140# a_51034_n9809# vss sky130_fd_pr__nfet_05v0_nvt ad=1.45 pd=10.29 as=1.45 ps=10.29 w=10 l=0.9
X655 vin a_1464_8048# a_51034_n9809# vss sky130_fd_pr__nfet_05v0_nvt ad=1.45 pd=10.29 as=1.45 ps=10.29 w=10 l=0.9
X656 a_51034_n9809# a_1464_8048# vin vss sky130_fd_pr__nfet_05v0_nvt ad=1.45 pd=10.29 as=2.9 ps=20.58 w=10 l=0.9
X657 a_42523_n6500# a_42634_n375# w_42120_n8480# w_42120_n8480# sky130_fd_pr__pfet_g5v0d10v5 ad=1.45 pd=10.58 as=0.725 ps=5.29 w=5 l=2
X658 i_ldo i_ldo vss vss sky130_fd_pr__nfet_g5v0d10v5 ad=0.725 pd=5.29 as=0.725 ps=5.29 w=5 l=2
X659 a_51034_n9809# a_1464_8048# vin vss sky130_fd_pr__nfet_05v0_nvt ad=1.45 pd=10.29 as=1.45 ps=10.29 w=10 l=0.9
X660 vss i_ldo a_19104_8048# vss sky130_fd_pr__nfet_g5v0d10v5 ad=0.87 pd=6.58 as=0.435 ps=3.29 w=3 l=2
X661 w_42120_n8480# a_19104_8048# a_19104_8048# w_42120_n8480# sky130_fd_pr__pfet_g5v0d10v5 ad=0.725 pd=5.29 as=1.45 ps=10.58 w=5 l=2
X662 a_19104_8048# a_19104_8048# w_42120_n8480# w_42120_n8480# sky130_fd_pr__pfet_g5v0d10v5 ad=0.725 pd=5.29 as=0.725 ps=5.29 w=5 l=2
X663 a_51034_n9809# a_1464_8048# vin vss sky130_fd_pr__nfet_05v0_nvt ad=1.45 pd=10.29 as=1.45 ps=10.29 w=10 l=0.9
X664 a_51034_n9809# a_23713_n11140# quiet vss sky130_fd_pr__nfet_05v0_nvt ad=1.45 pd=10.29 as=1.45 ps=10.29 w=10 l=0.9
X665 a_51034_n9809# a_1464_8048# vin vss sky130_fd_pr__nfet_05v0_nvt ad=1.45 pd=10.29 as=1.45 ps=10.29 w=10 l=0.9
X666 quiet a_23713_n11140# a_51034_n9809# vss sky130_fd_pr__nfet_05v0_nvt ad=1.45 pd=10.29 as=1.45 ps=10.29 w=10 l=0.9
X667 a_1464_8048# vss sky130_fd_pr__cap_mim_m3_1 l=29.42 w=29.42
X668 w_42120_n8480# a_19104_8048# a_19104_8048# w_42120_n8480# sky130_fd_pr__pfet_g5v0d10v5 ad=1.45 pd=10.58 as=0.725 ps=5.29 w=5 l=2
X669 a_29196_n3859# t5 a_33192_n6273# vss sky130_fd_pr__nfet_01v8 ad=1.55 pd=10.62 as=0.825 ps=5.33 w=5 l=0.15
X670 w_42120_n8480# a_22436_8048# vin vin sky130_fd_pr__pfet_g5v0d10v5 ad=0.725 pd=5.29 as=0.725 ps=5.29 w=5 l=2
X671 a_42523_n6500# a_36004_n3859# a_42633_n11868# w_42120_n8480# sky130_fd_pr__pfet_g5v0d10v5 ad=0.725 pd=5.29 as=0.725 ps=5.29 w=5 l=1
X672 vin a_1464_8048# a_51034_n9809# vss sky130_fd_pr__nfet_05v0_nvt ad=1.45 pd=10.29 as=1.45 ps=10.29 w=10 l=0.9
X673 vin a_1464_8048# a_51034_n9809# vss sky130_fd_pr__nfet_05v0_nvt ad=1.45 pd=10.29 as=1.45 ps=10.29 w=10 l=0.9
X674 a_15184_8048# a_14988_n7480# vss sky130_fd_pr__res_high_po w=0.5 l=75.64
X675 vss a_32800_3942# quiet vss sky130_fd_pr__nfet_01v8 ad=0.66 pd=4.33 as=0.66 ps=4.33 w=4 l=0.15
X676 a_8060_8048# a_8256_n7480# vss sky130_fd_pr__res_high_po w=0.5 l=75.64
X677 w_42120_n8480# a_42634_n375# a_23713_n11140# w_42120_n8480# sky130_fd_pr__pfet_g5v0d10v5 ad=0.725 pd=5.29 as=0.725 ps=5.29 w=5 l=2
X678 a_51034_n9809# a_1464_8048# vin vss sky130_fd_pr__nfet_05v0_nvt ad=1.45 pd=10.29 as=1.45 ps=10.29 w=10 l=0.9
X679 vin a_1464_8048# a_51034_n9809# vss sky130_fd_pr__nfet_05v0_nvt ad=1.45 pd=10.29 as=1.45 ps=10.29 w=10 l=0.9
X680 a_23713_n11140# a_42634_n375# w_42120_n8480# w_42120_n8480# sky130_fd_pr__pfet_g5v0d10v5 ad=0.725 pd=5.29 as=0.725 ps=5.29 w=5 l=2
X681 vss t0 a_29179_n11180# vss sky130_fd_pr__nfet_01v8 ad=0.825 pd=5.33 as=1.55 ps=10.62 w=5 l=0.15
X682 a_51034_n9809# a_1464_8048# vin vss sky130_fd_pr__nfet_05v0_nvt ad=1.45 pd=10.29 as=1.45 ps=10.29 w=10 l=0.9
X683 a_32008_n6273# a_31712_n8959# vss sky130_fd_pr__res_high_po w=1 l=11.43
X684 vin a_1464_8048# a_51034_n9809# vss sky130_fd_pr__nfet_05v0_nvt ad=1.45 pd=10.29 as=1.45 ps=10.29 w=10 l=0.9
X685 vss a_25242_n7480# a_29900_878# vss sky130_fd_pr__nfet_01v8 ad=0.66 pd=4.33 as=0.66 ps=4.33 w=4 l=0.15
X686 a_23713_n11140# a_2667_n10997# vss vss sky130_fd_pr__nfet_g5v0d10v5 ad=1.45 pd=10.58 as=0.725 ps=5.29 w=5 l=0.5
X687 vin a_1464_8048# a_51034_n9809# vss sky130_fd_pr__nfet_05v0_nvt ad=1.45 pd=10.29 as=1.45 ps=10.29 w=10 l=0.9
X688 a_23713_n11140# a_24907_n11228# vss vss sky130_fd_pr__nfet_g5v0d10v5 ad=0.725 pd=5.29 as=0.725 ps=5.29 w=5 l=0.5
X689 a_51034_n9809# a_1464_8048# vin vss sky130_fd_pr__nfet_05v0_nvt ad=1.45 pd=10.29 as=1.45 ps=10.29 w=10 l=0.9
X690 a_51034_n9809# a_1464_8048# vin vss sky130_fd_pr__nfet_05v0_nvt ad=1.45 pd=10.29 as=1.45 ps=10.29 w=10 l=0.9
X691 a_51034_n9809# a_1464_8048# vin vss sky130_fd_pr__nfet_05v0_nvt ad=1.45 pd=10.29 as=1.45 ps=10.29 w=10 l=0.9
X692 a_8452_8048# a_8256_n7480# vss sky130_fd_pr__res_high_po w=0.5 l=75.64
X693 a_15184_8048# a_15380_n7480# vss sky130_fd_pr__res_high_po w=0.5 l=75.64
X694 w_42120_n8480# a_19104_8048# a_19104_8048# w_42120_n8480# sky130_fd_pr__pfet_g5v0d10v5 ad=0.725 pd=5.29 as=1.45 ps=10.58 w=5 l=2
X695 vin a_1464_8048# a_51034_n9809# vss sky130_fd_pr__nfet_05v0_nvt ad=1.45 pd=10.29 as=1.45 ps=10.29 w=10 l=0.9
X696 quiet a_23713_n11140# a_51034_n9809# vss sky130_fd_pr__nfet_05v0_nvt ad=1.45 pd=10.29 as=1.45 ps=10.29 w=10 l=0.9
X697 w_42120_n8480# w_42120_n8480# a_42523_n6500# w_42120_n8480# sky130_fd_pr__pfet_g5v0d10v5 ad=1.45 pd=10.58 as=0.725 ps=5.29 w=5 l=1
X698 a_42523_n6500# a_42634_n375# w_42120_n8480# w_42120_n8480# sky130_fd_pr__pfet_g5v0d10v5 ad=0.725 pd=5.29 as=0.725 ps=5.29 w=5 l=2
X699 w_42120_n8480# a_42634_n375# a_42523_n6500# w_42120_n8480# sky130_fd_pr__pfet_g5v0d10v5 ad=0.725 pd=5.29 as=0.725 ps=5.29 w=5 l=2
X700 quiet a_23713_n11140# a_51034_n9809# vss sky130_fd_pr__nfet_05v0_nvt ad=1.45 pd=10.29 as=1.45 ps=10.29 w=10 l=0.9
X701 a_31416_n6273# a_30379_n11180# vss sky130_fd_pr__res_high_po w=1 l=11.43
X702 a_24907_n11228# a_7527_n10700# a_42523_n6500# w_42120_n8480# sky130_fd_pr__pfet_g5v0d10v5 ad=0.725 pd=5.29 as=0.725 ps=5.29 w=5 l=1
X703 a_16752_8048# a_16948_n7480# vss sky130_fd_pr__res_high_po w=0.5 l=75.64
X704 w_42120_n8480# a_19104_8048# a_19104_8048# w_42120_n8480# sky130_fd_pr__pfet_g5v0d10v5 ad=1.45 pd=10.58 as=0.725 ps=5.29 w=5 l=2
X705 vss a_32800_3942# quiet vss sky130_fd_pr__nfet_01v8 ad=0.66 pd=4.33 as=0.66 ps=4.33 w=4 l=0.15
X706 quiet a_29900_878# a_32800_3942# quiet sky130_fd_pr__pfet_01v8 ad=0.99 pd=6.33 as=1.86 ps=12.62 w=6 l=0.15
X707 vin a_1464_8048# a_51034_n9809# vss sky130_fd_pr__nfet_05v0_nvt ad=1.45 pd=10.29 as=1.45 ps=10.29 w=10 l=0.9
X708 vss a_24907_n11228# a_23713_n11140# vss sky130_fd_pr__nfet_g5v0d10v5 ad=0.725 pd=5.29 as=0.725 ps=5.29 w=5 l=0.5
X709 a_24907_n11228# a_42633_n11868# vss vss sky130_fd_pr__nfet_g5v0d10v5 ad=0.725 pd=5.29 as=0.725 ps=5.29 w=5 l=2
X710 vin a_1464_8048# a_51034_n9809# vss sky130_fd_pr__nfet_05v0_nvt ad=1.45 pd=10.29 as=1.45 ps=10.29 w=10 l=0.9
X711 a_29179_n11180# a_30379_n11180# vss sky130_fd_pr__res_high_po w=1 l=11.43
X712 a_42634_n375# a_42634_n375# w_42120_n8480# w_42120_n8480# sky130_fd_pr__pfet_g5v0d10v5 ad=1.45 pd=10.58 as=0.725 ps=5.29 w=5 l=2
X713 a_19104_8048# i_ldo vss vss sky130_fd_pr__nfet_g5v0d10v5 ad=0.435 pd=3.29 as=0.435 ps=3.29 w=3 l=2
X714 vin a_22436_8048# w_42120_n8480# vin sky130_fd_pr__pfet_g5v0d10v5 ad=0.725 pd=5.29 as=0.725 ps=5.29 w=5 l=2
X715 vss quiet sky130_fd_pr__cap_mim_m3_2 l=29.42 w=29.42
X716 quiet a_23713_n11140# a_51034_n9809# vss sky130_fd_pr__nfet_05v0_nvt ad=1.45 pd=10.29 as=2.9 ps=20.58 w=10 l=0.9
X717 a_25046_8048# a_25046_8048# vss vss sky130_fd_pr__nfet_01v8 ad=0.66 pd=4.33 as=0.66 ps=4.33 w=4 l=0.15
X718 vin a_1464_8048# a_51034_n9809# vss sky130_fd_pr__nfet_05v0_nvt ad=1.45 pd=10.29 as=1.45 ps=10.29 w=10 l=0.9
X719 a_51034_n9809# a_23713_n11140# quiet vss sky130_fd_pr__nfet_05v0_nvt ad=1.45 pd=10.29 as=1.45 ps=10.29 w=10 l=0.9
X720 a_51034_n9809# a_1464_8048# vin vss sky130_fd_pr__nfet_05v0_nvt ad=1.45 pd=10.29 as=1.45 ps=10.29 w=10 l=0.9
X721 quiet a_32800_3942# vss vss sky130_fd_pr__nfet_01v8 ad=0.66 pd=4.33 as=0.66 ps=4.33 w=4 l=0.15
X722 a_51034_n9809# a_23713_n11140# quiet vss sky130_fd_pr__nfet_05v0_nvt ad=1.45 pd=10.29 as=1.45 ps=10.29 w=10 l=0.9
X723 vin a_1464_8048# a_51034_n9809# vss sky130_fd_pr__nfet_05v0_nvt ad=1.45 pd=10.29 as=1.45 ps=10.29 w=10 l=0.9
X724 a_32800_3942# a_29900_878# quiet quiet sky130_fd_pr__pfet_01v8 ad=0.99 pd=6.33 as=0.99 ps=6.33 w=6 l=0.15
X725 w_42120_n8480# a_42634_n375# a_42523_n6500# w_42120_n8480# sky130_fd_pr__pfet_g5v0d10v5 ad=0.725 pd=5.29 as=0.725 ps=5.29 w=5 l=2
X726 vin a_1464_8048# a_51034_n9809# vss sky130_fd_pr__nfet_05v0_nvt ad=1.45 pd=10.29 as=1.45 ps=10.29 w=10 l=0.9
X727 quiet a_23713_n11140# a_51034_n9809# vss sky130_fd_pr__nfet_05v0_nvt ad=2.9 pd=20.58 as=1.45 ps=10.29 w=10 l=0.9
X728 quiet a_23713_n11140# a_51034_n9809# vss sky130_fd_pr__nfet_05v0_nvt ad=1.45 pd=10.29 as=1.45 ps=10.29 w=10 l=0.9
X729 w_42120_n8480# a_42634_n375# a_23713_n11140# w_42120_n8480# sky130_fd_pr__pfet_g5v0d10v5 ad=0.725 pd=5.29 as=0.725 ps=5.29 w=5 l=2
X730 a_51034_n9809# a_23713_n11140# quiet vss sky130_fd_pr__nfet_05v0_nvt ad=1.45 pd=10.29 as=1.45 ps=10.29 w=10 l=0.9
X731 a_42634_n375# i_ldo vss vss sky130_fd_pr__nfet_g5v0d10v5 ad=1.45 pd=10.58 as=0.725 ps=5.29 w=5 l=2
X732 vss a_25046_8048# a_25046_8048# vss sky130_fd_pr__nfet_01v8 ad=0.66 pd=4.33 as=1.24 ps=8.62 w=4 l=0.15
X733 a_19104_8048# a_19104_8048# w_42120_n8480# w_42120_n8480# sky130_fd_pr__pfet_g5v0d10v5 ad=0.725 pd=5.29 as=0.725 ps=5.29 w=5 l=2
X734 a_25046_8048# a_25046_8048# vss vss sky130_fd_pr__nfet_01v8 ad=0.66 pd=4.33 as=0.66 ps=4.33 w=4 l=0.15
X735 vin a_1464_8048# a_51034_n9809# vss sky130_fd_pr__nfet_05v0_nvt ad=1.45 pd=10.29 as=1.45 ps=10.29 w=10 l=0.9
X736 a_19104_8048# a_19104_8048# w_42120_n8480# w_42120_n8480# sky130_fd_pr__pfet_g5v0d10v5 ad=0.725 pd=5.29 as=0.725 ps=5.29 w=5 l=2
X737 w_42120_n8480# a_42634_n375# a_42523_n6500# w_42120_n8480# sky130_fd_pr__pfet_g5v0d10v5 ad=0.725 pd=5.29 as=0.725 ps=5.29 w=5 l=2
X738 a_51034_n9809# a_23713_n11140# quiet vss sky130_fd_pr__nfet_05v0_nvt ad=1.45 pd=10.29 as=1.45 ps=10.29 w=10 l=0.9
X739 a_31416_n6273# t3 a_32008_n6273# vss sky130_fd_pr__nfet_01v8 ad=0.825 pd=5.33 as=0.825 ps=5.33 w=5 l=0.15
X740 vss a_25242_n7480# a_29900_878# vss sky130_fd_pr__nfet_01v8 ad=0.66 pd=4.33 as=0.66 ps=4.33 w=4 l=0.15
X741 vin a_1464_8048# a_51034_n9809# vss sky130_fd_pr__nfet_05v0_nvt ad=1.45 pd=10.29 as=1.45 ps=10.29 w=10 l=0.9
X742 a_42523_n6500# a_36004_n3859# a_42633_n11868# w_42120_n8480# sky130_fd_pr__pfet_g5v0d10v5 ad=0.725 pd=5.29 as=0.725 ps=5.29 w=5 l=1
X743 vss a_25046_8048# a_25046_8048# vss sky130_fd_pr__nfet_01v8 ad=0.66 pd=4.33 as=0.66 ps=4.33 w=4 l=0.15
X744 a_1464_8048# vss sky130_fd_pr__cap_mim_m3_1 l=29.42 w=29.42
X745 a_6100_8048# a_6296_n7480# vss sky130_fd_pr__res_high_po w=0.5 l=75.64
X746 a_25046_8048# a_25046_8048# vss vss sky130_fd_pr__nfet_01v8 ad=1.24 pd=8.62 as=0.66 ps=4.33 w=4 l=0.15
X747 vss a_1464_8048# sky130_fd_pr__cap_mim_m3_2 l=29.42 w=29.42
X748 vin a_2640_n7480# vss sky130_fd_pr__res_high_po w=0.5 l=75.64
X749 vss a_32800_3942# quiet vss sky130_fd_pr__nfet_01v8 ad=0.66 pd=4.33 as=0.66 ps=4.33 w=4 l=0.15
X750 a_51034_n9809# a_23713_n11140# quiet vss sky130_fd_pr__nfet_05v0_nvt ad=1.45 pd=10.29 as=1.45 ps=10.29 w=10 l=0.9
X751 a_51034_n9809# a_23713_n11140# quiet vss sky130_fd_pr__nfet_05v0_nvt ad=1.45 pd=10.29 as=1.45 ps=10.29 w=10 l=0.9
X752 w_42120_n8480# a_19104_8048# a_19104_8048# w_42120_n8480# sky130_fd_pr__pfet_g5v0d10v5 ad=0.725 pd=5.29 as=0.725 ps=5.29 w=5 l=2
X753 a_31416_n6273# t3 a_32008_n6273# vss sky130_fd_pr__nfet_01v8 ad=0.825 pd=5.33 as=1.55 ps=10.62 w=5 l=0.15
X754 w_42120_n8480# w_42120_n8480# a_42523_n6500# w_42120_n8480# sky130_fd_pr__pfet_g5v0d10v5 ad=1.45 pd=10.58 as=0.725 ps=5.29 w=5 l=1
X755 vin a_1464_8048# a_51034_n9809# vss sky130_fd_pr__nfet_05v0_nvt ad=1.45 pd=10.29 as=1.45 ps=10.29 w=10 l=0.9
X756 vin a_1464_8048# a_51034_n9809# vss sky130_fd_pr__nfet_05v0_nvt ad=1.45 pd=10.29 as=1.45 ps=10.29 w=10 l=0.9
X757 quiet a_23713_n11140# a_51034_n9809# vss sky130_fd_pr__nfet_05v0_nvt ad=2.9 pd=20.58 as=1.45 ps=10.29 w=10 l=0.9
X758 vss a_25046_8048# a_25046_8048# vss sky130_fd_pr__nfet_01v8 ad=0.66 pd=4.33 as=0.66 ps=4.33 w=4 l=0.15
X759 a_42633_n11868# a_36004_n3859# a_42523_n6500# w_42120_n8480# sky130_fd_pr__pfet_g5v0d10v5 ad=0.725 pd=5.29 as=0.725 ps=5.29 w=5 l=1
X760 w_42120_n8480# a_42634_n375# sky130_fd_pr__cap_mim_m3_2 l=13.5 w=13.5
X761 vin a_1464_8048# a_51034_n9809# vss sky130_fd_pr__nfet_05v0_nvt ad=1.45 pd=10.29 as=1.45 ps=10.29 w=10 l=0.9
X762 a_6492_8048# a_6296_n7480# vss sky130_fd_pr__res_high_po w=0.5 l=75.64
X763 a_31416_n6273# t2 a_30379_n11180# vss sky130_fd_pr__nfet_01v8 ad=1.55 pd=10.62 as=0.825 ps=5.33 w=5 l=0.15
X764 quiet a_23713_n11140# a_51034_n9809# vss sky130_fd_pr__nfet_05v0_nvt ad=1.45 pd=10.29 as=1.45 ps=10.29 w=10 l=0.9
X765 quiet a_23713_n11140# a_51034_n9809# vss sky130_fd_pr__nfet_05v0_nvt ad=1.45 pd=10.29 as=2.9 ps=20.58 w=10 l=0.9
X766 a_29900_878# a_25242_n7480# vss vss sky130_fd_pr__nfet_01v8 ad=0.66 pd=4.33 as=0.66 ps=4.33 w=4 l=0.15
X767 a_51034_n9809# a_1464_8048# vin vss sky130_fd_pr__nfet_05v0_nvt ad=1.45 pd=10.29 as=1.45 ps=10.29 w=10 l=0.9
X768 quiet a_23713_n11140# a_51034_n9809# vss sky130_fd_pr__nfet_05v0_nvt ad=1.45 pd=10.29 as=2.9 ps=20.58 w=10 l=0.9
X769 w_42120_n8480# a_19104_8048# a_19104_8048# w_42120_n8480# sky130_fd_pr__pfet_g5v0d10v5 ad=0.725 pd=5.29 as=0.725 ps=5.29 w=5 l=2
X770 vss a_24907_n11228# a_23713_n11140# vss sky130_fd_pr__nfet_g5v0d10v5 ad=0.725 pd=5.29 as=0.725 ps=5.29 w=5 l=0.5
X771 quiet a_23713_n11140# a_51034_n9809# vss sky130_fd_pr__nfet_05v0_nvt ad=1.45 pd=10.29 as=1.45 ps=10.29 w=10 l=0.9
X772 a_14792_8048# a_14988_n7480# vss sky130_fd_pr__res_high_po w=0.5 l=75.64
X773 a_19104_8048# a_19104_8048# w_42120_n8480# w_42120_n8480# sky130_fd_pr__pfet_g5v0d10v5 ad=0.725 pd=5.29 as=0.725 ps=5.29 w=5 l=2
X774 a_42633_n11868# a_42633_n11868# vss vss sky130_fd_pr__nfet_g5v0d10v5 ad=0.725 pd=5.29 as=0.725 ps=5.29 w=5 l=2
X775 w_42120_n8480# a_22436_8048# vin vin sky130_fd_pr__pfet_g5v0d10v5 ad=0.725 pd=5.29 as=0.725 ps=5.29 w=5 l=2
X776 vin a_1464_8048# a_51034_n9809# vss sky130_fd_pr__nfet_05v0_nvt ad=1.45 pd=10.29 as=1.45 ps=10.29 w=10 l=0.9
X777 a_51034_n9809# a_23713_n11140# quiet vss sky130_fd_pr__nfet_05v0_nvt ad=1.45 pd=10.29 as=1.45 ps=10.29 w=10 l=0.9
X778 w_42120_n8480# a_22436_8048# vin vin sky130_fd_pr__pfet_g5v0d10v5 ad=0.725 pd=5.29 as=0.725 ps=5.29 w=5 l=2
X779 vin a_1464_8048# a_51034_n9809# vss sky130_fd_pr__nfet_05v0_nvt ad=1.45 pd=10.29 as=1.45 ps=10.29 w=10 l=0.9
X780 a_32800_3942# a_29900_878# quiet quiet sky130_fd_pr__pfet_01v8 ad=0.99 pd=6.33 as=0.99 ps=6.33 w=6 l=0.15
X781 a_42633_n11868# a_36004_n3859# a_42523_n6500# w_42120_n8480# sky130_fd_pr__pfet_g5v0d10v5 ad=0.725 pd=5.29 as=0.725 ps=5.29 w=5 l=1
X782 quiet a_32800_3942# vss vss sky130_fd_pr__nfet_01v8 ad=0.66 pd=4.33 as=0.66 ps=4.33 w=4 l=0.15
X783 a_29179_n11180# vss vss sky130_fd_pr__res_high_po w=1 l=11.43
X784 w_42120_n8480# a_42634_n375# a_23713_n11140# w_42120_n8480# sky130_fd_pr__pfet_g5v0d10v5 ad=0.725 pd=5.29 as=0.725 ps=5.29 w=5 l=2
X785 vss vss vss vss sky130_fd_pr__nfet_g5v0d10v5 ad=0.725 pd=5.29 as=0 ps=0 w=5 l=2
X786 a_51034_n9809# a_1464_8048# vin vss sky130_fd_pr__nfet_05v0_nvt ad=1.45 pd=10.29 as=1.45 ps=10.29 w=10 l=0.9
X787 a_51034_n9809# a_1464_8048# vin vss sky130_fd_pr__nfet_05v0_nvt ad=1.45 pd=10.29 as=1.45 ps=10.29 w=10 l=0.9
X788 a_10020_8048# a_10216_n7480# vss sky130_fd_pr__res_high_po w=0.5 l=75.64
X789 quiet a_23713_n11140# a_51034_n9809# vss sky130_fd_pr__nfet_05v0_nvt ad=1.45 pd=10.29 as=2.9 ps=20.58 w=10 l=0.9
X790 a_51034_n9809# a_1464_8048# vin vss sky130_fd_pr__nfet_05v0_nvt ad=1.45 pd=10.29 as=1.45 ps=10.29 w=10 l=0.9
X791 quiet a_23713_n11140# a_51034_n9809# vss sky130_fd_pr__nfet_05v0_nvt ad=1.45 pd=10.29 as=1.45 ps=10.29 w=10 l=0.9
X792 quiet a_23713_n11140# a_51034_n9809# vss sky130_fd_pr__nfet_05v0_nvt ad=1.45 pd=10.29 as=1.45 ps=10.29 w=10 l=0.9
X793 a_19104_8048# a_19104_8048# w_42120_n8480# w_42120_n8480# sky130_fd_pr__pfet_g5v0d10v5 ad=0.725 pd=5.29 as=0.725 ps=5.29 w=5 l=2
X794 vin a_1464_8048# a_51034_n9809# vss sky130_fd_pr__nfet_05v0_nvt ad=1.45 pd=10.29 as=1.45 ps=10.29 w=10 l=0.9
X795 w_42120_n8480# a_19104_8048# a_19104_8048# w_42120_n8480# sky130_fd_pr__pfet_g5v0d10v5 ad=0.725 pd=5.29 as=0.725 ps=5.29 w=5 l=2
X796 vss a_32800_3942# quiet vss sky130_fd_pr__nfet_01v8 ad=0.66 pd=4.33 as=0.66 ps=4.33 w=4 l=0.15
X797 a_51034_n9809# a_23713_n11140# quiet vss sky130_fd_pr__nfet_05v0_nvt ad=1.45 pd=10.29 as=1.45 ps=10.29 w=10 l=0.9
X798 a_51034_n9809# a_1464_8048# vin vss sky130_fd_pr__nfet_05v0_nvt ad=1.45 pd=10.29 as=1.45 ps=10.29 w=10 l=0.9
X799 quiet a_29900_878# a_32800_3942# quiet sky130_fd_pr__pfet_01v8 ad=0.99 pd=6.33 as=0.99 ps=6.33 w=6 l=0.15
X800 w_42120_n8480# a_42634_n375# a_23713_n11140# w_42120_n8480# sky130_fd_pr__pfet_g5v0d10v5 ad=0.725 pd=5.29 as=0.725 ps=5.29 w=5 l=2
X801 a_42523_n6500# a_7527_n10700# a_24907_n11228# w_42120_n8480# sky130_fd_pr__pfet_g5v0d10v5 ad=0.725 pd=5.29 as=0.725 ps=5.29 w=5 l=1
X802 vss a_32800_3942# quiet vss sky130_fd_pr__nfet_01v8 ad=0.66 pd=4.33 as=0.66 ps=4.33 w=4 l=0.15
X803 a_23713_n11140# a_42634_n375# w_42120_n8480# w_42120_n8480# sky130_fd_pr__pfet_g5v0d10v5 ad=0.725 pd=5.29 as=0.725 ps=5.29 w=5 l=2
X804 a_42523_n6500# a_42634_n375# w_42120_n8480# w_42120_n8480# sky130_fd_pr__pfet_g5v0d10v5 ad=0.725 pd=5.29 as=0.725 ps=5.29 w=5 l=2
X805 a_10412_8048# a_10216_n7480# vss sky130_fd_pr__res_high_po w=0.5 l=75.64
X806 vss a_24907_n11228# a_23713_n11140# vss sky130_fd_pr__nfet_g5v0d10v5 ad=0.725 pd=5.29 as=0.725 ps=5.29 w=5 l=0.5
X807 vin a_22436_8048# w_42120_n8480# vin sky130_fd_pr__pfet_g5v0d10v5 ad=0.725 pd=5.29 as=0.725 ps=5.29 w=5 l=2
X808 vin a_1464_8048# a_51034_n9809# vss sky130_fd_pr__nfet_05v0_nvt ad=1.45 pd=10.29 as=1.45 ps=10.29 w=10 l=0.9
X809 a_6100_8048# a_5904_n7480# vss sky130_fd_pr__res_high_po w=0.5 l=75.64
X810 vss a_1464_8048# sky130_fd_pr__cap_mim_m3_2 l=29.42 w=29.42
X811 a_21260_8048# a_21456_n7480# vss sky130_fd_pr__res_high_po w=0.5 l=75.64
X812 quiet vss sky130_fd_pr__cap_mim_m3_1 l=29.42 w=29.42
X813 a_51034_n9809# a_23713_n11140# quiet vss sky130_fd_pr__nfet_05v0_nvt ad=1.45 pd=10.29 as=1.45 ps=10.29 w=10 l=0.9
X814 a_19104_8048# a_19104_8048# w_42120_n8480# w_42120_n8480# sky130_fd_pr__pfet_g5v0d10v5 ad=0.725 pd=5.29 as=0.725 ps=5.29 w=5 l=2
X815 a_51034_n9809# a_1464_8048# vin vss sky130_fd_pr__nfet_05v0_nvt ad=1.45 pd=10.29 as=2.9 ps=20.58 w=10 l=0.9
X816 vin a_1464_8048# a_51034_n9809# vss sky130_fd_pr__nfet_05v0_nvt ad=1.45 pd=10.29 as=1.45 ps=10.29 w=10 l=0.9
X817 quiet a_23713_n11140# a_51034_n9809# vss sky130_fd_pr__nfet_05v0_nvt ad=1.45 pd=10.29 as=1.45 ps=10.29 w=10 l=0.9
X818 a_32800_3942# a_2667_n10997# vss vss sky130_fd_pr__nfet_01v8 ad=0.62 pd=4.62 as=0.33 ps=2.33 w=2 l=0.15
X819 vin a_1464_8048# a_51034_n9809# vss sky130_fd_pr__nfet_05v0_nvt ad=1.45 pd=10.29 as=1.45 ps=10.29 w=10 l=0.9
X820 a_51034_n9809# a_1464_8048# vin vss sky130_fd_pr__nfet_05v0_nvt ad=1.45 pd=10.29 as=2.9 ps=20.58 w=10 l=0.9
X821 a_19104_8048# a_19104_8048# w_42120_n8480# w_42120_n8480# sky130_fd_pr__pfet_g5v0d10v5 ad=0.725 pd=5.29 as=0.725 ps=5.29 w=5 l=2
X822 a_51034_n9809# a_23713_n11140# quiet vss sky130_fd_pr__nfet_05v0_nvt ad=1.45 pd=10.29 as=1.45 ps=10.29 w=10 l=0.9
X823 vss a_1464_8048# sky130_fd_pr__cap_mim_m3_2 l=29.42 w=29.42
X824 a_51034_n9809# a_1464_8048# vin vss sky130_fd_pr__nfet_05v0_nvt ad=1.45 pd=10.29 as=1.45 ps=10.29 w=10 l=0.9
X825 a_21652_8048# a_21456_n7480# vss sky130_fd_pr__res_high_po w=0.5 l=75.64
X826 a_19104_8048# a_19104_8048# w_42120_n8480# w_42120_n8480# sky130_fd_pr__pfet_g5v0d10v5 ad=0.725 pd=5.29 as=0.725 ps=5.29 w=5 l=2
X827 vin a_1464_8048# a_51034_n9809# vss sky130_fd_pr__nfet_05v0_nvt ad=1.45 pd=10.29 as=1.45 ps=10.29 w=10 l=0.9
X828 a_51034_n9809# a_1464_8048# vin vss sky130_fd_pr__nfet_05v0_nvt ad=1.45 pd=10.29 as=1.45 ps=10.29 w=10 l=0.9
X829 a_42523_n6500# a_42634_n375# w_42120_n8480# w_42120_n8480# sky130_fd_pr__pfet_g5v0d10v5 ad=0.725 pd=5.29 as=0.725 ps=5.29 w=5 l=2
X830 quiet a_23713_n11140# a_51034_n9809# vss sky130_fd_pr__nfet_05v0_nvt ad=1.45 pd=10.29 as=1.45 ps=10.29 w=10 l=0.9
X831 quiet a_23713_n11140# a_51034_n9809# vss sky130_fd_pr__nfet_05v0_nvt ad=1.45 pd=10.29 as=1.45 ps=10.29 w=10 l=0.9
X832 a_51034_n9809# a_1464_8048# vin vss sky130_fd_pr__nfet_05v0_nvt ad=1.45 pd=10.29 as=1.45 ps=10.29 w=10 l=0.9
X833 a_51034_n9809# a_1464_8048# vin vss sky130_fd_pr__nfet_05v0_nvt ad=1.45 pd=10.29 as=1.45 ps=10.29 w=10 l=0.9
X834 vss a_25242_n7480# a_29900_878# vss sky130_fd_pr__nfet_01v8 ad=0.66 pd=4.33 as=0.66 ps=4.33 w=4 l=0.15
X835 vss a_2667_n10997# a_32800_3942# vss sky130_fd_pr__nfet_01v8 ad=0.33 pd=2.33 as=0.62 ps=4.62 w=2 l=0.15
X836 a_24907_n11228# a_7527_n10700# a_42523_n6500# w_42120_n8480# sky130_fd_pr__pfet_g5v0d10v5 ad=0.725 pd=5.29 as=0.725 ps=5.29 w=5 l=1
X837 quiet a_23713_n11140# a_51034_n9809# vss sky130_fd_pr__nfet_05v0_nvt ad=1.45 pd=10.29 as=1.45 ps=10.29 w=10 l=0.9
X838 a_42523_n6500# a_7527_n10700# a_24907_n11228# w_42120_n8480# sky130_fd_pr__pfet_g5v0d10v5 ad=0.725 pd=5.29 as=0.725 ps=5.29 w=5 l=1
X839 a_29179_n11180# t0 vss vss sky130_fd_pr__nfet_01v8 ad=1.55 pd=10.62 as=0.825 ps=5.33 w=5 l=0.15
X840 quiet a_2667_n10997# a_24458_8048# quiet sky130_fd_pr__pfet_01v8 ad=0.33 pd=2.33 as=0.62 ps=4.62 w=2 l=0.15
X841 vin a_22436_8048# w_42120_n8480# vin sky130_fd_pr__pfet_g5v0d10v5 ad=0.725 pd=5.29 as=0.725 ps=5.29 w=5 l=2
X842 a_1464_8048# vss sky130_fd_pr__cap_mim_m3_1 l=29.42 w=29.42
X843 a_42523_n6500# a_7527_n10700# a_24907_n11228# w_42120_n8480# sky130_fd_pr__pfet_g5v0d10v5 ad=0.725 pd=5.29 as=0.725 ps=5.29 w=5 l=1
X844 a_19104_8048# a_19104_8048# w_42120_n8480# w_42120_n8480# sky130_fd_pr__pfet_g5v0d10v5 ad=0.725 pd=5.29 as=0.725 ps=5.29 w=5 l=2
X845 w_42120_n8480# a_19104_8048# a_19104_8048# w_42120_n8480# sky130_fd_pr__pfet_g5v0d10v5 ad=0.725 pd=5.29 as=0.725 ps=5.29 w=5 l=2
X846 vss a_32800_3942# quiet vss sky130_fd_pr__nfet_01v8 ad=0.66 pd=4.33 as=0.66 ps=4.33 w=4 l=0.15
X847 a_8844_8048# a_9040_n7480# vss sky130_fd_pr__res_high_po w=0.5 l=75.64
X848 a_51034_n9809# a_1464_8048# vin vss sky130_fd_pr__nfet_05v0_nvt ad=1.45 pd=10.29 as=1.45 ps=10.29 w=10 l=0.9
X849 a_42634_n375# w_42120_n8480# sky130_fd_pr__cap_mim_m3_1 l=13.5 w=13.5
X850 a_51034_n9809# a_1464_8048# vin vss sky130_fd_pr__nfet_05v0_nvt ad=1.45 pd=10.29 as=1.45 ps=10.29 w=10 l=0.9
X851 a_23713_n11140# a_24907_n11228# vss vss sky130_fd_pr__nfet_g5v0d10v5 ad=0.725 pd=5.29 as=0.725 ps=5.29 w=5 l=0.5
X852 a_51034_n9809# a_1464_8048# vin vss sky130_fd_pr__nfet_05v0_nvt ad=1.45 pd=10.29 as=1.45 ps=10.29 w=10 l=0.9
X853 quiet a_23713_n11140# a_51034_n9809# vss sky130_fd_pr__nfet_05v0_nvt ad=1.45 pd=10.29 as=1.45 ps=10.29 w=10 l=0.9
X854 a_51034_n9809# a_1464_8048# vin vss sky130_fd_pr__nfet_05v0_nvt ad=1.45 pd=10.29 as=1.45 ps=10.29 w=10 l=0.9
.ends
