* Geometry views for HV18 r4. Values approximate TT/27C; verify by passive card.
* high_po mapping follows the project's calibrated 378+317*L, divided by W.
* ngspice47 ignores model isnoisy=0; a dedicated resistor-noise check confirms
* high_po Johnson noise. Full physical noise/PEX coverage remains separate.
.subckt serdes_ldo_res a b sub params: r=1k
Xr a b sub sky130_fd_pr__res_high_po
+ w={max(1,ceil(1012/r))} l={(r*max(1,ceil(1012/r))-378)/317}
.ends serdes_ldo_res

* 1 Mohm reference resistor, 32 physical high_po units of31.25kohm.
* xhigh's behavioral body omits Johnson noise in installed ngspice; avoid it.
.subckt serdes_ldo_ref31 a b sub
Xr a b sub serdes_ldo_res r=31.25k
.ends serdes_ldo_ref31
.subckt serdes_ldo_ref62 a b sub
X0 a m sub serdes_ldo_ref31
X1 m b sub serdes_ldo_ref31
.ends serdes_ldo_ref62
.subckt serdes_ldo_ref125 a b sub
X0 a m sub serdes_ldo_ref62
X1 m b sub serdes_ldo_ref62
.ends serdes_ldo_ref125
.subckt serdes_ldo_ref250 a b sub
X0 a m sub serdes_ldo_ref125
X1 m b sub serdes_ldo_ref125
.ends serdes_ldo_ref250
.subckt serdes_ldo_ref500 a b sub
X0 a m sub serdes_ldo_ref250
X1 m b sub serdes_ldo_ref250
.ends serdes_ldo_ref500
.subckt serdes_ldo_ref_res a b sub
X0 a m sub serdes_ldo_ref500
X1 m b sub serdes_ldo_ref500
.ends serdes_ldo_ref_res

* One physical MIM per leaf. mf does NOT multiply nominal PDK capacitance.
.subckt serdes_ldo_mim1 a b
Xc a b sky130_fd_pr__cap_mim_m3_1 w=22.1965 l=22.1965
.ends serdes_ldo_mim1
.subckt serdes_ldo_mim2 a b
X0 a b serdes_ldo_mim1
X1 a b serdes_ldo_mim1
.ends serdes_ldo_mim2
.subckt serdes_ldo_mim4 a b
X0 a b serdes_ldo_mim2
X1 a b serdes_ldo_mim2
.ends serdes_ldo_mim4
.subckt serdes_ldo_mim8 a b
X0 a b serdes_ldo_mim4
X1 a b serdes_ldo_mim4
.ends serdes_ldo_mim8
.subckt serdes_ldo_mim16 a b
X0 a b serdes_ldo_mim8
X1 a b serdes_ldo_mim8
.ends serdes_ldo_mim16
.subckt serdes_ldo_mim32 a b
X0 a b serdes_ldo_mim16
X1 a b serdes_ldo_mim16
.ends serdes_ldo_mim32
.subckt serdes_ldo_mim50 a b
X0 a b serdes_ldo_mim32
X1 a b serdes_ldo_mim16
X2 a b serdes_ldo_mim2
.ends serdes_ldo_mim50
.subckt serdes_ldo_mim100 a b
X0 a b serdes_ldo_mim50
X1 a b serdes_ldo_mim50
.ends serdes_ldo_mim100
