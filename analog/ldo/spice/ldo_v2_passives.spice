* LDO v2 Physical Passives (Fused Stacked MIM1+MIM2 & Head-R-Calibrated Unit Resistors)
*
* Stacked MIM tiles: M3 (outer, port b) - M4 (inner, port a) - M5 (outer, port b).
* All tiles <= 29.415 um (< 30 um PDK wmax) so layout == schematic 1:1 with zero fusion error.
* Total macro MIM = 60.00 pF (15 x 3.5 pF large stacked tiles in a 5x3 bay + 6 small/med tiles).
*
* Every multi-segment sky130_fd_pr__res_high_po explicitly instantiates its exact physical bars
* (real .model resistors with Johnson noise in ngspice47; no xhigh_po / _0p35 behavioral omissions):
*   - Divider / precision units: w=1.0 um, l=11.425 um -> 4.000 kOhm/bar (TT/27C, 0.00% head-R error)
*   - High-R filter units (nx>=2 shared RPM, DRC=0): w=0.5 um, l=75.640 um -> 50.000 kOhm/bar

* --- Stacked Fused MIM Building Blocks ---
* 3.500 pF stacked site: 29.415 x 29.415 um (1.750 pF MIM1 + 1.750 pF MIM2)
.subckt serdes_ldo_v2_mim3p5 a b
Xm1 a b sky130_fd_pr__cap_mim_m3_1 w=29.415 l=29.415
Xm2 b a sky130_fd_pr__cap_mim_m3_2 w=29.415 l=29.415
.ends serdes_ldo_v2_mim3p5

.subckt serdes_ldo_v2_mim7p0 a b
X0 a b serdes_ldo_v2_mim3p5
X1 a b serdes_ldo_v2_mim3p5
.ends serdes_ldo_v2_mim7p0

.subckt serdes_ldo_v2_mim10p5 a b
X0 a b serdes_ldo_v2_mim3p5
X1 a b serdes_ldo_v2_mim3p5
X2 a b serdes_ldo_v2_mim3p5
.ends serdes_ldo_v2_mim10p5

.subckt serdes_ldo_v2_mim14p0 a b
X0 a b serdes_ldo_v2_mim7p0
X1 a b serdes_ldo_v2_mim7p0
.ends serdes_ldo_v2_mim14p0

.subckt serdes_ldo_v2_mim21p0 a b
X0 a b serdes_ldo_v2_mim14p0
X1 a b serdes_ldo_v2_mim7p0
.ends serdes_ldo_v2_mim21p0

* 2.000 pF stacked site: 22.195 x 22.195 um (1.000 pF MIM1 + 1.000 pF MIM2)
.subckt serdes_ldo_v2_mim2p0 a b
Xm1 a b sky130_fd_pr__cap_mim_m3_1 w=22.195 l=22.195
Xm2 b a sky130_fd_pr__cap_mim_m3_2 w=22.195 l=22.195
.ends serdes_ldo_v2_mim2p0

* 1.000 pF stacked site: 15.600 x 15.600 um (0.500 pF MIM1 + 0.500 pF MIM2)
.subckt serdes_ldo_v2_mim1p0 a b
Xm1 a b sky130_fd_pr__cap_mim_m3_1 w=15.600 l=15.600
Xm2 b a sky130_fd_pr__cap_mim_m3_2 w=15.600 l=15.600
.ends serdes_ldo_v2_mim1p0

* 0.750 pF stacked site: 13.500 x 13.500 um (0.375 pF MIM1 + 0.375 pF MIM2)
.subckt serdes_ldo_v2_mim0p75 a b
Xm1 a b sky130_fd_pr__cap_mim_m3_1 w=13.500 l=13.500
Xm2 b a sky130_fd_pr__cap_mim_m3_2 w=13.500 l=13.500
.ends serdes_ldo_v2_mim0p75

* --- Head-R-Calibrated Unit-Matched Feedback Divider Resistors ---
* 4.000 kOhm unit bar: w=1.0 um, l=11.425 um -> R = (378 + 317*11.425)/1.0 = 3999.7 Ohm
* All 47 divider bars are identical units -> 0.00% head-R ratio error across all RC corners.
.subckt serdes_ldo_v2_ru4k a b sub
Xr a b sub sky130_fd_pr__res_high_po w=1.0 l=11.425
.ends serdes_ldo_v2_ru4k

* 1.000 kOhm = 4 parallel unit 4 kOhm bars
.subckt serdes_ldo_v2_rdiv1k a b sub
X0 a b sub serdes_ldo_v2_ru4k
X1 a b sub serdes_ldo_v2_ru4k
X2 a b sub serdes_ldo_v2_ru4k
X3 a b sub serdes_ldo_v2_ru4k
.ends serdes_ldo_v2_rdiv1k

* 2.000 kOhm = 2 parallel unit 4 kOhm bars
.subckt serdes_ldo_v2_rdiv2k a b sub
X0 a b sub serdes_ldo_v2_ru4k
X1 a b sub serdes_ldo_v2_ru4k
.ends serdes_ldo_v2_rdiv2k

.subckt serdes_ldo_v2_rdiv4k a b sub
X0 a b sub serdes_ldo_v2_ru4k
.ends serdes_ldo_v2_rdiv4k

.subckt serdes_ldo_v2_rdiv8k a b sub
X0 a m0 sub serdes_ldo_v2_ru4k
X1 m0 b sub serdes_ldo_v2_ru4k
.ends serdes_ldo_v2_rdiv8k

.subckt serdes_ldo_v2_rdiv16k a b sub
X0 a m0 sub serdes_ldo_v2_rdiv8k
X1 m0 b sub serdes_ldo_v2_rdiv8k
.ends serdes_ldo_v2_rdiv16k

.subckt serdes_ldo_v2_rdiv32k a b sub
X0 a m0 sub serdes_ldo_v2_rdiv16k
X1 m0 b sub serdes_ldo_v2_rdiv16k
.ends serdes_ldo_v2_rdiv32k

.subckt serdes_ldo_v2_rdiv40k a b sub
X0 a m0 sub serdes_ldo_v2_rdiv32k
X1 m0 b sub serdes_ldo_v2_rdiv8k
.ends serdes_ldo_v2_rdiv40k

.subckt serdes_ldo_v2_rdiv64k a b sub
X0 a m0 sub serdes_ldo_v2_rdiv32k
X1 m0 b sub serdes_ldo_v2_rdiv32k
.ends serdes_ldo_v2_rdiv64k

* --- Compensation & Clamp Single-Bar Precision Resistors (w=1.0 um) ---
* 5.000 kOhm: w=1.0 um, l=14.580 um -> 5000.0 Ohm
.subckt serdes_ldo_v2_r5k a b sub
Xr a b sub sky130_fd_pr__res_high_po w=1.0 l=14.580
.ends serdes_ldo_v2_r5k

* 12.000 kOhm: w=1.0 um, l=36.660 um -> 11999.2 Ohm
.subckt serdes_ldo_v2_r12k a b sub
Xr a b sub sky130_fd_pr__res_high_po w=1.0 l=36.660
.ends serdes_ldo_v2_r12k

* --- High-R Filter Resistors (calibrated w=0.50 um, l=75.640 um -> 50.000 kOhm/bar) ---
* Instantiated in multi-bar (nx>=2) arrays sharing a single wide RPM enclosure (DRC rpm.1 = 0).
.subckt serdes_ldo_v2_rf50k a b sub
Xr a b sub sky130_fd_pr__res_high_po w=0.5 l=75.640
.ends serdes_ldo_v2_rf50k

.subckt serdes_ldo_v2_rf100k a b sub
X0 a m0 sub serdes_ldo_v2_rf50k
X1 m0 b sub serdes_ldo_v2_rf50k
.ends serdes_ldo_v2_rf100k

.subckt serdes_ldo_v2_rf200k a b sub
X0 a m0 sub serdes_ldo_v2_rf100k
X1 m0 b sub serdes_ldo_v2_rf100k
.ends serdes_ldo_v2_rf200k

.subckt serdes_ldo_v2_rf400k a b sub
X0 a m0 sub serdes_ldo_v2_rf200k
X1 m0 b sub serdes_ldo_v2_rf200k
.ends serdes_ldo_v2_rf400k

.subckt serdes_ldo_v2_rf800k a b sub
X0 a m0 sub serdes_ldo_v2_rf400k
X1 m0 b sub serdes_ldo_v2_rf400k
.ends serdes_ldo_v2_rf800k

.subckt serdes_ldo_v2_rf1p2m a b sub
X0 a m0 sub serdes_ldo_v2_rf400k
X1 m0 m1 sub serdes_ldo_v2_rf400k
X2 m1 b sub serdes_ldo_v2_rf400k
.ends serdes_ldo_v2_rf1p2m

.subckt serdes_ldo_v2_rf1p6m a b sub
X0 a m0 sub serdes_ldo_v2_rf800k
X1 m0 b sub serdes_ldo_v2_rf800k
.ends serdes_ldo_v2_rf1p6m
