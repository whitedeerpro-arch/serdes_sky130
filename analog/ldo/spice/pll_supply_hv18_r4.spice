* Static configuration only, 2026-11-10 interface agreement.
* HV configuration: vin=3.0..3.6V, quiet is an OUTPUT, enable=host logic high.
* External1.8V configuration: board ties vin AND quiet to ONE qualified1.8V
* supply, enable=0. No hot change, no isolated-vin=0/quiet=1.8V contract.
* Global bg/vgi belong to host. Set six trim bits before enable; factory voltage
* measurement is external. Bits high short binary bottom-divider segments.
* Dependencies: bias_dist, CMOS/primitives, ldo_passives, ldo_hv18_core_r4.
.subckt serdes_pll_supply_hv18_r4 vin host quiet bg vgi enable t0 t1 t2 t3 t4 t5 vss
Xloop vin host quiet bg vgi enable t0 t1 t2 t3 t4 t5 fb fb vss serdes_pll_supply_hv18_r4_probe
.ends serdes_pll_supply_hv18_r4

* Same circuit with externally accessible feedback break, for dual injection.
* Production wrapper above shorts both feedback pins, with no probe source.
.subckt serdes_pll_supply_hv18_r4_probe vin host quiet bg vgi enable t0 t1 t2 t3 t4 t5 fb_return fb_input vss
Xcopy ibias vgi host serdes_bias_pcopy n=4
Xinv enable off host vss serdes_cmos_inv
* Disconnect the shared bandgap when off, rather than loading it through1Mohm.
Xrefgate bg ref_start enable off host vss serdes_cmos_tgate wn=2 wp=4
Xrefres ref_start ref_local vss serdes_ldo_ref_res
Xrefcap ref_local vss serdes_ldo_mim16
Xrefreset ref_local off vss vss serdes_nfet w=2 l=0.15
Xcore vin quiet ref_local ibias fb_input off vss serdes_ldo_hv18_core_r4
Xrtop quiet fb_return vss serdes_ldo_res r=38k
Xrfixed fb_return n5 vss serdes_ldo_res r=62k
Xr5 n5 n4 vss serdes_ldo_res r=32k
Xr4 n4 n3 vss serdes_ldo_res r=16k
Xr3 n3 n2 vss serdes_ldo_res r=8k
Xr2 n2 n1 vss serdes_ldo_res r=4k
Xr1 n1 n0 vss serdes_ldo_res r=2k
Xr0 n0 vss vss serdes_ldo_res r=1k
Xs5 n5 t5 n4 vss serdes_nfet w=20 l=0.15
Xs4 n4 t4 n3 vss serdes_nfet w=20 l=0.15
Xs3 n3 t3 n2 vss serdes_nfet w=20 l=0.15
Xs2 n2 t2 n1 vss serdes_nfet w=20 l=0.15
Xs1 n1 t1 n0 vss serdes_nfet w=20 l=0.15
Xs0 n0 t0 vss vss serdes_nfet w=20 l=0.15
Xbleed quiet vss vss serdes_ldo_res r=100k
Xcout quiet vss serdes_ldo_mim100
.ends serdes_pll_supply_hv18_r4_probe

* Candidate filter AFTER the local CML diode, BEFORE VCO/buffer tail gates.
* Not inserted into the active PLL by this file. DC gate current must be tiny.
.subckt serdes_pll_bias_lowpass_r4 original filtered vss
Xr original filtered vss serdes_ldo_res r=100k
Xc filtered vss serdes_ldo_mim16
.ends serdes_pll_bias_lowpass_r4
