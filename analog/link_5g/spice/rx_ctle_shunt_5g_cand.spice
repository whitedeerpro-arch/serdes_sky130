* Shunt-Peaked PDK-Mapped RX CTLE Candidate for 5 Gb/s Feasibility Probe
* Isolated in analog/link_5g/spice/ — does NOT modify mainline analog/rx/cmos_rx/spice/rx_ctle_pdk.spice!
*
* Realistic SKY130A met4+met5 symmetric center-tapped spiral inductor model:
*   - Stackup: SKY130A met5 (1.26 um thick, Rsh=28.5 mOhm/sq, h=5.37 um, C_area=6.6 aF/um^2)
*     + met4 (0.845 um thick, Rsh=79 mOhm/sq, h=3.45 um, C_area=10.3 aF/um^2).
*   - Compact ~65x65 um^2 differential center-tapped stacked spiral:
*     L_half = 4.5 nH per side, mutual coupling k = 0.45 -> L_eff_diff = 4.5*(1+0.45) = 6.53 nH!
*     Realistic parasitics per half: Rs = 14 Ohm, C_sub = 32 fF (split to substrate via R_sub = 500 Ohm),
*     inter-winding C_w = 8 fF (SRF > 11 GHz, Q ~ 5-6 @ 2.5 GHz, negligible DC drop = 4.2 mV at 300 uA).
*   - Center-tap connected directly to VDD (AC virtual ground -> half of C_sub is shorted out!).
*
* Requires: sky130_primitives.spice, rx_ctle_pdk.spice (for ctle_inv_s, ctle_tgate_s).

.subckt sky130_m45_sym_ind pa pb ct sub params: lhalf=4.5n kmut=0.45 rs=14 csub=32f rsub=500 cw=8f
* Left half (pa <-> ct)
Rsa1 pa na1 {rs/2}
La   na1 na2 {lhalf}
Rsa2 na2 ct {rs/2}
Cwa  pa ct {cw}
Csa1 pa sa1 {csub/2}
Rsub_a1 sa1 sub {rsub}
Csa2 ct sa2 {csub/2}
Rsub_a2 sa2 sub {rsub}
* Right half (ct <-> pb) — dot convention: differential current enters pa & exits pb -> aiding flux!
Rsb1 ct nb1 {rs/2}
Lb   nb1 nb2 {lhalf}
Rsb2 nb2 pb {rs/2}
Cwb  ct pb {cw}
Csb1 ct sb1 {csub/2}
Rsub_b1 sb1 sub {rsub}
Csb2 pb sb2 {csub/2}
Rsub_b2 sb2 sub {rsub}
* Differential mutual coupling (aiding for differential signals, opposing for common-mode!)
Kab La Lb {kmut}
.ends sky130_m45_sym_ind

* Drop-in shunt-peaked CTLE (same 1.31 mW power & 600 Ohm RL as serdes_rx_ctle_pdk, + symmetric met4+met5 coil)
.subckt serdes_rx_ctle_shunt_5g inp inn outp outn eq0 eq1 vbias vdd vss
+ params: win=24 nfin=8 wtail=48 nftail=8 l_rload=4.14 l_rdeg=4.14 c_w=9.81 c_l=9.81 wsw=4
+ lhalf=4.5n kmut=0.45 rs=14 csub=32f cw=8f
Xind lp_mid ln_mid vdd vss sky130_m45_sym_ind lhalf={lhalf} kmut={kmut} rs={rs} csub={csub} cw={cw}
Xrp lp_mid outp vss sky130_fd_pr__res_high_po_2p85 l={l_rload}
Xrn ln_mid outn vss sky130_fd_pr__res_high_po_2p85 l={l_rload}
Xip outn inp sp vss serdes_nfet_lvt w={win} l=0.15 nf={nfin}
Xin outp inn sn vss serdes_nfet_lvt w={win} l=0.15 nf={nfin}
Xtp sp vbias vss vss serdes_nfet_lvt w={wtail} l=0.5 nf={nftail}
Xtn sn vbias vss vss serdes_nfet_lvt w={wtail} l=0.5 nf={nftail}
Xrdeg sp sn vss sky130_fd_pr__res_high_po_2p85 l={l_rdeg}
Xeq0 eq0 eq0_b vdd vss ctle_inv_s wn=1.0 wp=2.0
Xeq1 eq1 eq1_b vdd vss ctle_inv_s wn=1.0 wp=2.0
Xceq0  sp cap0 sky130_fd_pr__cap_mim_m3_1 w={c_w} l={c_l}
Xceq1a sp cap1 sky130_fd_pr__cap_mim_m3_1 w={c_w} l={c_l}
Xceq1b sp cap1 sky130_fd_pr__cap_mim_m3_1 w={c_w} l={c_l}
Xsw0 cap0 sn eq0 eq0_b vdd vss ctle_tgate_s wn={wsw} wp={2*wsw}
Xsw1 cap1 sn eq1 eq1_b vdd vss ctle_tgate_s wn={wsw} wp={2*wsw}
Xtie0 cap0 eq0_b sp vss serdes_nfet w=0.42 l=0.50 nf=1
Xtie1 cap1 eq1_b sp vss serdes_nfet w=0.42 l=0.50 nf=1
.ends serdes_rx_ctle_shunt_5g
