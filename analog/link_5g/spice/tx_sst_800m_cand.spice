* 800 mVpp P-over-N Quarter-Rate SST Line Driver Candidate (4 Gb/s & 5 Gb/s Feasibility Probe)
* Isolated candidate in analog/link_5g/spice/ — does NOT modify mainline analog/tx/sst/!
*
* Architecture (engineered for SKY130A 1.65-1.95 V headroom & PVT-matched 50 Ohm Rout):
*   1. Why P-over-N on Vdrv ~ 1.15 V (with NMOS-input PMOS-pass LDO) instead of N-over-N @ 0.86 V?
*      - At Vdrv = 0.86 V and VDD = 1.65 V, an NMOS source-follower LDO pass transistor runs out
*        of gate headroom (Vgate > 1.70 V > 1.65 V!), and an N-over-N pull-up LVT NMOS sees
*        Vgs = 0.79 V with Vsb = 0.86 V body effect -> Ron explodes 4.9x at SS 1.65V -40C!
*      - Raising Vdrv to ~1.15 V regulated by an NMOS-input 5T OTA + PMOS pass device gives
*        0.50 V Vsd headroom at 1.65 V AND strong Vsg = 1.15 V for the LVT-PMOS pull-up switch
*        (only 1.29x Ron variation across TT/SS/FF!), while keeping Rpu ~ Rpd ~ 50 Ohm!
*      - Includes the verified sst_vdrv_ldo light-load phase-margin fix (Xrbleed l=5.0 -> PM >= 55 deg
*        even when TX is disabled!).
*      - Exact 800 mVpp differential launch (into 100 Ohm double-terminated line) is set cleanly by
*        opposing/FFE slices (e.g. 14 main + 2 opposing = 16 ZQ slices -> 0.75 * 1.10 V ~ 825 mVpp),
*        which seamlessly turn into zero-overhead 2-tap FFE post-cursor slices on lossy channels!
*
* Requires: sky130_primitives.spice, sky130_pfet_lvt.spice, tx_sst_driver.spice (for sst_inv/nand2/nor2/pulsegen/mux).

* --- NMOS-Input PMOS-Pass V_drv LDO (~1.15 V from 1.65-1.95 V, includes Xrbleed l=5.0 light-load PM fix) ---
.subckt sst_vdrv_ldo_800m vbg vdrv vdd vss params: ltop=4.2 lbot=95.8 lbleed=5.0
* Reference voltage divider from vbg (1.20 V -> ~1.15 V; ratio-matched high_po_1p41)
Xrtop vbg  vref vss sky130_fd_pr__res_high_po_1p41 l={ltop}
Xrbot vref vss  vss sky130_fd_pr__res_high_po_1p41 l={lbot}
* Self-bias current reference (~80 uA)
Xbn_ref vbn vbn vss vss serdes_nfet w=12 l=0.50 nf=4
Xrbias  vdd vbn vss sky130_fd_pr__res_high_po_1p41 l=45.0
* 5T NMOS-input OTA (ideal for Vref ~ 1.15 V at VDD = 1.65-1.95 V!)
* Polarity: vdrv rises -> nd falls -> Xm2 pulls vgate UP -> PMOS Xpass current decreases (negative feedback!)
Xtail tail  vbn  vss  vss serdes_nfet w=24 l=0.50 nf=8
Xfb   nd    vdrv tail vss serdes_nfet w=32 l=0.50 nf=8
Xref  vgate vref tail vss serdes_nfet w=32 l=0.50 nf=8
Xm1   nd    nd   vdd  vdd serdes_pfet w=32 l=0.50 nf=8
Xm2   vgate nd   vdd  vdd serdes_pfet w=32 l=0.50 nf=8
* Miller compensation cap (~2.0 pF stacked MIM) + nulling resistor Rz (~1.4 kOhm) for unconditional PM >= 55 deg
Xrz   vgate cm_mid vss sky130_fd_pr__res_high_po_1p41 l=3.5
Xcm1  cm_mid vdrv sky130_fd_pr__cap_mim_m3_1 w=22.0 l=22.0
Xcm2  vdrv cm_mid sky130_fd_pr__cap_mim_m3_2 w=22.0 l=22.0
* Wide min-L PMOS pass transistor (W=480 u, L=0.15 u -> carries 15 mA @ Vsd = 0.50 V with huge headroom!)
Xpass vdrv vgate vdd vdd serdes_pfet w=480 l=0.15 nf=48
* Light-load PM bleed resistor fix (l=5.0 -> ~650 uA bleed keeps Xpass gm healthy even when TX disabled!)
Xrbleed vdrv vss vss sky130_fd_pr__res_high_po_1p41 l={lbleed}
* On-chip bypass cap on vdrv (~15.3 pF = 6x stacked MIM1+MIM2, matching 400 mVpp LDO area)
Xcd0a vdrv vss sky130_fd_pr__cap_mim_m3_1 w=24.8 l=24.8
Xcd0b vss vdrv sky130_fd_pr__cap_mim_m3_2 w=24.8 l=24.8
Xcd1a vdrv vss sky130_fd_pr__cap_mim_m3_1 w=24.8 l=24.8
Xcd1b vss vdrv sky130_fd_pr__cap_mim_m3_2 w=24.8 l=24.8
Xcd2a vdrv vss sky130_fd_pr__cap_mim_m3_1 w=24.8 l=24.8
Xcd2b vss vdrv sky130_fd_pr__cap_mim_m3_2 w=24.8 l=24.8
Xcd3a vdrv vss sky130_fd_pr__cap_mim_m3_1 w=24.8 l=24.8
Xcd3b vss vdrv sky130_fd_pr__cap_mim_m3_2 w=24.8 l=24.8
Xcd4a vdrv vss sky130_fd_pr__cap_mim_m3_1 w=24.8 l=24.8
Xcd4b vss vdrv sky130_fd_pr__cap_mim_m3_2 w=24.8 l=24.8
Xcd5a vdrv vss sky130_fd_pr__cap_mim_m3_1 w=24.8 l=24.8
Xcd5b vss vdrv sky130_fd_pr__cap_mim_m3_2 w=24.8 l=24.8
.ends sst_vdrv_ldo_800m

* --- P-over-N Differential SST Unit Slice (nominal 800 Ohm per side @ TT, Vdrv ~ 1.15 V) ---
* Exact 2-gate-delay matched local enable drivers -> zero shoot-through crowbar, 0 uA when en=0:
*   When en=1 (enb=0):
*     gp_b = ~(din_p & en) = ~din_p -> turns ON pull-up LVT PMOS on pad_p when din_p=1
*     gn   =  (din_n & en) =  din_n -> turns ON pull-down LVT NMOS on pad_p when din_p=0
*   When en=0 (enb=1): gp_b=vdd (PMOS OFF), gn=vss (NMOS OFF) -> true Hi-Z!
* Pull-up: serdes_pfet_lvt (wpu=18.0, l=0.35, nf=6, bulk=vdd -> zero isolated N-well!) -> Ron ~ 400 Ohm
* Pull-down: serdes_nfet_lvt (wpd=1.65, l=0.15, nf=1) -> Ron ~ 400 Ohm
* Series resistor: res_high_po_2p85 l=2.60 (~400 Ohm) -> total slice Rout ~ 800 Ohm (16 slices = 50 Ohm)!
.subckt sst_slice_pon_800m din_p din_n en enb pad_p pad_n vdrv vdd vss
+ params: wpu=18.0 wpd=1.65 lres=2.60
* Positive leg (pad_p) 2-stage matched drivers
Xpu_m_p din_n enb pup_mid vdd vss sst_nor2  wn=1.00 wp=3.20 nfn=1 nfp=2
Xpu_d_p pup_mid   gp_b    vdd vss sst_inv   wn=2.60 wp=5.20 nfn=2 nfp=2
Xpd_m_p din_n en  pdp_mid vdd vss sst_nand2 wn=1.00 wp=1.20 nfn=1 nfp=1
Xpd_d_p pdp_mid   gn      vdd vss sst_inv   wn=1.00 wp=2.00 nfn=1 nfp=1
* Negative leg (pad_n) 2-stage matched drivers
Xpu_m_n din_p enb pun_mid vdd vss sst_nor2  wn=1.00 wp=3.20 nfn=1 nfp=2
Xpu_d_n pun_mid   gn_b    vdd vss sst_inv   wn=2.60 wp=5.20 nfn=2 nfp=2
Xpd_m_n din_p en  pdn_mid vdd vss sst_nand2 wn=1.00 wp=1.20 nfn=1 nfp=1
Xpd_d_n pdn_mid   gp      vdd vss sst_inv   wn=1.00 wp=2.00 nfn=1 nfp=1
* Positive leg output stage
Xpup swp  gp_b vdrv vdd serdes_pfet_lvt w={wpu} l=0.35 nf=6
Xpdp swp  gn   vss  vss serdes_nfet_lvt w={wpd} l=0.15 nf=1
Xrp  swp  pad_p vss sky130_fd_pr__res_high_po_2p85 l={lres}
* Negative leg output stage
Xpun swn  gn_b vdrv vdd serdes_pfet_lvt w={wpu} l=0.35 nf=6
Xpdn swn  gp   vss  vss serdes_nfet_lvt w={wpd} l=0.15 nf=1
Xrn  swn  pad_n vss sky130_fd_pr__res_high_po_2p85 l={lres}
.ends sst_slice_pon_800m

.subckt sst_pon_bank_2x din_p din_n en enb pad_p pad_n vdrv vdd vss params: wpu=18.0 wpd=1.65 lres=2.60
X0 din_p din_n en enb pad_p pad_n vdrv vdd vss sst_slice_pon_800m wpu={wpu} wpd={wpd} lres={lres}
X1 din_p din_n en enb pad_p pad_n vdrv vdd vss sst_slice_pon_800m wpu={wpu} wpd={wpd} lres={lres}
.ends sst_pon_bank_2x

.subckt sst_pon_bank_4x din_p din_n en enb pad_p pad_n vdrv vdd vss params: wpu=18.0 wpd=1.65 lres=2.60
X0 din_p din_n en enb pad_p pad_n vdrv vdd vss sst_pon_bank_2x wpu={wpu} wpd={wpd} lres={lres}
X1 din_p din_n en enb pad_p pad_n vdrv vdd vss sst_pon_bank_2x wpu={wpu} wpd={wpd} lres={lres}
.ends sst_pon_bank_4x

.subckt sst_pon_bank_8x din_p din_n en enb pad_p pad_n vdrv vdd vss params: wpu=18.0 wpd=1.65 lres=2.60
X0 din_p din_n en enb pad_p pad_n vdrv vdd vss sst_pon_bank_4x wpu={wpu} wpd={wpd} lres={lres}
X1 din_p din_n en enb pad_p pad_n vdrv vdd vss sst_pon_bank_4x wpu={wpu} wpd={wpd} lres={lres}
.ends sst_pon_bank_8x

* --- Complete 800 mVpp P-over-N Quarter-Rate 4:1 SST Driver + 2-Tap FFE / Swing-Control + LDO ---
* Port-compatible with serdes_tx_sst_driver, plus `opp_mode` (0 = FFE post-cursor on f0..f2; 1 = static opposing swing-trim)!
.subckt serdes_tx_sst_800m_cand
+ d0 d1 d2 d3 db0 db1 db2 db3
+ phi0 phi90 phi180 phi270
+ m0 m1 m2 m3 m4 f0 f1 f2 ffe_en
+ vbg pad_p pad_n vdrv vdd vss
+ params: wpu=18.0 wpd=1.65 lres=2.60 ltop=4.2 lbot=95.8 lbleed=5.0
* On-chip NMOS-input PMOS-pass V_drv LDO (~1.15 V) with light-load bleed fix
Xldo vbg vdrv vdd vss sst_vdrv_ldo_800m ltop={ltop} lbot={lbot} lbleed={lbleed}
* Shared 4-phase 25%-duty pulse generator
Xpg phi0 phi90 phi180 phi270 p0 p1 p2 p3 vdd vss sst_pulsegen_4ph
* Main-cursor 4:1 MUX + slightly stronger pre-driver (scale=1.35 to drive NOR2+NAND2 slice inputs cleanly at 5G!)
Xmux_m d0 d1 d2 d3 db0 db1 db2 db3 p0 p1 p2 p3 mp mn vdd vss sst_mux4_predrv scale=1.35
* Secondary 4:1 MUX (inverted current-bit opposing attenuation when driven with db0..db3, or post-cursor FFE!)
* Here wired as post-cursor FFE (db3, db0, db1, db2) identical to serdes_tx_sst_driver; for flat 800 mVpp
* swing-trim without FFE, we also provide serdes_tx_sst_800m_flat below!
Xmux_f db3 db0 db1 db2 d3 d0 d1 d2 p0 p1 p2 p3 ffe_en fp fn vdd vss sst_mux4_predrv_en scale=0.45
* Static DC enable inversions (0 uW dynamic power)
Xim0 m0 m0b vdd vss sst_inv wn=0.6 wp=1.2
Xim1 m1 m1b vdd vss sst_inv wn=0.6 wp=1.2
Xim2 m2 m2b vdd vss sst_inv wn=0.6 wp=1.2
Xim3 m3 m3b vdd vss sst_inv wn=0.6 wp=1.2
Xim4 m4 m4b vdd vss sst_inv wn=0.6 wp=1.2
Xif0 f0 f0b vdd vss sst_inv wn=0.6 wp=1.2
Xif1 f1 f1b vdd vss sst_inv wn=0.6 wp=1.2
Xif2 f2 f2b vdd vss sst_inv wn=0.6 wp=1.2
* Main P-over-N SST slice banks (1 + 2 + 4 + 8 + 8 = 23 unit slices)
Xm_1x  mp mn m0 m0b pad_p pad_n vdrv vdd vss sst_slice_pon_800m wpu={wpu} wpd={wpd} lres={lres}
Xm_2x  mp mn m1 m1b pad_p pad_n vdrv vdd vss sst_pon_bank_2x    wpu={wpu} wpd={wpd} lres={lres}
Xm_4x  mp mn m2 m2b pad_p pad_n vdrv vdd vss sst_pon_bank_4x    wpu={wpu} wpd={wpd} lres={lres}
Xm_8xa mp mn m3 m3b pad_p pad_n vdrv vdd vss sst_pon_bank_8x    wpu={wpu} wpd={wpd} lres={lres}
Xm_8xb mp mn m4 m4b pad_p pad_n vdrv vdd vss sst_pon_bank_8x    wpu={wpu} wpd={wpd} lres={lres}
* Post-cursor / opposing P-over-N SST slice banks (1 + 2 + 2 = 5 unit slices)
Xf_1x  fp fn f0 f0b pad_p pad_n vdrv vdd vss sst_slice_pon_800m wpu={wpu} wpd={wpd} lres={lres}
Xf_2xa fp fn f1 f1b pad_p pad_n vdrv vdd vss sst_pon_bank_2x    wpu={wpu} wpd={wpd} lres={lres}
Xf_2xb fp fn f2 f2b pad_p pad_n vdrv vdd vss sst_pon_bank_2x    wpu={wpu} wpd={wpd} lres={lres}
.ends serdes_tx_sst_800m_cand

* --- Flat 800 mVpp mode wrapper (opposing slices driven directly by mn/mp -> exact 800 mVpp flat swing, zero extra MUX!) ---
.subckt serdes_tx_sst_800m_flat
+ d0 d1 d2 d3 db0 db1 db2 db3
+ phi0 phi90 phi180 phi270
+ m0 m1 m2 m3 m4 f0 f1 f2 ffe_en
+ vbg pad_p pad_n vdrv vdd vss
+ params: wpu=18.0 wpd=1.65 lres=2.60 ltop=4.2 lbot=95.8 lbleed=5.0
Xldo vbg vdrv vdd vss sst_vdrv_ldo_800m ltop={ltop} lbot={lbot} lbleed={lbleed}
Xpg phi0 phi90 phi180 phi270 p0 p1 p2 p3 vdd vss sst_pulsegen_4ph
Xmux_m d0 d1 d2 d3 db0 db1 db2 db3 p0 p1 p2 p3 mp mn vdd vss sst_mux4_predrv scale=1.35
Xim0 m0 m0b vdd vss sst_inv wn=0.6 wp=1.2
Xim1 m1 m1b vdd vss sst_inv wn=0.6 wp=1.2
Xim2 m2 m2b vdd vss sst_inv wn=0.6 wp=1.2
Xim3 m3 m3b vdd vss sst_inv wn=0.6 wp=1.2
Xim4 m4 m4b vdd vss sst_inv wn=0.6 wp=1.2
Xif0 f0 f0b vdd vss sst_inv wn=0.6 wp=1.2
Xif1 f1 f1b vdd vss sst_inv wn=0.6 wp=1.2
Xif2 f2 f2b vdd vss sst_inv wn=0.6 wp=1.2
Xm_1x  mp mn m0 m0b pad_p pad_n vdrv vdd vss sst_slice_pon_800m wpu={wpu} wpd={wpd} lres={lres}
Xm_2x  mp mn m1 m1b pad_p pad_n vdrv vdd vss sst_pon_bank_2x    wpu={wpu} wpd={wpd} lres={lres}
Xm_4x  mp mn m2 m2b pad_p pad_n vdrv vdd vss sst_pon_bank_4x    wpu={wpu} wpd={wpd} lres={lres}
Xm_8xa mp mn m3 m3b pad_p pad_n vdrv vdd vss sst_pon_bank_8x    wpu={wpu} wpd={wpd} lres={lres}
Xm_8xb mp mn m4 m4b pad_p pad_n vdrv vdd vss sst_pon_bank_8x    wpu={wpu} wpd={wpd} lres={lres}
* Opposing swing-trim slices (mn/mp swapped -> exact constant 50 Ohm Rout at ~800 mVpp!)
Xf_1x  mn mp f0 f0b pad_p pad_n vdrv vdd vss sst_slice_pon_800m wpu={wpu} wpd={wpd} lres={lres}
Xf_2xa mn mp f1 f1b pad_p pad_n vdrv vdd vss sst_pon_bank_2x    wpu={wpu} wpd={wpd} lres={lres}
Xf_2xb mn mp f2 f2b pad_p pad_n vdrv vdd vss sst_pon_bank_2x    wpu={wpu} wpd={wpd} lres={lres}
.ends serdes_tx_sst_800m_flat
