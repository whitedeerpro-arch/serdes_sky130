* NGSPICE file created from pll_cp_steer_v4_pdk.ext - technology: sky130A

.subckt pll_cp_steer_v4_pdk up dn out vbn vbp ibias vdd vss
X0 a_6625_603# a_6625_603# vdd vdd sky130_fd_pr__pfet_01v8_lvt ad=0.87 pd=6.29 as=1.74 ps=12.58 w=6 l=1
X1 vdd a_753_1463# a_753_1463# vdd sky130_fd_pr__pfet_01v8_lvt ad=0.29 pd=2.29 as=0.29 ps=2.29 w=2 l=1
X2 a_4067_580# a_6625_603# vdd vdd sky130_fd_pr__pfet_01v8_lvt ad=0.87 pd=6.29 as=0.87 ps=6.29 w=6 l=1
X3 vss ibias a_7471_n2420# vss sky130_fd_pr__nfet_01v8 ad=1.45 pd=10.58 as=0.725 ps=5.29 w=5 l=1
X4 a_4167_n980# vbn vss vss sky130_fd_pr__nfet_01v8 ad=0.725 pd=5.29 as=1.45 ps=10.58 w=5 l=1
X5 a_3777_1820# up a_4067_580# vdd sky130_fd_pr__pfet_01v8 ad=0.495 pd=3.33 as=0.495 ps=3.33 w=3 l=0.15
X6 a_753_1463# a_753_1463# vdd vdd sky130_fd_pr__pfet_01v8_lvt ad=0.29 pd=2.29 as=0.58 ps=4.58 w=2 l=1
X7 vdd a_1469_2640# a_3777_1820# vdd sky130_fd_pr__pfet_01v8 ad=1.015 pd=7.29 as=1.015 ps=7.29 w=7 l=1
X8 a_3777_1820# a_565_580# out vdd sky130_fd_pr__pfet_01v8 ad=0.93 pd=6.62 as=0.495 ps=3.33 w=3 l=0.15
X9 out a_565_580# a_3777_1820# vdd sky130_fd_pr__pfet_01v8 ad=0.495 pd=3.33 as=0.495 ps=3.33 w=3 l=0.15
X10 vdd a_1469_2640# a_3777_1820# vdd sky130_fd_pr__pfet_01v8 ad=1.015 pd=7.29 as=1.015 ps=7.29 w=7 l=1
X11 a_753_n1708# vss a_1753_3620# vdd sky130_fd_pr__pfet_01v8 ad=0.495 pd=3.33 as=0.93 ps=6.62 w=3 l=0.15
X12 vdd a_1469_2640# a_3777_1820# vdd sky130_fd_pr__pfet_01v8 ad=1.015 pd=7.29 as=1.015 ps=7.29 w=7 l=1
X13 a_695_n1620# out a_753_1463# vss sky130_fd_pr__nfet_01v8_lvt ad=0.29 pd=2.58 as=0.145 ps=1.29 w=1 l=1
X14 vdd a_6625_603# a_4067_580# vdd sky130_fd_pr__pfet_01v8_lvt ad=0.87 pd=6.29 as=0.87 ps=6.29 w=6 l=1
X15 vdd a_6625_603# a_4067_580# vdd sky130_fd_pr__pfet_01v8_lvt ad=0.87 pd=6.29 as=0.87 ps=6.29 w=6 l=1
X16 a_3777_1820# a_1469_2640# vdd vdd sky130_fd_pr__pfet_01v8 ad=1.015 pd=7.29 as=2.03 ps=14.58 w=7 l=1
X17 a_3777_1820# a_1469_2640# vdd vdd sky130_fd_pr__pfet_01v8 ad=1.015 pd=7.29 as=1.015 ps=7.29 w=7 l=1
X18 a_7471_n2420# a_4067_580# a_4067_580# vss sky130_fd_pr__nfet_01v8_lvt ad=0.87 pd=6.29 as=0.87 ps=6.29 w=6 l=1
X19 a_4167_n980# a_1401_580# a_4067_580# vss sky130_fd_pr__nfet_01v8 ad=0.33 pd=2.33 as=0.33 ps=2.33 w=2 l=0.15
X20 vdd a_6625_603# a_6625_603# vdd sky130_fd_pr__pfet_01v8_lvt ad=0.87 pd=6.29 as=0.87 ps=6.29 w=6 l=1
X21 vdd a_1469_2640# a_3777_1820# vdd sky130_fd_pr__pfet_01v8 ad=2.03 pd=14.58 as=1.015 ps=7.29 w=7 l=1
X22 vss a_1401_580# a_2071_580# vss sky130_fd_pr__nfet_01v8 ad=0.62 pd=4.62 as=0.33 ps=2.33 w=2 l=0.15
X23 a_6625_603# a_6625_603# vdd vdd sky130_fd_pr__pfet_01v8_lvt ad=0.87 pd=6.29 as=0.87 ps=6.29 w=6 l=1
X24 vdd a_1469_2640# a_1753_3620# vdd sky130_fd_pr__pfet_01v8 ad=2.03 pd=14.58 as=1.015 ps=7.29 w=7 l=1
X25 a_1753_3620# a_1469_2640# vdd vdd sky130_fd_pr__pfet_01v8 ad=1.015 pd=7.29 as=1.015 ps=7.29 w=7 l=1
X26 vdd a_753_2543# a_1469_2640# vdd sky130_fd_pr__pfet_01v8_lvt ad=0.58 pd=4.58 as=0.29 ps=2.29 w=2 l=1
X27 a_1469_2640# a_753_2543# vdd vdd sky130_fd_pr__pfet_01v8_lvt ad=0.29 pd=2.29 as=0.29 ps=2.29 w=2 l=1
X28 a_4067_580# a_6625_603# vdd vdd sky130_fd_pr__pfet_01v8_lvt ad=0.87 pd=6.29 as=0.87 ps=6.29 w=6 l=1
X29 vdd a_753_2543# a_753_2543# vdd sky130_fd_pr__pfet_01v8_lvt ad=0.29 pd=2.29 as=0.29 ps=2.29 w=2 l=1
X30 a_1401_580# dn vdd vdd sky130_fd_pr__pfet_01v8 ad=0.33 pd=2.33 as=0.62 ps=4.62 w=2 l=0.15
X31 a_480_n2608# a_480_n2608# vss vss sky130_fd_pr__nfet_01v8 ad=0.58 pd=4.58 as=0.58 ps=4.58 w=2 l=1
X32 a_1401_580# dn vdd vdd sky130_fd_pr__pfet_01v8 ad=0.33 pd=2.33 as=0.33 ps=2.33 w=2 l=0.15
X33 a_6625_603# a_6625_603# vdd vdd sky130_fd_pr__pfet_01v8_lvt ad=0.87 pd=6.29 as=0.87 ps=6.29 w=6 l=1
X34 vdd dn a_1401_580# vdd sky130_fd_pr__pfet_01v8 ad=0.33 pd=2.33 as=0.33 ps=2.33 w=2 l=0.15
X35 a_4067_580# a_1401_580# a_4167_n980# vss sky130_fd_pr__nfet_01v8 ad=0.33 pd=2.33 as=0.33 ps=2.33 w=2 l=0.15
X36 a_4067_580# up a_3777_1820# vdd sky130_fd_pr__pfet_01v8 ad=0.495 pd=3.33 as=0.495 ps=3.33 w=3 l=0.15
X37 vdd up a_565_580# vdd sky130_fd_pr__pfet_01v8 ad=0.33 pd=2.33 as=0.33 ps=2.33 w=2 l=0.15
X38 a_753_2543# a_753_2543# vdd vdd sky130_fd_pr__pfet_01v8_lvt ad=0.29 pd=2.29 as=0.58 ps=4.58 w=2 l=1
X39 vss up a_565_580# vss sky130_fd_pr__nfet_01v8 ad=0.58 pd=4.58 as=0.29 ps=2.29 w=2 l=0.3
X40 vdd dn a_1401_580# vdd sky130_fd_pr__pfet_01v8 ad=0.62 pd=4.62 as=0.33 ps=2.33 w=2 l=0.15
X41 a_565_580# up vdd vdd sky130_fd_pr__pfet_01v8 ad=0.33 pd=2.33 as=0.62 ps=4.62 w=2 l=0.15
X42 vdd up a_565_580# vdd sky130_fd_pr__pfet_01v8 ad=0.33 pd=2.33 as=0.33 ps=2.33 w=2 l=0.15
X43 a_4067_580# a_4067_580# a_7471_n2420# vss sky130_fd_pr__nfet_01v8_lvt ad=0.87 pd=6.29 as=0.87 ps=6.29 w=6 l=1
X44 vss vbn a_4167_n980# vss sky130_fd_pr__nfet_01v8 ad=0.725 pd=5.29 as=0.725 ps=5.29 w=5 l=1
X45 a_565_580# up vdd vdd sky130_fd_pr__pfet_01v8 ad=0.33 pd=2.33 as=0.33 ps=2.33 w=2 l=0.15
X46 a_4067_580# a_6625_603# vdd vdd sky130_fd_pr__pfet_01v8_lvt ad=0.87 pd=6.29 as=0.87 ps=6.29 w=6 l=1
X47 a_565_580# up vdd vdd sky130_fd_pr__pfet_01v8 ad=0.33 pd=2.33 as=0.33 ps=2.33 w=2 l=0.15
X48 vdd a_6625_603# a_6625_603# vdd sky130_fd_pr__pfet_01v8_lvt ad=0.87 pd=6.29 as=0.87 ps=6.29 w=6 l=1
X49 vdd a_6625_603# a_6625_603# vdd sky130_fd_pr__pfet_01v8_lvt ad=0.87 pd=6.29 as=0.87 ps=6.29 w=6 l=1
X50 a_6625_603# a_6625_603# vdd vdd sky130_fd_pr__pfet_01v8_lvt ad=0.87 pd=6.29 as=0.87 ps=6.29 w=6 l=1
X51 a_3777_1820# a_1469_2640# vdd vdd sky130_fd_pr__pfet_01v8 ad=1.015 pd=7.29 as=1.015 ps=7.29 w=7 l=1
X52 a_3777_1820# a_1469_2640# vdd vdd sky130_fd_pr__pfet_01v8 ad=1.015 pd=7.29 as=1.015 ps=7.29 w=7 l=1
X53 a_6625_603# a_6625_603# vdd vdd sky130_fd_pr__pfet_01v8_lvt ad=0.87 pd=6.29 as=0.87 ps=6.29 w=6 l=1
X54 ibias ibias vss vss sky130_fd_pr__nfet_01v8 ad=0.29 pd=2.58 as=0.29 ps=2.58 w=1 l=1
X55 a_2071_580# a_1401_580# vss vss sky130_fd_pr__nfet_01v8 ad=0.33 pd=2.33 as=0.62 ps=4.62 w=2 l=0.15
X56 a_6625_603# a_6625_603# vdd vdd sky130_fd_pr__pfet_01v8_lvt ad=0.87 pd=6.29 as=0.87 ps=6.29 w=6 l=1
X57 vdd a_6625_603# a_6625_603# vdd sky130_fd_pr__pfet_01v8_lvt ad=0.87 pd=6.29 as=0.87 ps=6.29 w=6 l=1
X58 vdd a_6625_603# a_6625_603# vdd sky130_fd_pr__pfet_01v8_lvt ad=0.87 pd=6.29 as=0.87 ps=6.29 w=6 l=1
X59 vdd up a_565_580# vdd sky130_fd_pr__pfet_01v8 ad=0.62 pd=4.62 as=0.33 ps=2.33 w=2 l=0.15
X60 a_6625_603# a_6625_603# vdd vdd sky130_fd_pr__pfet_01v8_lvt ad=0.87 pd=6.29 as=0.87 ps=6.29 w=6 l=1
X61 vss a_1313_n2628# a_1313_n2628# vss sky130_fd_pr__nfet_01v8 ad=0.29 pd=2.29 as=0.29 ps=2.29 w=2 l=1
X62 vdd a_6625_603# a_6625_603# vdd sky130_fd_pr__pfet_01v8_lvt ad=0.87 pd=6.29 as=0.87 ps=6.29 w=6 l=1
X63 a_1313_n2628# a_1313_n2628# vss vss sky130_fd_pr__nfet_01v8 ad=0.29 pd=2.29 as=0.58 ps=4.58 w=2 l=1
X64 vdd a_6625_603# a_4067_580# vdd sky130_fd_pr__pfet_01v8_lvt ad=0.87 pd=6.29 as=0.87 ps=6.29 w=6 l=1
X65 a_7471_n2420# ibias vss vss sky130_fd_pr__nfet_01v8 ad=0.725 pd=5.29 as=1.45 ps=10.58 w=5 l=1
X66 a_753_2543# a_753_n1708# a_695_n1620# vss sky130_fd_pr__nfet_01v8_lvt ad=0.145 pd=1.29 as=0.29 ps=2.58 w=1 l=1
X67 a_4067_580# a_6625_603# vdd vdd sky130_fd_pr__pfet_01v8_lvt ad=0.87 pd=6.29 as=0.87 ps=6.29 w=6 l=1
X68 vdd a_6625_603# a_6625_603# vdd sky130_fd_pr__pfet_01v8_lvt ad=0.87 pd=6.29 as=0.87 ps=6.29 w=6 l=1
X69 a_4167_n980# a_2071_580# out vss sky130_fd_pr__nfet_01v8 ad=0.33 pd=2.33 as=0.33 ps=2.33 w=2 l=0.15
X70 out a_565_580# a_3777_1820# vdd sky130_fd_pr__pfet_01v8 ad=0.495 pd=3.33 as=0.495 ps=3.33 w=3 l=0.15
X71 a_3777_1820# up a_4067_580# vdd sky130_fd_pr__pfet_01v8 ad=0.495 pd=3.33 as=0.495 ps=3.33 w=3 l=0.15
X72 a_3777_1820# up a_4067_580# vdd sky130_fd_pr__pfet_01v8 ad=0.495 pd=3.33 as=0.495 ps=3.33 w=3 l=0.15
X73 a_4067_580# up a_3777_1820# vdd sky130_fd_pr__pfet_01v8 ad=0.495 pd=3.33 as=0.495 ps=3.33 w=3 l=0.15
X74 a_3777_1820# up a_4067_580# vdd sky130_fd_pr__pfet_01v8 ad=0.495 pd=3.33 as=0.495 ps=3.33 w=3 l=0.15
X75 out a_565_580# a_3777_1820# vdd sky130_fd_pr__pfet_01v8 ad=0.495 pd=3.33 as=0.495 ps=3.33 w=3 l=0.15
X76 a_4067_580# up a_3777_1820# vdd sky130_fd_pr__pfet_01v8 ad=0.495 pd=3.33 as=0.495 ps=3.33 w=3 l=0.15
X77 a_3777_1820# a_565_580# out vdd sky130_fd_pr__pfet_01v8 ad=0.495 pd=3.33 as=0.495 ps=3.33 w=3 l=0.15
X78 a_4067_580# up a_3777_1820# vdd sky130_fd_pr__pfet_01v8 ad=0.495 pd=3.33 as=0.495 ps=3.33 w=3 l=0.15
X79 vdd a_1469_2640# a_3777_1820# vdd sky130_fd_pr__pfet_01v8 ad=1.015 pd=7.29 as=1.015 ps=7.29 w=7 l=1
X80 vdd a_6625_603# a_4067_580# vdd sky130_fd_pr__pfet_01v8_lvt ad=0.87 pd=6.29 as=0.87 ps=6.29 w=6 l=1
X81 a_3777_1820# a_565_580# out vdd sky130_fd_pr__pfet_01v8 ad=0.495 pd=3.33 as=0.495 ps=3.33 w=3 l=0.15
X82 a_3777_1820# a_1469_2640# vdd vdd sky130_fd_pr__pfet_01v8 ad=1.015 pd=7.29 as=2.03 ps=14.58 w=7 l=1
X83 a_6625_603# out a_7471_n2420# vss sky130_fd_pr__nfet_01v8_lvt ad=0.87 pd=6.29 as=0.87 ps=6.29 w=6 l=1
X84 vdd a_1469_2640# a_3777_1820# vdd sky130_fd_pr__pfet_01v8 ad=1.015 pd=7.29 as=1.015 ps=7.29 w=7 l=1
X85 a_695_n1620# a_753_n1708# a_753_2543# vss sky130_fd_pr__nfet_01v8_lvt ad=0.145 pd=1.29 as=0.145 ps=1.29 w=1 l=1
X86 vdd a_1469_2640# a_3777_1820# vdd sky130_fd_pr__pfet_01v8 ad=2.03 pd=14.58 as=1.015 ps=7.29 w=7 l=1
X87 a_4067_580# vss sky130_fd_pr__cap_mim_m3_1 l=12.08 w=12.08
X88 a_4067_580# a_1401_580# a_4167_n980# vss sky130_fd_pr__nfet_01v8 ad=0.33 pd=2.33 as=0.33 ps=2.33 w=2 l=0.15
X89 vss dn a_1401_580# vss sky130_fd_pr__nfet_01v8 ad=0.62 pd=4.62 as=0.33 ps=2.33 w=2 l=0.15
X90 a_7471_n2420# a_4067_580# a_4067_580# vss sky130_fd_pr__nfet_01v8_lvt ad=0.87 pd=6.29 as=0.87 ps=6.29 w=6 l=1
X91 a_480_n2608# vbp vdd vdd sky130_fd_pr__pfet_01v8 ad=0.58 pd=4.58 as=0.58 ps=4.58 w=2 l=1
X92 a_7471_n2420# out a_6625_603# vss sky130_fd_pr__nfet_01v8_lvt ad=0.87 pd=6.29 as=0.87 ps=6.29 w=6 l=1
X93 vdd a_1469_2640# a_3777_1820# vdd sky130_fd_pr__pfet_01v8 ad=1.015 pd=7.29 as=1.015 ps=7.29 w=7 l=1
X94 a_2335_n1640# vbn vss vss sky130_fd_pr__nfet_01v8 ad=1.45 pd=10.58 as=1.45 ps=10.58 w=5 l=1
X95 a_3777_1820# a_1469_2640# vdd vdd sky130_fd_pr__pfet_01v8 ad=1.015 pd=7.29 as=1.015 ps=7.29 w=7 l=1
X96 a_6625_603# out a_7471_n2420# vss sky130_fd_pr__nfet_01v8_lvt ad=0.87 pd=6.29 as=1.74 ps=12.58 w=6 l=1
X97 a_6625_603# a_6625_603# vdd vdd sky130_fd_pr__pfet_01v8_lvt ad=0.87 pd=6.29 as=0.87 ps=6.29 w=6 l=1
X98 a_4167_n980# a_2071_580# out vss sky130_fd_pr__nfet_01v8 ad=0.62 pd=4.62 as=0.33 ps=2.33 w=2 l=0.15
X99 a_2071_580# a_1401_580# vdd vdd sky130_fd_pr__pfet_01v8 ad=0.33 pd=2.33 as=0.62 ps=4.62 w=2 l=0.15
X100 a_2071_580# a_1401_580# vdd vdd sky130_fd_pr__pfet_01v8 ad=0.33 pd=2.33 as=0.33 ps=2.33 w=2 l=0.15
X101 vdd a_6625_603# a_4067_580# vdd sky130_fd_pr__pfet_01v8_lvt ad=1.74 pd=12.58 as=0.87 ps=6.29 w=6 l=1
X102 vdd a_1401_580# a_2071_580# vdd sky130_fd_pr__pfet_01v8 ad=0.33 pd=2.33 as=0.33 ps=2.33 w=2 l=0.15
X103 vdd a_1401_580# a_2071_580# vdd sky130_fd_pr__pfet_01v8 ad=0.62 pd=4.62 as=0.33 ps=2.33 w=2 l=0.15
X104 out a_2071_580# a_4167_n980# vss sky130_fd_pr__nfet_01v8 ad=0.33 pd=2.33 as=0.62 ps=4.62 w=2 l=0.15
X105 a_3777_1820# a_565_580# out vdd sky130_fd_pr__pfet_01v8 ad=0.495 pd=3.33 as=0.495 ps=3.33 w=3 l=0.15
X106 a_695_n1620# a_480_n2608# vss vss sky130_fd_pr__nfet_01v8 ad=0.29 pd=2.58 as=0.29 ps=2.58 w=1 l=1
X107 out a_565_580# a_3777_1820# vdd sky130_fd_pr__pfet_01v8 ad=0.495 pd=3.33 as=0.93 ps=6.62 w=3 l=0.15
X108 vdd a_6625_603# a_6625_603# vdd sky130_fd_pr__pfet_01v8_lvt ad=1.74 pd=12.58 as=0.87 ps=6.29 w=6 l=1
X109 vdd a_6625_603# a_4067_580# vdd sky130_fd_pr__pfet_01v8_lvt ad=0.87 pd=6.29 as=0.87 ps=6.29 w=6 l=1
X110 a_753_1463# out a_695_n1620# vss sky130_fd_pr__nfet_01v8_lvt ad=0.145 pd=1.29 as=0.145 ps=1.29 w=1 l=1
X111 a_2335_n1640# vdd a_753_n1708# vss sky130_fd_pr__nfet_01v8 ad=0.58 pd=4.58 as=0.58 ps=4.58 w=2 l=0.15
X112 a_3777_1820# a_1469_2640# vdd vdd sky130_fd_pr__pfet_01v8 ad=1.015 pd=7.29 as=1.015 ps=7.29 w=7 l=1
X113 vss a_1313_n2628# a_1469_2640# vss sky130_fd_pr__nfet_01v8 ad=0.58 pd=4.58 as=0.29 ps=2.29 w=2 l=1
X114 a_4167_n980# a_1401_580# a_4067_580# vss sky130_fd_pr__nfet_01v8 ad=0.33 pd=2.33 as=0.33 ps=2.33 w=2 l=0.15
X115 vss vbn a_4167_n980# vss sky130_fd_pr__nfet_01v8 ad=1.45 pd=10.58 as=0.725 ps=5.29 w=5 l=1
X116 a_1401_580# dn vss vss sky130_fd_pr__nfet_01v8 ad=0.33 pd=2.33 as=0.62 ps=4.62 w=2 l=0.15
X117 vdd a_6625_603# a_4067_580# vdd sky130_fd_pr__pfet_01v8_lvt ad=0.87 pd=6.29 as=0.87 ps=6.29 w=6 l=1
X118 a_753_n1708# a_1469_2640# sky130_fd_pr__cap_mim_m3_1 l=14 w=10
X119 a_1753_3620# vss a_753_n1708# vdd sky130_fd_pr__pfet_01v8 ad=0.93 pd=6.62 as=0.495 ps=3.33 w=3 l=0.15
X120 a_4067_580# a_6625_603# vdd vdd sky130_fd_pr__pfet_01v8_lvt ad=0.87 pd=6.29 as=1.74 ps=12.58 w=6 l=1
X121 a_4067_580# a_6625_603# vdd vdd sky130_fd_pr__pfet_01v8_lvt ad=0.87 pd=6.29 as=0.87 ps=6.29 w=6 l=1
X122 a_4167_n980# vbn vss vss sky130_fd_pr__nfet_01v8 ad=0.725 pd=5.29 as=0.725 ps=5.29 w=5 l=1
X123 vdd a_1469_2640# a_1753_3620# vdd sky130_fd_pr__pfet_01v8 ad=1.015 pd=7.29 as=1.015 ps=7.29 w=7 l=1
X124 vdd a_6625_603# a_4067_580# vdd sky130_fd_pr__pfet_01v8_lvt ad=0.87 pd=6.29 as=0.87 ps=6.29 w=6 l=1
X125 out a_2071_580# a_4167_n980# vss sky130_fd_pr__nfet_01v8 ad=0.33 pd=2.33 as=0.33 ps=2.33 w=2 l=0.15
X126 a_565_580# up vss vss sky130_fd_pr__nfet_01v8 ad=0.29 pd=2.29 as=0.58 ps=4.58 w=2 l=0.3
X127 a_3777_1820# a_1469_2640# vdd vdd sky130_fd_pr__pfet_01v8 ad=1.015 pd=7.29 as=1.015 ps=7.29 w=7 l=1
X128 a_1753_3620# a_1469_2640# vdd vdd sky130_fd_pr__pfet_01v8 ad=1.015 pd=7.29 as=2.03 ps=14.58 w=7 l=1
X129 a_4067_580# a_6625_603# vdd vdd sky130_fd_pr__pfet_01v8_lvt ad=0.87 pd=6.29 as=0.87 ps=6.29 w=6 l=1
X130 a_4067_580# a_4067_580# a_7471_n2420# vss sky130_fd_pr__nfet_01v8_lvt ad=0.87 pd=6.29 as=0.87 ps=6.29 w=6 l=1
X131 vdd a_753_1463# a_1313_n2628# vdd sky130_fd_pr__pfet_01v8_lvt ad=0.58 pd=4.58 as=0.29 ps=2.29 w=2 l=1
X132 a_1313_n2628# a_753_1463# vdd vdd sky130_fd_pr__pfet_01v8_lvt ad=0.29 pd=2.29 as=0.29 ps=2.29 w=2 l=1
X133 a_7471_n2420# out a_6625_603# vss sky130_fd_pr__nfet_01v8_lvt ad=1.74 pd=12.58 as=0.87 ps=6.29 w=6 l=1
X134 a_1469_2640# a_1313_n2628# vss vss sky130_fd_pr__nfet_01v8 ad=0.29 pd=2.29 as=0.29 ps=2.29 w=2 l=1
X135 a_4067_580# a_6625_603# vdd vdd sky130_fd_pr__pfet_01v8_lvt ad=0.87 pd=6.29 as=0.87 ps=6.29 w=6 l=1
C0 vbn a_480_n2608# 0.18239f
C1 a_3777_1820# a_1469_2640# 8.92724f
C2 dn a_695_n1620# 0.00163f
C3 a_480_n2608# up 0.16876f
C4 dn vdd 1.20138f
C5 a_1313_n2628# a_480_n2608# 0.06408f
C6 a_695_n1620# a_1401_580# 0
C7 a_6625_603# a_4067_580# 10.3952f
C8 a_4067_580# out 1.53366f
C9 a_753_n1708# a_1469_2640# 13.382f
C10 a_6625_603# ibias 0.00277f
C11 out ibias 0.00988f
C12 a_1401_580# vdd 2.28154f
C13 a_2071_580# out 0.2971f
C14 a_3777_1820# a_753_n1708# 0.00542f
C15 dn a_753_2543# 0.14881f
C16 a_1401_580# a_2335_n1640# 0.00265f
C17 a_695_n1620# ibias 0
C18 a_565_580# a_753_1463# 0.01727f
C19 a_4167_n980# a_565_580# 0
C20 a_480_n2608# a_1469_2640# 0.47119f
C21 a_1401_580# a_753_2543# 0.02451f
C22 vdd a_4067_580# 8.81135f
C23 vdd ibias 0
C24 vbn a_753_1463# 0
C25 a_4167_n980# vbn 1.56f
C26 a_2071_580# vdd 1.00039f
C27 up a_753_1463# 0.05913f
C28 a_4167_n980# up 0.00476f
C29 a_2335_n1640# ibias 0
C30 a_1313_n2628# a_753_1463# 1.09961f
C31 a_753_2543# ibias 0
C32 a_2071_580# a_2335_n1640# 0
C33 dn a_1401_580# 0.61127f
C34 a_753_n1708# a_480_n2608# 0.09172f
C35 a_2071_580# a_753_2543# 0
C36 a_6625_603# a_565_580# 0.00594f
C37 a_565_580# out 0.53655f
C38 vbn out 0.01995f
C39 a_1469_2640# a_753_1463# 0.21614f
C40 vdd a_1753_3620# 2.44453f
C41 a_6625_603# up 0.00421f
C42 out up 0.13824f
C43 a_1401_580# a_4067_580# 0.14446f
C44 a_1313_n2628# out 0.12343f
C45 dn a_2071_580# 0.00169f
C46 a_1401_580# ibias 0
C47 vdd a_565_580# 3.48456f
C48 a_695_n1620# vbn 0.00578f
C49 a_4167_n980# a_3777_1820# 0.00179f
C50 a_2071_580# a_1401_580# 1.98149f
C51 a_753_2543# a_1753_3620# 0.01652f
C52 a_695_n1620# up 0.00636f
C53 vbn vdd 0.00247f
C54 a_695_n1620# a_1313_n2628# 0.20388f
C55 a_565_580# a_2335_n1640# 0
C56 a_753_n1708# a_753_1463# 0.09472f
C57 vdd up 3.44307f
C58 a_4067_580# ibias 0
C59 a_753_2543# a_565_580# 0.18741f
C60 vdd a_1313_n2628# 0.45815f
C61 a_6625_603# a_1469_2640# 0.02324f
C62 out a_1469_2640# 0.1253f
C63 vbn a_2335_n1640# 0.43128f
C64 a_2071_580# a_4067_580# 0.02844f
C65 vbn a_753_2543# 0
C66 a_2335_n1640# up 0
C67 a_753_2543# up 0.14029f
C68 a_1313_n2628# a_2335_n1640# 0
C69 a_3777_1820# a_6625_603# 0.01888f
C70 a_3777_1820# out 2.5115f
C71 vbp a_1469_2640# 0.1573f
C72 a_480_n2608# a_753_1463# 0.06539f
C73 a_753_2543# a_1313_n2628# 0.05437f
C74 a_695_n1620# a_1469_2640# 0.0972f
C75 dn a_565_580# 0.26254f
C76 vdd a_1469_2640# 29.1025f
C77 a_753_n1708# out 0.20254f
C78 a_1401_580# a_565_580# 0.2035f
C79 dn up 0.33601f
C80 a_2335_n1640# a_1469_2640# 0.00563f
C81 a_3777_1820# vdd 9.21901f
C82 a_1401_580# vbn 0.13855f
C83 a_753_n1708# vbp 0.0133f
C84 a_753_2543# a_1469_2640# 1.93424f
C85 dn a_1313_n2628# 0.07309f
C86 a_695_n1620# a_753_n1708# 0.49762f
C87 a_6625_603# a_7471_n2420# 1.18593f
C88 a_7471_n2420# out 1.77777f
C89 a_1401_580# up 0.30361f
C90 a_4067_580# a_565_580# 0.06732f
C91 a_480_n2608# out 0.00716f
C92 a_1401_580# a_1313_n2628# 0.28279f
C93 vdd a_753_n1708# 1.30108f
C94 vbn a_4067_580# 0.00656f
C95 a_2071_580# a_565_580# 0.05968f
C96 vbn ibias 0.7091f
C97 a_4067_580# up 0.39799f
C98 a_480_n2608# vbp 0.23771f
C99 a_753_n1708# a_2335_n1640# 0.35544f
C100 a_695_n1620# a_480_n2608# 0.17497f
C101 a_2071_580# vbn 0.04829f
C102 dn a_1469_2640# 0.02666f
C103 a_753_2543# a_753_n1708# 0.33436f
C104 vdd a_7471_n2420# 0
C105 a_1313_n2628# ibias 0.01229f
C106 a_2071_580# up 0.07237f
C107 vdd a_480_n2608# 1.62123f
C108 a_1401_580# a_1469_2640# 0.30263f
C109 a_2071_580# a_1313_n2628# 0
C110 a_1401_580# a_3777_1820# 0.00168f
C111 a_753_2543# a_480_n2608# 0.15485f
C112 out a_753_1463# 0.29998f
C113 a_4067_580# a_1469_2640# 0.01173f
C114 dn a_753_n1708# 0.00862f
C115 a_4167_n980# out 0.95806f
C116 ibias a_1469_2640# 0
C117 a_1401_580# a_753_n1708# 0.11416f
C118 a_2071_580# a_1469_2640# 0.03567f
C119 a_3777_1820# a_4067_580# 2.67878f
C120 a_695_n1620# a_753_1463# 0.08799f
C121 dn a_480_n2608# 0.03917f
C122 a_2071_580# a_3777_1820# 0
C123 vdd a_753_1463# 3.36881f
C124 a_565_580# up 3.08187f
C125 a_4167_n980# vdd 0.00327f
C126 a_753_n1708# ibias 0
C127 a_565_580# a_1313_n2628# 0.00919f
C128 a_1401_580# a_480_n2608# 0
C129 a_6625_603# out 1.70145f
C130 a_2071_580# a_753_n1708# 0.19593f
C131 a_4167_n980# a_2335_n1640# 0.00416f
C132 vbn a_1313_n2628# 0.25315f
C133 a_753_2543# a_753_1463# 0.51033f
C134 a_4067_580# a_7471_n2420# 2.52111f
C135 a_1753_3620# a_1469_2640# 4.01666f
C136 a_1313_n2628# up 0.00974f
C137 a_7471_n2420# ibias 0.71101f
C138 a_695_n1620# out 0.21613f
C139 a_480_n2608# ibias 0.00745f
C140 a_565_580# a_1469_2640# 0.09199f
C141 vdd a_6625_603# 36.5423f
C142 vdd out 0.63879f
C143 a_3777_1820# a_1753_3620# 0.00421f
C144 vbn a_1469_2640# 0.02444f
C145 dn a_753_1463# 0.14812f
C146 a_3777_1820# a_565_580# 0.67317f
C147 a_1469_2640# up 0.2804f
C148 a_2335_n1640# out 0.00526f
C149 a_753_n1708# a_1753_3620# 0.6811f
C150 vdd vbp 1.17797f
C151 a_1401_580# a_753_1463# 0.12314f
C152 a_695_n1620# vdd 0
C153 a_753_2543# out 0.00908f
C154 a_1313_n2628# a_1469_2640# 0.9287f
C155 a_4167_n980# a_1401_580# 0.29548f
C156 a_565_580# a_753_n1708# 0.05585f
C157 a_3777_1820# up 0.71497f
C158 a_695_n1620# a_2335_n1640# 0
C159 a_753_2543# vbp 0
C160 vbn a_753_n1708# 0.02997f
C161 a_695_n1620# a_753_2543# 0.08441f
C162 a_480_n2608# a_1753_3620# 0
C163 a_4167_n980# a_4067_580# 0.98849f
C164 ibias a_753_1463# 0
C165 vdd a_2335_n1640# 0.10181f
C166 a_4167_n980# ibias 0
C167 a_753_n1708# up 0.07534f
C168 a_753_2543# vdd 4.01759f
C169 dn out 0.04346f
C170 a_2071_580# a_753_1463# 0
C171 a_1313_n2628# a_753_n1708# 0.15711f
C172 a_4167_n980# a_2071_580# 0.37902f
C173 a_565_580# a_480_n2608# 0.02864f
C174 a_1401_580# out 0.19951f
C175 ibias vss 7.1976f
C176 vbn vss 5.87473f
C177 out vss 8.59502f
C178 dn vss 1.38221f
C179 up vss 2.33796f
C180 vbp vss 0.21722f
C181 vdd vss 0.17496p
C182 a_7471_n2420# vss 2.42302f
C183 a_2335_n1640# vss 0.77724f
C184 a_695_n1620# vss 0.84911f
C185 a_4167_n980# vss 1.76954f
C186 a_2071_580# vss 2.27612f
C187 a_565_580# vss 1.00391f
C188 a_1401_580# vss 3.13429f
C189 a_4067_580# vss 20.7254f
C190 a_6625_603# vss 9.85988f
C191 a_1313_n2628# vss 2.87571f
C192 a_753_1463# vss 0.20355f
C193 a_753_n1708# vss 2.69353f
C194 a_753_2543# vss 0.31554f
C195 a_1469_2640# vss 1.61924f
C196 a_480_n2608# vss 3.66854f
.ends
