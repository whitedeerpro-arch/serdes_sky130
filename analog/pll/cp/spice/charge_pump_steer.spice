* Current-steering charge pump with a unity-gain buffer (exploration candidate, not adopted).
* Same mirrors and drivers as pll_cp; each side's current flows either to out (pulse on) or to a dummy node held at
* V(out) by a follower, so the mirror drains ps / ns never leave ~V(out) and nothing is shared onto out when a switch
* closes.  The follower is the 5-transistor LVT-input OTA of serdes_ref_pbuf / serdes_ref_vbuf (B2) without the
* target DAC and enable switch: tail = 10 uA (ibias) x 5 ntail.  cdum absorbs the short steps of the dummy current
* (the static-offset window, the UP / DN mismatch).
* UP/DN active high.  Positive output current means charge delivered to the filter.
.subckt pll_cp_steer up dn out vbn vbp ibias vdd vss
+ params: wn=5 wp=20 lmirror=1 wsn=2 wsp=4 up_wn=0.5 up_wp=2 up_ln=0.88 dn_wn=1 dn_wp=2 pnf=4 nnf=1
+ win=24 lin=1 wl=96 ll=1 ntail=2 cdum=0.3p
Xupn up_b up vss vss serdes_nfet w={up_wn} l={up_ln}
Xupp up_b up vdd vdd serdes_pfet w={up_wp}
Xdn1 dn dn_b vdd vss serdes_cmos_inv wn={dn_wn} wp={dn_wp}
Xdn2 dn_b dn_on vdd vss serdes_cmos_inv wn={dn_wn} wp={dn_wp}
Xp ps vbp vdd vdd serdes_pfet w={wp} l={lmirror} nf={pnf}
* UP side: to out while UP (gate up_b low), to the dummy otherwise (gate up low)
Xps out up_b ps vdd serdes_pfet w={wsp}
Xpd dum up ps vdd serdes_pfet w={wsp}
* DN side: from out while DN (gate dn_on high), from the dummy otherwise (gate dn_b high)
Xns out dn_on ns vss serdes_nfet w={wsn}
Xnd dum dn_b ns vss serdes_nfet w={wsn}
Xn ns vbn vss vss serdes_nfet w={wn} l={lmirror} nf={nnf}
* follower: input out on the diode side, dum fed back on the output side
Xbd ibias ibias vss vss serdes_nfet w=1 l=1
Xt tail ibias vss vss serdes_nfet w={5*ntail} l=1 nf={ntail}
Xa da out tail vss serdes_nfet_lvt w={win} l={lin}
Xb dum dum tail vss serdes_nfet_lvt w={win} l={lin}
Xla da da vdd vdd serdes_pfet_lvt w={wl} l={ll}
Xlb dum da vdd vdd serdes_pfet_lvt w={wl} l={ll}
Cdum dum vss {cdum}
.ends pll_cp_steer
