* Wide-swing active-matching current-steering charge pump (candidate v4.1, isolated from v3/v4).
* Exact 8-port drop-in interface: up dn out vbn vbp ibias vdd vss (UP/DN active high).
* 100% real SKY130A devices (no B-sources, no ideal R/C).
*
* Micro-fix over pll_cp_steer_v4 (dynamic UP/DN switching-skew alignment):
*   In v4, widening PMOS steering switches Xps/Xpd (16 -> 24 um) while keeping v3 Xupn/Xupp
*   (up_wn=2, up_wp=8, up_ln=0.88) left the single-stage slowed UP inverter 60-80 ps behind
*   the two-stage DN driver (Xdn1/Xdn2), causing a 45-51 mVpp negative DN-leads-UP switching
*   glitch and -26 ps static phase offset at SF 1.65V 85C.
*   v4.1 scales Xupn/Xupp cleanly (up_wn=4.0 nf=2, up_wp=12.0 nf=6, up_ln=0.30) to match
*   the 1.5x wider Xps gate capacitance, cutting 250 MHz Vctrl glitch by 2.5x-3.8x across PVT
*   and static |dPW| by 4.6x-7.7x at slow corners while preserving <0.2% DC mismatch and the
*   wide [0.38, 1.49] V 1.65 V operating window.
.subckt pll_cp_steer_v4p1_cand up dn out vbn vbp ibias vdd vss
+ params: wn=20 wp=112 lmirror=1 wsn=8 wsp=24 up_wn=4.0 up_wp=12.0 up_ln=0.30 dn_wn=4 dn_wp=8 pnf=16 nnf=4
+ win=24 lin=1 wl=96 ll=1 ntail=2 cdum_w=12.08 csrv_w=10.0 csrv_l=14.0
* --- Pulse drivers (v4.1 skew-aligned UP inverter for 24 um Xps switch) ---
Xupn up_b up vss vss serdes_nfet w={up_wn} l={up_ln} nf=2
Xupp up_b up vdd vdd serdes_pfet w={up_wp} nf=6
Xdn1 dn dn_b vdd vss serdes_cmos_inv wn={dn_wn} wp={dn_wp}
Xdn2 dn_b dn_on vdd vss serdes_cmos_inv wn={dn_wn} wp={dn_wp}

* --- Main current mirrors & steering switches ---
Xp ps vbp_srv vdd vdd serdes_pfet w={wp} l={lmirror} nf={pnf}
* UP side: to out while UP (gate up_b low), to dum otherwise (gate up low)
Xps out up_b ps vdd serdes_pfet w={wsp} l=0.15 nf=8
Xpd dum up ps vdd serdes_pfet w={wsp} l=0.15 nf=8
* DN side: from out while DN (gate dn_on high), from dum otherwise (gate dn_b high)
Xns out dn_on ns vss serdes_nfet w={wsn} l=0.15 nf=4
Xnd dum dn_b ns vss serdes_nfet w={wsn} l=0.15 nf=4
Xn ns vbn vss vss serdes_nfet w={wn} l={lmirror} nf={nnf}

* --- 1/4-scale exact unit-finger replica branch ---
Xpr psr vbp_srv vdd vdd serdes_pfet w={wp/4} l={lmirror} nf={pnf/4}
Xpsr rep vss psr vdd serdes_pfet w={wsp/4} l=0.15 nf=2
Xnsr rep vdd nsr vss serdes_nfet w={wsn/4} l=0.15 nf=1
Xnr nsr vbn vss vss serdes_nfet w={wn/4} l={lmirror} nf=1

* --- External vbp port -> 5 uA -> 2.5 uA servo bias generator ---
Xsb_p sbn vbp vdd vdd serdes_pfet w=2 l=1 nf=1
Xsb_n sbn sbn vss vss serdes_nfet w=2 l=1 nf=1

* --- 8T rail-to-rail symmetrical servo OTA (rep=(+), out=(-)) + Miller cap Xcsrv ---
Xst stail sbn vss vss serdes_nfet w=1 l=1 nf=1
Xsa sda rep stail vss serdes_nfet_lvt w=2 l=1 nf=2
Xsb sdb out stail vss serdes_nfet_lvt w=2 l=1 nf=2
Xsla sda sda vdd vdd serdes_pfet_lvt w=4 l=1 nf=2
Xslb sdb sdb vdd vdd serdes_pfet_lvt w=4 l=1 nf=2
Xslc vbp_srv sda vdd vdd serdes_pfet_lvt w=4 l=1 nf=2
Xsld snm sdb vdd vdd serdes_pfet_lvt w=4 l=1 nf=2
Xsn1 snm snm vss vss serdes_nfet w=4 l=1 nf=2
Xsn2 vbp_srv snm vss vss serdes_nfet w=4 l=1 nf=2
Xcsrv rep vbp_srv sky130_fd_pr__cap_mim_m3_1 w={csrv_w} l={csrv_l}

* --- Unity-gain dummy follower OTA + real PDK MIM Cdum (0.3 pF) ---
Xbd ibias ibias vss vss serdes_nfet w=1 l=1
Xt tail ibias vss vss serdes_nfet w={5*ntail} l=1 nf={ntail}
Xa da out tail vss serdes_nfet_lvt w={win} l={lin} nf=4
Xb dum dum tail vss serdes_nfet_lvt w={win} l={lin} nf=4
Xla da da vdd vdd serdes_pfet_lvt w={wl} l={ll} nf=16
Xlb dum da vdd vdd serdes_pfet_lvt w={wl} l={ll} nf=16
Xcdum dum vss sky130_fd_pr__cap_mim_m3_1 w={cdum_w} l={cdum_w}
.ends pll_cp_steer_v4p1_cand
