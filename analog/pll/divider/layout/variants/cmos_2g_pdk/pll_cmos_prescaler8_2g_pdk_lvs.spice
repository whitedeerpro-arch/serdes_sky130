* NGSPICE file created from pll_cmos_prescaler8_2g_pdk.ext - technology: sky130A

.subckt pll_cmos_prescaler8_2g_pdk clkp clkn q2p q2n q4p q4n q8p q8n vdd vss
X0 vdd a_8750_238# a_10114_792# vdd sky130_fd_pr__pfet_01v8 ad=0.558 pd=4.22 as=0.297 ps=2.13 w=1.8 l=0.15
X1 a_8380_n1152# a_8294_n774# vdd vdd sky130_fd_pr__pfet_01v8 ad=0.297 pd=2.13 as=0.558 ps=4.22 w=1.8 l=0.15
X2 vdd a_258_n774# a_2988_792# vdd sky130_fd_pr__pfet_01v8 ad=0.217 pd=2.02 as=0.1155 ps=1.03 w=0.7 l=0.15
X3 a_5324_n388# a_4732_n1252# vss vss sky130_fd_pr__nfet_01v8 ad=0.174 pd=1.78 as=0.174 ps=1.78 w=0.6 l=0.15
X4 vdd a_258_406# a_344_792# vdd sky130_fd_pr__pfet_01v8 ad=0.961 pd=6.82 as=0.5115 ps=3.43 w=3.1 l=0.15
X5 a_10114_792# a_8750_238# vdd vdd sky130_fd_pr__pfet_01v8 ad=0.297 pd=2.13 as=0.558 ps=4.22 w=1.8 l=0.15
X6 a_344_792# a_258_406# vdd vdd sky130_fd_pr__pfet_01v8 ad=0.5115 pd=3.43 as=0.961 ps=6.82 w=3.1 l=0.15
X7 a_8750_238# a_8750_n1152# vdd vdd sky130_fd_pr__pfet_01v8 ad=0.377 pd=3.18 as=0.377 ps=3.18 w=1.3 l=0.15
X8 vss a_258_406# q2n vss sky130_fd_pr__nfet_01v8 ad=0.465 pd=3.62 as=0.2475 ps=1.83 w=1.5 l=0.15
X9 vdd a_4276_n774# a_4362_n1252# vdd sky130_fd_pr__pfet_01v8 ad=0.713 pd=5.22 as=0.3795 ps=2.63 w=2.3 l=0.15
X10 a_8294_406# a_8294_n774# a_11076_n388# vss sky130_fd_pr__nfet_01v8 ad=0.174 pd=1.78 as=0.174 ps=1.78 w=0.6 l=0.15
X11 a_2078_n1412# clkp a_258_406# vdd sky130_fd_pr__pfet_01v8 ad=0.961 pd=6.82 as=0.5115 ps=3.43 w=3.1 l=0.15
X12 a_4732_n1252# q2n a_4362_n1252# vdd sky130_fd_pr__pfet_01v8 ad=0.3795 pd=2.63 as=0.713 ps=5.22 w=2.3 l=0.15
X13 a_4362_208# a_4276_406# vss vss sky130_fd_pr__nfet_01v8 ad=0.1485 pd=1.23 as=0.279 ps=2.42 w=0.9 l=0.15
X14 a_4362_n1252# q2n a_4732_n1252# vdd sky130_fd_pr__pfet_01v8 ad=0.713 pd=5.22 as=0.3795 ps=2.63 w=2.3 l=0.15
X15 vdd a_4732_n1252# a_6096_n1252# vdd sky130_fd_pr__pfet_01v8 ad=0.713 pd=5.22 as=0.3795 ps=2.63 w=2.3 l=0.15
X16 vss a_4276_406# a_4362_208# vss sky130_fd_pr__nfet_01v8 ad=0.279 pd=2.42 as=0.1485 ps=1.23 w=0.9 l=0.15
X17 a_4732_208# q2n a_4362_792# vdd sky130_fd_pr__pfet_01v8 ad=0.3795 pd=2.63 as=0.713 ps=5.22 w=2.3 l=0.15
X18 a_11024_792# a_8294_406# a_8294_n774# vdd sky130_fd_pr__pfet_01v8 ad=0.2015 pd=1.92 as=0.10725 ps=0.98 w=0.65 l=0.15
X19 q2n a_258_406# vdd vdd sky130_fd_pr__pfet_01v8 ad=0.3795 pd=2.63 as=0.713 ps=5.22 w=2.3 l=0.15
X20 a_8294_n774# a_8294_406# a_11024_792# vdd sky130_fd_pr__pfet_01v8 ad=0.10725 pd=0.98 as=0.2015 ps=1.92 w=0.65 l=0.15
X21 a_7006_792# a_4276_n774# vdd vdd sky130_fd_pr__pfet_01v8 ad=0.10725 pd=0.98 as=0.2015 ps=1.92 w=0.65 l=0.15
X22 vdd a_4276_n774# a_7006_792# vdd sky130_fd_pr__pfet_01v8 ad=0.2015 pd=1.92 as=0.10725 ps=0.98 w=0.65 l=0.15
X23 q8n a_8294_406# vdd vdd sky130_fd_pr__pfet_01v8 ad=0.3465 pd=2.43 as=0.651 ps=4.82 w=2.1 l=0.15
X24 q2p a_258_n774# vss vss sky130_fd_pr__nfet_01v8 ad=0.2475 pd=1.83 as=0.465 ps=3.62 w=1.5 l=0.15
X25 a_10114_238# q4n a_8294_n774# vss sky130_fd_pr__nfet_01v8 ad=0.2325 pd=2.12 as=0.12375 ps=1.08 w=0.75 l=0.15
X26 a_8294_n774# q4n a_10114_238# vss sky130_fd_pr__nfet_01v8 ad=0.12375 pd=1.08 as=0.2325 ps=2.12 w=0.75 l=0.15
X27 a_6096_n388# q2n a_4276_406# vss sky130_fd_pr__nfet_01v8 ad=0.279 pd=2.42 as=0.1485 ps=1.23 w=0.9 l=0.15
X28 a_8750_238# q4n a_8380_792# vdd sky130_fd_pr__pfet_01v8 ad=0.297 pd=2.13 as=0.558 ps=4.22 w=1.8 l=0.15
X29 vss a_8294_n774# q8p vss sky130_fd_pr__nfet_01v8 ad=0.31 pd=2.62 as=0.165 ps=1.33 w=1 l=0.15
X30 q8p a_8294_n774# vss vss sky130_fd_pr__nfet_01v8 ad=0.165 pd=1.33 as=0.31 ps=2.62 w=1 l=0.15
X31 a_258_n774# a_258_406# vdd vdd sky130_fd_pr__pfet_01v8 ad=0.377 pd=3.18 as=0.377 ps=3.18 w=1.3 l=0.15
X32 a_2078_792# clkp a_258_n774# vdd sky130_fd_pr__pfet_01v8 ad=0.961 pd=6.82 as=0.5115 ps=3.43 w=3.1 l=0.15
X33 a_8380_792# q4n a_8750_238# vdd sky130_fd_pr__pfet_01v8 ad=0.558 pd=4.22 as=0.297 ps=2.13 w=1.8 l=0.15
X34 vdd a_8294_406# q8n vdd sky130_fd_pr__pfet_01v8 ad=0.651 pd=4.82 as=0.3465 ps=2.43 w=2.1 l=0.15
X35 a_258_n774# clkp a_2078_792# vdd sky130_fd_pr__pfet_01v8 ad=0.5115 pd=3.43 as=0.961 ps=6.82 w=3.1 l=0.15
X36 q2p a_258_n774# vdd vdd sky130_fd_pr__pfet_01v8 ad=0.3795 pd=2.63 as=0.713 ps=5.22 w=2.3 l=0.15
X37 vss a_4732_n1252# a_6096_n388# vss sky130_fd_pr__nfet_01v8 ad=0.279 pd=2.42 as=0.1485 ps=1.23 w=0.9 l=0.15
X38 vdd a_8294_n774# a_11024_792# vdd sky130_fd_pr__pfet_01v8 ad=0.2015 pd=1.92 as=0.10725 ps=0.98 w=0.65 l=0.15
X39 a_4732_n1252# a_4732_208# a_5324_n388# vss sky130_fd_pr__nfet_01v8 ad=0.174 pd=1.78 as=0.174 ps=1.78 w=0.6 l=0.15
X40 a_4732_n1252# a_4732_208# vss vss sky130_fd_pr__nfet_01v8 ad=0.174 pd=1.78 as=0.174 ps=1.78 w=0.6 l=0.15
X41 a_258_406# a_258_n774# vss vss sky130_fd_pr__nfet_01v8 ad=0.174 pd=1.78 as=0.174 ps=1.78 w=0.6 l=0.15
X42 a_8380_238# a_8294_406# vss vss sky130_fd_pr__nfet_01v8 ad=0.12375 pd=1.08 as=0.2325 ps=2.12 w=0.75 l=0.15
X43 vdd a_258_n774# q2p vdd sky130_fd_pr__pfet_01v8 ad=0.713 pd=5.22 as=0.3795 ps=2.63 w=2.3 l=0.15
X44 a_11024_792# a_8294_n774# vdd vdd sky130_fd_pr__pfet_01v8 ad=0.10725 pd=0.98 as=0.2015 ps=1.92 w=0.65 l=0.15
X45 vss a_714_148# a_2078_148# vss sky130_fd_pr__nfet_01v8 ad=0.372 pd=3.02 as=0.198 ps=1.53 w=1.2 l=0.15
X46 vss a_8294_406# a_8380_238# vss sky130_fd_pr__nfet_01v8 ad=0.2325 pd=2.12 as=0.12375 ps=1.08 w=0.75 l=0.15
X47 a_344_792# clkn a_714_148# vdd sky130_fd_pr__pfet_01v8 ad=0.961 pd=6.82 as=0.5115 ps=3.43 w=3.1 l=0.15
X48 a_714_148# clkn a_344_792# vdd sky130_fd_pr__pfet_01v8 ad=0.5115 pd=3.43 as=0.961 ps=6.82 w=3.1 l=0.15
X49 a_2078_148# a_714_148# vss vss sky130_fd_pr__nfet_01v8 ad=0.198 pd=1.53 as=0.372 ps=3.02 w=1.2 l=0.15
X50 a_4276_406# q2p a_6096_n1252# vdd sky130_fd_pr__pfet_01v8 ad=0.3795 pd=2.63 as=0.713 ps=5.22 w=2.3 l=0.15
X51 a_344_n1412# a_258_n774# vdd vdd sky130_fd_pr__pfet_01v8 ad=0.5115 pd=3.43 as=0.961 ps=6.82 w=3.1 l=0.15
X52 a_8294_406# a_8294_n774# vdd vdd sky130_fd_pr__pfet_01v8 ad=0.377 pd=3.18 as=0.377 ps=3.18 w=1.3 l=0.15
X53 a_714_n1412# a_714_148# vdd vdd sky130_fd_pr__pfet_01v8 ad=0.377 pd=3.18 as=0.377 ps=3.18 w=1.3 l=0.15
X54 a_3040_n388# a_258_406# vss vss sky130_fd_pr__nfet_01v8 ad=0.203 pd=1.98 as=0.203 ps=1.98 w=0.7 l=0.15
X55 vdd a_8294_n774# a_8380_n1152# vdd sky130_fd_pr__pfet_01v8 ad=0.558 pd=4.22 as=0.297 ps=2.13 w=1.8 l=0.15
X56 a_8750_n1152# q4p a_8380_n388# vss sky130_fd_pr__nfet_01v8 ad=0.12375 pd=1.08 as=0.2325 ps=2.12 w=0.75 l=0.15
X57 a_714_n1412# clkn a_344_n1412# vdd sky130_fd_pr__pfet_01v8 ad=0.5115 pd=3.43 as=0.961 ps=6.82 w=3.1 l=0.15
X58 a_8750_n1152# q4n a_8380_n1152# vdd sky130_fd_pr__pfet_01v8 ad=0.297 pd=2.13 as=0.558 ps=4.22 w=1.8 l=0.15
X59 a_4732_n1252# a_4732_208# vdd vdd sky130_fd_pr__pfet_01v8 ad=0.377 pd=3.18 as=0.377 ps=3.18 w=1.3 l=0.15
X60 a_258_406# a_258_n774# a_3040_n388# vss sky130_fd_pr__nfet_01v8 ad=0.203 pd=1.98 as=0.203 ps=1.98 w=0.7 l=0.15
X61 vdd a_714_148# a_1254_792# vdd sky130_fd_pr__pfet_01v8 ad=0.217 pd=2.02 as=0.1155 ps=1.03 w=0.7 l=0.15
X62 a_4276_n774# a_4276_406# vss vss sky130_fd_pr__nfet_01v8 ad=0.174 pd=1.78 as=0.174 ps=1.78 w=0.6 l=0.15
X63 a_8750_n1152# a_8750_238# vdd vdd sky130_fd_pr__pfet_01v8 ad=0.377 pd=3.18 as=0.377 ps=3.18 w=1.3 l=0.15
X64 a_1254_792# a_714_148# vdd vdd sky130_fd_pr__pfet_01v8 ad=0.1155 pd=1.03 as=0.217 ps=2.02 w=0.7 l=0.15
X65 a_714_148# a_714_n1412# vss vss sky130_fd_pr__nfet_01v8 ad=0.174 pd=1.78 as=0.174 ps=1.78 w=0.6 l=0.15
X66 a_4362_208# q2p a_4732_208# vss sky130_fd_pr__nfet_01v8 ad=0.279 pd=2.42 as=0.1485 ps=1.23 w=0.9 l=0.15
X67 vss a_4276_n774# a_4362_n388# vss sky130_fd_pr__nfet_01v8 ad=0.279 pd=2.42 as=0.1485 ps=1.23 w=0.9 l=0.15
X68 vss a_4732_208# a_6096_208# vss sky130_fd_pr__nfet_01v8 ad=0.279 pd=2.42 as=0.1485 ps=1.23 w=0.9 l=0.15
X69 a_6096_208# a_4732_208# vss vss sky130_fd_pr__nfet_01v8 ad=0.1485 pd=1.23 as=0.279 ps=2.42 w=0.9 l=0.15
X70 a_8380_n388# a_8294_n774# vss vss sky130_fd_pr__nfet_01v8 ad=0.12375 pd=1.08 as=0.2325 ps=2.12 w=0.75 l=0.15
X71 a_4276_406# q2n a_6096_n388# vss sky130_fd_pr__nfet_01v8 ad=0.1485 pd=1.23 as=0.279 ps=2.42 w=0.9 l=0.15
X72 a_6096_792# q2p a_4276_n774# vdd sky130_fd_pr__pfet_01v8 ad=0.713 pd=5.22 as=0.3795 ps=2.63 w=2.3 l=0.15
X73 vdd a_258_n774# a_344_n1412# vdd sky130_fd_pr__pfet_01v8 ad=0.961 pd=6.82 as=0.5115 ps=3.43 w=3.1 l=0.15
X74 a_6096_n1252# q2p a_4276_406# vdd sky130_fd_pr__pfet_01v8 ad=0.713 pd=5.22 as=0.3795 ps=2.63 w=2.3 l=0.15
X75 a_4276_n774# q2p a_6096_792# vdd sky130_fd_pr__pfet_01v8 ad=0.3795 pd=2.63 as=0.713 ps=5.22 w=2.3 l=0.15
X76 a_1254_792# a_714_n1412# a_714_148# vdd sky130_fd_pr__pfet_01v8 ad=0.217 pd=2.02 as=0.1155 ps=1.03 w=0.7 l=0.15
X77 a_1306_n388# a_714_n1412# vss vss sky130_fd_pr__nfet_01v8 ad=0.203 pd=1.98 as=0.203 ps=1.98 w=0.7 l=0.15
X78 vdd a_258_406# q2n vdd sky130_fd_pr__pfet_01v8 ad=0.713 pd=5.22 as=0.3795 ps=2.63 w=2.3 l=0.15
X79 a_344_n1412# clkn a_714_n1412# vdd sky130_fd_pr__pfet_01v8 ad=0.961 pd=6.82 as=0.5115 ps=3.43 w=3.1 l=0.15
X80 a_714_148# a_714_n1412# a_1254_792# vdd sky130_fd_pr__pfet_01v8 ad=0.1155 pd=1.03 as=0.217 ps=2.02 w=0.7 l=0.15
X81 vdd a_4276_n774# q4p vdd sky130_fd_pr__pfet_01v8 ad=0.651 pd=4.82 as=0.3465 ps=2.43 w=2.1 l=0.15
X82 vss a_4276_n774# q4p vss sky130_fd_pr__nfet_01v8 ad=0.341 pd=2.82 as=0.1815 ps=1.43 w=1.1 l=0.15
X83 vss a_258_n774# a_344_n388# vss sky130_fd_pr__nfet_01v8 ad=0.372 pd=3.02 as=0.198 ps=1.53 w=1.2 l=0.15
X84 a_10114_n1152# a_8750_n1152# vdd vdd sky130_fd_pr__pfet_01v8 ad=0.297 pd=2.13 as=0.558 ps=4.22 w=1.8 l=0.15
X85 q2n a_258_406# vss vss sky130_fd_pr__nfet_01v8 ad=0.2475 pd=1.83 as=0.465 ps=3.62 w=1.5 l=0.15
X86 a_258_406# a_258_n774# vdd vdd sky130_fd_pr__pfet_01v8 ad=0.377 pd=3.18 as=0.377 ps=3.18 w=1.3 l=0.15
X87 a_6096_n388# a_4732_n1252# vss vss sky130_fd_pr__nfet_01v8 ad=0.1485 pd=1.23 as=0.279 ps=2.42 w=0.9 l=0.15
X88 a_4362_792# a_4276_406# vdd vdd sky130_fd_pr__pfet_01v8 ad=0.3795 pd=2.63 as=0.713 ps=5.22 w=2.3 l=0.15
X89 vss a_258_n774# q2p vss sky130_fd_pr__nfet_01v8 ad=0.465 pd=3.62 as=0.2475 ps=1.83 w=1.5 l=0.15
X90 vdd a_4276_406# a_4362_792# vdd sky130_fd_pr__pfet_01v8 ad=0.713 pd=5.22 as=0.3795 ps=2.63 w=2.3 l=0.15
X91 vdd a_4732_208# a_5272_792# vdd sky130_fd_pr__pfet_01v8 ad=0.2015 pd=1.92 as=0.10725 ps=0.98 w=0.65 l=0.15
X92 a_9342_n388# a_8750_n1152# vss vss sky130_fd_pr__nfet_01v8 ad=0.174 pd=1.78 as=0.174 ps=1.78 w=0.6 l=0.15
X93 a_5272_792# a_4732_208# vdd vdd sky130_fd_pr__pfet_01v8 ad=0.10725 pd=0.98 as=0.2015 ps=1.92 w=0.65 l=0.15
X94 a_4732_208# a_4732_n1252# vss vss sky130_fd_pr__nfet_01v8 ad=0.174 pd=1.78 as=0.174 ps=1.78 w=0.6 l=0.15
X95 a_2078_n1412# a_714_n1412# vdd vdd sky130_fd_pr__pfet_01v8 ad=0.5115 pd=3.43 as=0.961 ps=6.82 w=3.1 l=0.15
X96 a_8294_n774# a_8294_406# vss vss sky130_fd_pr__nfet_01v8 ad=0.174 pd=1.78 as=0.174 ps=1.78 w=0.6 l=0.15
X97 a_10114_792# q4p a_8294_n774# vdd sky130_fd_pr__pfet_01v8 ad=0.558 pd=4.22 as=0.297 ps=2.13 w=1.8 l=0.15
X98 a_10114_n388# q4n a_8294_406# vss sky130_fd_pr__nfet_01v8 ad=0.2325 pd=2.12 as=0.12375 ps=1.08 w=0.75 l=0.15
X99 vss a_4276_406# q4n vss sky130_fd_pr__nfet_01v8 ad=0.341 pd=2.82 as=0.1815 ps=1.43 w=1.1 l=0.15
X100 a_4362_n388# q2p a_4732_n1252# vss sky130_fd_pr__nfet_01v8 ad=0.279 pd=2.42 as=0.1485 ps=1.23 w=0.9 l=0.15
X101 a_8294_n774# q4p a_10114_792# vdd sky130_fd_pr__pfet_01v8 ad=0.297 pd=2.13 as=0.558 ps=4.22 w=1.8 l=0.15
X102 a_8750_n1152# a_8750_238# a_9342_n388# vss sky130_fd_pr__nfet_01v8 ad=0.174 pd=1.78 as=0.174 ps=1.78 w=0.6 l=0.15
X103 a_4276_406# a_4276_n774# vss vss sky130_fd_pr__nfet_01v8 ad=0.174 pd=1.78 as=0.174 ps=1.78 w=0.6 l=0.15
X104 vdd a_8750_n1152# a_10114_n1152# vdd sky130_fd_pr__pfet_01v8 ad=0.558 pd=4.22 as=0.297 ps=2.13 w=1.8 l=0.15
X105 vss a_8750_238# a_10114_238# vss sky130_fd_pr__nfet_01v8 ad=0.2325 pd=2.12 as=0.12375 ps=1.08 w=0.75 l=0.15
X106 a_5272_792# a_4732_n1252# a_4732_208# vdd sky130_fd_pr__pfet_01v8 ad=0.2015 pd=1.92 as=0.10725 ps=0.98 w=0.65 l=0.15
X107 a_4732_208# q2p a_4362_208# vss sky130_fd_pr__nfet_01v8 ad=0.1485 pd=1.23 as=0.279 ps=2.42 w=0.9 l=0.15
X108 a_10114_238# a_8750_238# vss vss sky130_fd_pr__nfet_01v8 ad=0.12375 pd=1.08 as=0.2325 ps=2.12 w=0.75 l=0.15
X109 a_4732_208# a_4732_n1252# a_5272_792# vdd sky130_fd_pr__pfet_01v8 ad=0.10725 pd=0.98 as=0.2015 ps=1.92 w=0.65 l=0.15
X110 vss a_258_406# a_344_148# vss sky130_fd_pr__nfet_01v8 ad=0.372 pd=3.02 as=0.198 ps=1.53 w=1.2 l=0.15
X111 a_7058_n388# a_4276_406# vss vss sky130_fd_pr__nfet_01v8 ad=0.174 pd=1.78 as=0.174 ps=1.78 w=0.6 l=0.15
X112 a_344_148# a_258_406# vss vss sky130_fd_pr__nfet_01v8 ad=0.198 pd=1.53 as=0.372 ps=3.02 w=1.2 l=0.15
X113 vss a_8750_n1152# a_10114_n388# vss sky130_fd_pr__nfet_01v8 ad=0.2325 pd=2.12 as=0.12375 ps=1.08 w=0.75 l=0.15
X114 a_344_n388# clkp a_714_n1412# vss sky130_fd_pr__nfet_01v8 ad=0.372 pd=3.02 as=0.198 ps=1.53 w=1.2 l=0.15
X115 vdd a_714_n1412# a_2078_n1412# vdd sky130_fd_pr__pfet_01v8 ad=0.961 pd=6.82 as=0.5115 ps=3.43 w=3.1 l=0.15
X116 a_2078_n388# clkn a_258_406# vss sky130_fd_pr__nfet_01v8 ad=0.372 pd=3.02 as=0.198 ps=1.53 w=1.2 l=0.15
X117 a_4362_n1252# a_4276_n774# vdd vdd sky130_fd_pr__pfet_01v8 ad=0.3795 pd=2.63 as=0.713 ps=5.22 w=2.3 l=0.15
X118 a_4276_406# a_4276_n774# a_7058_n388# vss sky130_fd_pr__nfet_01v8 ad=0.174 pd=1.78 as=0.174 ps=1.78 w=0.6 l=0.15
X119 a_8380_792# a_8294_406# vdd vdd sky130_fd_pr__pfet_01v8 ad=0.297 pd=2.13 as=0.558 ps=4.22 w=1.8 l=0.15
X120 vss a_8294_406# q8n vss sky130_fd_pr__nfet_01v8 ad=0.31 pd=2.62 as=0.165 ps=1.33 w=1 l=0.15
X121 a_4276_n774# a_4276_406# vdd vdd sky130_fd_pr__pfet_01v8 ad=0.377 pd=3.18 as=0.377 ps=3.18 w=1.3 l=0.15
X122 a_8294_406# a_8294_n774# vss vss sky130_fd_pr__nfet_01v8 ad=0.174 pd=1.78 as=0.174 ps=1.78 w=0.6 l=0.15
X123 a_344_n388# a_258_n774# vss vss sky130_fd_pr__nfet_01v8 ad=0.198 pd=1.53 as=0.372 ps=3.02 w=1.2 l=0.15
X124 q4n a_4276_406# vdd vdd sky130_fd_pr__pfet_01v8 ad=0.3465 pd=2.43 as=0.651 ps=4.82 w=2.1 l=0.15
X125 a_714_148# a_714_n1412# vdd vdd sky130_fd_pr__pfet_01v8 ad=0.377 pd=3.18 as=0.377 ps=3.18 w=1.3 l=0.15
X126 vdd a_714_148# a_2078_792# vdd sky130_fd_pr__pfet_01v8 ad=0.961 pd=6.82 as=0.5115 ps=3.43 w=3.1 l=0.15
X127 q4p a_4276_n774# vdd vdd sky130_fd_pr__pfet_01v8 ad=0.3465 pd=2.43 as=0.651 ps=4.82 w=2.1 l=0.15
X128 vdd a_8294_406# a_8380_792# vdd sky130_fd_pr__pfet_01v8 ad=0.558 pd=4.22 as=0.297 ps=2.13 w=1.8 l=0.15
X129 q4p a_4276_n774# vss vss sky130_fd_pr__nfet_01v8 ad=0.1815 pd=1.43 as=0.341 ps=2.82 w=1.1 l=0.15
X130 a_2078_792# a_714_148# vdd vdd sky130_fd_pr__pfet_01v8 ad=0.5115 pd=3.43 as=0.961 ps=6.82 w=3.1 l=0.15
X131 vdd a_4276_406# q4n vdd sky130_fd_pr__pfet_01v8 ad=0.651 pd=4.82 as=0.3465 ps=2.43 w=2.1 l=0.15
X132 a_8750_238# a_8750_n1152# vss vss sky130_fd_pr__nfet_01v8 ad=0.174 pd=1.78 as=0.174 ps=1.78 w=0.6 l=0.15
X133 a_8380_n1152# q4n a_8750_n1152# vdd sky130_fd_pr__pfet_01v8 ad=0.558 pd=4.22 as=0.297 ps=2.13 w=1.8 l=0.15
X134 vss a_714_n1412# a_2078_n388# vss sky130_fd_pr__nfet_01v8 ad=0.372 pd=3.02 as=0.198 ps=1.53 w=1.2 l=0.15
X135 a_714_n1412# a_714_148# a_1306_n388# vss sky130_fd_pr__nfet_01v8 ad=0.203 pd=1.98 as=0.203 ps=1.98 w=0.7 l=0.15
X136 a_714_n1412# a_714_148# vss vss sky130_fd_pr__nfet_01v8 ad=0.174 pd=1.78 as=0.174 ps=1.78 w=0.6 l=0.15
X137 a_258_n774# a_258_406# a_2988_792# vdd sky130_fd_pr__pfet_01v8 ad=0.1155 pd=1.03 as=0.217 ps=2.02 w=0.7 l=0.15
X138 a_8750_238# a_8750_n1152# a_9290_792# vdd sky130_fd_pr__pfet_01v8 ad=0.10725 pd=0.98 as=0.2015 ps=1.92 w=0.65 l=0.15
X139 a_8294_406# q4n a_10114_n388# vss sky130_fd_pr__nfet_01v8 ad=0.12375 pd=1.08 as=0.2325 ps=2.12 w=0.75 l=0.15
X140 q4n a_4276_406# vss vss sky130_fd_pr__nfet_01v8 ad=0.1815 pd=1.43 as=0.341 ps=2.82 w=1.1 l=0.15
X141 a_4732_n1252# q2p a_4362_n388# vss sky130_fd_pr__nfet_01v8 ad=0.1485 pd=1.23 as=0.279 ps=2.42 w=0.9 l=0.15
X142 a_2988_792# a_258_406# a_258_n774# vdd sky130_fd_pr__pfet_01v8 ad=0.217 pd=2.02 as=0.1155 ps=1.03 w=0.7 l=0.15
X143 a_9290_792# a_8750_n1152# a_8750_238# vdd sky130_fd_pr__pfet_01v8 ad=0.2015 pd=1.92 as=0.10725 ps=0.98 w=0.65 l=0.15
X144 a_8750_n1152# a_8750_238# vss vss sky130_fd_pr__nfet_01v8 ad=0.174 pd=1.78 as=0.174 ps=1.78 w=0.6 l=0.15
X145 a_4362_792# q2n a_4732_208# vdd sky130_fd_pr__pfet_01v8 ad=0.713 pd=5.22 as=0.3795 ps=2.63 w=2.3 l=0.15
X146 a_4732_208# a_4732_n1252# vdd vdd sky130_fd_pr__pfet_01v8 ad=0.377 pd=3.18 as=0.377 ps=3.18 w=1.3 l=0.15
X147 vdd a_4732_208# a_6096_792# vdd sky130_fd_pr__pfet_01v8 ad=0.713 pd=5.22 as=0.3795 ps=2.63 w=2.3 l=0.15
X148 a_8294_n774# a_8294_406# vdd vdd sky130_fd_pr__pfet_01v8 ad=0.377 pd=3.18 as=0.377 ps=3.18 w=1.3 l=0.15
X149 vdd a_8294_n774# q8p vdd sky130_fd_pr__pfet_01v8 ad=0.651 pd=4.82 as=0.3465 ps=2.43 w=2.1 l=0.15
X150 a_8294_406# q4p a_10114_n1152# vdd sky130_fd_pr__pfet_01v8 ad=0.297 pd=2.13 as=0.558 ps=4.22 w=1.8 l=0.15
X151 a_10114_n388# a_8750_n1152# vss vss sky130_fd_pr__nfet_01v8 ad=0.12375 pd=1.08 as=0.2325 ps=2.12 w=0.75 l=0.15
X152 a_8750_238# q4p a_8380_238# vss sky130_fd_pr__nfet_01v8 ad=0.12375 pd=1.08 as=0.2325 ps=2.12 w=0.75 l=0.15
X153 a_4276_406# a_4276_n774# vdd vdd sky130_fd_pr__pfet_01v8 ad=0.377 pd=3.18 as=0.377 ps=3.18 w=1.3 l=0.15
X154 a_8380_n388# q4p a_8750_n1152# vss sky130_fd_pr__nfet_01v8 ad=0.2325 pd=2.12 as=0.12375 ps=1.08 w=0.75 l=0.15
X155 a_714_n1412# clkp a_344_n388# vss sky130_fd_pr__nfet_01v8 ad=0.198 pd=1.53 as=0.372 ps=3.02 w=1.2 l=0.15
X156 a_6096_792# a_4732_208# vdd vdd sky130_fd_pr__pfet_01v8 ad=0.3795 pd=2.63 as=0.713 ps=5.22 w=2.3 l=0.15
X157 q8p a_8294_n774# vdd vdd sky130_fd_pr__pfet_01v8 ad=0.3465 pd=2.43 as=0.651 ps=4.82 w=2.1 l=0.15
X158 a_4362_n388# a_4276_n774# vss vss sky130_fd_pr__nfet_01v8 ad=0.1485 pd=1.23 as=0.279 ps=2.42 w=0.9 l=0.15
X159 a_258_406# clkn a_2078_n388# vss sky130_fd_pr__nfet_01v8 ad=0.198 pd=1.53 as=0.372 ps=3.02 w=1.2 l=0.15
X160 a_8380_238# q4p a_8750_238# vss sky130_fd_pr__nfet_01v8 ad=0.2325 pd=2.12 as=0.12375 ps=1.08 w=0.75 l=0.15
X161 a_2078_148# clkn a_258_n774# vss sky130_fd_pr__nfet_01v8 ad=0.372 pd=3.02 as=0.198 ps=1.53 w=1.2 l=0.15
X162 a_258_n774# clkn a_2078_148# vss sky130_fd_pr__nfet_01v8 ad=0.198 pd=1.53 as=0.372 ps=3.02 w=1.2 l=0.15
X163 q8n a_8294_406# vss vss sky130_fd_pr__nfet_01v8 ad=0.165 pd=1.33 as=0.31 ps=2.62 w=1 l=0.15
X164 a_258_406# clkp a_2078_n1412# vdd sky130_fd_pr__pfet_01v8 ad=0.5115 pd=3.43 as=0.961 ps=6.82 w=3.1 l=0.15
X165 a_344_148# clkp a_714_148# vss sky130_fd_pr__nfet_01v8 ad=0.372 pd=3.02 as=0.198 ps=1.53 w=1.2 l=0.15
X166 a_714_148# clkp a_344_148# vss sky130_fd_pr__nfet_01v8 ad=0.198 pd=1.53 as=0.372 ps=3.02 w=1.2 l=0.15
X167 vss a_8294_n774# a_8380_n388# vss sky130_fd_pr__nfet_01v8 ad=0.2325 pd=2.12 as=0.12375 ps=1.08 w=0.75 l=0.15
X168 a_2078_n388# a_714_n1412# vss vss sky130_fd_pr__nfet_01v8 ad=0.198 pd=1.53 as=0.372 ps=3.02 w=1.2 l=0.15
X169 a_258_n774# a_258_406# vss vss sky130_fd_pr__nfet_01v8 ad=0.174 pd=1.78 as=0.174 ps=1.78 w=0.6 l=0.15
X170 vdd a_8750_238# a_9290_792# vdd sky130_fd_pr__pfet_01v8 ad=0.2015 pd=1.92 as=0.10725 ps=0.98 w=0.65 l=0.15
X171 a_10114_n1152# q4p a_8294_406# vdd sky130_fd_pr__pfet_01v8 ad=0.558 pd=4.22 as=0.297 ps=2.13 w=1.8 l=0.15
X172 a_2988_792# a_258_n774# vdd vdd sky130_fd_pr__pfet_01v8 ad=0.1155 pd=1.03 as=0.217 ps=2.02 w=0.7 l=0.15
X173 a_9290_792# a_8750_238# vdd vdd sky130_fd_pr__pfet_01v8 ad=0.10725 pd=0.98 as=0.2015 ps=1.92 w=0.65 l=0.15
X174 a_6096_208# q2n a_4276_n774# vss sky130_fd_pr__nfet_01v8 ad=0.279 pd=2.42 as=0.1485 ps=1.23 w=0.9 l=0.15
X175 a_6096_n1252# a_4732_n1252# vdd vdd sky130_fd_pr__pfet_01v8 ad=0.3795 pd=2.63 as=0.713 ps=5.22 w=2.3 l=0.15
X176 a_7006_792# a_4276_406# a_4276_n774# vdd sky130_fd_pr__pfet_01v8 ad=0.2015 pd=1.92 as=0.10725 ps=0.98 w=0.65 l=0.15
X177 a_4276_n774# q2n a_6096_208# vss sky130_fd_pr__nfet_01v8 ad=0.1485 pd=1.23 as=0.279 ps=2.42 w=0.9 l=0.15
X178 a_4276_n774# a_4276_406# a_7006_792# vdd sky130_fd_pr__pfet_01v8 ad=0.10725 pd=0.98 as=0.2015 ps=1.92 w=0.65 l=0.15
X179 a_11076_n388# a_8294_406# vss vss sky130_fd_pr__nfet_01v8 ad=0.174 pd=1.78 as=0.174 ps=1.78 w=0.6 l=0.15
.ends
