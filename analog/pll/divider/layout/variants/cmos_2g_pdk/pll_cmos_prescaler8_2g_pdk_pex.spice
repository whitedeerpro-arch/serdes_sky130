* NGSPICE file created from pll_cmos_prescaler8_2g_pdk.ext - technology: sky130A

.subckt pll_cmos_prescaler8_2g_pdk clkp clkn q2p q2n q4p q4n q8p q8n vdd vss
X0 vdd a_8750_238# a_10114_792# vdd sky130_fd_pr__pfet_01v8 ad=0.558 pd=4.22 as=0.297 ps=2.13 w=1.8 l=0.15
X1 a_8380_n1152# a_8294_n774# vdd vdd sky130_fd_pr__pfet_01v8 ad=0.297 pd=2.13 as=0.558 ps=4.22 w=1.8 l=0.15
X2 vdd a_258_n774# a_2988_792# vdd sky130_fd_pr__pfet_01v8 ad=0.217 pd=2.02 as=0.1155 ps=1.03 w=0.7 l=0.15
X3 a_5324_n388# a_4732_n1252# vss vss sky130_fd_pr__nfet_01v8 ad=0.174 pd=1.78 as=0.174 ps=1.78 w=0.6 l=0.15
X4 vdd a_258_406# a_344_792# vdd sky130_fd_pr__pfet_01v8 ad=0.961 pd=6.82 as=0.5115 ps=3.43 w=3.1 l=0.15
X5 a_10114_792# a_8750_238# vdd vdd sky130_fd_pr__pfet_01v8 ad=0.297 pd=2.13 as=0.558 ps=4.22 w=1.8 l=0.15
X6 a_344_792# a_258_406# vdd vdd sky130_fd_pr__pfet_01v8 ad=0.5115 pd=3.43 as=0.961 ps=6.82 w=3.1 l=0.15
X7 a_8750_238# a_8750_n1152# vdd vdd sky130_fd_pr__pfet_01v8 ad=0.377 pd=3.18 as=0.377 ps=3.18 w=1.3 l=0.15
X8 vss a_258_406# q2n vss sky130_fd_pr__nfet_01v8 ad=0.465 pd=3.62 as=0.2475 ps=1.83 w=1.5 l=0.15
X9 vdd a_4276_n774# a_4362_n1252# vdd sky130_fd_pr__pfet_01v8 ad=0.713 pd=5.22 as=0.3795 ps=2.63 w=2.3 l=0.15
X10 a_8294_406# a_8294_n774# a_11076_n388# vss sky130_fd_pr__nfet_01v8 ad=0.174 pd=1.78 as=0.174 ps=1.78 w=0.6 l=0.15
X11 a_2078_n1412# clkp a_258_406# vdd sky130_fd_pr__pfet_01v8 ad=0.961 pd=6.82 as=0.5115 ps=3.43 w=3.1 l=0.15
X12 a_4732_n1252# q2n a_4362_n1252# vdd sky130_fd_pr__pfet_01v8 ad=0.3795 pd=2.63 as=0.713 ps=5.22 w=2.3 l=0.15
X13 a_4362_208# a_4276_406# vss vss sky130_fd_pr__nfet_01v8 ad=0.1485 pd=1.23 as=0.279 ps=2.42 w=0.9 l=0.15
X14 a_4362_n1252# q2n a_4732_n1252# vdd sky130_fd_pr__pfet_01v8 ad=0.713 pd=5.22 as=0.3795 ps=2.63 w=2.3 l=0.15
X15 vdd a_4732_n1252# a_6096_n1252# vdd sky130_fd_pr__pfet_01v8 ad=0.713 pd=5.22 as=0.3795 ps=2.63 w=2.3 l=0.15
X16 vss a_4276_406# a_4362_208# vss sky130_fd_pr__nfet_01v8 ad=0.279 pd=2.42 as=0.1485 ps=1.23 w=0.9 l=0.15
X17 a_4732_208# q2n a_4362_792# vdd sky130_fd_pr__pfet_01v8 ad=0.3795 pd=2.63 as=0.713 ps=5.22 w=2.3 l=0.15
X18 a_11024_792# a_8294_406# a_8294_n774# vdd sky130_fd_pr__pfet_01v8 ad=0.2015 pd=1.92 as=0.10725 ps=0.98 w=0.65 l=0.15
X19 q2n a_258_406# vdd vdd sky130_fd_pr__pfet_01v8 ad=0.3795 pd=2.63 as=0.713 ps=5.22 w=2.3 l=0.15
X20 a_8294_n774# a_8294_406# a_11024_792# vdd sky130_fd_pr__pfet_01v8 ad=0.10725 pd=0.98 as=0.2015 ps=1.92 w=0.65 l=0.15
X21 a_7006_792# a_4276_n774# vdd vdd sky130_fd_pr__pfet_01v8 ad=0.10725 pd=0.98 as=0.2015 ps=1.92 w=0.65 l=0.15
X22 vdd a_4276_n774# a_7006_792# vdd sky130_fd_pr__pfet_01v8 ad=0.2015 pd=1.92 as=0.10725 ps=0.98 w=0.65 l=0.15
X23 q8n a_8294_406# vdd vdd sky130_fd_pr__pfet_01v8 ad=0.3465 pd=2.43 as=0.651 ps=4.82 w=2.1 l=0.15
X24 q2p a_258_n774# vss vss sky130_fd_pr__nfet_01v8 ad=0.2475 pd=1.83 as=0.465 ps=3.62 w=1.5 l=0.15
X25 a_10114_238# q4n a_8294_n774# vss sky130_fd_pr__nfet_01v8 ad=0.2325 pd=2.12 as=0.12375 ps=1.08 w=0.75 l=0.15
X26 a_8294_n774# q4n a_10114_238# vss sky130_fd_pr__nfet_01v8 ad=0.12375 pd=1.08 as=0.2325 ps=2.12 w=0.75 l=0.15
X27 a_6096_n388# q2n a_4276_406# vss sky130_fd_pr__nfet_01v8 ad=0.279 pd=2.42 as=0.1485 ps=1.23 w=0.9 l=0.15
X28 a_8750_238# q4n a_8380_792# vdd sky130_fd_pr__pfet_01v8 ad=0.297 pd=2.13 as=0.558 ps=4.22 w=1.8 l=0.15
X29 vss a_8294_n774# q8p vss sky130_fd_pr__nfet_01v8 ad=0.31 pd=2.62 as=0.165 ps=1.33 w=1 l=0.15
X30 q8p a_8294_n774# vss vss sky130_fd_pr__nfet_01v8 ad=0.165 pd=1.33 as=0.31 ps=2.62 w=1 l=0.15
X31 a_258_n774# a_258_406# vdd vdd sky130_fd_pr__pfet_01v8 ad=0.377 pd=3.18 as=0.377 ps=3.18 w=1.3 l=0.15
X32 a_2078_792# clkp a_258_n774# vdd sky130_fd_pr__pfet_01v8 ad=0.961 pd=6.82 as=0.5115 ps=3.43 w=3.1 l=0.15
X33 a_8380_792# q4n a_8750_238# vdd sky130_fd_pr__pfet_01v8 ad=0.558 pd=4.22 as=0.297 ps=2.13 w=1.8 l=0.15
X34 vdd a_8294_406# q8n vdd sky130_fd_pr__pfet_01v8 ad=0.651 pd=4.82 as=0.3465 ps=2.43 w=2.1 l=0.15
X35 a_258_n774# clkp a_2078_792# vdd sky130_fd_pr__pfet_01v8 ad=0.5115 pd=3.43 as=0.961 ps=6.82 w=3.1 l=0.15
X36 q2p a_258_n774# vdd vdd sky130_fd_pr__pfet_01v8 ad=0.3795 pd=2.63 as=0.713 ps=5.22 w=2.3 l=0.15
X37 vss a_4732_n1252# a_6096_n388# vss sky130_fd_pr__nfet_01v8 ad=0.279 pd=2.42 as=0.1485 ps=1.23 w=0.9 l=0.15
X38 vdd a_8294_n774# a_11024_792# vdd sky130_fd_pr__pfet_01v8 ad=0.2015 pd=1.92 as=0.10725 ps=0.98 w=0.65 l=0.15
X39 a_4732_n1252# a_4732_208# a_5324_n388# vss sky130_fd_pr__nfet_01v8 ad=0.174 pd=1.78 as=0.174 ps=1.78 w=0.6 l=0.15
X40 a_4732_n1252# a_4732_208# vss vss sky130_fd_pr__nfet_01v8 ad=0.174 pd=1.78 as=0.174 ps=1.78 w=0.6 l=0.15
X41 a_258_406# a_258_n774# vss vss sky130_fd_pr__nfet_01v8 ad=0.174 pd=1.78 as=0.174 ps=1.78 w=0.6 l=0.15
X42 a_8380_238# a_8294_406# vss vss sky130_fd_pr__nfet_01v8 ad=0.12375 pd=1.08 as=0.2325 ps=2.12 w=0.75 l=0.15
X43 vdd a_258_n774# q2p vdd sky130_fd_pr__pfet_01v8 ad=0.713 pd=5.22 as=0.3795 ps=2.63 w=2.3 l=0.15
X44 a_11024_792# a_8294_n774# vdd vdd sky130_fd_pr__pfet_01v8 ad=0.10725 pd=0.98 as=0.2015 ps=1.92 w=0.65 l=0.15
X45 vss a_714_148# a_2078_148# vss sky130_fd_pr__nfet_01v8 ad=0.372 pd=3.02 as=0.198 ps=1.53 w=1.2 l=0.15
X46 vss a_8294_406# a_8380_238# vss sky130_fd_pr__nfet_01v8 ad=0.2325 pd=2.12 as=0.12375 ps=1.08 w=0.75 l=0.15
X47 a_344_792# clkn a_714_148# vdd sky130_fd_pr__pfet_01v8 ad=0.961 pd=6.82 as=0.5115 ps=3.43 w=3.1 l=0.15
X48 a_714_148# clkn a_344_792# vdd sky130_fd_pr__pfet_01v8 ad=0.5115 pd=3.43 as=0.961 ps=6.82 w=3.1 l=0.15
X49 a_2078_148# a_714_148# vss vss sky130_fd_pr__nfet_01v8 ad=0.198 pd=1.53 as=0.372 ps=3.02 w=1.2 l=0.15
X50 a_4276_406# q2p a_6096_n1252# vdd sky130_fd_pr__pfet_01v8 ad=0.3795 pd=2.63 as=0.713 ps=5.22 w=2.3 l=0.15
X51 a_344_n1412# a_258_n774# vdd vdd sky130_fd_pr__pfet_01v8 ad=0.5115 pd=3.43 as=0.961 ps=6.82 w=3.1 l=0.15
X52 a_8294_406# a_8294_n774# vdd vdd sky130_fd_pr__pfet_01v8 ad=0.377 pd=3.18 as=0.377 ps=3.18 w=1.3 l=0.15
X53 a_714_n1412# a_714_148# vdd vdd sky130_fd_pr__pfet_01v8 ad=0.377 pd=3.18 as=0.377 ps=3.18 w=1.3 l=0.15
X54 a_3040_n388# a_258_406# vss vss sky130_fd_pr__nfet_01v8 ad=0.203 pd=1.98 as=0.203 ps=1.98 w=0.7 l=0.15
X55 vdd a_8294_n774# a_8380_n1152# vdd sky130_fd_pr__pfet_01v8 ad=0.558 pd=4.22 as=0.297 ps=2.13 w=1.8 l=0.15
X56 a_8750_n1152# q4p a_8380_n388# vss sky130_fd_pr__nfet_01v8 ad=0.12375 pd=1.08 as=0.2325 ps=2.12 w=0.75 l=0.15
X57 a_714_n1412# clkn a_344_n1412# vdd sky130_fd_pr__pfet_01v8 ad=0.5115 pd=3.43 as=0.961 ps=6.82 w=3.1 l=0.15
X58 a_8750_n1152# q4n a_8380_n1152# vdd sky130_fd_pr__pfet_01v8 ad=0.297 pd=2.13 as=0.558 ps=4.22 w=1.8 l=0.15
X59 a_4732_n1252# a_4732_208# vdd vdd sky130_fd_pr__pfet_01v8 ad=0.377 pd=3.18 as=0.377 ps=3.18 w=1.3 l=0.15
X60 a_258_406# a_258_n774# a_3040_n388# vss sky130_fd_pr__nfet_01v8 ad=0.203 pd=1.98 as=0.203 ps=1.98 w=0.7 l=0.15
X61 vdd a_714_148# a_1254_792# vdd sky130_fd_pr__pfet_01v8 ad=0.217 pd=2.02 as=0.1155 ps=1.03 w=0.7 l=0.15
X62 a_4276_n774# a_4276_406# vss vss sky130_fd_pr__nfet_01v8 ad=0.174 pd=1.78 as=0.174 ps=1.78 w=0.6 l=0.15
X63 a_8750_n1152# a_8750_238# vdd vdd sky130_fd_pr__pfet_01v8 ad=0.377 pd=3.18 as=0.377 ps=3.18 w=1.3 l=0.15
X64 a_1254_792# a_714_148# vdd vdd sky130_fd_pr__pfet_01v8 ad=0.1155 pd=1.03 as=0.217 ps=2.02 w=0.7 l=0.15
X65 a_714_148# a_714_n1412# vss vss sky130_fd_pr__nfet_01v8 ad=0.174 pd=1.78 as=0.174 ps=1.78 w=0.6 l=0.15
X66 a_4362_208# q2p a_4732_208# vss sky130_fd_pr__nfet_01v8 ad=0.279 pd=2.42 as=0.1485 ps=1.23 w=0.9 l=0.15
X67 vss a_4276_n774# a_4362_n388# vss sky130_fd_pr__nfet_01v8 ad=0.279 pd=2.42 as=0.1485 ps=1.23 w=0.9 l=0.15
X68 vss a_4732_208# a_6096_208# vss sky130_fd_pr__nfet_01v8 ad=0.279 pd=2.42 as=0.1485 ps=1.23 w=0.9 l=0.15
X69 a_6096_208# a_4732_208# vss vss sky130_fd_pr__nfet_01v8 ad=0.1485 pd=1.23 as=0.279 ps=2.42 w=0.9 l=0.15
X70 a_8380_n388# a_8294_n774# vss vss sky130_fd_pr__nfet_01v8 ad=0.12375 pd=1.08 as=0.2325 ps=2.12 w=0.75 l=0.15
X71 a_4276_406# q2n a_6096_n388# vss sky130_fd_pr__nfet_01v8 ad=0.1485 pd=1.23 as=0.279 ps=2.42 w=0.9 l=0.15
X72 a_6096_792# q2p a_4276_n774# vdd sky130_fd_pr__pfet_01v8 ad=0.713 pd=5.22 as=0.3795 ps=2.63 w=2.3 l=0.15
X73 vdd a_258_n774# a_344_n1412# vdd sky130_fd_pr__pfet_01v8 ad=0.961 pd=6.82 as=0.5115 ps=3.43 w=3.1 l=0.15
X74 a_6096_n1252# q2p a_4276_406# vdd sky130_fd_pr__pfet_01v8 ad=0.713 pd=5.22 as=0.3795 ps=2.63 w=2.3 l=0.15
X75 a_4276_n774# q2p a_6096_792# vdd sky130_fd_pr__pfet_01v8 ad=0.3795 pd=2.63 as=0.713 ps=5.22 w=2.3 l=0.15
X76 a_1254_792# a_714_n1412# a_714_148# vdd sky130_fd_pr__pfet_01v8 ad=0.217 pd=2.02 as=0.1155 ps=1.03 w=0.7 l=0.15
X77 a_1306_n388# a_714_n1412# vss vss sky130_fd_pr__nfet_01v8 ad=0.203 pd=1.98 as=0.203 ps=1.98 w=0.7 l=0.15
X78 vdd a_258_406# q2n vdd sky130_fd_pr__pfet_01v8 ad=0.713 pd=5.22 as=0.3795 ps=2.63 w=2.3 l=0.15
X79 a_344_n1412# clkn a_714_n1412# vdd sky130_fd_pr__pfet_01v8 ad=0.961 pd=6.82 as=0.5115 ps=3.43 w=3.1 l=0.15
X80 a_714_148# a_714_n1412# a_1254_792# vdd sky130_fd_pr__pfet_01v8 ad=0.1155 pd=1.03 as=0.217 ps=2.02 w=0.7 l=0.15
X81 vdd a_4276_n774# q4p vdd sky130_fd_pr__pfet_01v8 ad=0.651 pd=4.82 as=0.3465 ps=2.43 w=2.1 l=0.15
X82 vss a_4276_n774# q4p vss sky130_fd_pr__nfet_01v8 ad=0.341 pd=2.82 as=0.1815 ps=1.43 w=1.1 l=0.15
X83 vss a_258_n774# a_344_n388# vss sky130_fd_pr__nfet_01v8 ad=0.372 pd=3.02 as=0.198 ps=1.53 w=1.2 l=0.15
X84 a_10114_n1152# a_8750_n1152# vdd vdd sky130_fd_pr__pfet_01v8 ad=0.297 pd=2.13 as=0.558 ps=4.22 w=1.8 l=0.15
X85 q2n a_258_406# vss vss sky130_fd_pr__nfet_01v8 ad=0.2475 pd=1.83 as=0.465 ps=3.62 w=1.5 l=0.15
X86 a_258_406# a_258_n774# vdd vdd sky130_fd_pr__pfet_01v8 ad=0.377 pd=3.18 as=0.377 ps=3.18 w=1.3 l=0.15
X87 a_6096_n388# a_4732_n1252# vss vss sky130_fd_pr__nfet_01v8 ad=0.1485 pd=1.23 as=0.279 ps=2.42 w=0.9 l=0.15
X88 a_4362_792# a_4276_406# vdd vdd sky130_fd_pr__pfet_01v8 ad=0.3795 pd=2.63 as=0.713 ps=5.22 w=2.3 l=0.15
X89 vss a_258_n774# q2p vss sky130_fd_pr__nfet_01v8 ad=0.465 pd=3.62 as=0.2475 ps=1.83 w=1.5 l=0.15
X90 vdd a_4276_406# a_4362_792# vdd sky130_fd_pr__pfet_01v8 ad=0.713 pd=5.22 as=0.3795 ps=2.63 w=2.3 l=0.15
X91 vdd a_4732_208# a_5272_792# vdd sky130_fd_pr__pfet_01v8 ad=0.2015 pd=1.92 as=0.10725 ps=0.98 w=0.65 l=0.15
X92 a_9342_n388# a_8750_n1152# vss vss sky130_fd_pr__nfet_01v8 ad=0.174 pd=1.78 as=0.174 ps=1.78 w=0.6 l=0.15
X93 a_5272_792# a_4732_208# vdd vdd sky130_fd_pr__pfet_01v8 ad=0.10725 pd=0.98 as=0.2015 ps=1.92 w=0.65 l=0.15
X94 a_4732_208# a_4732_n1252# vss vss sky130_fd_pr__nfet_01v8 ad=0.174 pd=1.78 as=0.174 ps=1.78 w=0.6 l=0.15
X95 a_2078_n1412# a_714_n1412# vdd vdd sky130_fd_pr__pfet_01v8 ad=0.5115 pd=3.43 as=0.961 ps=6.82 w=3.1 l=0.15
X96 a_8294_n774# a_8294_406# vss vss sky130_fd_pr__nfet_01v8 ad=0.174 pd=1.78 as=0.174 ps=1.78 w=0.6 l=0.15
X97 a_10114_792# q4p a_8294_n774# vdd sky130_fd_pr__pfet_01v8 ad=0.558 pd=4.22 as=0.297 ps=2.13 w=1.8 l=0.15
X98 a_10114_n388# q4n a_8294_406# vss sky130_fd_pr__nfet_01v8 ad=0.2325 pd=2.12 as=0.12375 ps=1.08 w=0.75 l=0.15
X99 vss a_4276_406# q4n vss sky130_fd_pr__nfet_01v8 ad=0.341 pd=2.82 as=0.1815 ps=1.43 w=1.1 l=0.15
X100 a_4362_n388# q2p a_4732_n1252# vss sky130_fd_pr__nfet_01v8 ad=0.279 pd=2.42 as=0.1485 ps=1.23 w=0.9 l=0.15
X101 a_8294_n774# q4p a_10114_792# vdd sky130_fd_pr__pfet_01v8 ad=0.297 pd=2.13 as=0.558 ps=4.22 w=1.8 l=0.15
X102 a_8750_n1152# a_8750_238# a_9342_n388# vss sky130_fd_pr__nfet_01v8 ad=0.174 pd=1.78 as=0.174 ps=1.78 w=0.6 l=0.15
X103 a_4276_406# a_4276_n774# vss vss sky130_fd_pr__nfet_01v8 ad=0.174 pd=1.78 as=0.174 ps=1.78 w=0.6 l=0.15
X104 vdd a_8750_n1152# a_10114_n1152# vdd sky130_fd_pr__pfet_01v8 ad=0.558 pd=4.22 as=0.297 ps=2.13 w=1.8 l=0.15
X105 vss a_8750_238# a_10114_238# vss sky130_fd_pr__nfet_01v8 ad=0.2325 pd=2.12 as=0.12375 ps=1.08 w=0.75 l=0.15
X106 a_5272_792# a_4732_n1252# a_4732_208# vdd sky130_fd_pr__pfet_01v8 ad=0.2015 pd=1.92 as=0.10725 ps=0.98 w=0.65 l=0.15
X107 a_4732_208# q2p a_4362_208# vss sky130_fd_pr__nfet_01v8 ad=0.1485 pd=1.23 as=0.279 ps=2.42 w=0.9 l=0.15
X108 a_10114_238# a_8750_238# vss vss sky130_fd_pr__nfet_01v8 ad=0.12375 pd=1.08 as=0.2325 ps=2.12 w=0.75 l=0.15
X109 a_4732_208# a_4732_n1252# a_5272_792# vdd sky130_fd_pr__pfet_01v8 ad=0.10725 pd=0.98 as=0.2015 ps=1.92 w=0.65 l=0.15
X110 vss a_258_406# a_344_148# vss sky130_fd_pr__nfet_01v8 ad=0.372 pd=3.02 as=0.198 ps=1.53 w=1.2 l=0.15
X111 a_7058_n388# a_4276_406# vss vss sky130_fd_pr__nfet_01v8 ad=0.174 pd=1.78 as=0.174 ps=1.78 w=0.6 l=0.15
X112 a_344_148# a_258_406# vss vss sky130_fd_pr__nfet_01v8 ad=0.198 pd=1.53 as=0.372 ps=3.02 w=1.2 l=0.15
X113 vss a_8750_n1152# a_10114_n388# vss sky130_fd_pr__nfet_01v8 ad=0.2325 pd=2.12 as=0.12375 ps=1.08 w=0.75 l=0.15
X114 a_344_n388# clkp a_714_n1412# vss sky130_fd_pr__nfet_01v8 ad=0.372 pd=3.02 as=0.198 ps=1.53 w=1.2 l=0.15
X115 vdd a_714_n1412# a_2078_n1412# vdd sky130_fd_pr__pfet_01v8 ad=0.961 pd=6.82 as=0.5115 ps=3.43 w=3.1 l=0.15
X116 a_2078_n388# clkn a_258_406# vss sky130_fd_pr__nfet_01v8 ad=0.372 pd=3.02 as=0.198 ps=1.53 w=1.2 l=0.15
X117 a_4362_n1252# a_4276_n774# vdd vdd sky130_fd_pr__pfet_01v8 ad=0.3795 pd=2.63 as=0.713 ps=5.22 w=2.3 l=0.15
X118 a_4276_406# a_4276_n774# a_7058_n388# vss sky130_fd_pr__nfet_01v8 ad=0.174 pd=1.78 as=0.174 ps=1.78 w=0.6 l=0.15
X119 a_8380_792# a_8294_406# vdd vdd sky130_fd_pr__pfet_01v8 ad=0.297 pd=2.13 as=0.558 ps=4.22 w=1.8 l=0.15
X120 vss a_8294_406# q8n vss sky130_fd_pr__nfet_01v8 ad=0.31 pd=2.62 as=0.165 ps=1.33 w=1 l=0.15
X121 a_4276_n774# a_4276_406# vdd vdd sky130_fd_pr__pfet_01v8 ad=0.377 pd=3.18 as=0.377 ps=3.18 w=1.3 l=0.15
X122 a_8294_406# a_8294_n774# vss vss sky130_fd_pr__nfet_01v8 ad=0.174 pd=1.78 as=0.174 ps=1.78 w=0.6 l=0.15
X123 a_344_n388# a_258_n774# vss vss sky130_fd_pr__nfet_01v8 ad=0.198 pd=1.53 as=0.372 ps=3.02 w=1.2 l=0.15
X124 q4n a_4276_406# vdd vdd sky130_fd_pr__pfet_01v8 ad=0.3465 pd=2.43 as=0.651 ps=4.82 w=2.1 l=0.15
X125 a_714_148# a_714_n1412# vdd vdd sky130_fd_pr__pfet_01v8 ad=0.377 pd=3.18 as=0.377 ps=3.18 w=1.3 l=0.15
X126 vdd a_714_148# a_2078_792# vdd sky130_fd_pr__pfet_01v8 ad=0.961 pd=6.82 as=0.5115 ps=3.43 w=3.1 l=0.15
X127 q4p a_4276_n774# vdd vdd sky130_fd_pr__pfet_01v8 ad=0.3465 pd=2.43 as=0.651 ps=4.82 w=2.1 l=0.15
X128 vdd a_8294_406# a_8380_792# vdd sky130_fd_pr__pfet_01v8 ad=0.558 pd=4.22 as=0.297 ps=2.13 w=1.8 l=0.15
X129 q4p a_4276_n774# vss vss sky130_fd_pr__nfet_01v8 ad=0.1815 pd=1.43 as=0.341 ps=2.82 w=1.1 l=0.15
X130 a_2078_792# a_714_148# vdd vdd sky130_fd_pr__pfet_01v8 ad=0.5115 pd=3.43 as=0.961 ps=6.82 w=3.1 l=0.15
X131 vdd a_4276_406# q4n vdd sky130_fd_pr__pfet_01v8 ad=0.651 pd=4.82 as=0.3465 ps=2.43 w=2.1 l=0.15
X132 a_8750_238# a_8750_n1152# vss vss sky130_fd_pr__nfet_01v8 ad=0.174 pd=1.78 as=0.174 ps=1.78 w=0.6 l=0.15
X133 a_8380_n1152# q4n a_8750_n1152# vdd sky130_fd_pr__pfet_01v8 ad=0.558 pd=4.22 as=0.297 ps=2.13 w=1.8 l=0.15
X134 vss a_714_n1412# a_2078_n388# vss sky130_fd_pr__nfet_01v8 ad=0.372 pd=3.02 as=0.198 ps=1.53 w=1.2 l=0.15
X135 a_714_n1412# a_714_148# a_1306_n388# vss sky130_fd_pr__nfet_01v8 ad=0.203 pd=1.98 as=0.203 ps=1.98 w=0.7 l=0.15
X136 a_714_n1412# a_714_148# vss vss sky130_fd_pr__nfet_01v8 ad=0.174 pd=1.78 as=0.174 ps=1.78 w=0.6 l=0.15
X137 a_258_n774# a_258_406# a_2988_792# vdd sky130_fd_pr__pfet_01v8 ad=0.1155 pd=1.03 as=0.217 ps=2.02 w=0.7 l=0.15
X138 a_8750_238# a_8750_n1152# a_9290_792# vdd sky130_fd_pr__pfet_01v8 ad=0.10725 pd=0.98 as=0.2015 ps=1.92 w=0.65 l=0.15
X139 a_8294_406# q4n a_10114_n388# vss sky130_fd_pr__nfet_01v8 ad=0.12375 pd=1.08 as=0.2325 ps=2.12 w=0.75 l=0.15
X140 q4n a_4276_406# vss vss sky130_fd_pr__nfet_01v8 ad=0.1815 pd=1.43 as=0.341 ps=2.82 w=1.1 l=0.15
X141 a_4732_n1252# q2p a_4362_n388# vss sky130_fd_pr__nfet_01v8 ad=0.1485 pd=1.23 as=0.279 ps=2.42 w=0.9 l=0.15
X142 a_2988_792# a_258_406# a_258_n774# vdd sky130_fd_pr__pfet_01v8 ad=0.217 pd=2.02 as=0.1155 ps=1.03 w=0.7 l=0.15
X143 a_9290_792# a_8750_n1152# a_8750_238# vdd sky130_fd_pr__pfet_01v8 ad=0.2015 pd=1.92 as=0.10725 ps=0.98 w=0.65 l=0.15
X144 a_8750_n1152# a_8750_238# vss vss sky130_fd_pr__nfet_01v8 ad=0.174 pd=1.78 as=0.174 ps=1.78 w=0.6 l=0.15
X145 a_4362_792# q2n a_4732_208# vdd sky130_fd_pr__pfet_01v8 ad=0.713 pd=5.22 as=0.3795 ps=2.63 w=2.3 l=0.15
X146 a_4732_208# a_4732_n1252# vdd vdd sky130_fd_pr__pfet_01v8 ad=0.377 pd=3.18 as=0.377 ps=3.18 w=1.3 l=0.15
X147 vdd a_4732_208# a_6096_792# vdd sky130_fd_pr__pfet_01v8 ad=0.713 pd=5.22 as=0.3795 ps=2.63 w=2.3 l=0.15
X148 a_8294_n774# a_8294_406# vdd vdd sky130_fd_pr__pfet_01v8 ad=0.377 pd=3.18 as=0.377 ps=3.18 w=1.3 l=0.15
X149 vdd a_8294_n774# q8p vdd sky130_fd_pr__pfet_01v8 ad=0.651 pd=4.82 as=0.3465 ps=2.43 w=2.1 l=0.15
X150 a_8294_406# q4p a_10114_n1152# vdd sky130_fd_pr__pfet_01v8 ad=0.297 pd=2.13 as=0.558 ps=4.22 w=1.8 l=0.15
X151 a_10114_n388# a_8750_n1152# vss vss sky130_fd_pr__nfet_01v8 ad=0.12375 pd=1.08 as=0.2325 ps=2.12 w=0.75 l=0.15
X152 a_8750_238# q4p a_8380_238# vss sky130_fd_pr__nfet_01v8 ad=0.12375 pd=1.08 as=0.2325 ps=2.12 w=0.75 l=0.15
X153 a_4276_406# a_4276_n774# vdd vdd sky130_fd_pr__pfet_01v8 ad=0.377 pd=3.18 as=0.377 ps=3.18 w=1.3 l=0.15
X154 a_8380_n388# q4p a_8750_n1152# vss sky130_fd_pr__nfet_01v8 ad=0.2325 pd=2.12 as=0.12375 ps=1.08 w=0.75 l=0.15
X155 a_714_n1412# clkp a_344_n388# vss sky130_fd_pr__nfet_01v8 ad=0.198 pd=1.53 as=0.372 ps=3.02 w=1.2 l=0.15
X156 a_6096_792# a_4732_208# vdd vdd sky130_fd_pr__pfet_01v8 ad=0.3795 pd=2.63 as=0.713 ps=5.22 w=2.3 l=0.15
X157 q8p a_8294_n774# vdd vdd sky130_fd_pr__pfet_01v8 ad=0.3465 pd=2.43 as=0.651 ps=4.82 w=2.1 l=0.15
X158 a_4362_n388# a_4276_n774# vss vss sky130_fd_pr__nfet_01v8 ad=0.1485 pd=1.23 as=0.279 ps=2.42 w=0.9 l=0.15
X159 a_258_406# clkn a_2078_n388# vss sky130_fd_pr__nfet_01v8 ad=0.198 pd=1.53 as=0.372 ps=3.02 w=1.2 l=0.15
X160 a_8380_238# q4p a_8750_238# vss sky130_fd_pr__nfet_01v8 ad=0.2325 pd=2.12 as=0.12375 ps=1.08 w=0.75 l=0.15
X161 a_2078_148# clkn a_258_n774# vss sky130_fd_pr__nfet_01v8 ad=0.372 pd=3.02 as=0.198 ps=1.53 w=1.2 l=0.15
X162 a_258_n774# clkn a_2078_148# vss sky130_fd_pr__nfet_01v8 ad=0.198 pd=1.53 as=0.372 ps=3.02 w=1.2 l=0.15
X163 q8n a_8294_406# vss vss sky130_fd_pr__nfet_01v8 ad=0.165 pd=1.33 as=0.31 ps=2.62 w=1 l=0.15
X164 a_258_406# clkp a_2078_n1412# vdd sky130_fd_pr__pfet_01v8 ad=0.5115 pd=3.43 as=0.961 ps=6.82 w=3.1 l=0.15
X165 a_344_148# clkp a_714_148# vss sky130_fd_pr__nfet_01v8 ad=0.372 pd=3.02 as=0.198 ps=1.53 w=1.2 l=0.15
X166 a_714_148# clkp a_344_148# vss sky130_fd_pr__nfet_01v8 ad=0.198 pd=1.53 as=0.372 ps=3.02 w=1.2 l=0.15
X167 vss a_8294_n774# a_8380_n388# vss sky130_fd_pr__nfet_01v8 ad=0.2325 pd=2.12 as=0.12375 ps=1.08 w=0.75 l=0.15
X168 a_2078_n388# a_714_n1412# vss vss sky130_fd_pr__nfet_01v8 ad=0.198 pd=1.53 as=0.372 ps=3.02 w=1.2 l=0.15
X169 a_258_n774# a_258_406# vss vss sky130_fd_pr__nfet_01v8 ad=0.174 pd=1.78 as=0.174 ps=1.78 w=0.6 l=0.15
X170 vdd a_8750_238# a_9290_792# vdd sky130_fd_pr__pfet_01v8 ad=0.2015 pd=1.92 as=0.10725 ps=0.98 w=0.65 l=0.15
X171 a_10114_n1152# q4p a_8294_406# vdd sky130_fd_pr__pfet_01v8 ad=0.558 pd=4.22 as=0.297 ps=2.13 w=1.8 l=0.15
X172 a_2988_792# a_258_n774# vdd vdd sky130_fd_pr__pfet_01v8 ad=0.1155 pd=1.03 as=0.217 ps=2.02 w=0.7 l=0.15
X173 a_9290_792# a_8750_238# vdd vdd sky130_fd_pr__pfet_01v8 ad=0.10725 pd=0.98 as=0.2015 ps=1.92 w=0.65 l=0.15
X174 a_6096_208# q2n a_4276_n774# vss sky130_fd_pr__nfet_01v8 ad=0.279 pd=2.42 as=0.1485 ps=1.23 w=0.9 l=0.15
X175 a_6096_n1252# a_4732_n1252# vdd vdd sky130_fd_pr__pfet_01v8 ad=0.3795 pd=2.63 as=0.713 ps=5.22 w=2.3 l=0.15
X176 a_7006_792# a_4276_406# a_4276_n774# vdd sky130_fd_pr__pfet_01v8 ad=0.2015 pd=1.92 as=0.10725 ps=0.98 w=0.65 l=0.15
X177 a_4276_n774# q2n a_6096_208# vss sky130_fd_pr__nfet_01v8 ad=0.1485 pd=1.23 as=0.279 ps=2.42 w=0.9 l=0.15
X178 a_4276_n774# a_4276_406# a_7006_792# vdd sky130_fd_pr__pfet_01v8 ad=0.10725 pd=0.98 as=0.2015 ps=1.92 w=0.65 l=0.15
X179 a_11076_n388# a_8294_406# vss vss sky130_fd_pr__nfet_01v8 ad=0.174 pd=1.78 as=0.174 ps=1.78 w=0.6 l=0.15
C0 a_8294_406# a_8294_n774# 0.88148f
C1 a_3040_n388# a_4276_n774# 0
C2 clkn vdd 0.98744f
C3 a_6096_208# a_4276_406# 0.00289f
C4 a_8294_n774# a_11024_792# 0.15954f
C5 a_8380_238# q4p 0.1195f
C6 q2n a_4362_208# 0.05867f
C7 a_8294_406# a_8380_n388# 0
C8 a_10114_n388# a_11076_n388# 0.00225f
C9 a_344_148# a_714_148# 0.12323f
C10 a_7006_792# a_8750_n1152# 0
C11 a_4362_n1252# a_4276_n774# 0.12707f
C12 clkn q2p 0
C13 vdd a_2078_148# 0.01678f
C14 a_10114_n1152# a_8380_n1152# 0.00102f
C15 clkn a_714_148# 0.27334f
C16 a_5272_792# a_4362_792# 0
C17 q4p a_8380_792# 0.11307f
C18 a_9342_n388# a_4276_406# 0
C19 vdd a_5272_792# 0.25286f
C20 vdd a_4362_792# 0.52644f
C21 a_8294_n774# a_7058_n388# 0
C22 q4p a_8294_406# 1.07429f
C23 a_11076_n388# q8n 0
C24 a_4732_n1252# a_5324_n388# 0.07828f
C25 q4p a_11024_792# 0.00117f
C26 a_714_n1412# a_258_406# 0.01573f
C27 a_5324_n388# a_7058_n388# 0
C28 a_4732_n1252# a_6096_792# 0
C29 a_258_406# a_4276_406# 0.0047f
C30 q2p a_2078_148# 0
C31 a_7058_n388# a_8380_n388# 0.00121f
C32 a_8380_n1152# a_4276_406# 0
C33 a_2078_148# a_714_148# 0.03965f
C34 a_2078_792# a_344_792# 0.00102f
C35 a_9290_792# a_8750_n1152# 0.03849f
C36 a_8380_238# a_4276_n774# 0
C37 q2p a_4362_792# 0.08885f
C38 a_714_n1412# a_258_n774# 0.04219f
C39 q2p a_5272_792# 0.03269f
C40 q8p q8n 0.00511f
C41 a_6096_n388# a_4276_n774# 0.0013f
C42 a_258_n774# a_4276_406# 0.01303f
C43 a_3040_n388# a_1306_n388# 0
C44 a_4362_n388# a_4276_n774# 0.03009f
C45 a_258_406# a_258_n774# 0.89618f
C46 q2p vdd 1.26126f
C47 vdd a_714_148# 1.29137f
C48 clkp a_344_148# 0.13729f
C49 a_2988_792# a_4362_792# 0
C50 a_8294_406# a_10114_n388# 0.0935f
C51 q4p a_7058_n388# 0
C52 q2n clkn 0.00204f
C53 a_4276_n774# a_8380_792# 0
C54 vdd a_2988_792# 0.26406f
C55 clkn clkp 0.475f
C56 a_4732_208# a_3040_n388# 0
C57 a_8294_406# a_4276_n774# 0.01245f
C58 a_714_n1412# a_2078_n1412# 0.07185f
C59 a_258_406# a_2078_n1412# 0.24669f
C60 a_6096_792# a_7006_792# 0
C61 q2p a_2988_792# 0.00529f
C62 a_2988_792# a_714_148# 0
C63 vdd a_8750_n1152# 1.26132f
C64 a_8294_406# q8n 0.17559f
C65 a_4732_208# a_4362_n1252# 0
C66 clkp a_2078_148# 0.06469f
C67 q2n a_4362_792# 0.09524f
C68 q2n a_5272_792# 0
C69 a_258_n774# a_2078_n1412# 0.06729f
C70 q4n a_11076_n388# 0
C71 a_6096_n1252# a_4276_n774# 0.0464f
C72 q2n vdd 1.3159f
C73 vdd clkp 0.93171f
C74 a_8294_n774# a_9290_792# 0
C75 a_4732_n1252# a_4276_n774# 0.03683f
C76 a_4276_n774# a_7058_n388# 0.14303f
C77 q4p a_7006_792# 0.00482f
C78 q4n q8p 0
C79 a_8380_238# a_8750_238# 0.09156f
C80 vdd a_10114_238# 0.01647f
C81 a_10114_792# q8p 0
C82 q2n q2p 0.47587f
C83 clkn a_1254_792# 0
C84 a_714_n1412# a_344_792# 0
C85 a_4732_208# a_6096_n388# 0.00269f
C86 q4n a_8380_238# 0.05703f
C87 a_714_n1412# a_3040_n388# 0
C88 q2p clkp 0.00238f
C89 a_4732_208# a_4362_n388# 0
C90 q4n a_6096_n388# 0
C91 clkp a_714_148# 0.19499f
C92 a_258_406# a_344_792# 0.15746f
C93 a_1306_n388# a_344_n388# 0.00127f
C94 a_3040_n388# a_258_406# 0.08452f
C95 q2n a_2988_792# 0
C96 a_8380_792# a_8750_238# 0.15902f
C97 a_9342_n388# a_11076_n388# 0
C98 a_4362_208# a_4276_n774# 0
C99 q4p a_9290_792# 0.03269f
C100 clkp a_2988_792# 0.00139f
C101 a_8294_406# a_8750_238# 0.02874f
C102 a_3040_n388# a_258_n774# 0.14232f
C103 q4n a_8380_792# 0.08415f
C104 a_10114_792# a_8380_792# 0.00102f
C105 a_11024_792# a_8750_238# 0
C106 a_258_406# a_4362_n1252# 0
C107 vdd a_8294_n774# 2.46139f
C108 q4n a_8294_406# 0.10756f
C109 a_7006_792# a_4276_n774# 0.15954f
C110 a_1254_792# vdd 0.26015f
C111 a_6096_792# a_5272_792# 0
C112 a_6096_792# a_4362_792# 0.00102f
C113 a_8294_406# a_10114_792# 0.03927f
C114 a_714_n1412# a_344_n1412# 0.24665f
C115 vdd a_5324_n388# 0.00414f
C116 a_11024_792# a_10114_792# 0
C117 a_4362_n1252# a_258_n774# 0
C118 vdd a_6096_792# 0.52705f
C119 a_1306_n388# a_2078_n388# 0.00218f
C120 vdd a_8380_n388# 0.01647f
C121 a_10114_238# a_8750_n1152# 0
C122 a_4732_208# a_6096_n1252# 0
C123 q2n clkp 0
C124 a_8380_238# a_4276_406# 0
C125 q4n a_6096_n1252# 0
C126 a_1254_792# a_714_148# 0.16478f
C127 a_344_n1412# a_258_n774# 0.15977f
C128 a_7058_n388# a_8750_238# 0
C129 q2p a_5324_n388# 0.00118f
C130 a_6096_n388# a_4276_406# 0.10449f
C131 q2p a_6096_792# 0.1643f
C132 a_4362_n388# a_4276_406# 0
C133 a_4732_208# a_4732_n1252# 0.68215f
C134 a_258_406# a_4362_n388# 0
C135 a_10114_n1152# a_8294_406# 0.15904f
C136 a_4276_n774# a_9290_792# 0
C137 vdd q4p 1.23607f
C138 q4n a_7058_n388# 0
C139 a_1254_792# a_2988_792# 0.00101f
C140 a_8294_406# a_9342_n388# 0
C141 a_8380_792# a_4276_406# 0
C142 a_4362_n388# a_258_n774# 0
C143 a_4732_n1252# a_6096_208# 0
C144 a_714_n1412# a_344_n388# 0.12565f
C145 a_8294_406# a_4276_406# 0.0047f
C146 a_344_n1412# a_2078_n1412# 0.00102f
C147 q2p q4p 0.00238f
C148 a_8294_n774# a_8750_n1152# 0.03356f
C149 a_4732_208# a_4362_208# 0.10234f
C150 a_344_n388# a_258_406# 0
C151 a_8750_n1152# a_8380_n388# 0.09349f
C152 vdd a_10114_n388# 0.01647f
C153 a_7006_792# a_8750_238# 0
C154 a_344_n388# a_258_n774# 0.0365f
C155 q2n a_5324_n388# 0.00422f
C156 a_5272_792# a_4276_n774# 0
C157 q2n a_6096_792# 0.00958f
C158 a_4732_208# a_7006_792# 0
C159 a_1254_792# clkp 0.0342f
C160 a_6096_n1252# a_4276_406# 0.19332f
C161 a_4362_208# a_6096_208# 0.00102f
C162 vdd a_4276_n774# 2.47012f
C163 q4n a_7006_792# 0
C164 a_10114_238# a_8294_n774# 0.0917f
C165 a_4732_n1252# a_4276_406# 0.01574f
C166 a_714_n1412# a_2078_n388# 0.03692f
C167 a_7058_n388# a_4276_406# 0.07845f
C168 a_4732_n1252# a_258_406# 0
C169 a_2078_n388# a_258_406# 0.12567f
C170 q4p a_8750_n1152# 0.09894f
C171 a_2078_792# clkn 0.01025f
C172 vdd q8n 0.43468f
C173 q2p a_4276_n774# 0.22652f
C174 clkn a_1306_n388# 0.00471f
C175 a_4732_n1252# a_258_n774# 0
C176 a_9290_792# a_8750_238# 0.15954f
C177 q2n q4p 0
C178 a_2078_n388# a_258_n774# 0.00196f
C179 q4n a_9290_792# 0
C180 a_4362_208# a_4276_406# 0.03009f
C181 a_2078_792# a_2078_148# 0.01054f
C182 a_9290_792# a_10114_792# 0
C183 a_258_406# a_4362_208# 0
C184 a_10114_238# q4p 0.0597f
C185 a_3040_n388# a_4362_n388# 0.00112f
C186 a_10114_n388# a_8750_n1152# 0.0271f
C187 a_4362_208# a_258_n774# 0.00105f
C188 a_2078_792# vdd 0.67277f
C189 a_8294_n774# a_8380_n388# 0.02685f
C190 a_7006_792# a_4276_406# 0.04435f
C191 a_2078_n388# a_2078_n1412# 0.01054f
C192 vdd a_1306_n388# 0.00491f
C193 a_4276_n774# a_8750_n1152# 0
C194 a_4362_n1252# a_4362_n388# 0.01155f
C195 q2n a_4276_n774# 0.71248f
C196 vdd a_8750_238# 1.20851f
C197 a_2078_792# q2p 0
C198 a_4732_208# a_4362_792# 0.19328f
C199 a_4732_208# a_5272_792# 0.15954f
C200 a_2078_792# a_714_148# 0.07196f
C201 a_1306_n388# a_714_148# 0.14071f
C202 a_4732_208# vdd 1.23236f
C203 q4p a_8294_n774# 0.21224f
C204 q4n vdd 1.28984f
C205 a_714_n1412# a_344_148# 0.00344f
C206 vdd a_10114_792# 0.44634f
C207 a_2078_792# a_2988_792# 0
C208 q4p a_6096_792# 0
C209 a_8294_406# a_11076_n388# 0.07837f
C210 a_258_406# a_344_148# 0.0365f
C211 q4p a_8380_n388# 0.11639f
C212 a_714_n1412# clkn 0.45756f
C213 a_6096_n388# a_4362_n388# 0
C214 vdd a_6096_208# 0.01673f
C215 a_4732_208# q2p 0.18549f
C216 a_344_148# a_258_n774# 0
C217 q4n q2p 0
C218 a_3040_n388# a_4732_n1252# 0
C219 clkn a_258_406# 0.12559f
C220 a_8294_406# q8p 0.01414f
C221 a_3040_n388# a_2078_n388# 0.00127f
C222 a_344_n388# a_344_n1412# 0.01054f
C223 a_8380_238# a_8380_792# 0.01228f
C224 a_11024_792# q8p 0.00478f
C225 a_6096_n1252# a_4362_n1252# 0.00102f
C226 a_8294_n774# a_10114_n388# 0.00124f
C227 vdd a_10114_n1152# 0.44671f
C228 a_4732_208# a_2988_792# 0
C229 clkn a_258_n774# 0.69097f
C230 a_714_n1412# a_2078_148# 0
C231 a_8380_238# a_8294_406# 0.02685f
C232 q2p a_6096_208# 0.0617f
C233 a_4732_n1252# a_4362_n1252# 0.19328f
C234 vdd a_9342_n388# 0.00414f
C235 a_258_406# a_2078_148# 0.00363f
C236 a_10114_n388# a_8380_n388# 0
C237 a_8294_n774# a_4276_n774# 0.00949f
C238 a_2078_792# clkp 0.15835f
C239 a_5272_792# a_4276_406# 0.00779f
C240 a_4362_792# a_4276_406# 0.12476f
C241 a_8750_n1152# a_8750_238# 0.68166f
C242 a_5324_n388# a_4276_n774# 0
C243 a_1306_n388# clkp 0.00147f
C244 a_714_n1412# vdd 1.34724f
C245 a_258_406# a_4362_792# 0
C246 a_6096_792# a_4276_n774# 0.19332f
C247 vdd a_4276_406# 2.34933f
C248 a_4276_n774# a_8380_n388# 0
C249 a_2078_148# a_258_n774# 0.12339f
C250 vdd a_258_406# 2.37372f
C251 a_8294_406# a_8380_792# 0.10291f
C252 vdd a_8380_n1152# 0.44613f
C253 a_8294_n774# q8n 0.03645f
C254 q4n a_8750_n1152# 0.42614f
C255 a_10114_792# a_8750_n1152# 0
C256 a_5272_792# a_258_n774# 0
C257 a_4362_792# a_258_n774# 0
C258 a_6096_n1252# a_6096_n388# 0.01155f
C259 clkn a_2078_n1412# 0.05682f
C260 q2n a_4732_208# 0.25549f
C261 q4n q2n 0.00204f
C262 q4p a_10114_n388# 0.05703f
C263 vdd a_258_n774# 2.50308f
C264 a_8294_406# a_11024_792# 0.04435f
C265 a_10114_238# a_8750_238# 0.0292f
C266 a_714_n1412# a_714_148# 0.6865f
C267 a_4732_n1252# a_6096_n388# 0.03052f
C268 q2p a_4276_406# 1.08688f
C269 a_6096_n388# a_7058_n388# 0.00185f
C270 a_4732_n1252# a_4362_n388# 0.10447f
C271 q2p a_258_406# 0.01791f
C272 q4p a_4276_n774# 0.21467f
C273 a_258_406# a_714_148# 0.0371f
C274 q4n a_10114_238# 0.11626f
C275 q2n a_6096_208# 0.12239f
C276 a_10114_238# a_10114_792# 0.01228f
C277 q2p a_258_n774# 0.22811f
C278 a_2988_792# a_4276_406# 0
C279 a_258_n774# a_714_148# 0.01614f
C280 a_10114_n1152# a_8750_n1152# 0.04768f
C281 a_258_406# a_2988_792# 0.04586f
C282 a_2078_792# a_1254_792# 0
C283 q4p q8n 0
C284 vdd a_2078_n1412# 0.67302f
C285 a_344_148# a_344_792# 0.01054f
C286 a_9342_n388# a_8750_n1152# 0.07812f
C287 a_2988_792# a_258_n774# 0.16478f
C288 a_2078_n388# a_344_n388# 0
C289 a_8750_n1152# a_4276_406# 0
C290 clkn a_344_792# 0.1121f
C291 a_8294_n774# a_8750_238# 0.01615f
C292 clkn a_3040_n388# 0
C293 a_8380_n1152# a_8750_n1152# 0.15901f
C294 a_714_148# a_2078_n1412# 0
C295 q2n a_4276_406# 0.11422f
C296 a_6096_n1252# a_4732_n1252# 0.05716f
C297 a_8750_238# a_8380_n388# 0
C298 q2n a_258_406# 0.18968f
C299 q4n a_8294_n774# 0.70603f
C300 a_714_n1412# clkp 0.11151f
C301 a_4732_208# a_5324_n388# 0.14148f
C302 a_8294_n774# a_10114_792# 0.15906f
C303 a_4732_208# a_6096_792# 0.05727f
C304 a_10114_n388# q8n 0
C305 clkp a_258_406# 1.07462f
C306 q4n a_8380_n388# 0.06002f
C307 a_4732_n1252# a_7058_n388# 0
C308 q2n a_258_n774# 0.03947f
C309 a_7006_792# a_8380_792# 0
C310 clkp a_258_n774# 0.24864f
C311 vdd a_344_792# 0.67687f
C312 a_8294_406# a_7006_792# 0
C313 a_6096_792# a_6096_208# 0.01155f
C314 q4p a_8750_238# 0.17961f
C315 clkn a_344_n1412# 0.15897f
C316 vdd a_3040_n388# 0.00459f
C317 a_10114_n1152# a_8294_n774# 0.03602f
C318 q4n q4p 0.46835f
C319 q4p a_10114_792# 0.1695f
C320 a_4732_n1252# a_4362_208# 0.00289f
C321 a_8294_n774# a_9342_n388# 0
C322 q2n a_2078_n1412# 0
C323 vdd a_4362_n1252# 0.5267f
C324 a_344_792# a_714_148# 0.24665f
C325 vdd a_11076_n388# 0.00446f
C326 q2p a_3040_n388# 0
C327 a_9290_792# a_8380_792# 0
C328 clkp a_2078_n1412# 0.1121f
C329 a_9342_n388# a_8380_n388# 0.00225f
C330 a_714_n1412# a_1254_792# 0.03969f
C331 q4p a_6096_208# 0
C332 a_8294_n774# a_4276_406# 0.01106f
C333 a_8294_406# a_9290_792# 0.00779f
C334 a_1254_792# a_258_406# 0.00791f
C335 a_8380_n1152# a_8294_n774# 0.10539f
C336 a_5324_n388# a_4276_406# 0
C337 vdd a_344_n1412# 0.67711f
C338 a_10114_n388# a_8750_238# 0.00221f
C339 a_9290_792# a_11024_792# 0.00101f
C340 vdd q8p 0.44198f
C341 a_6096_792# a_4276_406# 0.05293f
C342 a_258_406# a_5324_n388# 0
C343 a_4276_406# a_8380_n388# 0
C344 q2p a_4362_n1252# 0.00958f
C345 q4p a_10114_n1152# 0.08415f
C346 a_8380_n1152# a_8380_n388# 0.01228f
C347 a_1254_792# a_258_n774# 0
C348 q4n a_10114_n388# 0.11861f
C349 a_4276_n774# a_8750_238# 0
C350 clkn a_344_n388# 0.06469f
C351 vdd a_8380_238# 0.01647f
C352 q4p a_9342_n388# 0.00105f
C353 a_4732_208# a_4276_n774# 0.01615f
C354 vdd a_6096_n388# 0.01673f
C355 vdd a_4362_n388# 0.01673f
C356 q4n a_4276_n774# 0.03806f
C357 a_344_n1412# a_714_148# 0
C358 q4p a_4276_406# 0.0169f
C359 q2n a_3040_n388# 0
C360 q4p a_8380_n1152# 0.00905f
C361 vdd a_8380_792# 0.44578f
C362 a_4276_n774# a_6096_208# 0.10249f
C363 q2p a_6096_n388# 0.05867f
C364 q4n q8n 0.00204f
C365 clkp a_344_792# 0.06528f
C366 q2p a_4362_n388# 0.12253f
C367 a_3040_n388# clkp 0
C368 a_10114_n1152# a_10114_n388# 0.01228f
C369 a_11076_n388# a_8750_n1152# 0
C370 vdd a_8294_406# 2.34062f
C371 clkn a_2078_n388# 0.13677f
C372 vdd a_344_n388# 0.02046f
C373 vdd a_11024_792# 0.25676f
C374 a_10114_n388# a_9342_n388# 0.00354f
C375 q2n a_4362_n1252# 0.16536f
C376 vdd a_6096_n1252# 0.52729f
C377 a_10114_n1152# q8n 0
C378 a_344_n388# a_714_148# 0.00146f
C379 a_4732_n1252# a_4362_792# 0
C380 a_4732_n1252# a_5272_792# 0.03849f
C381 a_8380_238# a_8750_n1152# 0.00279f
C382 a_4276_n774# a_4276_406# 0.88472f
C383 clkp a_344_n1412# 0.01025f
C384 a_258_406# a_4276_n774# 0.01155f
C385 vdd a_4732_n1252# 1.28516f
C386 vdd a_7058_n388# 0.00446f
C387 a_8380_n1152# a_4276_n774# 0
C388 vdd a_2078_n388# 0.01677f
C389 a_10114_238# q8p 0
C390 q2n a_6096_n388# 0.1251f
C391 q2n a_4362_n388# 0.06203f
C392 a_1254_792# a_344_792# 0
C393 q2p a_6096_n1252# 0.09524f
C394 a_4276_n774# a_258_n774# 0.00958f
C395 q4n a_8750_238# 0.24473f
C396 a_10114_792# a_8750_238# 0.04786f
C397 a_8750_n1152# a_8380_792# 0
C398 a_10114_238# a_8380_238# 0.00102f
C399 q2p a_4732_n1252# 0.10308f
C400 q2p a_7058_n388# 0
C401 a_4362_208# a_4362_792# 0.01155f
C402 a_8294_406# a_8750_n1152# 0.01574f
C403 a_2078_n388# a_714_148# 0.00364f
C404 q4n a_10114_792# 0.00905f
C405 vdd a_4362_208# 0.01673f
C406 a_8294_n774# a_11076_n388# 0.14303f
C407 a_4732_208# a_6096_208# 0.03278f
C408 a_4732_n1252# a_2988_792# 0
C409 a_5272_792# a_7006_792# 0.00101f
C410 a_2078_792# a_714_n1412# 0
C411 clkp a_344_n388# 0.13422f
C412 a_10114_n1152# a_8750_238# 0
C413 clkn a_344_148# 0.06171f
C414 a_8294_n774# q8p 0.18954f
C415 a_714_n1412# a_1306_n388# 0.08448f
C416 vdd a_7006_792# 0.25722f
C417 q2p a_4362_208# 0.12599f
C418 a_2078_792# a_258_406# 0.07034f
C419 a_10114_238# a_8294_406# 0.00279f
C420 a_1306_n388# a_258_406# 0
C421 a_9342_n388# a_8750_238# 0.14148f
C422 q4n a_10114_n1152# 0.09908f
C423 q2n a_6096_n1252# 0.07589f
C424 a_8380_238# a_8294_n774# 0
C425 a_7058_n388# a_8750_n1152# 0
C426 a_2078_792# a_258_n774# 0.24669f
C427 q4n a_9342_n388# 0.00407f
C428 a_2078_148# a_344_148# 0.00102f
C429 a_1306_n388# a_258_n774# 0
C430 a_8750_238# a_4276_406# 0
C431 q4p a_11076_n388# 0
C432 q2p a_7006_792# 0.00117f
C433 q2n a_4732_n1252# 0.43875f
C434 a_6096_n388# a_5324_n388# 0.003f
C435 q2n a_7058_n388# 0
C436 q2n a_2078_n388# 0
C437 a_4362_n388# a_5324_n388# 0.00185f
C438 a_8380_n1152# a_8750_238# 0
C439 a_4732_208# a_4276_406# 0.0317f
C440 a_4732_208# a_258_406# 0
C441 q4n a_4276_406# 0.1779f
C442 clkp a_2078_n388# 0.06171f
C443 clkn a_2078_148# 0.13407f
C444 vdd a_344_148# 0.02046f
C445 vdd a_9290_792# 0.25286f
C446 q4n a_8380_n1152# 0.17301f
C447 q4p q8p 0.00239f
C448 a_4732_208# a_258_n774# 0
C449 q8n vss 0.29927f
C450 q8p vss 0.30239f
C451 q4n vss 1.47102f
C452 q4p vss 1.54165f
C453 q2n vss 1.49197f
C454 q2p vss 1.56083f
C455 clkp vss 1.40925f
C456 clkn vss 1.28447f
C457 vdd vss 97.624f
C458 a_10114_n1152# vss 0.00482f
C459 a_8380_n1152# vss 0.00431f
C460 a_6096_n1252# vss 0.0025f
C461 a_4362_n1252# vss 0.00218f
C462 a_11076_n388# vss 0.19681f
C463 a_10114_n388# vss 0.25868f
C464 a_9342_n388# vss 0.19196f
C465 a_8380_n388# vss 0.26094f
C466 a_344_n1412# vss 0.00212f
C467 a_7058_n388# vss 0.19416f
C468 a_6096_n388# vss 0.27957f
C469 a_5324_n388# vss 0.19333f
C470 a_4362_n388# vss 0.28079f
C471 a_3040_n388# vss 0.20468f
C472 a_2078_n388# vss 0.3238f
C473 a_1306_n388# vss 0.20531f
C474 a_344_n388# vss 0.32662f
C475 a_10114_238# vss 0.26673f
C476 a_8380_238# vss 0.26607f
C477 a_6096_208# vss 0.28593f
C478 a_4362_208# vss 0.28527f
C479 a_11024_792# vss 0.00755f
C480 a_10114_792# vss 0.00431f
C481 a_9290_792# vss 0.00579f
C482 a_8750_n1152# vss 1.4709f
C483 a_8380_792# vss 0.0043f
C484 a_8750_238# vss 1.46295f
C485 a_8294_406# vss 1.88074f
C486 a_8294_n774# vss 2.08149f
C487 a_2078_148# vss 0.32765f
C488 a_344_148# vss 0.32812f
C489 a_7006_792# vss 0.00607f
C490 a_4276_n774# vss 1.99225f
C491 a_6096_792# vss 0.00218f
C492 a_5272_792# vss 0.00579f
C493 a_4732_n1252# vss 1.47666f
C494 a_4362_792# vss 0.00218f
C495 a_4732_208# vss 1.46792f
C496 a_4276_406# vss 1.8615f
C497 a_2988_792# vss 0.00588f
C498 a_258_n774# vss 2.1411f
C499 a_1254_792# vss 0.0059f
C500 a_714_n1412# vss 1.49666f
C501 a_344_792# vss 0.00212f
C502 a_714_148# vss 1.48482f
C503 a_258_406# vss 2.0158f
.ends
