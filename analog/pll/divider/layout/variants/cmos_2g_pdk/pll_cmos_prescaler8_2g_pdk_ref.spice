* PDK LVS reference netlist for pll_cmos_prescaler8_2g_pdk
.subckt pll_cmos_prescaler8_2g_pdk clkp clkn q2p q2n q4p q4n q8p q8n vdd vss
Xd2_mp_p1 d2_n1mp d2_qni vdd vdd sky130_fd_pr__pfet_01v8 w=6.2 l=0.15
Xd2_mp_p2 d2_mp clkn d2_n1mp vdd sky130_fd_pr__pfet_01v8 w=6.2 l=0.15
Xd2_mp_n1 d2_mp clkp d2_n2mp vss sky130_fd_pr__nfet_01v8 w=2.4 l=0.15
Xd2_mp_n2 d2_n2mp d2_qni vss vss sky130_fd_pr__nfet_01v8 w=2.4 l=0.15
Xd2_mn_p1 d2_n1mn d2_qpi vdd vdd sky130_fd_pr__pfet_01v8 w=6.2 l=0.15
Xd2_mn_p2 d2_mn clkn d2_n1mn vdd sky130_fd_pr__pfet_01v8 w=6.2 l=0.15
Xd2_mn_n1 d2_mn clkp d2_n2mn vss sky130_fd_pr__nfet_01v8 w=2.4 l=0.15
Xd2_mn_n2 d2_n2mn d2_qpi vss vss sky130_fd_pr__nfet_01v8 w=2.4 l=0.15
Xd2_kmp_n d2_mp d2_mn vss vss sky130_fd_pr__nfet_01v8 w=0.6 l=0.15
Xd2_kmp_p d2_mp d2_mn vdd vdd sky130_fd_pr__pfet_01v8 w=1.3 l=0.15
Xd2_kmn_n d2_mn d2_mp vss vss sky130_fd_pr__nfet_01v8 w=0.6 l=0.15
Xd2_kmn_p d2_mn d2_mp vdd vdd sky130_fd_pr__pfet_01v8 w=1.3 l=0.15
Xd2_cmmn1 d2_mn d2_mp d2_ncmm vss sky130_fd_pr__nfet_01v8 w=0.7 l=0.15
Xd2_cmmn2 d2_ncmm d2_mn vss vss sky130_fd_pr__nfet_01v8 w=0.7 l=0.15
Xd2_cmmp1 d2_mp d2_mn d2_pcmm vdd sky130_fd_pr__pfet_01v8 w=1.4 l=0.15
Xd2_cmmp2 d2_pcmm d2_mp vdd vdd sky130_fd_pr__pfet_01v8 w=1.4 l=0.15
Xd2_sp_p1 d2_n1sp d2_mp vdd vdd sky130_fd_pr__pfet_01v8 w=6.2 l=0.15
Xd2_sp_p2 d2_qpi clkp d2_n1sp vdd sky130_fd_pr__pfet_01v8 w=6.2 l=0.15
Xd2_sp_n1 d2_qpi clkn d2_n2sp vss sky130_fd_pr__nfet_01v8 w=2.4 l=0.15
Xd2_sp_n2 d2_n2sp d2_mp vss vss sky130_fd_pr__nfet_01v8 w=2.4 l=0.15
Xd2_sn_p1 d2_n1sn d2_mn vdd vdd sky130_fd_pr__pfet_01v8 w=6.2 l=0.15
Xd2_sn_p2 d2_qni clkp d2_n1sn vdd sky130_fd_pr__pfet_01v8 w=6.2 l=0.15
Xd2_sn_n1 d2_qni clkn d2_n2sn vss sky130_fd_pr__nfet_01v8 w=2.4 l=0.15
Xd2_sn_n2 d2_n2sn d2_mn vss vss sky130_fd_pr__nfet_01v8 w=2.4 l=0.15
Xd2_kqp_n d2_qpi d2_qni vss vss sky130_fd_pr__nfet_01v8 w=0.6 l=0.15
Xd2_kqp_p d2_qpi d2_qni vdd vdd sky130_fd_pr__pfet_01v8 w=1.3 l=0.15
Xd2_kqn_n d2_qni d2_qpi vss vss sky130_fd_pr__nfet_01v8 w=0.6 l=0.15
Xd2_kqn_p d2_qni d2_qpi vdd vdd sky130_fd_pr__pfet_01v8 w=1.3 l=0.15
Xd2_cmqn1 d2_qni d2_qpi d2_ncmq vss sky130_fd_pr__nfet_01v8 w=0.7 l=0.15
Xd2_cmqn2 d2_ncmq d2_qni vss vss sky130_fd_pr__nfet_01v8 w=0.7 l=0.15
Xd2_cmqp1 d2_qpi d2_qni d2_pcmq vdd sky130_fd_pr__pfet_01v8 w=1.4 l=0.15
Xd2_cmqp2 d2_pcmq d2_qpi vdd vdd sky130_fd_pr__pfet_01v8 w=1.4 l=0.15
Xd2_obp_n q2p d2_qpi vss vss sky130_fd_pr__nfet_01v8 w=3.0 l=0.15
Xd2_obp_p q2p d2_qpi vdd vdd sky130_fd_pr__pfet_01v8 w=4.6 l=0.15
Xd2_obn_n q2n d2_qni vss vss sky130_fd_pr__nfet_01v8 w=3.0 l=0.15
Xd2_obn_p q2n d2_qni vdd vdd sky130_fd_pr__pfet_01v8 w=4.6 l=0.15
Xd4_mp_p1 d4_n1mp d4_qni vdd vdd sky130_fd_pr__pfet_01v8 w=4.6 l=0.15
Xd4_mp_p2 d4_mp q2n d4_n1mp vdd sky130_fd_pr__pfet_01v8 w=4.6 l=0.15
Xd4_mp_n1 d4_mp q2p d4_n2mp vss sky130_fd_pr__nfet_01v8 w=1.8 l=0.15
Xd4_mp_n2 d4_n2mp d4_qni vss vss sky130_fd_pr__nfet_01v8 w=1.8 l=0.15
Xd4_mn_p1 d4_n1mn d4_qpi vdd vdd sky130_fd_pr__pfet_01v8 w=4.6 l=0.15
Xd4_mn_p2 d4_mn q2n d4_n1mn vdd sky130_fd_pr__pfet_01v8 w=4.6 l=0.15
Xd4_mn_n1 d4_mn q2p d4_n2mn vss sky130_fd_pr__nfet_01v8 w=1.8 l=0.15
Xd4_mn_n2 d4_n2mn d4_qpi vss vss sky130_fd_pr__nfet_01v8 w=1.8 l=0.15
Xd4_kmp_n d4_mp d4_mn vss vss sky130_fd_pr__nfet_01v8 w=0.6 l=0.15
Xd4_kmp_p d4_mp d4_mn vdd vdd sky130_fd_pr__pfet_01v8 w=1.3 l=0.15
Xd4_kmn_n d4_mn d4_mp vss vss sky130_fd_pr__nfet_01v8 w=0.6 l=0.15
Xd4_kmn_p d4_mn d4_mp vdd vdd sky130_fd_pr__pfet_01v8 w=1.3 l=0.15
Xd4_cmmn1 d4_mn d4_mp d4_ncmm vss sky130_fd_pr__nfet_01v8 w=0.6 l=0.15
Xd4_cmmn2 d4_ncmm d4_mn vss vss sky130_fd_pr__nfet_01v8 w=0.6 l=0.15
Xd4_cmmp1 d4_mp d4_mn d4_pcmm vdd sky130_fd_pr__pfet_01v8 w=1.3 l=0.15
Xd4_cmmp2 d4_pcmm d4_mp vdd vdd sky130_fd_pr__pfet_01v8 w=1.3 l=0.15
Xd4_sp_p1 d4_n1sp d4_mp vdd vdd sky130_fd_pr__pfet_01v8 w=4.6 l=0.15
Xd4_sp_p2 d4_qpi q2p d4_n1sp vdd sky130_fd_pr__pfet_01v8 w=4.6 l=0.15
Xd4_sp_n1 d4_qpi q2n d4_n2sp vss sky130_fd_pr__nfet_01v8 w=1.8 l=0.15
Xd4_sp_n2 d4_n2sp d4_mp vss vss sky130_fd_pr__nfet_01v8 w=1.8 l=0.15
Xd4_sn_p1 d4_n1sn d4_mn vdd vdd sky130_fd_pr__pfet_01v8 w=4.6 l=0.15
Xd4_sn_p2 d4_qni q2p d4_n1sn vdd sky130_fd_pr__pfet_01v8 w=4.6 l=0.15
Xd4_sn_n1 d4_qni q2n d4_n2sn vss sky130_fd_pr__nfet_01v8 w=1.8 l=0.15
Xd4_sn_n2 d4_n2sn d4_mn vss vss sky130_fd_pr__nfet_01v8 w=1.8 l=0.15
Xd4_kqp_n d4_qpi d4_qni vss vss sky130_fd_pr__nfet_01v8 w=0.6 l=0.15
Xd4_kqp_p d4_qpi d4_qni vdd vdd sky130_fd_pr__pfet_01v8 w=1.3 l=0.15
Xd4_kqn_n d4_qni d4_qpi vss vss sky130_fd_pr__nfet_01v8 w=0.6 l=0.15
Xd4_kqn_p d4_qni d4_qpi vdd vdd sky130_fd_pr__pfet_01v8 w=1.3 l=0.15
Xd4_cmqn1 d4_qni d4_qpi d4_ncmq vss sky130_fd_pr__nfet_01v8 w=0.6 l=0.15
Xd4_cmqn2 d4_ncmq d4_qni vss vss sky130_fd_pr__nfet_01v8 w=0.6 l=0.15
Xd4_cmqp1 d4_qpi d4_qni d4_pcmq vdd sky130_fd_pr__pfet_01v8 w=1.3 l=0.15
Xd4_cmqp2 d4_pcmq d4_qpi vdd vdd sky130_fd_pr__pfet_01v8 w=1.3 l=0.15
Xd4_obp_n q4p d4_qpi vss vss sky130_fd_pr__nfet_01v8 w=2.2 l=0.15
Xd4_obp_p q4p d4_qpi vdd vdd sky130_fd_pr__pfet_01v8 w=4.2 l=0.15
Xd4_obn_n q4n d4_qni vss vss sky130_fd_pr__nfet_01v8 w=2.2 l=0.15
Xd4_obn_p q4n d4_qni vdd vdd sky130_fd_pr__pfet_01v8 w=4.2 l=0.15
Xd8_mp_p1 d8_n1mp d8_qni vdd vdd sky130_fd_pr__pfet_01v8 w=3.6 l=0.15
Xd8_mp_p2 d8_mp q4n d8_n1mp vdd sky130_fd_pr__pfet_01v8 w=3.6 l=0.15
Xd8_mp_n1 d8_mp q4p d8_n2mp vss sky130_fd_pr__nfet_01v8 w=1.5 l=0.15
Xd8_mp_n2 d8_n2mp d8_qni vss vss sky130_fd_pr__nfet_01v8 w=1.5 l=0.15
Xd8_mn_p1 d8_n1mn d8_qpi vdd vdd sky130_fd_pr__pfet_01v8 w=3.6 l=0.15
Xd8_mn_p2 d8_mn q4n d8_n1mn vdd sky130_fd_pr__pfet_01v8 w=3.6 l=0.15
Xd8_mn_n1 d8_mn q4p d8_n2mn vss sky130_fd_pr__nfet_01v8 w=1.5 l=0.15
Xd8_mn_n2 d8_n2mn d8_qpi vss vss sky130_fd_pr__nfet_01v8 w=1.5 l=0.15
Xd8_kmp_n d8_mp d8_mn vss vss sky130_fd_pr__nfet_01v8 w=0.6 l=0.15
Xd8_kmp_p d8_mp d8_mn vdd vdd sky130_fd_pr__pfet_01v8 w=1.3 l=0.15
Xd8_kmn_n d8_mn d8_mp vss vss sky130_fd_pr__nfet_01v8 w=0.6 l=0.15
Xd8_kmn_p d8_mn d8_mp vdd vdd sky130_fd_pr__pfet_01v8 w=1.3 l=0.15
Xd8_cmmn1 d8_mn d8_mp d8_ncmm vss sky130_fd_pr__nfet_01v8 w=0.6 l=0.15
Xd8_cmmn2 d8_ncmm d8_mn vss vss sky130_fd_pr__nfet_01v8 w=0.6 l=0.15
Xd8_cmmp1 d8_mp d8_mn d8_pcmm vdd sky130_fd_pr__pfet_01v8 w=1.3 l=0.15
Xd8_cmmp2 d8_pcmm d8_mp vdd vdd sky130_fd_pr__pfet_01v8 w=1.3 l=0.15
Xd8_sp_p1 d8_n1sp d8_mp vdd vdd sky130_fd_pr__pfet_01v8 w=3.6 l=0.15
Xd8_sp_p2 d8_qpi q4p d8_n1sp vdd sky130_fd_pr__pfet_01v8 w=3.6 l=0.15
Xd8_sp_n1 d8_qpi q4n d8_n2sp vss sky130_fd_pr__nfet_01v8 w=1.5 l=0.15
Xd8_sp_n2 d8_n2sp d8_mp vss vss sky130_fd_pr__nfet_01v8 w=1.5 l=0.15
Xd8_sn_p1 d8_n1sn d8_mn vdd vdd sky130_fd_pr__pfet_01v8 w=3.6 l=0.15
Xd8_sn_p2 d8_qni q4p d8_n1sn vdd sky130_fd_pr__pfet_01v8 w=3.6 l=0.15
Xd8_sn_n1 d8_qni q4n d8_n2sn vss sky130_fd_pr__nfet_01v8 w=1.5 l=0.15
Xd8_sn_n2 d8_n2sn d8_mn vss vss sky130_fd_pr__nfet_01v8 w=1.5 l=0.15
Xd8_kqp_n d8_qpi d8_qni vss vss sky130_fd_pr__nfet_01v8 w=0.6 l=0.15
Xd8_kqp_p d8_qpi d8_qni vdd vdd sky130_fd_pr__pfet_01v8 w=1.3 l=0.15
Xd8_kqn_n d8_qni d8_qpi vss vss sky130_fd_pr__nfet_01v8 w=0.6 l=0.15
Xd8_kqn_p d8_qni d8_qpi vdd vdd sky130_fd_pr__pfet_01v8 w=1.3 l=0.15
Xd8_cmqn1 d8_qni d8_qpi d8_ncmq vss sky130_fd_pr__nfet_01v8 w=0.6 l=0.15
Xd8_cmqn2 d8_ncmq d8_qni vss vss sky130_fd_pr__nfet_01v8 w=0.6 l=0.15
Xd8_cmqp1 d8_qpi d8_qni d8_pcmq vdd sky130_fd_pr__pfet_01v8 w=1.3 l=0.15
Xd8_cmqp2 d8_pcmq d8_qpi vdd vdd sky130_fd_pr__pfet_01v8 w=1.3 l=0.15
Xd8_obp_n q8p d8_qpi vss vss sky130_fd_pr__nfet_01v8 w=2.0 l=0.15
Xd8_obp_p q8p d8_qpi vdd vdd sky130_fd_pr__pfet_01v8 w=4.2 l=0.15
Xd8_obn_n q8n d8_qni vss vss sky130_fd_pr__nfet_01v8 w=2.0 l=0.15
Xd8_obn_p q8n d8_qni vdd vdd sky130_fd_pr__pfet_01v8 w=4.2 l=0.15
.ends pll_cmos_prescaler8_2g_pdk
