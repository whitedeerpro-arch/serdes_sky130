* NGSPICE file created from pll_div_ab_5g_pdk.ext - technology: sky130A

.subckt pll_div_ab_5g_pdk clkp clkn mode_5g rst_n fb250 fb250_b vdd vss
X0 a_23761_n1316# a_458_n1256# a_23857_n604# vss sky130_fd_pr__nfet_01v8_lvt ad=0.2475 pd=1.83 as=0.465 ps=3.62 w=1.5 l=0.15
X1 a_3761_n1520# a_3761_1016# vdd vdd sky130_fd_pr__pfet_01v8 ad=0.609 pd=4.78 as=0.609 ps=4.78 w=2.1 l=0.15
X2 vdd a_1579_n1464# a_3761_n1520# vdd sky130_fd_pr__pfet_01v8 ad=0.4158 pd=2.85 as=0.4158 ps=2.85 w=2.52 l=0.15
X3 a_11026_n1576# a_11026_1016# vss vss sky130_fd_pr__nfet_01v8_lvt ad=0.1218 pd=1.42 as=0.1218 ps=1.42 w=0.42 l=0.15
X4 a_25726_n1296# a_26044_1016# a_26044_n1336# vss sky130_fd_pr__nfet_01v8_lvt ad=0.403 pd=3.22 as=0.2145 ps=1.63 w=1.3 l=0.15
X5 a_27304_n1336# rst_n vdd vdd sky130_fd_pr__pfet_01v8 ad=0.696 pd=5.38 as=0.696 ps=5.38 w=2.4 l=0.18
X6 a_17736_n1316# a_7623_1016# a_8606_n998# vdd sky130_fd_pr__pfet_01v8 ad=0.2475 pd=1.83 as=0.465 ps=3.62 w=1.5 l=0.15
X7 a_8606_n998# a_15745_1016# vss vss sky130_fd_pr__nfet_01v8_lvt ad=0.464 pd=3.78 as=0.464 ps=3.78 w=1.6 l=0.15
X8 a_23761_n1316# a_458_n1256# a_24327_n1516# vdd sky130_fd_pr__pfet_01v8 ad=0.4125 pd=2.83 as=0.775 ps=5.62 w=2.5 l=0.15
X9 a_2697_n1464# a_2323_n1520# vss vss sky130_fd_pr__nfet_01v8_lvt ad=0.464 pd=3.78 as=0.464 ps=3.78 w=1.6 l=0.15
X10 a_25726_n1296# a_3167_n1520# vdd vdd sky130_fd_pr__pfet_01v8 ad=0.406 pd=3.38 as=0.406 ps=3.38 w=1.4 l=0.15
X11 a_25678_n604# a_23761_n1316# a_25726_1016# vss sky130_fd_pr__nfet_01v8_lvt ad=0.465 pd=3.62 as=0.2475 ps=1.83 w=1.5 l=0.15
X12 vss a_21784_1016# a_22846_n1496# vss sky130_fd_pr__nfet_01v8_lvt ad=0.372 pd=3.02 as=0.198 ps=1.53 w=1.2 l=0.15
X13 a_859_n1496# clkn vss vss sky130_fd_pr__nfet_01v8_lvt ad=0.348 pd=2.98 as=0.348 ps=2.98 w=1.2 l=0.15
X14 a_22846_1016# a_22846_n1496# vss vss sky130_fd_pr__nfet_01v8_lvt ad=0.1218 pd=1.42 as=0.1218 ps=1.42 w=0.42 l=0.15
X15 vss a_27010_n1576# a_27304_324# vss sky130_fd_pr__nfet_01v8_lvt ad=0.434 pd=3.42 as=0.231 ps=1.73 w=1.4 l=0.15
X16 vdd a_5119_n716# a_7623_n1520# vdd sky130_fd_pr__pfet_01v8 ad=0.4158 pd=2.85 as=0.4158 ps=2.85 w=2.52 l=0.15
X17 a_25726_1016# a_23761_n1316# a_25678_n604# vss sky130_fd_pr__nfet_01v8_lvt ad=0.2475 pd=1.83 as=0.465 ps=3.62 w=1.5 l=0.15
X18 a_5119_622# rst_n vdd vdd sky130_fd_pr__pfet_01v8 ad=0.696 pd=5.38 as=0.696 ps=5.38 w=2.4 l=0.18
X19 a_3167_n1520# a_2697_n1464# vss vss sky130_fd_pr__nfet_01v8_lvt ad=0.198 pd=1.53 as=0.372 ps=3.02 w=1.2 l=0.15
X20 vdd a_8606_622# a_8696_1016# vdd sky130_fd_pr__pfet_01v8 ad=0.744 pd=5.42 as=0.396 ps=2.73 w=2.4 l=0.15
X21 a_27304_324# a_27010_n1576# vss vss sky130_fd_pr__nfet_01v8_lvt ad=0.231 pd=1.73 as=0.434 ps=3.42 w=1.4 l=0.15
X22 a_17736_n1316# a_17736_1016# vss vss sky130_fd_pr__nfet_01v8 ad=0.1218 pd=1.42 as=0.1218 ps=1.42 w=0.42 l=0.28
X23 vdd a_12921_1016# a_23761_1016# vdd sky130_fd_pr__pfet_01v8 ad=0.33 pd=2.33 as=0.33 ps=2.33 w=2 l=0.15
X24 a_8980_n998# a_8980_622# vdd vdd sky130_fd_pr__pfet_01v8 ad=0.5104 pd=4.1 as=0.5104 ps=4.1 w=1.76 l=0.15
X25 a_13850_1016# a_7623_n1520# a_12921_1016# vss sky130_fd_pr__nfet_01v8_lvt ad=0.348 pd=2.98 as=0.348 ps=2.98 w=1.2 l=0.15
X26 a_11026_n1576# a_9964_1016# vss vss sky130_fd_pr__nfet_01v8_lvt ad=0.406 pd=3.38 as=0.406 ps=3.38 w=1.4 l=0.15
X27 a_5119_n716# a_5209_1016# vdd vdd sky130_fd_pr__pfet_01v8 ad=0.3465 pd=2.43 as=0.651 ps=4.82 w=2.1 l=0.15
X28 a_458_484# rst_n vdd vdd sky130_fd_pr__pfet_01v8 ad=0.348 pd=2.98 as=0.348 ps=2.98 w=1.2 l=0.18
X29 a_2323_n1520# a_1579_n1464# vdd vdd sky130_fd_pr__pfet_01v8 ad=0.4158 pd=2.85 as=0.7812 ps=5.66 w=2.52 l=0.15
X30 a_26044_1016# a_3167_n1520# a_26044_n1336# vdd sky130_fd_pr__pfet_01v8 ad=0.319 pd=2.78 as=0.319 ps=2.78 w=1.1 l=0.15
X31 vdd a_26044_n1336# a_27304_n1336# vdd sky130_fd_pr__pfet_01v8 ad=0.496 pd=3.82 as=0.264 ps=1.93 w=1.6 l=0.15
X32 a_8606_n998# a_8606_622# vss vss sky130_fd_pr__nfet_01v8_lvt ad=0.1218 pd=1.42 as=0.1218 ps=1.42 w=0.42 l=0.15
X33 vdd a_2323_n1520# a_2697_n1464# vdd sky130_fd_pr__pfet_01v8 ad=0.3696 pd=2.57 as=0.3696 ps=2.57 w=2.24 l=0.15
X34 a_23761_n1316# a_12921_n1656# vdd vdd sky130_fd_pr__pfet_01v8 ad=0.2475 pd=1.83 as=0.465 ps=3.62 w=1.5 l=0.15
X35 vdd a_859_n1496# a_1579_n1464# vdd sky130_fd_pr__pfet_01v8 ad=0.3696 pd=2.57 as=0.3696 ps=2.57 w=2.24 l=0.15
X36 vdd a_27304_n1336# fb250 vdd sky130_fd_pr__pfet_01v8 ad=0.4158 pd=2.85 as=0.4158 ps=2.85 w=2.52 l=0.15
X37 a_4843_n604# a_3761_n1520# vss vss sky130_fd_pr__nfet_01v8_lvt ad=0.23925 pd=1.78 as=0.4495 ps=3.52 w=1.45 l=0.15
X38 fb250_b a_27304_324# vdd vdd sky130_fd_pr__pfet_01v8 ad=0.4158 pd=2.85 as=0.7812 ps=5.66 w=2.52 l=0.15
X39 a_26044_n1336# a_3167_n1520# a_26044_1016# vdd sky130_fd_pr__pfet_01v8 ad=0.319 pd=2.78 as=0.319 ps=2.78 w=1.1 l=0.15
X40 a_24327_n1516# a_22846_n1496# vdd vdd sky130_fd_pr__pfet_01v8 ad=0.4125 pd=2.83 as=0.4125 ps=2.83 w=2.5 l=0.15
X41 a_2323_n1520# a_1579_n1464# vss vss sky130_fd_pr__nfet_01v8_lvt ad=0.348 pd=2.98 as=0.348 ps=2.98 w=1.2 l=0.15
X42 a_9030_244# mode_5g vss vss sky130_fd_pr__nfet_01v8_lvt ad=0.522 pd=4.18 as=0.522 ps=4.18 w=1.8 l=0.15
X43 a_23761_1016# a_22846_1016# a_23857_404# vdd sky130_fd_pr__pfet_01v8 ad=0.33 pd=2.33 as=0.33 ps=2.33 w=2 l=0.15
X44 a_27304_n1336# a_27010_464# vss vss sky130_fd_pr__nfet_01v8_lvt ad=0.231 pd=1.73 as=0.434 ps=3.42 w=1.4 l=0.15
X45 a_13850_n1316# a_13850_1016# vss vss sky130_fd_pr__nfet_01v8 ad=0.1218 pd=1.42 as=0.1218 ps=1.42 w=0.42 l=0.28
X46 a_3761_n1520# a_1579_n1464# vdd vdd sky130_fd_pr__pfet_01v8 ad=0.4158 pd=2.85 as=0.4158 ps=2.85 w=2.52 l=0.15
X47 a_23857_n604# a_458_n1256# a_23761_n1316# vss sky130_fd_pr__nfet_01v8_lvt ad=0.465 pd=3.62 as=0.2475 ps=1.83 w=1.5 l=0.15
X48 a_22846_1016# a_21784_n1456# vss vss sky130_fd_pr__nfet_01v8_lvt ad=0.198 pd=1.53 as=0.372 ps=3.02 w=1.2 l=0.15
X49 vdd a_21784_n1456# a_22846_1016# vdd sky130_fd_pr__pfet_01v8 ad=0.744 pd=5.42 as=0.396 ps=2.73 w=2.4 l=0.15
X50 a_15745_n1316# a_7623_n1520# a_14912_n1520# vdd sky130_fd_pr__pfet_01v8 ad=0.2475 pd=1.83 as=0.465 ps=3.62 w=1.5 l=0.15
X51 a_27304_324# a_27304_n1336# vss vss sky130_fd_pr__nfet_01v8 ad=0.1595 pd=1.68 as=0.1595 ps=1.68 w=0.55 l=0.15
X52 a_8606_n998# a_7623_1016# a_17736_n1316# vdd sky130_fd_pr__pfet_01v8 ad=0.465 pd=3.62 as=0.2475 ps=1.83 w=1.5 l=0.15
X53 a_8980_622# a_19631_n1316# vss vss sky130_fd_pr__nfet_01v8_lvt ad=0.464 pd=3.78 as=0.464 ps=3.78 w=1.6 l=0.15
X54 a_12921_1016# a_7623_1016# a_21784_1016# vdd sky130_fd_pr__pfet_01v8 ad=0.682 pd=5.02 as=0.363 ps=2.53 w=2.2 l=0.15
X55 vdd a_11859_n1416# a_12921_1016# vdd sky130_fd_pr__pfet_01v8 ad=0.528 pd=3.53 as=0.528 ps=3.53 w=3.2 l=0.15
X56 a_9964_1016# a_9964_n1416# vdd vdd sky130_fd_pr__pfet_01v8 ad=0.1218 pd=1.42 as=0.1218 ps=1.42 w=0.42 l=0.28
X57 a_5209_n1336# a_5209_1016# a_4891_n1296# vss sky130_fd_pr__nfet_01v8_lvt ad=0.2475 pd=1.83 as=0.465 ps=3.62 w=1.5 l=0.15
X58 a_7623_n1520# a_5119_n716# vdd vdd sky130_fd_pr__pfet_01v8 ad=0.4158 pd=2.85 as=0.4158 ps=2.85 w=2.52 l=0.15
X59 a_19631_1016# a_7623_n1520# a_18798_1016# vdd sky130_fd_pr__pfet_01v8 ad=0.2475 pd=1.83 as=0.465 ps=3.62 w=1.5 l=0.15
X60 a_4843_n604# a_5119_n716# a_4891_n1296# vss sky130_fd_pr__nfet_01v8_lvt ad=0.558 pd=4.22 as=0.297 ps=2.13 w=1.8 l=0.15
X61 a_12921_1016# a_11859_n1416# vss vss sky130_fd_pr__nfet_01v8_lvt ad=0.696 pd=5.38 as=0.696 ps=5.38 w=2.4 l=0.15
X62 a_859_1016# a_859_n1496# vss vss sky130_fd_pr__nfet_01v8_lvt ad=0.1218 pd=1.42 as=0.1218 ps=1.42 w=0.42 l=0.15
X63 vdd a_19631_n1316# a_8980_622# vdd sky130_fd_pr__pfet_01v8 ad=0.3696 pd=2.57 as=0.3696 ps=2.57 w=2.24 l=0.15
X64 a_8980_n998# a_8980_622# vss vss sky130_fd_pr__nfet_01v8_lvt ad=0.1218 pd=1.42 as=0.1218 ps=1.42 w=0.42 l=0.15
X65 a_8744_364# a_8606_622# vss vss sky130_fd_pr__nfet_01v8_lvt ad=0.348 pd=2.98 as=0.348 ps=2.98 w=1.2 l=0.15
X66 a_22846_n1496# a_21784_1016# vss vss sky130_fd_pr__nfet_01v8_lvt ad=0.198 pd=1.53 as=0.372 ps=3.02 w=1.2 l=0.15
X67 vdd a_1579_1016# a_2323_1016# vdd sky130_fd_pr__pfet_01v8 ad=0.7812 pd=5.66 as=0.4158 ps=2.85 w=2.52 l=0.15
X68 vdd a_1579_1016# a_3761_1016# vdd sky130_fd_pr__pfet_01v8 ad=0.4158 pd=2.85 as=0.4158 ps=2.85 w=2.52 l=0.15
X69 a_12921_1016# a_12921_n1656# vdd vdd sky130_fd_pr__pfet_01v8 ad=0.5104 pd=4.1 as=0.5104 ps=4.1 w=1.76 l=0.15
X70 a_1579_n1464# a_859_n1496# vdd vdd sky130_fd_pr__pfet_01v8 ad=0.6944 pd=5.1 as=0.3696 ps=2.57 w=2.24 l=0.15
X71 a_8606_n998# a_8606_622# vdd vdd sky130_fd_pr__pfet_01v8 ad=0.5104 pd=4.1 as=0.5104 ps=4.1 w=1.76 l=0.15
X72 a_15745_n1316# a_15745_1016# vss vss sky130_fd_pr__nfet_01v8 ad=0.1218 pd=1.42 as=0.1218 ps=1.42 w=0.42 l=0.28
X73 a_25678_n604# a_3167_n1520# vss vss sky130_fd_pr__nfet_01v8_lvt ad=0.198 pd=1.53 as=0.372 ps=3.02 w=1.2 l=0.15
X74 vdd a_17736_n1316# a_18798_1016# vdd sky130_fd_pr__pfet_01v8 ad=0.7812 pd=5.66 as=0.4158 ps=2.85 w=2.52 l=0.15
X75 a_4843_n604# a_3761_n1520# vss vss sky130_fd_pr__nfet_01v8_lvt ad=0.23925 pd=1.78 as=0.4495 ps=3.52 w=1.45 l=0.15
X76 a_12921_n1656# a_11859_1016# vdd vdd sky130_fd_pr__pfet_01v8 ad=0.528 pd=3.53 as=0.992 ps=7.02 w=3.2 l=0.15
X77 a_13850_n1316# rst_n vdd vdd sky130_fd_pr__pfet_01v8 ad=0.464 pd=3.78 as=0.464 ps=3.78 w=1.6 l=0.18
X78 vdd a_26044_1016# a_27304_324# vdd sky130_fd_pr__pfet_01v8 ad=0.496 pd=3.82 as=0.264 ps=1.93 w=1.6 l=0.15
X79 vdd a_27304_324# fb250_b vdd sky130_fd_pr__pfet_01v8 ad=0.4158 pd=2.85 as=0.4158 ps=2.85 w=2.52 l=0.15
X80 a_21784_n1456# a_7623_1016# a_12921_n1656# vdd sky130_fd_pr__pfet_01v8 ad=0.363 pd=2.53 as=0.682 ps=5.02 w=2.2 l=0.15
X81 a_6175_n1536# a_5209_n1336# vss vss sky130_fd_pr__nfet_01v8_lvt ad=0.1885 pd=1.88 as=0.1885 ps=1.88 w=0.65 l=0.15
X82 a_23761_1016# mode_5g a_23857_404# vdd sky130_fd_pr__pfet_01v8 ad=0.62 pd=4.62 as=0.33 ps=2.33 w=2 l=0.15
X83 vdd a_22846_n1496# a_24327_n1516# vdd sky130_fd_pr__pfet_01v8 ad=0.775 pd=5.62 as=0.4125 ps=2.83 w=2.5 l=0.15
X84 a_14912_n1520# a_14912_1016# vss vss sky130_fd_pr__nfet_01v8_lvt ad=0.1218 pd=1.42 as=0.1218 ps=1.42 w=0.42 l=0.15
X85 a_8696_n1376# a_8980_n998# a_8744_n604# vss sky130_fd_pr__nfet_01v8_lvt ad=0.522 pd=4.18 as=0.522 ps=4.18 w=1.8 l=0.15
X86 a_5209_n1336# a_5209_1016# vdd vdd sky130_fd_pr__pfet_01v8 ad=0.464 pd=3.78 as=0.464 ps=3.78 w=1.6 l=0.15
X87 a_11859_1016# a_11859_n1416# vdd vdd sky130_fd_pr__pfet_01v8 ad=0.1218 pd=1.42 as=0.1218 ps=1.42 w=0.42 l=0.28
X88 a_21784_1016# a_458_484# vss vss sky130_fd_pr__nfet_01v8 ad=0.261 pd=2.38 as=0.261 ps=2.38 w=0.9 l=0.18
X89 a_458_484# rst_n vss vss sky130_fd_pr__nfet_01v8 ad=0.174 pd=1.78 as=0.174 ps=1.78 w=0.6 l=0.18
X90 a_5209_1016# a_3761_n1520# a_5209_n1336# vdd sky130_fd_pr__pfet_01v8 ad=0.319 pd=2.78 as=0.319 ps=2.78 w=1.1 l=0.15
X91 vss a_3761_n1520# a_4843_n604# vss sky130_fd_pr__nfet_01v8_lvt ad=0.4495 pd=3.52 as=0.23925 ps=1.78 w=1.45 l=0.15
X92 a_27010_n1576# a_26044_n1336# vss vss sky130_fd_pr__nfet_01v8_lvt ad=0.203 pd=1.98 as=0.203 ps=1.98 w=0.7 l=0.15
X93 a_859_n1496# a_859_1016# vdd vdd sky130_fd_pr__pfet_01v8 ad=0.5104 pd=4.1 as=0.5104 ps=4.1 w=1.76 l=0.15
X94 a_14912_n1520# a_7623_n1520# a_15745_n1316# vdd sky130_fd_pr__pfet_01v8 ad=0.465 pd=3.62 as=0.2475 ps=1.83 w=1.5 l=0.15
X95 a_17736_1016# a_458_484# vss vss sky130_fd_pr__nfet_01v8 ad=0.261 pd=2.38 as=0.261 ps=2.38 w=0.9 l=0.18
X96 a_5119_n716# a_5119_622# vss vss sky130_fd_pr__nfet_01v8 ad=0.1595 pd=1.68 as=0.1595 ps=1.68 w=0.55 l=0.15
X97 a_26044_n1336# a_26044_1016# a_25726_n1296# vss sky130_fd_pr__nfet_01v8_lvt ad=0.2145 pd=1.63 as=0.403 ps=3.22 w=1.3 l=0.15
X98 a_22846_n1496# a_21784_1016# vdd vdd sky130_fd_pr__pfet_01v8 ad=0.396 pd=2.73 as=0.744 ps=5.42 w=2.4 l=0.15
X99 a_6175_474# a_5209_1016# vss vss sky130_fd_pr__nfet_01v8_lvt ad=0.1885 pd=1.88 as=0.1885 ps=1.88 w=0.65 l=0.15
X100 a_3761_1016# a_3761_n1520# vss vss sky130_fd_pr__nfet_01v8_lvt ad=0.145 pd=1.58 as=0.145 ps=1.58 w=0.5 l=0.15
X101 a_12921_1016# a_11859_n1416# vdd vdd sky130_fd_pr__pfet_01v8 ad=0.992 pd=7.02 as=0.528 ps=3.53 w=3.2 l=0.15
X102 vdd a_5119_n716# a_7623_n1520# vdd sky130_fd_pr__pfet_01v8 ad=0.7812 pd=5.66 as=0.4158 ps=2.85 w=2.52 l=0.15
X103 a_22846_n1496# a_22846_1016# vss vss sky130_fd_pr__nfet_01v8_lvt ad=0.1218 pd=1.42 as=0.1218 ps=1.42 w=0.42 l=0.15
X104 a_3761_1016# a_3761_n1520# vdd vdd sky130_fd_pr__pfet_01v8 ad=0.609 pd=4.78 as=0.609 ps=4.78 w=2.1 l=0.15
X105 a_25678_n604# a_23857_404# a_25726_n1296# vss sky130_fd_pr__nfet_01v8_lvt ad=0.465 pd=3.62 as=0.2475 ps=1.83 w=1.5 l=0.15
X106 a_8696_1016# a_8606_622# vdd vdd sky130_fd_pr__pfet_01v8 ad=0.396 pd=2.73 as=0.744 ps=5.42 w=2.4 l=0.15
X107 vss a_27304_n1336# fb250 vss sky130_fd_pr__nfet_01v8_lvt ad=0.372 pd=3.02 as=0.198 ps=1.53 w=1.2 l=0.15
X108 a_11026_1016# a_9964_n1416# vdd vdd sky130_fd_pr__pfet_01v8 ad=0.462 pd=3.13 as=0.868 ps=6.22 w=2.8 l=0.15
X109 fb250_b fb250 vss vss sky130_fd_pr__nfet_01v8_lvt ad=0.145 pd=1.58 as=0.145 ps=1.58 w=0.5 l=0.15
X110 a_1579_1016# a_859_1016# vss vss sky130_fd_pr__nfet_01v8_lvt ad=0.464 pd=3.78 as=0.464 ps=3.78 w=1.6 l=0.15
X111 a_17736_1016# a_17736_n1316# vdd vdd sky130_fd_pr__pfet_01v8 ad=0.1218 pd=1.42 as=0.1218 ps=1.42 w=0.42 l=0.28
X112 a_19631_n1316# a_19631_1016# vss vss sky130_fd_pr__nfet_01v8 ad=0.1218 pd=1.42 as=0.1218 ps=1.42 w=0.42 l=0.28
X113 fb250 a_27304_n1336# vss vss sky130_fd_pr__nfet_01v8_lvt ad=0.198 pd=1.53 as=0.372 ps=3.02 w=1.2 l=0.15
X114 a_15745_1016# a_458_484# vss vss sky130_fd_pr__nfet_01v8 ad=0.261 pd=2.38 as=0.261 ps=2.38 w=0.9 l=0.18
X115 a_8696_1016# a_8980_622# a_8744_364# vdd sky130_fd_pr__pfet_01v8 ad=0.744 pd=5.42 as=0.396 ps=2.73 w=2.4 l=0.15
X116 a_18798_1016# a_18798_n1520# vss vss sky130_fd_pr__nfet_01v8_lvt ad=0.1218 pd=1.42 as=0.1218 ps=1.42 w=0.42 l=0.15
X117 a_14912_n1520# a_14912_1016# vdd vdd sky130_fd_pr__pfet_01v8 ad=0.5104 pd=4.1 as=0.5104 ps=4.1 w=1.76 l=0.15
X118 a_11859_n1416# rst_n vdd vdd sky130_fd_pr__pfet_01v8 ad=0.464 pd=3.78 as=0.464 ps=3.78 w=1.6 l=0.18
X119 a_11859_n1416# a_11859_1016# vdd vdd sky130_fd_pr__pfet_01v8 ad=0.1218 pd=1.42 as=0.1218 ps=1.42 w=0.42 l=0.28
X120 fb250 a_27304_n1336# vdd vdd sky130_fd_pr__pfet_01v8 ad=0.4158 pd=2.85 as=0.7812 ps=5.66 w=2.52 l=0.15
X121 a_26044_1016# a_26044_n1336# vdd vdd sky130_fd_pr__pfet_01v8 ad=0.464 pd=3.78 as=0.464 ps=3.78 w=1.6 l=0.15
X122 fb250_b a_27304_324# vdd vdd sky130_fd_pr__pfet_01v8 ad=0.4158 pd=2.85 as=0.4158 ps=2.85 w=2.52 l=0.15
X123 a_23761_1016# mode_5g a_23857_404# vdd sky130_fd_pr__pfet_01v8 ad=0.33 pd=2.33 as=0.33 ps=2.33 w=2 l=0.15
X124 a_12921_n1656# a_7623_1016# a_21784_n1456# vdd sky130_fd_pr__pfet_01v8 ad=0.682 pd=5.02 as=0.363 ps=2.53 w=2.2 l=0.15
X125 a_13850_n1316# a_7623_n1520# a_12921_n1656# vss sky130_fd_pr__nfet_01v8_lvt ad=0.348 pd=2.98 as=0.348 ps=2.98 w=1.2 l=0.15
X126 a_23857_n604# a_22846_n1496# a_23761_n1316# vss sky130_fd_pr__nfet_01v8_lvt ad=0.465 pd=3.62 as=0.2475 ps=1.83 w=1.5 l=0.15
X127 a_11026_1016# a_11026_n1576# vdd vdd sky130_fd_pr__pfet_01v8 ad=0.5104 pd=4.1 as=0.5104 ps=4.1 w=1.76 l=0.15
X128 a_23857_404# a_22846_1016# a_23761_1016# vdd sky130_fd_pr__pfet_01v8 ad=0.33 pd=2.33 as=0.62 ps=4.62 w=2 l=0.15
X129 a_13850_n1316# a_7623_1016# a_12921_n1656# vdd sky130_fd_pr__pfet_01v8 ad=0.2475 pd=1.83 as=0.465 ps=3.62 w=1.5 l=0.15
X130 a_859_n1496# a_859_1016# vss vss sky130_fd_pr__nfet_01v8_lvt ad=0.1218 pd=1.42 as=0.1218 ps=1.42 w=0.42 l=0.15
X131 vdd a_15745_n1316# a_8606_622# vdd sky130_fd_pr__pfet_01v8 ad=0.3696 pd=2.57 as=0.3696 ps=2.57 w=2.24 l=0.15
X132 vss a_12921_1016# a_23857_404# vss sky130_fd_pr__nfet_01v8_lvt ad=0.31 pd=2.62 as=0.165 ps=1.33 w=1 l=0.15
X133 a_25726_1016# a_26044_n1336# a_26044_1016# vss sky130_fd_pr__nfet_01v8_lvt ad=0.403 pd=3.22 as=0.2145 ps=1.63 w=1.3 l=0.15
X134 a_13850_1016# a_13850_n1316# vdd vdd sky130_fd_pr__pfet_01v8 ad=0.1218 pd=1.42 as=0.1218 ps=1.42 w=0.42 l=0.28
X135 a_22846_1016# a_21784_n1456# vdd vdd sky130_fd_pr__pfet_01v8 ad=0.396 pd=2.73 as=0.396 ps=2.73 w=2.4 l=0.15
X136 vdd a_9964_1016# a_11026_n1576# vdd sky130_fd_pr__pfet_01v8 ad=0.868 pd=6.22 as=0.462 ps=3.13 w=2.8 l=0.15
X137 vdd a_21784_1016# a_22846_n1496# vdd sky130_fd_pr__pfet_01v8 ad=0.396 pd=2.73 as=0.396 ps=2.73 w=2.4 l=0.15
X138 a_458_n1256# mode_5g vdd vdd sky130_fd_pr__pfet_01v8 ad=0.348 pd=2.98 as=0.348 ps=2.98 w=1.2 l=0.18
X139 a_23857_404# a_12921_1016# vss vss sky130_fd_pr__nfet_01v8_lvt ad=0.165 pd=1.33 as=0.31 ps=2.62 w=1 l=0.15
X140 vdd a_13850_1016# a_14912_n1520# vdd sky130_fd_pr__pfet_01v8 ad=0.7812 pd=5.66 as=0.4158 ps=2.85 w=2.52 l=0.15
X141 a_26044_1016# a_26044_n1336# a_25726_1016# vss sky130_fd_pr__nfet_01v8_lvt ad=0.2145 pd=1.63 as=0.403 ps=3.22 w=1.3 l=0.15
X142 a_21784_1016# a_7623_1016# a_12921_1016# vdd sky130_fd_pr__pfet_01v8 ad=0.363 pd=2.53 as=0.682 ps=5.02 w=2.2 l=0.15
X143 vss a_1579_1016# a_3761_1016# vss sky130_fd_pr__nfet_01v8_lvt ad=0.372 pd=3.02 as=0.198 ps=1.53 w=1.2 l=0.15
X144 a_11026_n1576# a_9964_1016# vdd vdd sky130_fd_pr__pfet_01v8 ad=0.462 pd=3.13 as=0.868 ps=6.22 w=2.8 l=0.15
X145 vdd a_1579_n1464# a_3761_n1520# vdd sky130_fd_pr__pfet_01v8 ad=0.7812 pd=5.66 as=0.4158 ps=2.85 w=2.52 l=0.15
X146 a_13850_1016# a_458_484# vss vss sky130_fd_pr__nfet_01v8 ad=0.261 pd=2.38 as=0.261 ps=2.38 w=0.9 l=0.18
X147 a_3761_1016# a_1579_1016# vss vss sky130_fd_pr__nfet_01v8_lvt ad=0.198 pd=1.53 as=0.372 ps=3.02 w=1.2 l=0.15
X148 a_21784_n1456# a_21784_1016# vdd vdd sky130_fd_pr__pfet_01v8 ad=0.1218 pd=1.42 as=0.1218 ps=1.42 w=0.42 l=0.28
X149 a_1579_n1464# a_1579_1016# vdd vdd sky130_fd_pr__pfet_01v8 ad=0.5481 pd=4.36 as=0.5481 ps=4.36 w=1.89 l=0.15
X150 a_8606_622# a_8606_n998# vss vss sky130_fd_pr__nfet_01v8_lvt ad=0.1218 pd=1.42 as=0.1218 ps=1.42 w=0.42 l=0.15
X151 a_11859_n1416# a_7623_n1520# a_11026_n1576# vdd sky130_fd_pr__pfet_01v8 ad=0.33 pd=2.33 as=0.62 ps=4.62 w=2 l=0.15
X152 a_23761_n1316# a_458_n1256# a_24327_n1516# vdd sky130_fd_pr__pfet_01v8 ad=0.4125 pd=2.83 as=0.4125 ps=2.83 w=2.5 l=0.15
X153 a_8696_n1376# a_458_n1256# a_8744_n604# vss sky130_fd_pr__nfet_01v8_lvt ad=0.522 pd=4.18 as=0.522 ps=4.18 w=1.8 l=0.15
X154 a_5119_622# a_5119_n716# vss vss sky130_fd_pr__nfet_01v8 ad=0.261 pd=2.38 as=0.261 ps=2.38 w=0.9 l=0.15
X155 a_4891_n1296# a_5119_n716# a_4843_n604# vss sky130_fd_pr__nfet_01v8_lvt ad=0.297 pd=2.13 as=0.558 ps=4.22 w=1.8 l=0.15
X156 a_24327_n1516# a_458_n1256# a_23761_n1316# vdd sky130_fd_pr__pfet_01v8 ad=0.4125 pd=2.83 as=0.4125 ps=2.83 w=2.5 l=0.15
X157 a_7623_n1520# a_7623_1016# vdd vdd sky130_fd_pr__pfet_01v8 ad=0.609 pd=4.78 as=0.609 ps=4.78 w=2.1 l=0.15
X158 a_8606_622# a_8606_n998# vdd vdd sky130_fd_pr__pfet_01v8 ad=0.5104 pd=4.1 as=0.5104 ps=4.1 w=1.76 l=0.15
X159 a_9964_n1416# a_7623_1016# a_8696_n1376# vdd sky130_fd_pr__pfet_01v8 ad=0.33 pd=2.33 as=0.62 ps=4.62 w=2 l=0.15
X160 vdd a_27304_n1336# fb250 vdd sky130_fd_pr__pfet_01v8 ad=0.7812 pd=5.66 as=0.4158 ps=2.85 w=2.52 l=0.15
X161 vdd a_9964_n1416# a_11026_1016# vdd sky130_fd_pr__pfet_01v8 ad=0.868 pd=6.22 as=0.462 ps=3.13 w=2.8 l=0.15
X162 a_12921_1016# a_7623_1016# a_13850_1016# vdd sky130_fd_pr__pfet_01v8 ad=0.465 pd=3.62 as=0.2475 ps=1.83 w=1.5 l=0.15
X163 a_8980_n998# a_19631_1016# vdd vdd sky130_fd_pr__pfet_01v8 ad=0.3696 pd=2.57 as=0.6944 ps=5.1 w=2.24 l=0.15
X164 a_3167_n1520# a_2697_n1464# vdd vdd sky130_fd_pr__pfet_01v8 ad=0.4158 pd=2.85 as=0.7812 ps=5.66 w=2.52 l=0.15
X165 a_23857_404# a_22846_1016# a_24331_304# vss sky130_fd_pr__nfet_01v8_lvt ad=0.2475 pd=1.83 as=0.465 ps=3.62 w=1.5 l=0.15
X166 a_23761_1016# a_22846_1016# a_23857_404# vdd sky130_fd_pr__pfet_01v8 ad=0.62 pd=4.62 as=0.33 ps=2.33 w=2 l=0.15
X167 a_11859_1016# a_458_484# vss vss sky130_fd_pr__nfet_01v8 ad=0.261 pd=2.38 as=0.261 ps=2.38 w=0.9 l=0.18
X168 a_18798_1016# a_17736_n1316# vdd vdd sky130_fd_pr__pfet_01v8 ad=0.4158 pd=2.85 as=0.7812 ps=5.66 w=2.52 l=0.15
X169 a_18798_n1520# a_18798_1016# vss vss sky130_fd_pr__nfet_01v8_lvt ad=0.1218 pd=1.42 as=0.1218 ps=1.42 w=0.42 l=0.15
X170 a_21784_1016# a_21784_n1456# vss vss sky130_fd_pr__nfet_01v8 ad=0.1218 pd=1.42 as=0.1218 ps=1.42 w=0.42 l=0.28
X171 a_15745_1016# a_15745_n1316# vdd vdd sky130_fd_pr__pfet_01v8 ad=0.1218 pd=1.42 as=0.1218 ps=1.42 w=0.42 l=0.28
X172 a_27304_324# a_26044_1016# vdd vdd sky130_fd_pr__pfet_01v8 ad=0.264 pd=1.93 as=0.496 ps=3.82 w=1.6 l=0.15
X173 a_14912_1016# a_14912_n1520# vss vss sky130_fd_pr__nfet_01v8_lvt ad=0.1218 pd=1.42 as=0.1218 ps=1.42 w=0.42 l=0.15
X174 a_4891_1016# a_3761_n1520# vdd vdd sky130_fd_pr__pfet_01v8 ad=0.406 pd=3.38 as=0.406 ps=3.38 w=1.4 l=0.15
X175 vdd a_1579_n1464# a_2323_n1520# vdd sky130_fd_pr__pfet_01v8 ad=0.7812 pd=5.66 as=0.4158 ps=2.85 w=2.52 l=0.15
X176 a_1579_1016# a_1579_n1464# vss vss sky130_fd_pr__nfet_01v8_lvt ad=0.1305 pd=1.48 as=0.1305 ps=1.48 w=0.45 l=0.15
X177 a_5209_n1336# a_3761_n1520# vdd vdd sky130_fd_pr__pfet_01v8 ad=0.264 pd=1.93 as=0.496 ps=3.82 w=1.6 l=0.15
X178 a_23857_404# mode_5g a_23761_1016# vdd sky130_fd_pr__pfet_01v8 ad=0.33 pd=2.33 as=0.33 ps=2.33 w=2 l=0.15
X179 a_24331_304# a_22846_1016# a_23857_404# vss sky130_fd_pr__nfet_01v8_lvt ad=0.465 pd=3.62 as=0.2475 ps=1.83 w=1.5 l=0.15
X180 a_2697_n1464# a_2323_n1520# vdd vdd sky130_fd_pr__pfet_01v8 ad=0.6944 pd=5.1 as=0.3696 ps=2.57 w=2.24 l=0.15
X181 vdd a_12921_n1656# a_23761_n1316# vdd sky130_fd_pr__pfet_01v8 ad=0.2475 pd=1.83 as=0.2475 ps=1.83 w=1.5 l=0.15
X182 vss mode_5g a_24331_304# vss sky130_fd_pr__nfet_01v8_lvt ad=0.465 pd=3.62 as=0.2475 ps=1.83 w=1.5 l=0.15
X183 a_1579_n1464# a_859_n1496# vss vss sky130_fd_pr__nfet_01v8_lvt ad=0.464 pd=3.78 as=0.464 ps=3.78 w=1.6 l=0.15
X184 a_8696_1016# mode_5g a_8744_364# vdd sky130_fd_pr__pfet_01v8 ad=0.744 pd=5.42 as=0.396 ps=2.73 w=2.4 l=0.15
X185 a_9964_1016# a_458_484# vss vss sky130_fd_pr__nfet_01v8 ad=0.261 pd=2.38 as=0.261 ps=2.38 w=0.9 l=0.18
X186 a_11859_n1416# a_7623_1016# a_11026_n1576# vss sky130_fd_pr__nfet_01v8_lvt ad=0.464 pd=3.78 as=0.464 ps=3.78 w=1.6 l=0.15
X187 a_27010_n1576# a_26044_n1336# vdd vdd sky130_fd_pr__pfet_01v8 ad=0.812 pd=6.18 as=0.812 ps=6.18 w=2.8 l=0.15
X188 vss a_5119_n716# a_7623_n1520# vss sky130_fd_pr__nfet_01v8_lvt ad=0.372 pd=3.02 as=0.198 ps=1.53 w=1.2 l=0.15
X189 a_5209_1016# a_5209_n1336# vdd vdd sky130_fd_pr__pfet_01v8 ad=0.464 pd=3.78 as=0.464 ps=3.78 w=1.6 l=0.15
X190 vdd a_3761_n1520# a_5209_1016# vdd sky130_fd_pr__pfet_01v8 ad=0.496 pd=3.82 as=0.264 ps=1.93 w=1.6 l=0.15
X191 a_7623_1016# a_5119_622# vdd vdd sky130_fd_pr__pfet_01v8 ad=0.4158 pd=2.85 as=0.7812 ps=5.66 w=2.52 l=0.15
X192 a_14912_1016# a_13850_n1316# vdd vdd sky130_fd_pr__pfet_01v8 ad=0.4158 pd=2.85 as=0.7812 ps=5.66 w=2.52 l=0.15
X193 a_8980_622# a_8980_n998# vdd vdd sky130_fd_pr__pfet_01v8 ad=0.5104 pd=4.1 as=0.5104 ps=4.1 w=1.76 l=0.15
X194 a_11026_n1576# a_7623_n1520# a_11859_n1416# vdd sky130_fd_pr__pfet_01v8 ad=0.62 pd=4.62 as=0.33 ps=2.33 w=2 l=0.15
X195 a_24327_n1516# a_458_n1256# a_23761_n1316# vdd sky130_fd_pr__pfet_01v8 ad=0.775 pd=5.62 as=0.4125 ps=2.83 w=2.5 l=0.15
X196 vdd a_21784_n1456# a_22846_1016# vdd sky130_fd_pr__pfet_01v8 ad=0.396 pd=2.73 as=0.396 ps=2.73 w=2.4 l=0.15
X197 a_25726_n1296# a_23857_404# a_25678_n604# vss sky130_fd_pr__nfet_01v8_lvt ad=0.2475 pd=1.83 as=0.465 ps=3.62 w=1.5 l=0.15
X198 a_1579_n1464# a_1579_1016# vss vss sky130_fd_pr__nfet_01v8_lvt ad=0.1305 pd=1.48 as=0.1305 ps=1.48 w=0.45 l=0.15
X199 a_12921_1016# a_12921_n1656# vss vss sky130_fd_pr__nfet_01v8_lvt ad=0.1218 pd=1.42 as=0.1218 ps=1.42 w=0.42 l=0.15
X200 vdd a_2697_n1464# a_3167_n1520# vdd sky130_fd_pr__pfet_01v8 ad=0.4158 pd=2.85 as=0.4158 ps=2.85 w=2.52 l=0.15
X201 a_9964_n1416# rst_n vdd vdd sky130_fd_pr__pfet_01v8 ad=0.464 pd=3.78 as=0.464 ps=3.78 w=1.6 l=0.18
X202 a_19631_1016# a_19631_n1316# vdd vdd sky130_fd_pr__pfet_01v8 ad=0.1218 pd=1.42 as=0.1218 ps=1.42 w=0.42 l=0.28
X203 a_27304_n1336# a_27304_324# vdd vdd sky130_fd_pr__pfet_01v8 ad=0.1885 pd=1.88 as=0.1885 ps=1.88 w=0.65 l=0.15
X204 a_9964_n1416# a_9964_1016# vdd vdd sky130_fd_pr__pfet_01v8 ad=0.1218 pd=1.42 as=0.1218 ps=1.42 w=0.42 l=0.28
X205 a_7623_n1520# a_7623_1016# vss vss sky130_fd_pr__nfet_01v8_lvt ad=0.145 pd=1.58 as=0.145 ps=1.58 w=0.5 l=0.15
X206 a_17736_n1316# a_7623_n1520# a_8606_n998# vss sky130_fd_pr__nfet_01v8_lvt ad=0.348 pd=2.98 as=0.348 ps=2.98 w=1.2 l=0.15
X207 a_6175_474# a_5209_1016# vdd vdd sky130_fd_pr__pfet_01v8 ad=0.754 pd=5.78 as=0.754 ps=5.78 w=2.6 l=0.15
X208 a_25726_1016# a_3167_n1520# vdd vdd sky130_fd_pr__pfet_01v8 ad=0.406 pd=3.38 as=0.406 ps=3.38 w=1.4 l=0.15
X209 a_2323_1016# a_1579_1016# vss vss sky130_fd_pr__nfet_01v8_lvt ad=0.348 pd=2.98 as=0.348 ps=2.98 w=1.2 l=0.15
X210 a_14912_1016# a_14912_n1520# vdd vdd sky130_fd_pr__pfet_01v8 ad=0.5104 pd=4.1 as=0.5104 ps=4.1 w=1.76 l=0.15
X211 a_8606_n998# a_15745_1016# vdd vdd sky130_fd_pr__pfet_01v8 ad=0.3696 pd=2.57 as=0.6944 ps=5.1 w=2.24 l=0.15
X212 vss a_12921_n1656# a_23857_n604# vss sky130_fd_pr__nfet_01v8_lvt ad=0.465 pd=3.62 as=0.2475 ps=1.83 w=1.5 l=0.15
X213 a_11026_1016# a_7623_n1520# a_11859_1016# vdd sky130_fd_pr__pfet_01v8 ad=0.62 pd=4.62 as=0.33 ps=2.33 w=2 l=0.15
X214 a_19631_1016# a_458_484# vss vss sky130_fd_pr__nfet_01v8 ad=0.261 pd=2.38 as=0.261 ps=2.38 w=0.9 l=0.18
X215 vss a_6175_474# a_5119_622# vss sky130_fd_pr__nfet_01v8_lvt ad=0.558 pd=4.22 as=0.297 ps=2.13 w=1.8 l=0.15
X216 a_23761_1016# a_12921_1016# vdd vdd sky130_fd_pr__pfet_01v8 ad=0.33 pd=2.33 as=0.62 ps=4.62 w=2 l=0.15
X217 vdd a_3761_n1520# a_5209_n1336# vdd sky130_fd_pr__pfet_01v8 ad=0.496 pd=3.82 as=0.264 ps=1.93 w=1.6 l=0.15
X218 a_27010_464# a_26044_1016# vdd vdd sky130_fd_pr__pfet_01v8 ad=0.812 pd=6.18 as=0.812 ps=6.18 w=2.8 l=0.15
X219 a_1579_1016# a_859_1016# vdd vdd sky130_fd_pr__pfet_01v8 ad=0.6944 pd=5.1 as=0.3696 ps=2.57 w=2.24 l=0.15
X220 a_9070_n1616# a_8980_n998# vdd vdd sky130_fd_pr__pfet_01v8 ad=0.495 pd=3.33 as=0.93 ps=6.62 w=3 l=0.15
X221 a_23761_n1316# a_12921_n1656# vdd vdd sky130_fd_pr__pfet_01v8 ad=0.2475 pd=1.83 as=0.2475 ps=1.83 w=1.5 l=0.15
X222 a_12921_n1656# a_11859_1016# vdd vdd sky130_fd_pr__pfet_01v8 ad=0.992 pd=7.02 as=0.528 ps=3.53 w=3.2 l=0.15
X223 a_11026_1016# a_11026_n1576# vss vss sky130_fd_pr__nfet_01v8_lvt ad=0.1218 pd=1.42 as=0.1218 ps=1.42 w=0.42 l=0.15
X224 a_8606_622# a_15745_n1316# vdd vdd sky130_fd_pr__pfet_01v8 ad=0.3696 pd=2.57 as=0.6944 ps=5.1 w=2.24 l=0.15
X225 vdd a_5119_622# a_7623_1016# vdd sky130_fd_pr__pfet_01v8 ad=0.7812 pd=5.66 as=0.4158 ps=2.85 w=2.52 l=0.15
X226 vdd a_11859_1016# a_12921_n1656# vdd sky130_fd_pr__pfet_01v8 ad=0.528 pd=3.53 as=0.528 ps=3.53 w=3.2 l=0.15
X227 vss a_27304_324# fb250_b vss sky130_fd_pr__nfet_01v8_lvt ad=0.372 pd=3.02 as=0.198 ps=1.53 w=1.2 l=0.15
X228 a_9964_n1416# a_7623_n1520# a_8696_n1376# vss sky130_fd_pr__nfet_01v8_lvt ad=0.464 pd=3.78 as=0.464 ps=3.78 w=1.6 l=0.15
X229 a_19631_n1316# a_7623_n1520# a_18798_n1520# vdd sky130_fd_pr__pfet_01v8 ad=0.2475 pd=1.83 as=0.465 ps=3.62 w=1.5 l=0.15
X230 a_22846_1016# a_22846_n1496# vdd vdd sky130_fd_pr__pfet_01v8 ad=0.5104 pd=4.1 as=0.5104 ps=4.1 w=1.76 l=0.15
X231 vss a_2697_n1464# a_3167_n1520# vss sky130_fd_pr__nfet_01v8_lvt ad=0.372 pd=3.02 as=0.198 ps=1.53 w=1.2 l=0.15
X232 a_5119_n716# a_458_484# vss vss sky130_fd_pr__nfet_01v8 ad=0.348 pd=2.98 as=0.348 ps=2.98 w=1.2 l=0.18
X233 vdd a_3167_n1520# a_26044_1016# vdd sky130_fd_pr__pfet_01v8 ad=0.496 pd=3.82 as=0.264 ps=1.93 w=1.6 l=0.15
X234 a_8696_n1376# a_7623_1016# a_9964_n1416# vdd sky130_fd_pr__pfet_01v8 ad=0.62 pd=4.62 as=0.33 ps=2.33 w=2 l=0.15
X235 a_8980_622# a_8980_n998# vss vss sky130_fd_pr__nfet_01v8_lvt ad=0.1218 pd=1.42 as=0.1218 ps=1.42 w=0.42 l=0.15
X236 vss a_3167_n1520# a_25678_n604# vss sky130_fd_pr__nfet_01v8_lvt ad=0.372 pd=3.02 as=0.198 ps=1.53 w=1.2 l=0.15
X237 fb250 fb250_b vdd vdd sky130_fd_pr__pfet_01v8 ad=0.609 pd=4.78 as=0.609 ps=4.78 w=2.1 l=0.15
X238 a_18798_n1520# a_7623_n1520# a_19631_n1316# vdd sky130_fd_pr__pfet_01v8 ad=0.465 pd=3.62 as=0.2475 ps=1.83 w=1.5 l=0.15
X239 a_22846_n1496# a_21784_1016# vdd vdd sky130_fd_pr__pfet_01v8 ad=0.396 pd=2.73 as=0.396 ps=2.73 w=2.4 l=0.15
X240 a_8606_622# a_7623_1016# a_17736_1016# vdd sky130_fd_pr__pfet_01v8 ad=0.465 pd=3.62 as=0.2475 ps=1.83 w=1.5 l=0.15
X241 a_21784_n1456# a_21784_1016# vss vss sky130_fd_pr__nfet_01v8 ad=0.1218 pd=1.42 as=0.1218 ps=1.42 w=0.42 l=0.28
X242 a_25678_n604# a_3167_n1520# vss vss sky130_fd_pr__nfet_01v8_lvt ad=0.198 pd=1.53 as=0.372 ps=3.02 w=1.2 l=0.15
X243 a_19631_n1316# a_7623_1016# a_18798_n1520# vss sky130_fd_pr__nfet_01v8_lvt ad=0.348 pd=2.98 as=0.348 ps=2.98 w=1.2 l=0.15
X244 a_5119_n716# a_5119_622# vdd vdd sky130_fd_pr__pfet_01v8 ad=0.29 pd=2.58 as=0.29 ps=2.58 w=1 l=0.15
X245 a_12921_1016# a_11859_n1416# vdd vdd sky130_fd_pr__pfet_01v8 ad=0.528 pd=3.53 as=0.992 ps=7.02 w=3.2 l=0.15
X246 a_19631_n1316# a_19631_1016# vdd vdd sky130_fd_pr__pfet_01v8 ad=0.1218 pd=1.42 as=0.1218 ps=1.42 w=0.42 l=0.28
X247 vss a_3761_n1520# a_4843_n604# vss sky130_fd_pr__nfet_01v8_lvt ad=0.4495 pd=3.52 as=0.23925 ps=1.78 w=1.45 l=0.15
X248 a_26044_n1336# a_3167_n1520# vdd vdd sky130_fd_pr__pfet_01v8 ad=0.264 pd=1.93 as=0.496 ps=3.82 w=1.6 l=0.15
X249 vdd a_15745_1016# a_8606_n998# vdd sky130_fd_pr__pfet_01v8 ad=0.3696 pd=2.57 as=0.3696 ps=2.57 w=2.24 l=0.15
X250 a_23857_404# a_22846_1016# a_23761_1016# vdd sky130_fd_pr__pfet_01v8 ad=0.33 pd=2.33 as=0.33 ps=2.33 w=2 l=0.15
X251 a_17736_n1316# rst_n vdd vdd sky130_fd_pr__pfet_01v8 ad=0.464 pd=3.78 as=0.464 ps=3.78 w=1.6 l=0.18
X252 a_8980_622# a_19631_n1316# vdd vdd sky130_fd_pr__pfet_01v8 ad=0.3696 pd=2.57 as=0.6944 ps=5.1 w=2.24 l=0.15
X253 a_859_1016# a_859_n1496# vdd vdd sky130_fd_pr__pfet_01v8 ad=0.5104 pd=4.1 as=0.5104 ps=4.1 w=1.76 l=0.15
X254 a_24327_n1516# a_22846_n1496# vdd vdd sky130_fd_pr__pfet_01v8 ad=0.4125 pd=2.83 as=0.775 ps=5.62 w=2.5 l=0.15
X255 a_17736_n1316# a_17736_1016# vdd vdd sky130_fd_pr__pfet_01v8 ad=0.1218 pd=1.42 as=0.1218 ps=1.42 w=0.42 l=0.28
X256 vss a_1579_n1464# a_3761_n1520# vss sky130_fd_pr__nfet_01v8_lvt ad=0.372 pd=3.02 as=0.198 ps=1.53 w=1.2 l=0.15
X257 a_5209_1016# a_5209_n1336# a_4891_1016# vss sky130_fd_pr__nfet_01v8_lvt ad=0.2475 pd=1.83 as=0.465 ps=3.62 w=1.5 l=0.15
X258 a_3761_n1520# a_1579_n1464# vdd vdd sky130_fd_pr__pfet_01v8 ad=0.4158 pd=2.85 as=0.7812 ps=5.66 w=2.52 l=0.15
X259 a_5119_622# a_5119_n716# vdd vdd sky130_fd_pr__pfet_01v8 ad=0.1885 pd=1.88 as=0.1885 ps=1.88 w=0.65 l=0.15
X260 a_5209_n1336# a_3761_n1520# a_5209_1016# vdd sky130_fd_pr__pfet_01v8 ad=0.319 pd=2.78 as=0.319 ps=2.78 w=1.1 l=0.15
X261 a_2323_1016# a_1579_1016# vdd vdd sky130_fd_pr__pfet_01v8 ad=0.4158 pd=2.85 as=0.7812 ps=5.66 w=2.52 l=0.15
X262 a_15745_n1316# a_7623_1016# a_14912_n1520# vss sky130_fd_pr__nfet_01v8_lvt ad=0.348 pd=2.98 as=0.348 ps=2.98 w=1.2 l=0.15
X263 a_3761_1016# a_1579_1016# vdd vdd sky130_fd_pr__pfet_01v8 ad=0.4158 pd=2.85 as=0.7812 ps=5.66 w=2.52 l=0.15
X264 fb250_b fb250 vdd vdd sky130_fd_pr__pfet_01v8 ad=0.609 pd=4.78 as=0.609 ps=4.78 w=2.1 l=0.15
X265 a_4891_n1296# a_5209_1016# a_5209_n1336# vss sky130_fd_pr__nfet_01v8_lvt ad=0.465 pd=3.62 as=0.2475 ps=1.83 w=1.5 l=0.15
X266 a_26044_n1336# a_26044_1016# vdd vdd sky130_fd_pr__pfet_01v8 ad=0.464 pd=3.78 as=0.464 ps=3.78 w=1.6 l=0.15
X267 vdd a_27304_324# fb250_b vdd sky130_fd_pr__pfet_01v8 ad=0.7812 pd=5.66 as=0.4158 ps=2.85 w=2.52 l=0.15
X268 a_8744_364# mode_5g a_8696_1016# vdd sky130_fd_pr__pfet_01v8 ad=0.396 pd=2.73 as=0.744 ps=5.42 w=2.4 l=0.15
X269 a_4891_1016# a_5209_n1336# a_5209_1016# vss sky130_fd_pr__nfet_01v8_lvt ad=0.465 pd=3.62 as=0.2475 ps=1.83 w=1.5 l=0.15
X270 fb250 fb250_b vss vss sky130_fd_pr__nfet_01v8_lvt ad=0.145 pd=1.58 as=0.145 ps=1.58 w=0.5 l=0.15
X271 a_859_n1496# clkn vdd vdd sky130_fd_pr__pfet_01v8_lvt ad=0.348 pd=2.69 as=0.696 ps=5.38 w=2.4 l=0.35
X272 a_7623_n1520# a_5119_n716# vss vss sky130_fd_pr__nfet_01v8_lvt ad=0.198 pd=1.53 as=0.372 ps=3.02 w=1.2 l=0.15
X273 a_18798_n1520# a_17736_1016# vdd vdd sky130_fd_pr__pfet_01v8 ad=0.4158 pd=2.85 as=0.7812 ps=5.66 w=2.52 l=0.15
X274 a_7623_n1520# a_5119_n716# vdd vdd sky130_fd_pr__pfet_01v8 ad=0.4158 pd=2.85 as=0.7812 ps=5.66 w=2.52 l=0.15
X275 a_17736_1016# a_17736_n1316# vss vss sky130_fd_pr__nfet_01v8 ad=0.1218 pd=1.42 as=0.1218 ps=1.42 w=0.42 l=0.28
X276 a_12921_n1656# a_7623_1016# a_13850_n1316# vdd sky130_fd_pr__pfet_01v8 ad=0.465 pd=3.62 as=0.2475 ps=1.83 w=1.5 l=0.15
X277 a_5209_1016# a_3761_n1520# vdd vdd sky130_fd_pr__pfet_01v8 ad=0.264 pd=1.93 as=0.496 ps=3.82 w=1.6 l=0.15
X278 a_27010_464# a_26044_1016# vss vss sky130_fd_pr__nfet_01v8_lvt ad=0.203 pd=1.98 as=0.203 ps=1.98 w=0.7 l=0.15
X279 vdd a_21784_1016# a_22846_n1496# vdd sky130_fd_pr__pfet_01v8 ad=0.744 pd=5.42 as=0.396 ps=2.73 w=2.4 l=0.15
X280 vdd a_12921_1016# a_23761_1016# vdd sky130_fd_pr__pfet_01v8 ad=0.62 pd=4.62 as=0.33 ps=2.33 w=2 l=0.15
X281 a_21784_n1456# rst_n vdd vdd sky130_fd_pr__pfet_01v8 ad=0.464 pd=3.78 as=0.464 ps=3.78 w=1.6 l=0.18
X282 a_22846_1016# a_21784_n1456# vdd vdd sky130_fd_pr__pfet_01v8 ad=0.396 pd=2.73 as=0.744 ps=5.42 w=2.4 l=0.15
X283 a_24331_304# mode_5g vss vss sky130_fd_pr__nfet_01v8_lvt ad=0.2475 pd=1.83 as=0.465 ps=3.62 w=1.5 l=0.15
X284 a_8696_n1376# a_458_n1256# a_9070_n1616# vdd sky130_fd_pr__pfet_01v8 ad=0.495 pd=3.33 as=0.93 ps=6.62 w=3 l=0.15
X285 a_27304_324# a_458_484# vss vss sky130_fd_pr__nfet_01v8 ad=0.348 pd=2.98 as=0.348 ps=2.98 w=1.2 l=0.18
X286 a_6175_n1536# a_5209_n1336# vdd vdd sky130_fd_pr__pfet_01v8 ad=0.754 pd=5.78 as=0.754 ps=5.78 w=2.6 l=0.15
X287 a_8744_n604# a_8606_n998# vss vss sky130_fd_pr__nfet_01v8_lvt ad=0.522 pd=4.18 as=0.522 ps=4.18 w=1.8 l=0.15
X288 a_18798_1016# a_18798_n1520# vdd vdd sky130_fd_pr__pfet_01v8 ad=0.5104 pd=4.1 as=0.5104 ps=4.1 w=1.76 l=0.15
X289 a_14912_1016# a_7623_n1520# a_15745_1016# vdd sky130_fd_pr__pfet_01v8 ad=0.465 pd=3.62 as=0.2475 ps=1.83 w=1.5 l=0.15
X290 a_27304_n1336# a_27304_324# vss vss sky130_fd_pr__nfet_01v8 ad=0.1595 pd=1.68 as=0.1595 ps=1.68 w=0.55 l=0.15
X291 vdd a_3167_n1520# a_26044_n1336# vdd sky130_fd_pr__pfet_01v8 ad=0.496 pd=3.82 as=0.264 ps=1.93 w=1.6 l=0.15
X292 a_18798_n1520# a_18798_1016# vdd vdd sky130_fd_pr__pfet_01v8 ad=0.5104 pd=4.1 as=0.5104 ps=4.1 w=1.76 l=0.15
X293 a_15745_1016# a_15745_n1316# vss vss sky130_fd_pr__nfet_01v8 ad=0.1218 pd=1.42 as=0.1218 ps=1.42 w=0.42 l=0.28
X294 a_15745_n1316# rst_n vdd vdd sky130_fd_pr__pfet_01v8 ad=0.464 pd=3.78 as=0.464 ps=3.78 w=1.6 l=0.18
X295 a_23857_n604# a_12921_n1656# vss vss sky130_fd_pr__nfet_01v8_lvt ad=0.2475 pd=1.83 as=0.465 ps=3.62 w=1.5 l=0.15
X296 a_15745_n1316# a_15745_1016# vdd vdd sky130_fd_pr__pfet_01v8 ad=0.1218 pd=1.42 as=0.1218 ps=1.42 w=0.42 l=0.28
X297 a_11859_1016# a_7623_n1520# a_11026_1016# vdd sky130_fd_pr__pfet_01v8 ad=0.33 pd=2.33 as=0.62 ps=4.62 w=2 l=0.15
X298 vdd a_19631_1016# a_8980_n998# vdd sky130_fd_pr__pfet_01v8 ad=0.3696 pd=2.57 as=0.3696 ps=2.57 w=2.24 l=0.15
X299 a_859_1016# clkp vdd vdd sky130_fd_pr__pfet_01v8_lvt ad=0.348 pd=2.69 as=0.696 ps=5.38 w=2.4 l=0.35
X300 a_12921_n1656# a_12921_1016# vdd vdd sky130_fd_pr__pfet_01v8 ad=0.5104 pd=4.1 as=0.5104 ps=4.1 w=1.76 l=0.15
X301 vdd a_22846_n1496# a_24327_n1516# vdd sky130_fd_pr__pfet_01v8 ad=0.4125 pd=2.83 as=0.4125 ps=2.83 w=2.5 l=0.15
X302 a_5119_622# a_6175_474# vss vss sky130_fd_pr__nfet_01v8_lvt ad=0.297 pd=2.13 as=0.558 ps=4.22 w=1.8 l=0.15
X303 vdd a_859_1016# a_1579_1016# vdd sky130_fd_pr__pfet_01v8 ad=0.3696 pd=2.57 as=0.3696 ps=2.57 w=2.24 l=0.15
X304 a_859_1016# clkp vss vss sky130_fd_pr__nfet_01v8_lvt ad=0.348 pd=2.98 as=0.348 ps=2.98 w=1.2 l=0.15
X305 a_8744_364# a_8980_622# a_8696_1016# vdd sky130_fd_pr__pfet_01v8 ad=0.396 pd=2.73 as=0.744 ps=5.42 w=2.4 l=0.15
X306 a_18798_1016# a_17736_n1316# vss vss sky130_fd_pr__nfet_01v8_lvt ad=0.348 pd=2.98 as=0.348 ps=2.98 w=1.2 l=0.15
X307 a_7623_1016# a_5119_622# vdd vdd sky130_fd_pr__pfet_01v8 ad=0.4158 pd=2.85 as=0.4158 ps=2.85 w=2.52 l=0.15
X308 fb250_b a_27304_324# vss vss sky130_fd_pr__nfet_01v8_lvt ad=0.198 pd=1.53 as=0.372 ps=3.02 w=1.2 l=0.15
X309 a_13850_1016# a_13850_n1316# vss vss sky130_fd_pr__nfet_01v8 ad=0.1218 pd=1.42 as=0.1218 ps=1.42 w=0.42 l=0.28
X310 a_8744_364# a_7623_1016# a_9964_1016# vdd sky130_fd_pr__pfet_01v8 ad=0.62 pd=4.62 as=0.33 ps=2.33 w=2 l=0.15
X311 vdd a_12921_n1656# a_23761_n1316# vdd sky130_fd_pr__pfet_01v8 ad=0.465 pd=3.62 as=0.2475 ps=1.83 w=1.5 l=0.15
X312 a_23857_404# mode_5g a_23761_1016# vdd sky130_fd_pr__pfet_01v8 ad=0.33 pd=2.33 as=0.62 ps=4.62 w=2 l=0.15
X313 vdd a_17736_1016# a_18798_n1520# vdd sky130_fd_pr__pfet_01v8 ad=0.7812 pd=5.66 as=0.4158 ps=2.85 w=2.52 l=0.15
X314 a_26044_1016# a_3167_n1520# vdd vdd sky130_fd_pr__pfet_01v8 ad=0.264 pd=1.93 as=0.496 ps=3.82 w=1.6 l=0.15
X315 a_23761_n1316# a_22846_n1496# a_23857_n604# vss sky130_fd_pr__nfet_01v8_lvt ad=0.2475 pd=1.83 as=0.465 ps=3.62 w=1.5 l=0.15
X316 a_5119_622# a_5209_n1336# vdd vdd sky130_fd_pr__pfet_01v8 ad=0.3465 pd=2.43 as=0.651 ps=4.82 w=2.1 l=0.15
X317 vdd clkn a_859_n1496# vdd sky130_fd_pr__pfet_01v8_lvt ad=0.696 pd=5.38 as=0.348 ps=2.69 w=2.4 l=0.35
X318 vss a_5119_622# a_7623_1016# vss sky130_fd_pr__nfet_01v8_lvt ad=0.372 pd=3.02 as=0.198 ps=1.53 w=1.2 l=0.15
X319 a_21784_n1456# a_7623_n1520# a_12921_n1656# vss sky130_fd_pr__nfet_01v8_lvt ad=0.522 pd=4.18 as=0.522 ps=4.18 w=1.8 l=0.15
X320 a_11859_1016# a_7623_1016# a_11026_1016# vss sky130_fd_pr__nfet_01v8_lvt ad=0.464 pd=3.78 as=0.464 ps=3.78 w=1.6 l=0.15
X321 a_1579_1016# a_1579_n1464# vdd vdd sky130_fd_pr__pfet_01v8 ad=0.5481 pd=4.36 as=0.5481 ps=4.36 w=1.89 l=0.15
X322 a_7623_1016# a_5119_622# vss vss sky130_fd_pr__nfet_01v8_lvt ad=0.198 pd=1.53 as=0.372 ps=3.02 w=1.2 l=0.15
X323 a_17736_1016# a_7623_1016# a_8606_622# vdd sky130_fd_pr__pfet_01v8 ad=0.2475 pd=1.83 as=0.465 ps=3.62 w=1.5 l=0.15
X324 a_9070_n1616# a_458_n1256# a_8696_n1376# vdd sky130_fd_pr__pfet_01v8 ad=0.93 pd=6.62 as=0.495 ps=3.33 w=3 l=0.15
X325 vdd a_1579_1016# a_3761_1016# vdd sky130_fd_pr__pfet_01v8 ad=0.7812 pd=5.66 as=0.4158 ps=2.85 w=2.52 l=0.15
X326 a_21784_1016# a_21784_n1456# vdd vdd sky130_fd_pr__pfet_01v8 ad=0.1218 pd=1.42 as=0.1218 ps=1.42 w=0.42 l=0.28
X327 a_8696_n1376# a_8606_n998# vdd vdd sky130_fd_pr__pfet_01v8 ad=0.297 pd=2.13 as=0.558 ps=4.22 w=1.8 l=0.15
X328 a_12921_n1656# a_11859_1016# vss vss sky130_fd_pr__nfet_01v8_lvt ad=0.696 pd=5.38 as=0.696 ps=5.38 w=2.4 l=0.15
X329 a_7623_1016# a_7623_n1520# vdd vdd sky130_fd_pr__pfet_01v8 ad=0.609 pd=4.78 as=0.609 ps=4.78 w=2.1 l=0.15
X330 a_23761_1016# a_12921_1016# vdd vdd sky130_fd_pr__pfet_01v8 ad=0.33 pd=2.33 as=0.33 ps=2.33 w=2 l=0.15
X331 a_458_n1256# mode_5g vss vss sky130_fd_pr__nfet_01v8 ad=0.174 pd=1.78 as=0.174 ps=1.78 w=0.6 l=0.18
X332 vss a_6175_n1536# a_5119_n716# vss sky130_fd_pr__nfet_01v8_lvt ad=0.558 pd=4.22 as=0.297 ps=2.13 w=1.8 l=0.15
X333 a_21784_1016# a_7623_n1520# a_12921_1016# vss sky130_fd_pr__nfet_01v8_lvt ad=0.522 pd=4.18 as=0.522 ps=4.18 w=1.8 l=0.15
X334 vdd a_5209_1016# a_5119_n716# vdd sky130_fd_pr__pfet_01v8 ad=0.651 pd=4.82 as=0.3465 ps=2.43 w=2.1 l=0.15
X335 a_11026_n1576# a_11026_1016# vdd vdd sky130_fd_pr__pfet_01v8 ad=0.5104 pd=4.1 as=0.5104 ps=4.1 w=1.76 l=0.15
X336 a_8980_n998# a_19631_1016# vss vss sky130_fd_pr__nfet_01v8_lvt ad=0.464 pd=3.78 as=0.464 ps=3.78 w=1.6 l=0.15
X337 a_8606_622# a_15745_n1316# vdd vdd sky130_fd_pr__pfet_01v8 ad=0.6944 pd=5.1 as=0.3696 ps=2.57 w=2.24 l=0.15
X338 a_8980_n998# a_19631_1016# vdd vdd sky130_fd_pr__pfet_01v8 ad=0.6944 pd=5.1 as=0.3696 ps=2.57 w=2.24 l=0.15
X339 a_5119_n716# a_6175_n1536# vss vss sky130_fd_pr__nfet_01v8_lvt ad=0.297 pd=2.13 as=0.558 ps=4.22 w=1.8 l=0.15
X340 a_9964_1016# a_7623_1016# a_8744_364# vdd sky130_fd_pr__pfet_01v8 ad=0.33 pd=2.33 as=0.62 ps=4.62 w=2 l=0.15
X341 a_14912_1016# a_13850_n1316# vss vss sky130_fd_pr__nfet_01v8_lvt ad=0.348 pd=2.98 as=0.348 ps=2.98 w=1.2 l=0.15
X342 a_19631_n1316# rst_n vdd vdd sky130_fd_pr__pfet_01v8 ad=0.464 pd=3.78 as=0.464 ps=3.78 w=1.6 l=0.18
X343 a_3167_n1520# a_2697_n1464# vdd vdd sky130_fd_pr__pfet_01v8 ad=0.4158 pd=2.85 as=0.4158 ps=2.85 w=2.52 l=0.15
X344 a_8744_364# a_8980_622# a_9030_244# vss sky130_fd_pr__nfet_01v8_lvt ad=0.522 pd=4.18 as=0.522 ps=4.18 w=1.8 l=0.15
X345 a_3761_n1520# a_1579_n1464# vss vss sky130_fd_pr__nfet_01v8_lvt ad=0.198 pd=1.53 as=0.372 ps=3.02 w=1.2 l=0.15
X346 a_18798_n1520# a_17736_1016# vss vss sky130_fd_pr__nfet_01v8_lvt ad=0.348 pd=2.98 as=0.348 ps=2.98 w=1.2 l=0.15
X347 fb250 a_27304_n1336# vdd vdd sky130_fd_pr__pfet_01v8 ad=0.4158 pd=2.85 as=0.4158 ps=2.85 w=2.52 l=0.15
X348 a_11859_1016# a_11859_n1416# vss vss sky130_fd_pr__nfet_01v8 ad=0.1218 pd=1.42 as=0.1218 ps=1.42 w=0.42 l=0.28
X349 a_13850_1016# a_7623_1016# a_12921_1016# vdd sky130_fd_pr__pfet_01v8 ad=0.2475 pd=1.83 as=0.465 ps=3.62 w=1.5 l=0.15
X350 vdd clkp a_859_1016# vdd sky130_fd_pr__pfet_01v8_lvt ad=0.696 pd=5.38 as=0.348 ps=2.69 w=2.4 l=0.35
X351 a_12921_n1656# a_12921_1016# vss vss sky130_fd_pr__nfet_01v8_lvt ad=0.1218 pd=1.42 as=0.1218 ps=1.42 w=0.42 l=0.15
X352 a_9964_1016# a_7623_n1520# a_8744_364# vss sky130_fd_pr__nfet_01v8_lvt ad=0.464 pd=3.78 as=0.464 ps=3.78 w=1.6 l=0.15
X353 a_8606_622# a_15745_n1316# vss vss sky130_fd_pr__nfet_01v8_lvt ad=0.464 pd=3.78 as=0.464 ps=3.78 w=1.6 l=0.15
X354 vss a_27010_464# a_27304_n1336# vss sky130_fd_pr__nfet_01v8_lvt ad=0.434 pd=3.42 as=0.231 ps=1.73 w=1.4 l=0.15
X355 a_19631_1016# a_7623_1016# a_18798_1016# vss sky130_fd_pr__nfet_01v8_lvt ad=0.348 pd=2.98 as=0.348 ps=2.98 w=1.2 l=0.15
X356 vdd a_8980_n998# a_9070_n1616# vdd sky130_fd_pr__pfet_01v8 ad=0.93 pd=6.62 as=0.495 ps=3.33 w=3 l=0.15
X357 vss a_21784_n1456# a_22846_1016# vss sky130_fd_pr__nfet_01v8_lvt ad=0.372 pd=3.02 as=0.198 ps=1.53 w=1.2 l=0.15
X358 vdd a_5209_n1336# a_5119_622# vdd sky130_fd_pr__pfet_01v8 ad=0.651 pd=4.82 as=0.3465 ps=2.43 w=2.1 l=0.15
X359 a_9964_1016# a_9964_n1416# vss vss sky130_fd_pr__nfet_01v8 ad=0.1218 pd=1.42 as=0.1218 ps=1.42 w=0.42 l=0.28
X360 a_9964_n1416# a_9964_1016# vss vss sky130_fd_pr__nfet_01v8 ad=0.1218 pd=1.42 as=0.1218 ps=1.42 w=0.42 l=0.28
X361 a_22846_n1496# a_22846_1016# vdd vdd sky130_fd_pr__pfet_01v8 ad=0.5104 pd=4.1 as=0.5104 ps=4.1 w=1.76 l=0.15
X362 a_4891_n1296# a_3761_n1520# vdd vdd sky130_fd_pr__pfet_01v8 ad=0.406 pd=3.38 as=0.406 ps=3.38 w=1.4 l=0.15
X363 a_18798_1016# a_7623_n1520# a_19631_1016# vdd sky130_fd_pr__pfet_01v8 ad=0.465 pd=3.62 as=0.2475 ps=1.83 w=1.5 l=0.15
X364 a_14912_n1520# a_13850_1016# vss vss sky130_fd_pr__nfet_01v8_lvt ad=0.348 pd=2.98 as=0.348 ps=2.98 w=1.2 l=0.15
X365 vdd a_8606_n998# a_8696_n1376# vdd sky130_fd_pr__pfet_01v8 ad=0.558 pd=4.22 as=0.297 ps=2.13 w=1.8 l=0.15
X366 a_17736_1016# a_7623_n1520# a_8606_622# vss sky130_fd_pr__nfet_01v8_lvt ad=0.348 pd=2.98 as=0.348 ps=2.98 w=1.2 l=0.15
X367 a_8980_622# a_19631_n1316# vdd vdd sky130_fd_pr__pfet_01v8 ad=0.6944 pd=5.1 as=0.3696 ps=2.57 w=2.24 l=0.15
X368 a_19631_1016# a_19631_n1316# vss vss sky130_fd_pr__nfet_01v8 ad=0.1218 pd=1.42 as=0.1218 ps=1.42 w=0.42 l=0.28
X369 a_3761_n1520# a_3761_1016# vss vss sky130_fd_pr__nfet_01v8_lvt ad=0.145 pd=1.58 as=0.145 ps=1.58 w=0.5 l=0.15
X370 a_15745_1016# a_7623_n1520# a_14912_1016# vdd sky130_fd_pr__pfet_01v8 ad=0.2475 pd=1.83 as=0.465 ps=3.62 w=1.5 l=0.15
X371 a_13850_n1316# a_13850_1016# vdd vdd sky130_fd_pr__pfet_01v8 ad=0.1218 pd=1.42 as=0.1218 ps=1.42 w=0.42 l=0.28
X372 a_7623_1016# a_7623_n1520# vss vss sky130_fd_pr__nfet_01v8_lvt ad=0.145 pd=1.58 as=0.145 ps=1.58 w=0.5 l=0.15
X373 a_3761_1016# a_1579_1016# vdd vdd sky130_fd_pr__pfet_01v8 ad=0.4158 pd=2.85 as=0.4158 ps=2.85 w=2.52 l=0.15
X374 a_4843_n604# a_5119_622# a_4891_1016# vss sky130_fd_pr__nfet_01v8_lvt ad=0.558 pd=4.22 as=0.297 ps=2.13 w=1.8 l=0.15
X375 a_27304_324# a_27304_n1336# vdd vdd sky130_fd_pr__pfet_01v8 ad=0.1885 pd=1.88 as=0.1885 ps=1.88 w=0.65 l=0.15
X376 a_27304_n1336# a_26044_n1336# vdd vdd sky130_fd_pr__pfet_01v8 ad=0.264 pd=1.93 as=0.496 ps=3.82 w=1.6 l=0.15
X377 a_11026_1016# a_9964_n1416# vss vss sky130_fd_pr__nfet_01v8_lvt ad=0.406 pd=3.38 as=0.406 ps=3.38 w=1.4 l=0.15
X378 vdd a_2697_n1464# a_3167_n1520# vdd sky130_fd_pr__pfet_01v8 ad=0.7812 pd=5.66 as=0.4158 ps=2.85 w=2.52 l=0.15
X379 a_4891_1016# a_5119_622# a_4843_n604# vss sky130_fd_pr__nfet_01v8_lvt ad=0.297 pd=2.13 as=0.558 ps=4.22 w=1.8 l=0.15
X380 vss a_3167_n1520# a_25678_n604# vss sky130_fd_pr__nfet_01v8_lvt ad=0.372 pd=3.02 as=0.198 ps=1.53 w=1.2 l=0.15
X381 a_2697_n1464# a_2323_n1520# vdd vdd sky130_fd_pr__pfet_01v8 ad=0.3696 pd=2.57 as=0.6944 ps=5.1 w=2.24 l=0.15
X382 a_1579_n1464# a_859_n1496# vdd vdd sky130_fd_pr__pfet_01v8 ad=0.3696 pd=2.57 as=0.6944 ps=5.1 w=2.24 l=0.15
X383 a_1579_1016# a_859_1016# vdd vdd sky130_fd_pr__pfet_01v8 ad=0.3696 pd=2.57 as=0.6944 ps=5.1 w=2.24 l=0.15
X384 a_15745_1016# a_7623_1016# a_14912_1016# vss sky130_fd_pr__nfet_01v8_lvt ad=0.348 pd=2.98 as=0.348 ps=2.98 w=1.2 l=0.15
X385 a_8606_n998# a_15745_1016# vdd vdd sky130_fd_pr__pfet_01v8 ad=0.6944 pd=5.1 as=0.3696 ps=2.57 w=2.24 l=0.15
X386 a_11859_n1416# a_11859_1016# vss vss sky130_fd_pr__nfet_01v8 ad=0.1218 pd=1.42 as=0.1218 ps=1.42 w=0.42 l=0.28
X387 vdd a_13850_n1316# a_14912_1016# vdd sky130_fd_pr__pfet_01v8 ad=0.7812 pd=5.66 as=0.4158 ps=2.85 w=2.52 l=0.15
X388 vdd a_5119_622# a_7623_1016# vdd sky130_fd_pr__pfet_01v8 ad=0.4158 pd=2.85 as=0.4158 ps=2.85 w=2.52 l=0.15
X389 a_14912_n1520# a_13850_1016# vdd vdd sky130_fd_pr__pfet_01v8 ad=0.4158 pd=2.85 as=0.7812 ps=5.66 w=2.52 l=0.15
.ends
