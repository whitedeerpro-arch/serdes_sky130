* NGSPICE file created from pll_div_ab_5g_v2_pdk.ext - technology: sky130A

.subckt pll_div_ab_5g_v2_pdk clkp clkn mode_5g rst_n fb250 fb250_b vdd vss
X0 a_13712_n1576# a_12650_1016# vdd vdd sky130_fd_pr__pfet_01v8 ad=0.462 pd=3.13 as=0.868 ps=6.22 w=2.8 l=0.15
X1 a_1653_n1476# a_859_n1456# vdd vdd sky130_fd_pr__pfet_01v8 ad=0.713 pd=5.22 as=0.3795 ps=2.63 w=2.3 l=0.15
X2 vdd a_4919_n1556# a_28730_1016# vdd sky130_fd_pr__pfet_01v8 ad=0.527 pd=4.02 as=0.2805 ps=2.03 w=1.7 l=0.15
X3 a_25532_n1496# a_24470_1016# vdd vdd sky130_fd_pr__pfet_01v8 ad=0.396 pd=2.73 as=0.396 ps=2.73 w=2.4 l=0.15
X4 a_28730_n1356# a_28730_1016# a_28412_n1316# vss sky130_fd_pr__nfet_01v8_lvt ad=0.231 pd=1.73 as=0.434 ps=3.42 w=1.4 l=0.15
X5 vdd a_11292_n998# a_11382_n1376# vdd sky130_fd_pr__pfet_01v8 ad=0.558 pd=4.22 as=0.297 ps=2.13 w=1.8 l=0.15
X6 a_8591_n1536# a_7625_n1396# vdd vdd sky130_fd_pr__pfet_01v8 ad=0.754 pd=5.78 as=0.754 ps=5.78 w=2.6 l=0.15
X7 a_14545_n1416# a_10251_n1496# a_13712_n1576# vdd sky130_fd_pr__pfet_01v8 ad=0.33 pd=2.33 as=0.62 ps=4.62 w=2 l=0.15
X8 a_4449_n1536# a_3979_n1426# vdd vdd sky130_fd_pr__pfet_01v8 ad=0.429 pd=2.93 as=0.806 ps=5.82 w=2.6 l=0.15
X9 vdd a_1653_n1476# a_2483_n1396# vdd sky130_fd_pr__pfet_01v8 ad=0.589 pd=4.42 as=0.3135 ps=2.23 w=1.9 l=0.15
X10 vdd clkn a_859_n1456# vdd sky130_fd_pr__pfet_01v8_lvt ad=0.638 pd=4.98 as=0.319 ps=2.49 w=2.2 l=0.35
X11 a_27013_n1516# a_458_n1256# a_26447_n1316# vdd sky130_fd_pr__pfet_01v8 ad=0.4125 pd=2.83 as=0.4125 ps=2.83 w=2.5 l=0.15
X12 a_859_n1456# a_859_1016# vdd vdd sky130_fd_pr__pfet_01v8 ad=0.2436 pd=2.26 as=0.2436 ps=2.26 w=0.84 l=0.28
X13 a_7535_n716# a_7535_622# vss vss sky130_fd_pr__nfet_01v8 ad=0.145 pd=1.58 as=0.145 ps=1.58 w=0.5 l=0.15
X14 a_11382_1016# mode_5g a_11430_364# vdd sky130_fd_pr__pfet_01v8 ad=0.744 pd=5.42 as=0.396 ps=2.73 w=2.4 l=0.15
X15 a_24470_n1456# a_24470_1016# vss vss sky130_fd_pr__nfet_01v8 ad=0.1218 pd=1.42 as=0.1218 ps=1.42 w=0.42 l=0.28
X16 a_859_n1456# clkn vss vss sky130_fd_pr__nfet_01v8_lvt ad=0.348 pd=2.98 as=0.348 ps=2.98 w=1.2 l=0.15
X17 a_18431_1016# a_458_484# vss vss sky130_fd_pr__nfet_01v8 ad=0.261 pd=2.38 as=0.261 ps=2.38 w=0.9 l=0.18
X18 a_25532_1016# a_24470_n1456# vdd vdd sky130_fd_pr__pfet_01v8 ad=0.396 pd=2.73 as=0.396 ps=2.73 w=2.4 l=0.15
X19 vss a_15607_n1656# a_26543_n604# vss sky130_fd_pr__nfet_01v8_lvt ad=0.465 pd=3.62 as=0.2475 ps=1.83 w=1.5 l=0.15
X20 vdd a_1653_n1476# a_5513_n1556# vdd sky130_fd_pr__pfet_01v8 ad=0.837 pd=6.02 as=0.4455 ps=3.03 w=2.7 l=0.15
X21 a_13712_1016# a_12650_n1416# vdd vdd sky130_fd_pr__pfet_01v8 ad=0.462 pd=3.13 as=0.868 ps=6.22 w=2.8 l=0.15
X22 a_17598_n1520# a_17598_1016# vdd vdd sky130_fd_pr__pfet_01v8 ad=0.5104 pd=4.1 as=0.5104 ps=4.1 w=1.76 l=0.15
X23 a_29696_464# a_28730_1016# vdd vdd sky130_fd_pr__pfet_01v8 ad=0.812 pd=6.18 as=0.812 ps=6.18 w=2.8 l=0.15
X24 a_26447_1016# a_15607_1016# vdd vdd sky130_fd_pr__pfet_01v8 ad=0.33 pd=2.33 as=0.62 ps=4.62 w=2 l=0.15
X25 a_26543_404# a_15607_1016# vss vss sky130_fd_pr__nfet_01v8_lvt ad=0.165 pd=1.33 as=0.31 ps=2.62 w=1 l=0.15
X26 a_14545_n1416# a_14545_1016# vdd vdd sky130_fd_pr__pfet_01v8 ad=0.1218 pd=1.42 as=0.1218 ps=1.42 w=0.42 l=0.28
X27 a_458_484# rst_n vdd vdd sky130_fd_pr__pfet_01v8 ad=0.348 pd=2.98 as=0.348 ps=2.98 w=1.2 l=0.18
X28 vss a_8591_494# a_7535_622# vss sky130_fd_pr__nfet_01v8_lvt ad=0.372 pd=3.02 as=0.198 ps=1.53 w=1.2 l=0.15
X29 vss a_1653_1016# a_5513_1016# vss sky130_fd_pr__nfet_01v8_lvt ad=0.434 pd=3.42 as=0.231 ps=1.73 w=1.4 l=0.15
X30 a_11666_n998# a_11666_622# vdd vdd sky130_fd_pr__pfet_01v8 ad=0.5104 pd=4.1 as=0.5104 ps=4.1 w=1.76 l=0.15
X31 a_16536_1016# a_458_484# vss vss sky130_fd_pr__nfet_01v8 ad=0.261 pd=2.38 as=0.261 ps=2.38 w=0.9 l=0.18
X32 a_3605_n1556# a_3231_n1476# vdd vdd sky130_fd_pr__pfet_01v8 ad=0.4455 pd=3.03 as=0.837 ps=6.02 w=2.7 l=0.15
X33 a_1653_n1476# a_859_n1456# vss vss sky130_fd_pr__nfet_01v8_lvt ad=0.522 pd=4.18 as=0.522 ps=4.18 w=1.8 l=0.15
X34 a_21484_1016# a_20422_n1316# vdd vdd sky130_fd_pr__pfet_01v8 ad=0.4158 pd=2.85 as=0.7812 ps=5.66 w=2.52 l=0.15
X35 a_5513_1016# a_1653_1016# vss vss sky130_fd_pr__nfet_01v8_lvt ad=0.231 pd=1.73 as=0.434 ps=3.42 w=1.4 l=0.15
X36 fb250 fb250_b vdd vdd sky130_fd_pr__pfet_01v8 ad=0.348 pd=2.98 as=0.348 ps=2.98 w=1.2 l=0.15
X37 vdd a_15607_n1656# a_26447_n1316# vdd sky130_fd_pr__pfet_01v8 ad=0.2475 pd=1.83 as=0.2475 ps=1.83 w=1.5 l=0.15
X38 vss a_15607_1016# a_26543_404# vss sky130_fd_pr__nfet_01v8_lvt ad=0.31 pd=2.62 as=0.165 ps=1.33 w=1 l=0.15
X39 a_25532_1016# a_25532_n1496# vdd vdd sky130_fd_pr__pfet_01v8 ad=0.5104 pd=4.1 as=0.5104 ps=4.1 w=1.76 l=0.15
X40 a_28730_1016# a_28730_n1356# vdd vdd sky130_fd_pr__pfet_01v8 ad=0.464 pd=3.78 as=0.464 ps=3.78 w=1.6 l=0.15
X41 a_26447_1016# mode_5g a_26543_404# vdd sky130_fd_pr__pfet_01v8 ad=0.33 pd=2.33 as=0.33 ps=2.33 w=2 l=0.15
X42 a_16536_n1316# a_10251_n1496# a_15607_n1656# vss sky130_fd_pr__nfet_01v8_lvt ad=0.348 pd=2.98 as=0.348 ps=2.98 w=1.2 l=0.15
X43 a_15607_n1656# a_14545_1016# vdd vdd sky130_fd_pr__pfet_01v8 ad=0.528 pd=3.53 as=0.992 ps=7.02 w=3.2 l=0.15
X44 a_26543_n604# a_25532_n1496# a_26447_n1316# vss sky130_fd_pr__nfet_01v8_lvt ad=0.465 pd=3.62 as=0.2475 ps=1.83 w=1.5 l=0.15
X45 a_13712_1016# a_13712_n1576# vdd vdd sky130_fd_pr__pfet_01v8 ad=0.5104 pd=4.1 as=0.5104 ps=4.1 w=1.76 l=0.15
X46 a_11292_n998# a_10251_1016# a_20422_n1316# vdd sky130_fd_pr__pfet_01v8 ad=0.465 pd=3.62 as=0.2475 ps=1.83 w=1.5 l=0.15
X47 vdd a_24470_1016# a_25532_n1496# vdd sky130_fd_pr__pfet_01v8 ad=0.744 pd=5.42 as=0.396 ps=2.73 w=2.4 l=0.15
X48 a_7535_622# a_7625_n1396# vdd vdd sky130_fd_pr__pfet_01v8 ad=0.396 pd=2.73 as=0.396 ps=2.73 w=2.4 l=0.15
X49 a_14545_1016# a_458_484# vss vss sky130_fd_pr__nfet_01v8 ad=0.261 pd=2.38 as=0.261 ps=2.38 w=0.9 l=0.18
X50 a_13712_n1576# a_10251_n1496# a_14545_n1416# vdd sky130_fd_pr__pfet_01v8 ad=0.62 pd=4.62 as=0.33 ps=2.33 w=2 l=0.15
X51 a_24470_n1456# a_24470_1016# vdd vdd sky130_fd_pr__pfet_01v8 ad=0.1218 pd=1.42 as=0.1218 ps=1.42 w=0.42 l=0.28
X52 vdd a_3979_n1426# a_4449_n1536# vdd sky130_fd_pr__pfet_01v8 ad=0.429 pd=2.93 as=0.429 ps=2.93 w=2.6 l=0.15
X53 a_24470_1016# a_10251_1016# a_15607_1016# vdd sky130_fd_pr__pfet_01v8 ad=0.363 pd=2.53 as=0.682 ps=5.02 w=2.2 l=0.15
X54 a_15607_1016# a_14545_n1416# vdd vdd sky130_fd_pr__pfet_01v8 ad=0.528 pd=3.53 as=0.992 ps=7.02 w=3.2 l=0.15
X55 a_26447_n1316# a_458_n1256# a_27013_n1516# vdd sky130_fd_pr__pfet_01v8 ad=0.4125 pd=2.83 as=0.4125 ps=2.83 w=2.5 l=0.15
X56 vdd a_15607_1016# a_26447_1016# vdd sky130_fd_pr__pfet_01v8 ad=0.62 pd=4.62 as=0.33 ps=2.33 w=2 l=0.15
X57 a_5513_1016# a_5513_n1556# vss vss sky130_fd_pr__nfet_01v8 ad=0.1305 pd=1.48 as=0.1305 ps=1.48 w=0.45 l=0.2
X58 a_29990_n1456# a_29990_344# vss vss sky130_fd_pr__nfet_01v8 ad=0.1595 pd=1.68 as=0.1595 ps=1.68 w=0.55 l=0.15
X59 a_27017_304# a_25532_1016# a_26543_404# vss sky130_fd_pr__nfet_01v8_lvt ad=0.465 pd=3.62 as=0.2475 ps=1.83 w=1.5 l=0.15
X60 a_10251_n1496# a_10251_1016# vss vss sky130_fd_pr__nfet_01v8 ad=0.1305 pd=1.48 as=0.1305 ps=1.48 w=0.45 l=0.2
X61 a_7625_n1396# a_7625_1016# a_7307_n1336# vss sky130_fd_pr__nfet_01v8_lvt ad=0.231 pd=1.73 as=0.434 ps=3.42 w=1.4 l=0.15
X62 a_26543_404# a_25532_1016# a_27017_304# vss sky130_fd_pr__nfet_01v8_lvt ad=0.2475 pd=1.83 as=0.465 ps=3.62 w=1.5 l=0.15
X63 vdd a_7625_1016# a_7535_n716# vdd sky130_fd_pr__pfet_01v8 ad=0.744 pd=5.42 as=0.396 ps=2.73 w=2.4 l=0.15
X64 a_12650_n1416# a_12650_1016# vdd vdd sky130_fd_pr__pfet_01v8 ad=0.1218 pd=1.42 as=0.1218 ps=1.42 w=0.42 l=0.28
X65 a_11666_622# a_22317_n1316# vdd vdd sky130_fd_pr__pfet_01v8 ad=0.3696 pd=2.57 as=0.6944 ps=5.1 w=2.24 l=0.15
X66 a_7535_n716# a_458_484# vss vss sky130_fd_pr__nfet_01v8 ad=0.348 pd=2.98 as=0.348 ps=2.98 w=1.2 l=0.18
X67 a_7625_1016# a_7625_n1396# a_7307_1016# vss sky130_fd_pr__nfet_01v8_lvt ad=0.231 pd=1.73 as=0.434 ps=3.42 w=1.4 l=0.15
X68 vdd a_7535_622# a_10251_1016# vdd sky130_fd_pr__pfet_01v8 ad=0.744 pd=5.42 as=0.396 ps=2.73 w=2.4 l=0.15
X69 a_1653_1016# a_859_1016# vdd vdd sky130_fd_pr__pfet_01v8 ad=0.713 pd=5.22 as=0.3795 ps=2.63 w=2.3 l=0.15
X70 a_11292_n998# a_18431_1016# vdd vdd sky130_fd_pr__pfet_01v8 ad=0.3696 pd=2.57 as=0.6944 ps=5.1 w=2.24 l=0.15
X71 a_15607_1016# a_10251_1016# a_16536_1016# vdd sky130_fd_pr__pfet_01v8 ad=0.465 pd=3.62 as=0.2475 ps=1.83 w=1.5 l=0.15
X72 a_21484_n1520# a_21484_1016# vdd vdd sky130_fd_pr__pfet_01v8 ad=0.5104 pd=4.1 as=0.5104 ps=4.1 w=1.76 l=0.15
X73 a_18431_n1316# a_10251_1016# a_17598_n1520# vss sky130_fd_pr__nfet_01v8_lvt ad=0.348 pd=2.98 as=0.348 ps=2.98 w=1.2 l=0.15
X74 a_1653_n1476# a_1653_1016# vdd vdd sky130_fd_pr__pfet_01v8 ad=0.406 pd=3.38 as=0.406 ps=3.38 w=1.4 l=0.2
X75 a_20422_n1316# a_10251_n1496# a_11292_n998# vss sky130_fd_pr__nfet_01v8_lvt ad=0.348 pd=2.98 as=0.348 ps=2.98 w=1.2 l=0.15
X76 vdd a_3231_n1476# a_3605_n1556# vdd sky130_fd_pr__pfet_01v8 ad=0.837 pd=6.02 as=0.4455 ps=3.03 w=2.7 l=0.15
X77 vss a_1653_n1476# a_5513_n1556# vss sky130_fd_pr__nfet_01v8_lvt ad=0.434 pd=3.42 as=0.231 ps=1.73 w=1.4 l=0.15
X78 a_26447_1016# a_25532_1016# a_26543_404# vdd sky130_fd_pr__pfet_01v8 ad=0.62 pd=4.62 as=0.33 ps=2.33 w=2 l=0.15
X79 a_5513_1016# a_1653_1016# vdd vdd sky130_fd_pr__pfet_01v8 ad=0.4455 pd=3.03 as=0.837 ps=6.02 w=2.7 l=0.15
X80 vdd a_14545_1016# a_15607_n1656# vdd sky130_fd_pr__pfet_01v8 ad=0.528 pd=3.53 as=0.528 ps=3.53 w=3.2 l=0.15
X81 a_12650_1016# a_458_484# vss vss sky130_fd_pr__nfet_01v8 ad=0.261 pd=2.38 as=0.261 ps=2.38 w=0.9 l=0.18
X82 a_7535_622# a_8591_494# vss vss sky130_fd_pr__nfet_01v8_lvt ad=0.198 pd=1.53 as=0.372 ps=3.02 w=1.2 l=0.15
X83 a_15607_n1656# a_10251_1016# a_24470_n1456# vdd sky130_fd_pr__pfet_01v8 ad=0.682 pd=5.02 as=0.363 ps=2.53 w=2.2 l=0.15
X84 a_15607_1016# a_15607_n1656# vss vss sky130_fd_pr__nfet_01v8_lvt ad=0.1218 pd=1.42 as=0.1218 ps=1.42 w=0.42 l=0.15
X85 a_3231_n1476# a_2857_n1396# vss vss sky130_fd_pr__nfet_01v8_lvt ad=0.348 pd=2.98 as=0.348 ps=2.98 w=1.2 l=0.15
X86 a_29990_344# a_29990_n1456# vss vss sky130_fd_pr__nfet_01v8 ad=0.1595 pd=1.68 as=0.1595 ps=1.68 w=0.55 l=0.15
X87 a_458_484# rst_n vss vss sky130_fd_pr__nfet_01v8 ad=0.174 pd=1.78 as=0.174 ps=1.78 w=0.6 l=0.18
X88 a_12650_n1416# a_10251_1016# a_11382_n1376# vdd sky130_fd_pr__pfet_01v8 ad=0.33 pd=2.33 as=0.62 ps=4.62 w=2 l=0.15
X89 a_16536_n1316# a_10251_1016# a_15607_n1656# vdd sky130_fd_pr__pfet_01v8 ad=0.2475 pd=1.83 as=0.465 ps=3.62 w=1.5 l=0.15
X90 vdd a_7625_n1396# a_7535_622# vdd sky130_fd_pr__pfet_01v8 ad=0.744 pd=5.42 as=0.396 ps=2.73 w=2.4 l=0.15
X91 vss a_5513_n1556# a_7259_n604# vss sky130_fd_pr__nfet_01v8_lvt ad=0.434 pd=3.42 as=0.231 ps=1.73 w=1.4 l=0.15
X92 a_1653_n1476# a_1653_1016# vss vss sky130_fd_pr__nfet_01v8 ad=0.1218 pd=1.42 as=0.1218 ps=1.42 w=0.42 l=0.2
X93 a_4449_n1536# a_3979_n1426# vdd vdd sky130_fd_pr__pfet_01v8 ad=0.806 pd=5.82 as=0.429 ps=2.93 w=2.6 l=0.15
X94 a_14545_n1416# a_10251_1016# a_13712_n1576# vss sky130_fd_pr__nfet_01v8_lvt ad=0.464 pd=3.78 as=0.464 ps=3.78 w=1.6 l=0.15
X95 a_28730_1016# a_4919_n1556# vdd vdd sky130_fd_pr__pfet_01v8 ad=0.2805 pd=2.03 as=0.527 ps=4.02 w=1.7 l=0.15
X96 vdd a_7535_n716# a_10251_n1496# vdd sky130_fd_pr__pfet_01v8 ad=0.396 pd=2.73 as=0.396 ps=2.73 w=2.4 l=0.15
X97 a_22317_1016# a_458_484# vss vss sky130_fd_pr__nfet_01v8 ad=0.261 pd=2.38 as=0.261 ps=2.38 w=0.9 l=0.18
X98 a_4919_n1556# a_4449_n1536# vss vss sky130_fd_pr__nfet_01v8_lvt ad=0.231 pd=1.73 as=0.434 ps=3.42 w=1.4 l=0.15
X99 a_11292_622# a_10251_1016# a_20422_1016# vdd sky130_fd_pr__pfet_01v8 ad=0.465 pd=3.62 as=0.2475 ps=1.83 w=1.5 l=0.15
X100 vdd a_24470_n1456# a_25532_1016# vdd sky130_fd_pr__pfet_01v8 ad=0.396 pd=2.73 as=0.396 ps=2.73 w=2.4 l=0.15
X101 a_24470_n1456# rst_n vdd vdd sky130_fd_pr__pfet_01v8 ad=0.464 pd=3.78 as=0.464 ps=3.78 w=1.6 l=0.18
X102 a_24470_1016# a_24470_n1456# vdd vdd sky130_fd_pr__pfet_01v8 ad=0.1218 pd=1.42 as=0.1218 ps=1.42 w=0.42 l=0.28
X103 a_11430_364# mode_5g a_11382_1016# vdd sky130_fd_pr__pfet_01v8 ad=0.396 pd=2.73 as=0.744 ps=5.42 w=2.4 l=0.15
X104 a_13712_1016# a_13712_n1576# vss vss sky130_fd_pr__nfet_01v8_lvt ad=0.1218 pd=1.42 as=0.1218 ps=1.42 w=0.42 l=0.15
X105 a_22317_n1316# a_10251_1016# a_21484_n1520# vss sky130_fd_pr__nfet_01v8_lvt ad=0.348 pd=2.98 as=0.348 ps=2.98 w=1.2 l=0.15
X106 a_7307_n1336# a_7625_1016# a_7625_n1396# vss sky130_fd_pr__nfet_01v8_lvt ad=0.434 pd=3.42 as=0.231 ps=1.73 w=1.4 l=0.15
X107 fb250 a_29990_n1456# vdd vdd sky130_fd_pr__pfet_01v8 ad=0.651 pd=4.82 as=0.3465 ps=2.43 w=2.1 l=0.15
X108 vdd a_1653_1016# a_5513_1016# vdd sky130_fd_pr__pfet_01v8 ad=0.837 pd=6.02 as=0.4455 ps=3.03 w=2.7 l=0.15
X109 vss a_8591_n1536# a_7535_n716# vss sky130_fd_pr__nfet_01v8_lvt ad=0.372 pd=3.02 as=0.198 ps=1.53 w=1.2 l=0.15
X110 a_11666_n998# a_22317_1016# vdd vdd sky130_fd_pr__pfet_01v8 ad=0.3696 pd=2.57 as=0.6944 ps=5.1 w=2.24 l=0.15
X111 a_16536_n1316# a_16536_1016# vss vss sky130_fd_pr__nfet_01v8 ad=0.1218 pd=1.42 as=0.1218 ps=1.42 w=0.42 l=0.28
X112 vdd a_5513_1016# a_6439_1016# vdd sky130_fd_pr__pfet_01v8 ad=0.62 pd=4.62 as=0.33 ps=2.33 w=2 l=0.15
X113 vss a_29696_464# a_29990_n1456# vss sky130_fd_pr__nfet_01v8_lvt ad=0.403 pd=3.22 as=0.2145 ps=1.63 w=1.3 l=0.15
X114 a_28412_1016# a_4919_n1556# vdd vdd sky130_fd_pr__pfet_01v8 ad=0.435 pd=3.58 as=0.435 ps=3.58 w=1.5 l=0.15
X115 fb250 fb250_b vss vss sky130_fd_pr__nfet_01v8_lvt ad=0.1305 pd=1.48 as=0.1305 ps=1.48 w=0.45 l=0.15
X116 a_13712_1016# a_10251_n1496# a_14545_1016# vdd sky130_fd_pr__pfet_01v8 ad=0.62 pd=4.62 as=0.33 ps=2.33 w=2 l=0.15
X117 a_26543_404# mode_5g a_26447_1016# vdd sky130_fd_pr__pfet_01v8 ad=0.33 pd=2.33 as=0.62 ps=4.62 w=2 l=0.15
X118 a_28730_n1356# a_28730_1016# vdd vdd sky130_fd_pr__pfet_01v8 ad=0.464 pd=3.78 as=0.464 ps=3.78 w=1.6 l=0.15
X119 a_11430_n604# a_11292_n998# vss vss sky130_fd_pr__nfet_01v8_lvt ad=0.522 pd=4.18 as=0.522 ps=4.18 w=1.8 l=0.15
X120 a_26447_n1316# a_25532_n1496# a_26543_n604# vss sky130_fd_pr__nfet_01v8_lvt ad=0.2475 pd=1.83 as=0.465 ps=3.62 w=1.5 l=0.15
X121 a_20422_1016# a_458_484# vss vss sky130_fd_pr__nfet_01v8 ad=0.261 pd=2.38 as=0.261 ps=2.38 w=0.9 l=0.18
X122 a_7535_622# rst_n vdd vdd sky130_fd_pr__pfet_01v8 ad=0.696 pd=5.38 as=0.696 ps=5.38 w=2.4 l=0.18
X123 vss a_3979_n1426# a_4449_n1536# vss sky130_fd_pr__nfet_01v8_lvt ad=0.31 pd=2.62 as=0.165 ps=1.33 w=1 l=0.15
X124 a_11292_622# a_11292_n998# vss vss sky130_fd_pr__nfet_01v8_lvt ad=0.1218 pd=1.42 as=0.1218 ps=1.42 w=0.42 l=0.15
X125 a_11292_622# a_18431_n1316# vdd vdd sky130_fd_pr__pfet_01v8 ad=0.3696 pd=2.57 as=0.6944 ps=5.1 w=2.24 l=0.15
X126 a_15607_n1656# a_10251_1016# a_16536_n1316# vdd sky130_fd_pr__pfet_01v8 ad=0.465 pd=3.62 as=0.2475 ps=1.83 w=1.5 l=0.15
X127 vss a_7535_n716# a_10251_n1496# vss sky130_fd_pr__nfet_01v8_lvt ad=0.372 pd=3.02 as=0.198 ps=1.53 w=1.2 l=0.15
X128 a_24470_1016# a_10251_n1496# a_15607_1016# vss sky130_fd_pr__nfet_01v8_lvt ad=0.522 pd=4.18 as=0.522 ps=4.18 w=1.8 l=0.15
X129 a_5513_n1556# a_5513_1016# vss vss sky130_fd_pr__nfet_01v8 ad=0.1305 pd=1.48 as=0.1305 ps=1.48 w=0.45 l=0.2
X130 a_4919_n1556# a_4449_n1536# vdd vdd sky130_fd_pr__pfet_01v8 ad=0.4455 pd=3.03 as=0.837 ps=6.02 w=2.7 l=0.15
X131 a_10251_1016# a_7535_622# vdd vdd sky130_fd_pr__pfet_01v8 ad=0.396 pd=2.73 as=0.744 ps=5.42 w=2.4 l=0.15
X132 a_29990_n1456# rst_n vdd vdd sky130_fd_pr__pfet_01v8 ad=0.696 pd=5.38 as=0.696 ps=5.38 w=2.4 l=0.18
X133 a_10251_n1496# a_7535_n716# vdd vdd sky130_fd_pr__pfet_01v8 ad=0.396 pd=2.73 as=0.396 ps=2.73 w=2.4 l=0.15
X134 a_11666_n998# a_11666_622# vss vss sky130_fd_pr__nfet_01v8_lvt ad=0.1218 pd=1.42 as=0.1218 ps=1.42 w=0.42 l=0.15
X135 a_859_1016# a_859_n1456# vss vss sky130_fd_pr__nfet_01v8 ad=0.1218 pd=1.42 as=0.1218 ps=1.42 w=0.42 l=0.28
X136 a_458_n1256# mode_5g vdd vdd sky130_fd_pr__pfet_01v8 ad=0.348 pd=2.98 as=0.348 ps=2.98 w=1.2 l=0.18
X137 vdd a_12650_1016# a_13712_n1576# vdd sky130_fd_pr__pfet_01v8 ad=0.868 pd=6.22 as=0.462 ps=3.13 w=2.8 l=0.15
X138 a_26447_1016# a_15607_1016# vdd vdd sky130_fd_pr__pfet_01v8 ad=0.33 pd=2.33 as=0.33 ps=2.33 w=2 l=0.15
X139 a_29696_n1576# a_28730_n1356# vdd vdd sky130_fd_pr__pfet_01v8 ad=0.812 pd=6.18 as=0.812 ps=6.18 w=2.8 l=0.15
X140 a_2483_1016# a_1653_1016# vdd vdd sky130_fd_pr__pfet_01v8 ad=0.3135 pd=2.23 as=0.589 ps=4.42 w=1.9 l=0.15
X141 vss a_4449_n1536# a_4919_n1556# vss sky130_fd_pr__nfet_01v8_lvt ad=0.434 pd=3.42 as=0.231 ps=1.73 w=1.4 l=0.15
X142 a_29990_344# a_29990_n1456# vdd vdd sky130_fd_pr__pfet_01v8 ad=0.1885 pd=1.88 as=0.1885 ps=1.88 w=0.65 l=0.15
X143 vss a_5513_1016# a_6439_1016# vss sky130_fd_pr__nfet_01v8_lvt ad=0.496 pd=3.82 as=0.264 ps=1.93 w=1.6 l=0.15
X144 vss a_7535_622# a_10251_1016# vss sky130_fd_pr__nfet_01v8_lvt ad=0.372 pd=3.02 as=0.198 ps=1.53 w=1.2 l=0.15
X145 a_10251_1016# a_10251_n1496# vdd vdd sky130_fd_pr__pfet_01v8 ad=0.464 pd=3.78 as=0.464 ps=3.78 w=1.6 l=0.2
X146 a_3605_n1556# a_3231_n1476# vss vss sky130_fd_pr__nfet_01v8_lvt ad=0.406 pd=3.38 as=0.406 ps=3.38 w=1.4 l=0.15
X147 a_7535_n716# a_7625_1016# vdd vdd sky130_fd_pr__pfet_01v8 ad=0.396 pd=2.73 as=0.396 ps=2.73 w=2.4 l=0.15
X148 vdd a_11292_622# a_11382_1016# vdd sky130_fd_pr__pfet_01v8 ad=0.744 pd=5.42 as=0.396 ps=2.73 w=2.4 l=0.15
X149 a_20422_n1316# a_20422_1016# vss vss sky130_fd_pr__nfet_01v8 ad=0.1218 pd=1.42 as=0.1218 ps=1.42 w=0.42 l=0.28
X150 a_24470_1016# a_24470_n1456# vss vss sky130_fd_pr__nfet_01v8 ad=0.1218 pd=1.42 as=0.1218 ps=1.42 w=0.42 l=0.28
X151 a_17598_1016# a_17598_n1520# vss vss sky130_fd_pr__nfet_01v8_lvt ad=0.1218 pd=1.42 as=0.1218 ps=1.42 w=0.42 l=0.15
X152 a_6439_1016# a_5513_1016# vss vss sky130_fd_pr__nfet_01v8_lvt ad=0.264 pd=1.93 as=0.496 ps=3.82 w=1.6 l=0.15
X153 a_10251_1016# a_7535_622# vss vss sky130_fd_pr__nfet_01v8_lvt ad=0.198 pd=1.53 as=0.372 ps=3.02 w=1.2 l=0.15
X154 a_16536_1016# a_10251_1016# a_15607_1016# vdd sky130_fd_pr__pfet_01v8 ad=0.2475 pd=1.83 as=0.465 ps=3.62 w=1.5 l=0.15
X155 vdd a_859_1016# a_1653_1016# vdd sky130_fd_pr__pfet_01v8 ad=0.3795 pd=2.63 as=0.3795 ps=2.63 w=2.3 l=0.15
X156 a_26447_1016# mode_5g a_26543_404# vdd sky130_fd_pr__pfet_01v8 ad=0.62 pd=4.62 as=0.33 ps=2.33 w=2 l=0.15
X157 vdd a_22317_1016# a_11666_n998# vdd sky130_fd_pr__pfet_01v8 ad=0.3696 pd=2.57 as=0.3696 ps=2.57 w=2.24 l=0.15
X158 a_1653_1016# a_1653_n1476# vss vss sky130_fd_pr__nfet_01v8 ad=0.1218 pd=1.42 as=0.1218 ps=1.42 w=0.42 l=0.2
X159 a_15607_n1656# a_15607_1016# vdd vdd sky130_fd_pr__pfet_01v8 ad=0.5104 pd=4.1 as=0.5104 ps=4.1 w=1.76 l=0.15
X160 a_29990_344# a_29696_n1576# vss vss sky130_fd_pr__nfet_01v8_lvt ad=0.2145 pd=1.63 as=0.403 ps=3.22 w=1.3 l=0.15
X161 vss mode_5g a_27017_304# vss sky130_fd_pr__nfet_01v8_lvt ad=0.465 pd=3.62 as=0.2475 ps=1.83 w=1.5 l=0.15
X162 a_27013_n1516# a_25532_n1496# vdd vdd sky130_fd_pr__pfet_01v8 ad=0.4125 pd=2.83 as=0.775 ps=5.62 w=2.5 l=0.15
X163 a_12650_n1416# rst_n vdd vdd sky130_fd_pr__pfet_01v8 ad=0.464 pd=3.78 as=0.464 ps=3.78 w=1.6 l=0.18
X164 a_5513_n1556# a_1653_n1476# vss vss sky130_fd_pr__nfet_01v8_lvt ad=0.231 pd=1.73 as=0.434 ps=3.42 w=1.4 l=0.15
X165 a_26543_404# a_25532_1016# a_26447_1016# vdd sky130_fd_pr__pfet_01v8 ad=0.33 pd=2.33 as=0.33 ps=2.33 w=2 l=0.15
X166 a_27017_304# mode_5g vss vss sky130_fd_pr__nfet_01v8_lvt ad=0.2475 pd=1.83 as=0.465 ps=3.62 w=1.5 l=0.15
X167 fb250_b a_29990_344# vss vss sky130_fd_pr__nfet_01v8_lvt ad=0.198 pd=1.53 as=0.372 ps=3.02 w=1.2 l=0.15
X168 a_7259_n604# a_7535_n716# a_7307_n1336# vss sky130_fd_pr__nfet_01v8_lvt ad=0.527 pd=4.02 as=0.2805 ps=2.03 w=1.7 l=0.15
X169 a_14545_n1416# a_14545_1016# vss vss sky130_fd_pr__nfet_01v8 ad=0.1218 pd=1.42 as=0.1218 ps=1.42 w=0.42 l=0.28
X170 a_15607_1016# a_14545_n1416# vdd vdd sky130_fd_pr__pfet_01v8 ad=0.992 pd=7.02 as=0.528 ps=3.53 w=3.2 l=0.15
X171 a_7259_n604# a_7535_622# a_7307_1016# vss sky130_fd_pr__nfet_01v8_lvt ad=0.527 pd=4.02 as=0.2805 ps=2.03 w=1.7 l=0.15
X172 a_4919_n1556# a_4449_n1536# vdd vdd sky130_fd_pr__pfet_01v8 ad=0.4455 pd=3.03 as=0.4455 ps=3.03 w=2.7 l=0.15
X173 a_26447_n1316# a_15607_n1656# vdd vdd sky130_fd_pr__pfet_01v8 ad=0.2475 pd=1.83 as=0.2475 ps=1.83 w=1.5 l=0.15
X174 a_17598_n1520# a_16536_1016# vss vss sky130_fd_pr__nfet_01v8_lvt ad=0.348 pd=2.98 as=0.348 ps=2.98 w=1.2 l=0.15
X175 a_29696_464# a_28730_1016# vss vss sky130_fd_pr__nfet_01v8_lvt ad=0.203 pd=1.98 as=0.203 ps=1.98 w=0.7 l=0.15
X176 a_12650_1016# a_10251_1016# a_11430_364# vdd sky130_fd_pr__pfet_01v8 ad=0.33 pd=2.33 as=0.62 ps=4.62 w=2 l=0.15
X177 vdd a_4449_n1536# a_4919_n1556# vdd sky130_fd_pr__pfet_01v8 ad=0.4455 pd=3.03 as=0.4455 ps=3.03 w=2.7 l=0.15
X178 a_7259_n604# a_5513_n1556# vss vss sky130_fd_pr__nfet_01v8_lvt ad=0.231 pd=1.73 as=0.434 ps=3.42 w=1.4 l=0.15
X179 a_7307_1016# a_7535_622# a_7259_n604# vss sky130_fd_pr__nfet_01v8_lvt ad=0.2805 pd=2.03 as=0.527 ps=4.02 w=1.7 l=0.15
X180 a_5513_n1556# a_5513_1016# vdd vdd sky130_fd_pr__pfet_01v8 ad=0.464 pd=3.78 as=0.464 ps=3.78 w=1.6 l=0.2
X181 a_1653_1016# a_1653_n1476# vdd vdd sky130_fd_pr__pfet_01v8 ad=0.406 pd=3.38 as=0.406 ps=3.38 w=1.4 l=0.2
X182 a_22317_n1316# a_22317_1016# vss vss sky130_fd_pr__nfet_01v8 ad=0.1218 pd=1.42 as=0.1218 ps=1.42 w=0.42 l=0.28
X183 a_11382_n1376# a_11666_n998# a_11430_n604# vss sky130_fd_pr__nfet_01v8_lvt ad=0.522 pd=4.18 as=0.522 ps=4.18 w=1.8 l=0.15
X184 vdd a_3605_n1556# a_3979_n1426# vdd sky130_fd_pr__pfet_01v8 ad=0.33825 pd=2.38 as=0.33825 ps=2.38 w=2.05 l=0.15
X185 vdd a_28730_n1356# a_29990_n1456# vdd sky130_fd_pr__pfet_01v8 ad=0.682 pd=5.02 as=0.363 ps=2.53 w=2.2 l=0.15
X186 a_3979_n1426# a_3605_n1556# vdd vdd sky130_fd_pr__pfet_01v8 ad=0.33825 pd=2.38 as=0.6355 ps=4.72 w=2.05 l=0.15
X187 a_7625_1016# a_7625_n1396# vdd vdd sky130_fd_pr__pfet_01v8 ad=0.464 pd=3.78 as=0.464 ps=3.78 w=1.6 l=0.15
X188 a_5513_n1556# a_1653_n1476# vdd vdd sky130_fd_pr__pfet_01v8 ad=0.4455 pd=3.03 as=0.837 ps=6.02 w=2.7 l=0.15
X189 a_2483_1016# a_1653_1016# vss vss sky130_fd_pr__nfet_01v8_lvt ad=0.29 pd=2.58 as=0.29 ps=2.58 w=1 l=0.15
X190 a_7625_n1396# a_5513_n1556# a_7625_1016# vdd sky130_fd_pr__pfet_01v8 ad=0.348 pd=2.98 as=0.348 ps=2.98 w=1.2 l=0.15
X191 a_8591_n1536# a_7625_n1396# vss vss sky130_fd_pr__nfet_01v8_lvt ad=0.1595 pd=1.68 as=0.1595 ps=1.68 w=0.55 l=0.15
X192 a_25532_1016# a_24470_n1456# vdd vdd sky130_fd_pr__pfet_01v8 ad=0.396 pd=2.73 as=0.744 ps=5.42 w=2.4 l=0.15
X193 a_21484_n1520# a_21484_1016# vss vss sky130_fd_pr__nfet_01v8_lvt ad=0.1218 pd=1.42 as=0.1218 ps=1.42 w=0.42 l=0.15
X194 a_27013_n1516# a_458_n1256# a_26447_n1316# vdd sky130_fd_pr__pfet_01v8 ad=0.775 pd=5.62 as=0.4125 ps=2.83 w=2.5 l=0.15
X195 a_5513_1016# a_1653_1016# vdd vdd sky130_fd_pr__pfet_01v8 ad=0.4455 pd=3.03 as=0.4455 ps=3.03 w=2.7 l=0.15
X196 a_13712_n1576# a_13712_1016# vdd vdd sky130_fd_pr__pfet_01v8 ad=0.5104 pd=4.1 as=0.5104 ps=4.1 w=1.76 l=0.15
X197 fb250_b fb250 vdd vdd sky130_fd_pr__pfet_01v8 ad=0.348 pd=2.98 as=0.348 ps=2.98 w=1.2 l=0.15
X198 a_7535_n716# a_8591_n1536# vss vss sky130_fd_pr__nfet_01v8_lvt ad=0.198 pd=1.53 as=0.372 ps=3.02 w=1.2 l=0.15
X199 a_11666_n998# a_22317_1016# vdd vdd sky130_fd_pr__pfet_01v8 ad=0.6944 pd=5.1 as=0.3696 ps=2.57 w=2.24 l=0.15
X200 a_17598_1016# a_10251_n1496# a_18431_1016# vdd sky130_fd_pr__pfet_01v8 ad=0.465 pd=3.62 as=0.2475 ps=1.83 w=1.5 l=0.15
X201 a_13712_n1576# a_12650_1016# vss vss sky130_fd_pr__nfet_01v8_lvt ad=0.406 pd=3.38 as=0.406 ps=3.38 w=1.4 l=0.15
X202 a_18431_n1316# a_18431_1016# vdd vdd sky130_fd_pr__pfet_01v8 ad=0.1218 pd=1.42 as=0.1218 ps=1.42 w=0.42 l=0.28
X203 a_7535_622# a_7535_n716# vdd vdd sky130_fd_pr__pfet_01v8 ad=0.464 pd=3.78 as=0.464 ps=3.78 w=1.6 l=0.15
X204 a_22317_n1316# rst_n vdd vdd sky130_fd_pr__pfet_01v8 ad=0.464 pd=3.78 as=0.464 ps=3.78 w=1.6 l=0.18
X205 a_11292_n998# a_11292_622# vss vss sky130_fd_pr__nfet_01v8_lvt ad=0.1218 pd=1.42 as=0.1218 ps=1.42 w=0.42 l=0.15
X206 vss a_29696_n1576# a_29990_344# vss sky130_fd_pr__nfet_01v8_lvt ad=0.403 pd=3.22 as=0.2145 ps=1.63 w=1.3 l=0.15
X207 vdd a_7625_1016# a_7535_n716# vdd sky130_fd_pr__pfet_01v8 ad=0.396 pd=2.73 as=0.396 ps=2.73 w=2.4 l=0.15
X208 a_14545_1016# a_10251_1016# a_13712_1016# vss sky130_fd_pr__nfet_01v8_lvt ad=0.464 pd=3.78 as=0.464 ps=3.78 w=1.6 l=0.15
X209 a_16536_1016# a_16536_n1316# vdd vdd sky130_fd_pr__pfet_01v8 ad=0.1218 pd=1.42 as=0.1218 ps=1.42 w=0.42 l=0.28
X210 a_6439_1016# a_5513_1016# vdd vdd sky130_fd_pr__pfet_01v8 ad=0.33 pd=2.33 as=0.33 ps=2.33 w=2 l=0.15
X211 a_26543_n604# a_15607_n1656# vss vss sky130_fd_pr__nfet_01v8_lvt ad=0.2475 pd=1.83 as=0.465 ps=3.62 w=1.5 l=0.15
X212 vdd a_18431_1016# a_11292_n998# vdd sky130_fd_pr__pfet_01v8 ad=0.3696 pd=2.57 as=0.3696 ps=2.57 w=2.24 l=0.15
X213 a_14545_1016# a_10251_n1496# a_13712_1016# vdd sky130_fd_pr__pfet_01v8 ad=0.33 pd=2.33 as=0.62 ps=4.62 w=2 l=0.15
X214 a_21484_n1520# a_20422_1016# vss vss sky130_fd_pr__nfet_01v8_lvt ad=0.348 pd=2.98 as=0.348 ps=2.98 w=1.2 l=0.15
X215 a_1653_n1476# a_859_n1456# vdd vdd sky130_fd_pr__pfet_01v8 ad=0.3795 pd=2.63 as=0.713 ps=5.22 w=2.3 l=0.15
X216 a_11382_1016# a_11666_622# a_11430_364# vdd sky130_fd_pr__pfet_01v8 ad=0.744 pd=5.42 as=0.396 ps=2.73 w=2.4 l=0.15
X217 a_11292_n998# a_18431_1016# vss vss sky130_fd_pr__nfet_01v8_lvt ad=0.464 pd=3.78 as=0.464 ps=3.78 w=1.6 l=0.15
X218 vdd a_15607_n1656# a_26447_n1316# vdd sky130_fd_pr__pfet_01v8 ad=0.465 pd=3.62 as=0.2475 ps=1.83 w=1.5 l=0.15
X219 a_11382_n1376# a_458_n1256# a_11756_n1616# vdd sky130_fd_pr__pfet_01v8 ad=0.495 pd=3.33 as=0.93 ps=6.62 w=3 l=0.15
X220 a_22317_n1316# a_10251_n1496# a_21484_n1520# vdd sky130_fd_pr__pfet_01v8 ad=0.2475 pd=1.83 as=0.465 ps=3.62 w=1.5 l=0.15
X221 a_4449_n1536# a_3979_n1426# vss vss sky130_fd_pr__nfet_01v8_lvt ad=0.165 pd=1.33 as=0.31 ps=2.62 w=1 l=0.15
X222 a_29990_n1456# a_29696_464# vss vss sky130_fd_pr__nfet_01v8_lvt ad=0.2145 pd=1.63 as=0.403 ps=3.22 w=1.3 l=0.15
X223 a_10251_n1496# a_7535_n716# vss vss sky130_fd_pr__nfet_01v8_lvt ad=0.198 pd=1.53 as=0.372 ps=3.02 w=1.2 l=0.15
X224 a_15607_n1656# a_14545_1016# vdd vdd sky130_fd_pr__pfet_01v8 ad=0.992 pd=7.02 as=0.528 ps=3.53 w=3.2 l=0.15
X225 a_26543_n604# a_458_n1256# a_26447_n1316# vss sky130_fd_pr__nfet_01v8_lvt ad=0.465 pd=3.62 as=0.2475 ps=1.83 w=1.5 l=0.15
X226 a_5513_1016# a_5513_n1556# vdd vdd sky130_fd_pr__pfet_01v8 ad=0.464 pd=3.78 as=0.464 ps=3.78 w=1.6 l=0.2
X227 a_11756_n1616# a_458_n1256# a_11382_n1376# vdd sky130_fd_pr__pfet_01v8 ad=0.93 pd=6.62 as=0.495 ps=3.33 w=3 l=0.15
X228 vdd a_12650_n1416# a_13712_1016# vdd sky130_fd_pr__pfet_01v8 ad=0.868 pd=6.22 as=0.462 ps=3.13 w=2.8 l=0.15
X229 a_7625_1016# a_5513_n1556# a_7625_n1396# vdd sky130_fd_pr__pfet_01v8 ad=0.348 pd=2.98 as=0.348 ps=2.98 w=1.2 l=0.15
X230 a_3979_n1426# a_3605_n1556# vdd vdd sky130_fd_pr__pfet_01v8 ad=0.6355 pd=4.72 as=0.33825 ps=2.38 w=2.05 l=0.15
X231 a_24470_n1456# a_10251_n1496# a_15607_n1656# vss sky130_fd_pr__nfet_01v8_lvt ad=0.522 pd=4.18 as=0.522 ps=4.18 w=1.8 l=0.15
X232 a_11666_622# a_11666_n998# vss vss sky130_fd_pr__nfet_01v8_lvt ad=0.1218 pd=1.42 as=0.1218 ps=1.42 w=0.42 l=0.15
X233 a_11382_n1376# a_10251_1016# a_12650_n1416# vdd sky130_fd_pr__pfet_01v8 ad=0.62 pd=4.62 as=0.33 ps=2.33 w=2 l=0.15
X234 a_21484_1016# a_10251_n1496# a_22317_1016# vdd sky130_fd_pr__pfet_01v8 ad=0.465 pd=3.62 as=0.2475 ps=1.83 w=1.5 l=0.15
X235 a_12650_1016# a_10251_n1496# a_11430_364# vss sky130_fd_pr__nfet_01v8_lvt ad=0.464 pd=3.78 as=0.464 ps=3.78 w=1.6 l=0.15
X236 a_15607_n1656# a_14545_1016# vss vss sky130_fd_pr__nfet_01v8_lvt ad=0.696 pd=5.38 as=0.696 ps=5.38 w=2.4 l=0.15
X237 vss a_24470_n1456# a_25532_1016# vss sky130_fd_pr__nfet_01v8_lvt ad=0.372 pd=3.02 as=0.198 ps=1.53 w=1.2 l=0.15
X238 a_859_n1456# a_859_1016# vss vss sky130_fd_pr__nfet_01v8 ad=0.1218 pd=1.42 as=0.1218 ps=1.42 w=0.42 l=0.28
X239 vdd a_28730_1016# a_29990_344# vdd sky130_fd_pr__pfet_01v8 ad=0.682 pd=5.02 as=0.363 ps=2.53 w=2.2 l=0.15
X240 a_20422_1016# a_20422_n1316# vdd vdd sky130_fd_pr__pfet_01v8 ad=0.1218 pd=1.42 as=0.1218 ps=1.42 w=0.42 l=0.28
X241 a_17598_1016# a_16536_n1316# vss vss sky130_fd_pr__nfet_01v8_lvt ad=0.348 pd=2.98 as=0.348 ps=2.98 w=1.2 l=0.15
X242 a_25532_1016# a_24470_n1456# vss vss sky130_fd_pr__nfet_01v8_lvt ad=0.198 pd=1.53 as=0.372 ps=3.02 w=1.2 l=0.15
X243 vdd a_29990_344# fb250_b vdd sky130_fd_pr__pfet_01v8 ad=0.3465 pd=2.43 as=0.3465 ps=2.43 w=2.1 l=0.15
X244 a_12650_1016# a_12650_n1416# vss vss sky130_fd_pr__nfet_01v8 ad=0.1218 pd=1.42 as=0.1218 ps=1.42 w=0.42 l=0.28
X245 fb250_b a_29990_344# vdd vdd sky130_fd_pr__pfet_01v8 ad=0.3465 pd=2.43 as=0.651 ps=4.82 w=2.1 l=0.15
X246 a_22317_n1316# a_22317_1016# vdd vdd sky130_fd_pr__pfet_01v8 ad=0.1218 pd=1.42 as=0.1218 ps=1.42 w=0.42 l=0.28
X247 a_28364_n604# a_26447_n1316# a_28412_1016# vss sky130_fd_pr__nfet_01v8_lvt ad=0.496 pd=3.82 as=0.264 ps=1.93 w=1.6 l=0.15
X248 a_26447_1016# a_25532_1016# a_26543_404# vdd sky130_fd_pr__pfet_01v8 ad=0.33 pd=2.33 as=0.33 ps=2.33 w=2 l=0.15
X249 a_11666_n998# a_22317_1016# vss vss sky130_fd_pr__nfet_01v8_lvt ad=0.464 pd=3.78 as=0.464 ps=3.78 w=1.6 l=0.15
X250 a_11292_622# a_18431_n1316# vss vss sky130_fd_pr__nfet_01v8_lvt ad=0.464 pd=3.78 as=0.464 ps=3.78 w=1.6 l=0.15
X251 a_11292_n998# a_18431_1016# vdd vdd sky130_fd_pr__pfet_01v8 ad=0.6944 pd=5.1 as=0.3696 ps=2.57 w=2.24 l=0.15
X252 a_18431_n1316# a_18431_1016# vss vss sky130_fd_pr__nfet_01v8 ad=0.1218 pd=1.42 as=0.1218 ps=1.42 w=0.42 l=0.28
X253 a_21484_1016# a_21484_n1520# vss vss sky130_fd_pr__nfet_01v8_lvt ad=0.1218 pd=1.42 as=0.1218 ps=1.42 w=0.42 l=0.15
X254 a_11292_622# a_18431_n1316# vdd vdd sky130_fd_pr__pfet_01v8 ad=0.6944 pd=5.1 as=0.3696 ps=2.57 w=2.24 l=0.15
X255 a_3979_n1426# a_3605_n1556# vss vss sky130_fd_pr__nfet_01v8_lvt ad=0.464 pd=3.78 as=0.464 ps=3.78 w=1.6 l=0.15
X256 fb250 a_29990_n1456# vdd vdd sky130_fd_pr__pfet_01v8 ad=0.3465 pd=2.43 as=0.651 ps=4.82 w=2.1 l=0.15
X257 a_18431_n1316# rst_n vdd vdd sky130_fd_pr__pfet_01v8 ad=0.464 pd=3.78 as=0.464 ps=3.78 w=1.6 l=0.18
X258 a_10251_1016# a_7535_622# vdd vdd sky130_fd_pr__pfet_01v8 ad=0.396 pd=2.73 as=0.396 ps=2.73 w=2.4 l=0.15
X259 vdd a_25532_n1496# a_27013_n1516# vdd sky130_fd_pr__pfet_01v8 ad=0.4125 pd=2.83 as=0.4125 ps=2.83 w=2.5 l=0.15
X260 a_7307_n1336# a_7535_n716# a_7259_n604# vss sky130_fd_pr__nfet_01v8_lvt ad=0.2805 pd=2.03 as=0.527 ps=4.02 w=1.7 l=0.15
X261 a_15607_1016# a_10251_1016# a_24470_1016# vdd sky130_fd_pr__pfet_01v8 ad=0.682 pd=5.02 as=0.363 ps=2.53 w=2.2 l=0.15
X262 a_15607_n1656# a_15607_1016# vss vss sky130_fd_pr__nfet_01v8_lvt ad=0.1218 pd=1.42 as=0.1218 ps=1.42 w=0.42 l=0.15
X263 a_17598_n1520# a_17598_1016# vss vss sky130_fd_pr__nfet_01v8_lvt ad=0.1218 pd=1.42 as=0.1218 ps=1.42 w=0.42 l=0.15
X264 a_11666_622# a_11666_n998# vdd vdd sky130_fd_pr__pfet_01v8 ad=0.5104 pd=4.1 as=0.5104 ps=4.1 w=1.76 l=0.15
X265 a_21484_n1520# a_10251_n1496# a_22317_n1316# vdd sky130_fd_pr__pfet_01v8 ad=0.465 pd=3.62 as=0.2475 ps=1.83 w=1.5 l=0.15
X266 a_14545_1016# a_14545_n1416# vdd vdd sky130_fd_pr__pfet_01v8 ad=0.1218 pd=1.42 as=0.1218 ps=1.42 w=0.42 l=0.28
X267 a_11382_n1376# a_11292_n998# vdd vdd sky130_fd_pr__pfet_01v8 ad=0.297 pd=2.13 as=0.558 ps=4.22 w=1.8 l=0.15
X268 a_28412_1016# a_28730_n1356# a_28730_1016# vss sky130_fd_pr__nfet_01v8_lvt ad=0.434 pd=3.42 as=0.231 ps=1.73 w=1.4 l=0.15
X269 a_2483_n1396# a_1653_n1476# vdd vdd sky130_fd_pr__pfet_01v8 ad=0.3135 pd=2.23 as=0.589 ps=4.42 w=1.9 l=0.15
X270 a_28730_1016# a_28730_n1356# a_28412_1016# vss sky130_fd_pr__nfet_01v8_lvt ad=0.231 pd=1.73 as=0.434 ps=3.42 w=1.4 l=0.15
X271 a_1653_1016# a_859_1016# vss vss sky130_fd_pr__nfet_01v8_lvt ad=0.522 pd=4.18 as=0.522 ps=4.18 w=1.8 l=0.15
X272 a_12650_n1416# a_12650_1016# vss vss sky130_fd_pr__nfet_01v8 ad=0.1218 pd=1.42 as=0.1218 ps=1.42 w=0.42 l=0.28
X273 a_22317_1016# a_22317_n1316# vdd vdd sky130_fd_pr__pfet_01v8 ad=0.1218 pd=1.42 as=0.1218 ps=1.42 w=0.42 l=0.28
X274 a_7535_622# a_7535_n716# vss vss sky130_fd_pr__nfet_01v8 ad=0.2175 pd=2.08 as=0.2175 ps=2.08 w=0.75 l=0.15
X275 a_28364_n604# a_26543_404# a_28412_n1316# vss sky130_fd_pr__nfet_01v8_lvt ad=0.496 pd=3.82 as=0.264 ps=1.93 w=1.6 l=0.15
X276 vdd a_7535_n716# a_10251_n1496# vdd sky130_fd_pr__pfet_01v8 ad=0.744 pd=5.42 as=0.396 ps=2.73 w=2.4 l=0.15
X277 a_18431_1016# a_18431_n1316# vss vss sky130_fd_pr__nfet_01v8 ad=0.1218 pd=1.42 as=0.1218 ps=1.42 w=0.42 l=0.28
X278 a_11382_n1376# a_458_n1256# a_11430_n604# vss sky130_fd_pr__nfet_01v8_lvt ad=0.522 pd=4.18 as=0.522 ps=4.18 w=1.8 l=0.15
X279 a_24470_1016# a_458_484# vss vss sky130_fd_pr__nfet_01v8 ad=0.261 pd=2.38 as=0.261 ps=2.38 w=0.9 l=0.18
X280 vdd a_1653_1016# a_5513_1016# vdd sky130_fd_pr__pfet_01v8 ad=0.4455 pd=3.03 as=0.4455 ps=3.03 w=2.7 l=0.15
X281 a_11666_622# a_22317_n1316# vdd vdd sky130_fd_pr__pfet_01v8 ad=0.6944 pd=5.1 as=0.3696 ps=2.57 w=2.24 l=0.15
X282 vss a_24470_1016# a_25532_n1496# vss sky130_fd_pr__nfet_01v8_lvt ad=0.372 pd=3.02 as=0.198 ps=1.53 w=1.2 l=0.15
X283 a_8591_494# a_7625_1016# vss vss sky130_fd_pr__nfet_01v8_lvt ad=0.1595 pd=1.68 as=0.1595 ps=1.68 w=0.55 l=0.15
X284 a_20422_1016# a_10251_1016# a_11292_622# vdd sky130_fd_pr__pfet_01v8 ad=0.2475 pd=1.83 as=0.465 ps=3.62 w=1.5 l=0.15
X285 a_18431_1016# a_10251_n1496# a_17598_1016# vdd sky130_fd_pr__pfet_01v8 ad=0.2475 pd=1.83 as=0.465 ps=3.62 w=1.5 l=0.15
X286 a_18431_1016# a_10251_1016# a_17598_1016# vss sky130_fd_pr__nfet_01v8_lvt ad=0.348 pd=2.98 as=0.348 ps=2.98 w=1.2 l=0.15
X287 a_7535_n716# a_7625_1016# vdd vdd sky130_fd_pr__pfet_01v8 ad=0.396 pd=2.73 as=0.744 ps=5.42 w=2.4 l=0.15
X288 vdd a_5513_n1556# a_7625_1016# vdd sky130_fd_pr__pfet_01v8 ad=0.589 pd=4.42 as=0.3135 ps=2.23 w=1.9 l=0.15
X289 vdd a_5513_1016# a_6439_1016# vdd sky130_fd_pr__pfet_01v8 ad=0.33 pd=2.33 as=0.33 ps=2.33 w=2 l=0.15
X290 a_29696_n1576# a_28730_n1356# vss vss sky130_fd_pr__nfet_01v8_lvt ad=0.203 pd=1.98 as=0.203 ps=1.98 w=0.7 l=0.15
X291 a_11756_n1616# a_11666_n998# vdd vdd sky130_fd_pr__pfet_01v8 ad=0.495 pd=3.33 as=0.93 ps=6.62 w=3 l=0.15
X292 a_28730_n1356# a_4919_n1556# a_28730_1016# vdd sky130_fd_pr__pfet_01v8 ad=0.319 pd=2.78 as=0.319 ps=2.78 w=1.1 l=0.15
X293 a_859_1016# clkp vdd vdd sky130_fd_pr__pfet_01v8_lvt ad=0.319 pd=2.49 as=0.638 ps=4.98 w=2.2 l=0.35
X294 a_27013_n1516# a_25532_n1496# vdd vdd sky130_fd_pr__pfet_01v8 ad=0.4125 pd=2.83 as=0.4125 ps=2.83 w=2.5 l=0.15
X295 vdd a_29990_n1456# fb250 vdd sky130_fd_pr__pfet_01v8 ad=0.3465 pd=2.43 as=0.3465 ps=2.43 w=2.1 l=0.15
X296 vss a_4919_n1556# a_28364_n604# vss sky130_fd_pr__nfet_01v8_lvt ad=0.403 pd=3.22 as=0.2145 ps=1.63 w=1.3 l=0.15
X297 a_20422_n1316# a_10251_1016# a_11292_n998# vdd sky130_fd_pr__pfet_01v8 ad=0.2475 pd=1.83 as=0.465 ps=3.62 w=1.5 l=0.15
X298 a_21484_n1520# a_20422_1016# vdd vdd sky130_fd_pr__pfet_01v8 ad=0.4158 pd=2.85 as=0.7812 ps=5.66 w=2.52 l=0.15
X299 vss a_5513_n1556# a_7259_n604# vss sky130_fd_pr__nfet_01v8_lvt ad=0.434 pd=3.42 as=0.231 ps=1.73 w=1.4 l=0.15
X300 a_11430_364# a_11666_622# a_11382_1016# vdd sky130_fd_pr__pfet_01v8 ad=0.396 pd=2.73 as=0.744 ps=5.42 w=2.4 l=0.15
X301 a_859_1016# clkp vss vss sky130_fd_pr__nfet_01v8_lvt ad=0.348 pd=2.98 as=0.348 ps=2.98 w=1.2 l=0.15
X302 a_18431_n1316# a_10251_n1496# a_17598_n1520# vdd sky130_fd_pr__pfet_01v8 ad=0.2475 pd=1.83 as=0.465 ps=3.62 w=1.5 l=0.15
X303 a_26543_404# a_25532_1016# a_26447_1016# vdd sky130_fd_pr__pfet_01v8 ad=0.33 pd=2.33 as=0.62 ps=4.62 w=2 l=0.15
X304 fb250_b fb250 vss vss sky130_fd_pr__nfet_01v8_lvt ad=0.1305 pd=1.48 as=0.1305 ps=1.48 w=0.45 l=0.15
X305 a_7625_n1396# a_7625_1016# vdd vdd sky130_fd_pr__pfet_01v8 ad=0.464 pd=3.78 as=0.464 ps=3.78 w=1.6 l=0.15
X306 a_7259_n604# a_5513_n1556# vss vss sky130_fd_pr__nfet_01v8_lvt ad=0.231 pd=1.73 as=0.434 ps=3.42 w=1.4 l=0.15
X307 vdd a_16536_n1316# a_17598_1016# vdd sky130_fd_pr__pfet_01v8 ad=0.7812 pd=5.66 as=0.4158 ps=2.85 w=2.52 l=0.15
X308 a_28730_n1356# a_4919_n1556# vdd vdd sky130_fd_pr__pfet_01v8 ad=0.2805 pd=2.03 as=0.527 ps=4.02 w=1.7 l=0.15
X309 a_7535_622# a_7625_n1396# vdd vdd sky130_fd_pr__pfet_01v8 ad=0.396 pd=2.73 as=0.744 ps=5.42 w=2.4 l=0.15
X310 a_16536_1016# a_10251_n1496# a_15607_1016# vss sky130_fd_pr__nfet_01v8_lvt ad=0.348 pd=2.98 as=0.348 ps=2.98 w=1.2 l=0.15
X311 a_7307_1016# a_5513_n1556# vdd vdd sky130_fd_pr__pfet_01v8 ad=0.464 pd=3.78 as=0.464 ps=3.78 w=1.6 l=0.15
X312 a_25532_n1496# a_25532_1016# vss vss sky130_fd_pr__nfet_01v8_lvt ad=0.1218 pd=1.42 as=0.1218 ps=1.42 w=0.42 l=0.15
X313 a_16536_1016# a_16536_n1316# vss vss sky130_fd_pr__nfet_01v8 ad=0.1218 pd=1.42 as=0.1218 ps=1.42 w=0.42 l=0.28
X314 a_26447_n1316# a_458_n1256# a_26543_n604# vss sky130_fd_pr__nfet_01v8_lvt ad=0.2475 pd=1.83 as=0.465 ps=3.62 w=1.5 l=0.15
X315 a_25532_1016# a_25532_n1496# vss vss sky130_fd_pr__nfet_01v8_lvt ad=0.1218 pd=1.42 as=0.1218 ps=1.42 w=0.42 l=0.15
X316 a_8591_494# a_7625_1016# vdd vdd sky130_fd_pr__pfet_01v8 ad=0.754 pd=5.78 as=0.754 ps=5.78 w=2.6 l=0.15
X317 a_17598_n1520# a_10251_n1496# a_18431_n1316# vdd sky130_fd_pr__pfet_01v8 ad=0.465 pd=3.62 as=0.2475 ps=1.83 w=1.5 l=0.15
X318 vdd a_4919_n1556# a_28730_n1356# vdd sky130_fd_pr__pfet_01v8 ad=0.527 pd=4.02 as=0.2805 ps=2.03 w=1.7 l=0.15
X319 a_13712_n1576# a_13712_1016# vss vss sky130_fd_pr__nfet_01v8_lvt ad=0.1218 pd=1.42 as=0.1218 ps=1.42 w=0.42 l=0.15
X320 a_21484_1016# a_21484_n1520# vdd vdd sky130_fd_pr__pfet_01v8 ad=0.5104 pd=4.1 as=0.5104 ps=4.1 w=1.76 l=0.15
X321 a_28412_n1316# a_28730_1016# a_28730_n1356# vss sky130_fd_pr__nfet_01v8_lvt ad=0.434 pd=3.42 as=0.231 ps=1.73 w=1.4 l=0.15
X322 vdd a_4449_n1536# a_4919_n1556# vdd sky130_fd_pr__pfet_01v8 ad=0.837 pd=6.02 as=0.4455 ps=3.03 w=2.7 l=0.15
X323 a_11430_364# a_11666_622# a_11716_244# vss sky130_fd_pr__nfet_01v8_lvt ad=0.522 pd=4.18 as=0.522 ps=4.18 w=1.8 l=0.15
X324 a_29990_n1456# a_28730_n1356# vdd vdd sky130_fd_pr__pfet_01v8 ad=0.363 pd=2.53 as=0.682 ps=5.02 w=2.2 l=0.15
X325 a_29990_344# a_458_484# vss vss sky130_fd_pr__nfet_01v8 ad=0.348 pd=2.98 as=0.348 ps=2.98 w=1.2 l=0.18
X326 a_22317_1016# a_10251_n1496# a_21484_1016# vdd sky130_fd_pr__pfet_01v8 ad=0.2475 pd=1.83 as=0.465 ps=3.62 w=1.5 l=0.15
X327 vdd a_24470_n1456# a_25532_1016# vdd sky130_fd_pr__pfet_01v8 ad=0.744 pd=5.42 as=0.396 ps=2.73 w=2.4 l=0.15
X328 a_25532_n1496# a_25532_1016# vdd vdd sky130_fd_pr__pfet_01v8 ad=0.5104 pd=4.1 as=0.5104 ps=4.1 w=1.76 l=0.15
X329 a_2483_n1396# a_1653_n1476# vss vss sky130_fd_pr__nfet_01v8_lvt ad=0.29 pd=2.58 as=0.29 ps=2.58 w=1 l=0.15
X330 a_21484_1016# a_20422_n1316# vss vss sky130_fd_pr__nfet_01v8_lvt ad=0.348 pd=2.98 as=0.348 ps=2.98 w=1.2 l=0.15
X331 a_28412_n1316# a_4919_n1556# vdd vdd sky130_fd_pr__pfet_01v8 ad=0.435 pd=3.58 as=0.435 ps=3.58 w=1.5 l=0.15
X332 a_11292_622# a_11292_n998# vdd vdd sky130_fd_pr__pfet_01v8 ad=0.5104 pd=4.1 as=0.5104 ps=4.1 w=1.76 l=0.15
X333 a_859_1016# a_859_n1456# vdd vdd sky130_fd_pr__pfet_01v8 ad=0.2436 pd=2.26 as=0.2436 ps=2.26 w=0.84 l=0.28
X334 a_14545_1016# a_14545_n1416# vss vss sky130_fd_pr__nfet_01v8 ad=0.1218 pd=1.42 as=0.1218 ps=1.42 w=0.42 l=0.28
X335 a_20422_n1316# a_20422_1016# vdd vdd sky130_fd_pr__pfet_01v8 ad=0.1218 pd=1.42 as=0.1218 ps=1.42 w=0.42 l=0.28
X336 a_2857_n1396# a_2483_n1396# vdd vdd sky130_fd_pr__pfet_01v8 ad=0.3135 pd=2.23 as=0.589 ps=4.42 w=1.9 l=0.15
X337 a_11716_244# mode_5g vss vss sky130_fd_pr__nfet_01v8_lvt ad=0.522 pd=4.18 as=0.522 ps=4.18 w=1.8 l=0.15
X338 a_29990_n1456# a_29990_344# vdd vdd sky130_fd_pr__pfet_01v8 ad=0.1885 pd=1.88 as=0.1885 ps=1.88 w=0.65 l=0.15
X339 vdd a_1653_n1476# a_5513_n1556# vdd sky130_fd_pr__pfet_01v8 ad=0.4455 pd=3.03 as=0.4455 ps=3.03 w=2.7 l=0.15
X340 vdd a_15607_1016# a_26447_1016# vdd sky130_fd_pr__pfet_01v8 ad=0.33 pd=2.33 as=0.33 ps=2.33 w=2 l=0.15
X341 a_11666_622# a_22317_n1316# vss vss sky130_fd_pr__nfet_01v8_lvt ad=0.464 pd=3.78 as=0.464 ps=3.78 w=1.6 l=0.15
X342 a_458_n1256# mode_5g vss vss sky130_fd_pr__nfet_01v8 ad=0.174 pd=1.78 as=0.174 ps=1.78 w=0.6 l=0.18
X343 a_16536_n1316# rst_n vdd vdd sky130_fd_pr__pfet_01v8 ad=0.464 pd=3.78 as=0.464 ps=3.78 w=1.6 l=0.18
X344 a_28730_1016# a_4919_n1556# a_28730_n1356# vdd sky130_fd_pr__pfet_01v8 ad=0.319 pd=2.78 as=0.319 ps=2.78 w=1.1 l=0.15
X345 vdd a_11666_n998# a_11756_n1616# vdd sky130_fd_pr__pfet_01v8 ad=0.93 pd=6.62 as=0.495 ps=3.33 w=3 l=0.15
X346 a_11430_364# a_11292_622# vss vss sky130_fd_pr__nfet_01v8_lvt ad=0.348 pd=2.98 as=0.348 ps=2.98 w=1.2 l=0.15
X347 vdd a_18431_n1316# a_11292_622# vdd sky130_fd_pr__pfet_01v8 ad=0.3696 pd=2.57 as=0.3696 ps=2.57 w=2.24 l=0.15
X348 a_24470_n1456# a_10251_1016# a_15607_n1656# vdd sky130_fd_pr__pfet_01v8 ad=0.363 pd=2.53 as=0.682 ps=5.02 w=2.2 l=0.15
X349 a_28412_1016# a_26447_n1316# a_28364_n604# vss sky130_fd_pr__nfet_01v8_lvt ad=0.264 pd=1.93 as=0.496 ps=3.82 w=1.6 l=0.15
X350 a_11382_1016# a_11292_622# vdd vdd sky130_fd_pr__pfet_01v8 ad=0.396 pd=2.73 as=0.744 ps=5.42 w=2.4 l=0.15
X351 vdd a_25532_n1496# a_27013_n1516# vdd sky130_fd_pr__pfet_01v8 ad=0.775 pd=5.62 as=0.4125 ps=2.83 w=2.5 l=0.15
X352 a_18431_1016# a_18431_n1316# vdd vdd sky130_fd_pr__pfet_01v8 ad=0.1218 pd=1.42 as=0.1218 ps=1.42 w=0.42 l=0.28
X353 a_29990_344# a_28730_1016# vdd vdd sky130_fd_pr__pfet_01v8 ad=0.363 pd=2.53 as=0.682 ps=5.02 w=2.2 l=0.15
X354 vdd a_20422_n1316# a_21484_1016# vdd sky130_fd_pr__pfet_01v8 ad=0.7812 pd=5.66 as=0.4158 ps=2.85 w=2.52 l=0.15
X355 vdd a_20422_1016# a_21484_n1520# vdd sky130_fd_pr__pfet_01v8 ad=0.7812 pd=5.66 as=0.4158 ps=2.85 w=2.52 l=0.15
X356 vdd a_7535_622# a_10251_1016# vdd sky130_fd_pr__pfet_01v8 ad=0.396 pd=2.73 as=0.396 ps=2.73 w=2.4 l=0.15
X357 a_1653_1016# a_859_1016# vdd vdd sky130_fd_pr__pfet_01v8 ad=0.3795 pd=2.63 as=0.713 ps=5.22 w=2.3 l=0.15
X358 a_15607_1016# a_14545_n1416# vss vss sky130_fd_pr__nfet_01v8_lvt ad=0.696 pd=5.38 as=0.696 ps=5.38 w=2.4 l=0.15
X359 vdd clkp a_859_1016# vdd sky130_fd_pr__pfet_01v8_lvt ad=0.638 pd=4.98 as=0.319 ps=2.49 w=2.2 l=0.35
X360 a_26543_404# mode_5g a_26447_1016# vdd sky130_fd_pr__pfet_01v8 ad=0.33 pd=2.33 as=0.33 ps=2.33 w=2 l=0.15
X361 vdd a_7625_n1396# a_7535_622# vdd sky130_fd_pr__pfet_01v8 ad=0.396 pd=2.73 as=0.396 ps=2.73 w=2.4 l=0.15
X362 a_10251_n1496# a_7535_n716# vdd vdd sky130_fd_pr__pfet_01v8 ad=0.396 pd=2.73 as=0.744 ps=5.42 w=2.4 l=0.15
X363 vdd a_1653_1016# a_2483_1016# vdd sky130_fd_pr__pfet_01v8 ad=0.589 pd=4.42 as=0.3135 ps=2.23 w=1.9 l=0.15
X364 a_25532_n1496# a_24470_1016# vdd vdd sky130_fd_pr__pfet_01v8 ad=0.396 pd=2.73 as=0.744 ps=5.42 w=2.4 l=0.15
X365 a_10251_n1496# a_10251_1016# vdd vdd sky130_fd_pr__pfet_01v8 ad=0.464 pd=3.78 as=0.464 ps=3.78 w=1.6 l=0.2
X366 a_17598_n1520# a_16536_1016# vdd vdd sky130_fd_pr__pfet_01v8 ad=0.4158 pd=2.85 as=0.7812 ps=5.66 w=2.52 l=0.15
X367 a_7625_n1396# a_5513_n1556# vdd vdd sky130_fd_pr__pfet_01v8 ad=0.3135 pd=2.23 as=0.589 ps=4.42 w=1.9 l=0.15
X368 a_7307_n1336# a_5513_n1556# vdd vdd sky130_fd_pr__pfet_01v8 ad=0.464 pd=3.78 as=0.464 ps=3.78 w=1.6 l=0.15
X369 a_12650_n1416# a_10251_n1496# a_11382_n1376# vss sky130_fd_pr__nfet_01v8_lvt ad=0.464 pd=3.78 as=0.464 ps=3.78 w=1.6 l=0.15
X370 vdd a_859_n1456# a_1653_n1476# vdd sky130_fd_pr__pfet_01v8 ad=0.3795 pd=2.63 as=0.3795 ps=2.63 w=2.3 l=0.15
X371 a_7307_1016# a_7625_n1396# a_7625_1016# vss sky130_fd_pr__nfet_01v8_lvt ad=0.434 pd=3.42 as=0.231 ps=1.73 w=1.4 l=0.15
X372 vdd a_24470_1016# a_25532_n1496# vdd sky130_fd_pr__pfet_01v8 ad=0.396 pd=2.73 as=0.396 ps=2.73 w=2.4 l=0.15
X373 a_859_n1456# clkn vdd vdd sky130_fd_pr__pfet_01v8_lvt ad=0.319 pd=2.49 as=0.638 ps=4.98 w=2.2 l=0.35
X374 vss a_4919_n1556# a_28364_n604# vss sky130_fd_pr__nfet_01v8_lvt ad=0.403 pd=3.22 as=0.2145 ps=1.63 w=1.3 l=0.15
X375 vdd a_14545_n1416# a_15607_1016# vdd sky130_fd_pr__pfet_01v8 ad=0.528 pd=3.53 as=0.528 ps=3.53 w=3.2 l=0.15
X376 a_12650_1016# a_12650_n1416# vdd vdd sky130_fd_pr__pfet_01v8 ad=0.1218 pd=1.42 as=0.1218 ps=1.42 w=0.42 l=0.28
X377 a_7535_n716# a_7535_622# vdd vdd sky130_fd_pr__pfet_01v8 ad=0.5365 pd=4.28 as=0.5365 ps=4.28 w=1.85 l=0.15
X378 a_28364_n604# a_4919_n1556# vss vss sky130_fd_pr__nfet_01v8_lvt ad=0.2145 pd=1.63 as=0.403 ps=3.22 w=1.3 l=0.15
X379 a_26447_n1316# a_458_n1256# a_27013_n1516# vdd sky130_fd_pr__pfet_01v8 ad=0.4125 pd=2.83 as=0.775 ps=5.62 w=2.5 l=0.15
X380 a_28412_n1316# a_26543_404# a_28364_n604# vss sky130_fd_pr__nfet_01v8_lvt ad=0.264 pd=1.93 as=0.496 ps=3.82 w=1.6 l=0.15
X381 a_10251_1016# a_10251_n1496# vss vss sky130_fd_pr__nfet_01v8 ad=0.1305 pd=1.48 as=0.1305 ps=1.48 w=0.45 l=0.2
X382 a_13712_1016# a_12650_n1416# vss vss sky130_fd_pr__nfet_01v8_lvt ad=0.406 pd=3.38 as=0.406 ps=3.38 w=1.4 l=0.15
X383 vdd a_2483_n1396# a_2857_n1396# vdd sky130_fd_pr__pfet_01v8 ad=0.589 pd=4.42 as=0.3135 ps=2.23 w=1.9 l=0.15
X384 a_5513_n1556# a_1653_n1476# vdd vdd sky130_fd_pr__pfet_01v8 ad=0.4455 pd=3.03 as=0.4455 ps=3.03 w=2.7 l=0.15
X385 vdd a_22317_n1316# a_11666_622# vdd sky130_fd_pr__pfet_01v8 ad=0.3696 pd=2.57 as=0.3696 ps=2.57 w=2.24 l=0.15
X386 a_25532_n1496# a_24470_1016# vss vss sky130_fd_pr__nfet_01v8_lvt ad=0.198 pd=1.53 as=0.372 ps=3.02 w=1.2 l=0.15
X387 a_3231_n1476# a_2857_n1396# vdd vdd sky130_fd_pr__pfet_01v8 ad=0.3795 pd=2.63 as=0.713 ps=5.22 w=2.3 l=0.15
X388 a_22317_1016# a_10251_1016# a_21484_1016# vss sky130_fd_pr__nfet_01v8_lvt ad=0.348 pd=2.98 as=0.348 ps=2.98 w=1.2 l=0.15
X389 a_14545_n1416# rst_n vdd vdd sky130_fd_pr__pfet_01v8 ad=0.464 pd=3.78 as=0.464 ps=3.78 w=1.6 l=0.18
X390 vss a_29990_344# fb250_b vss sky130_fd_pr__nfet_01v8_lvt ad=0.372 pd=3.02 as=0.198 ps=1.53 w=1.2 l=0.15
X391 a_22317_1016# a_22317_n1316# vss vss sky130_fd_pr__nfet_01v8 ad=0.1218 pd=1.42 as=0.1218 ps=1.42 w=0.42 l=0.28
X392 a_11292_n998# a_11292_622# vdd vdd sky130_fd_pr__pfet_01v8 ad=0.5104 pd=4.1 as=0.5104 ps=4.1 w=1.76 l=0.15
X393 a_7625_1016# a_5513_n1556# vdd vdd sky130_fd_pr__pfet_01v8 ad=0.3135 pd=2.23 as=0.589 ps=4.42 w=1.9 l=0.15
X394 vdd a_2857_n1396# a_3231_n1476# vdd sky130_fd_pr__pfet_01v8 ad=0.713 pd=5.22 as=0.3795 ps=2.63 w=2.3 l=0.15
X395 a_6439_1016# a_5513_1016# vdd vdd sky130_fd_pr__pfet_01v8 ad=0.33 pd=2.33 as=0.62 ps=4.62 w=2 l=0.15
X396 a_17598_1016# a_17598_n1520# vdd vdd sky130_fd_pr__pfet_01v8 ad=0.5104 pd=4.1 as=0.5104 ps=4.1 w=1.76 l=0.15
X397 a_15607_1016# a_15607_n1656# vdd vdd sky130_fd_pr__pfet_01v8 ad=0.5104 pd=4.1 as=0.5104 ps=4.1 w=1.76 l=0.15
X398 a_16536_n1316# a_16536_1016# vdd vdd sky130_fd_pr__pfet_01v8 ad=0.1218 pd=1.42 as=0.1218 ps=1.42 w=0.42 l=0.28
X399 a_20422_n1316# rst_n vdd vdd sky130_fd_pr__pfet_01v8 ad=0.464 pd=3.78 as=0.464 ps=3.78 w=1.6 l=0.18
X400 a_11430_364# a_10251_1016# a_12650_1016# vdd sky130_fd_pr__pfet_01v8 ad=0.62 pd=4.62 as=0.33 ps=2.33 w=2 l=0.15
X401 fb250 a_29990_n1456# vss vss sky130_fd_pr__nfet_01v8_lvt ad=0.198 pd=1.53 as=0.372 ps=3.02 w=1.2 l=0.15
X402 a_28364_n604# a_4919_n1556# vss vss sky130_fd_pr__nfet_01v8_lvt ad=0.2145 pd=1.63 as=0.403 ps=3.22 w=1.3 l=0.15
X403 fb250_b a_29990_344# vdd vdd sky130_fd_pr__pfet_01v8 ad=0.651 pd=4.82 as=0.3465 ps=2.43 w=2.1 l=0.15
X404 a_2857_n1396# a_2483_n1396# vss vss sky130_fd_pr__nfet_01v8_lvt ad=0.29 pd=2.58 as=0.29 ps=2.58 w=1 l=0.15
X405 a_26447_n1316# a_15607_n1656# vdd vdd sky130_fd_pr__pfet_01v8 ad=0.2475 pd=1.83 as=0.465 ps=3.62 w=1.5 l=0.15
X406 a_20422_1016# a_10251_n1496# a_11292_622# vss sky130_fd_pr__nfet_01v8_lvt ad=0.348 pd=2.98 as=0.348 ps=2.98 w=1.2 l=0.15
X407 a_20422_1016# a_20422_n1316# vss vss sky130_fd_pr__nfet_01v8 ad=0.1218 pd=1.42 as=0.1218 ps=1.42 w=0.42 l=0.28
X408 a_17598_1016# a_16536_n1316# vdd vdd sky130_fd_pr__pfet_01v8 ad=0.4158 pd=2.85 as=0.7812 ps=5.66 w=2.52 l=0.15
X409 vdd a_16536_1016# a_17598_n1520# vdd sky130_fd_pr__pfet_01v8 ad=0.7812 pd=5.66 as=0.4158 ps=2.85 w=2.52 l=0.15
X410 vss a_29990_n1456# fb250 vss sky130_fd_pr__nfet_01v8_lvt ad=0.372 pd=3.02 as=0.198 ps=1.53 w=1.2 l=0.15
X411 vdd a_5513_n1556# a_7625_n1396# vdd sky130_fd_pr__pfet_01v8 ad=0.589 pd=4.42 as=0.3135 ps=2.23 w=1.9 l=0.15
.ends
