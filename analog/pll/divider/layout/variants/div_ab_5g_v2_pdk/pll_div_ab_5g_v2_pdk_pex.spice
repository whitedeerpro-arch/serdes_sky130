* NGSPICE file created from pll_div_ab_5g_v2_pdk.ext - technology: sky130A

.subckt pll_div_ab_5g_v2_pdk clkp clkn mode_5g rst_n fb250 fb250_b vdd vss
X0 a_13712_n1576# a_12650_1016# vdd vdd sky130_fd_pr__pfet_01v8 ad=0.462 pd=3.13 as=0.868 ps=6.22 w=2.8 l=0.15
X1 a_1653_n1476# a_859_n1456# vdd vdd sky130_fd_pr__pfet_01v8 ad=0.713 pd=5.22 as=0.3795 ps=2.63 w=2.3 l=0.15
X2 vdd a_4919_n1556# a_28730_1016# vdd sky130_fd_pr__pfet_01v8 ad=0.527 pd=4.02 as=0.2805 ps=2.03 w=1.7 l=0.15
X3 a_25532_n1496# a_24470_1016# vdd vdd sky130_fd_pr__pfet_01v8 ad=0.396 pd=2.73 as=0.396 ps=2.73 w=2.4 l=0.15
X4 a_28730_n1356# a_28730_1016# a_28412_n1316# vss sky130_fd_pr__nfet_01v8_lvt ad=0.231 pd=1.73 as=0.434 ps=3.42 w=1.4 l=0.15
X5 vdd a_11292_n998# a_11382_n1376# vdd sky130_fd_pr__pfet_01v8 ad=0.558 pd=4.22 as=0.297 ps=2.13 w=1.8 l=0.15
X6 a_8591_n1536# a_7625_n1396# vdd vdd sky130_fd_pr__pfet_01v8 ad=0.754 pd=5.78 as=0.754 ps=5.78 w=2.6 l=0.15
X7 a_14545_n1416# a_10251_n1496# a_13712_n1576# vdd sky130_fd_pr__pfet_01v8 ad=0.33 pd=2.33 as=0.62 ps=4.62 w=2 l=0.15
X8 a_4449_n1536# a_3979_n1426# vdd vdd sky130_fd_pr__pfet_01v8 ad=0.429 pd=2.93 as=0.806 ps=5.82 w=2.6 l=0.15
X9 vdd a_1653_n1476# a_2483_n1396# vdd sky130_fd_pr__pfet_01v8 ad=0.589 pd=4.42 as=0.3135 ps=2.23 w=1.9 l=0.15
X10 vdd clkn a_859_n1456# vdd sky130_fd_pr__pfet_01v8_lvt ad=0.638 pd=4.98 as=0.319 ps=2.49 w=2.2 l=0.35
X11 a_27013_n1516# a_458_n1256# a_26447_n1316# vdd sky130_fd_pr__pfet_01v8 ad=0.4125 pd=2.83 as=0.4125 ps=2.83 w=2.5 l=0.15
X12 a_859_n1456# a_859_1016# vdd vdd sky130_fd_pr__pfet_01v8 ad=0.2436 pd=2.26 as=0.2436 ps=2.26 w=0.84 l=0.28
X13 a_7535_n716# a_7535_622# vss vss sky130_fd_pr__nfet_01v8 ad=0.145 pd=1.58 as=0.145 ps=1.58 w=0.5 l=0.15
X14 a_11382_1016# mode_5g a_11430_364# vdd sky130_fd_pr__pfet_01v8 ad=0.744 pd=5.42 as=0.396 ps=2.73 w=2.4 l=0.15
X15 a_24470_n1456# a_24470_1016# vss vss sky130_fd_pr__nfet_01v8 ad=0.1218 pd=1.42 as=0.1218 ps=1.42 w=0.42 l=0.28
X16 a_859_n1456# clkn vss vss sky130_fd_pr__nfet_01v8_lvt ad=0.348 pd=2.98 as=0.348 ps=2.98 w=1.2 l=0.15
X17 a_18431_1016# a_458_484# vss vss sky130_fd_pr__nfet_01v8 ad=0.261 pd=2.38 as=0.261 ps=2.38 w=0.9 l=0.18
X18 a_25532_1016# a_24470_n1456# vdd vdd sky130_fd_pr__pfet_01v8 ad=0.396 pd=2.73 as=0.396 ps=2.73 w=2.4 l=0.15
X19 vss a_15607_n1656# a_26543_n604# vss sky130_fd_pr__nfet_01v8_lvt ad=0.465 pd=3.62 as=0.2475 ps=1.83 w=1.5 l=0.15
X20 vdd a_1653_n1476# a_5513_n1556# vdd sky130_fd_pr__pfet_01v8 ad=0.837 pd=6.02 as=0.4455 ps=3.03 w=2.7 l=0.15
X21 a_13712_1016# a_12650_n1416# vdd vdd sky130_fd_pr__pfet_01v8 ad=0.462 pd=3.13 as=0.868 ps=6.22 w=2.8 l=0.15
X22 a_17598_n1520# a_17598_1016# vdd vdd sky130_fd_pr__pfet_01v8 ad=0.5104 pd=4.1 as=0.5104 ps=4.1 w=1.76 l=0.15
X23 a_29696_464# a_28730_1016# vdd vdd sky130_fd_pr__pfet_01v8 ad=0.812 pd=6.18 as=0.812 ps=6.18 w=2.8 l=0.15
X24 a_26447_1016# a_15607_1016# vdd vdd sky130_fd_pr__pfet_01v8 ad=0.33 pd=2.33 as=0.62 ps=4.62 w=2 l=0.15
X25 a_26543_404# a_15607_1016# vss vss sky130_fd_pr__nfet_01v8_lvt ad=0.165 pd=1.33 as=0.31 ps=2.62 w=1 l=0.15
X26 a_14545_n1416# a_14545_1016# vdd vdd sky130_fd_pr__pfet_01v8 ad=0.1218 pd=1.42 as=0.1218 ps=1.42 w=0.42 l=0.28
X27 a_458_484# rst_n vdd vdd sky130_fd_pr__pfet_01v8 ad=0.348 pd=2.98 as=0.348 ps=2.98 w=1.2 l=0.18
X28 vss a_8591_494# a_7535_622# vss sky130_fd_pr__nfet_01v8_lvt ad=0.372 pd=3.02 as=0.198 ps=1.53 w=1.2 l=0.15
X29 vss a_1653_1016# a_5513_1016# vss sky130_fd_pr__nfet_01v8_lvt ad=0.434 pd=3.42 as=0.231 ps=1.73 w=1.4 l=0.15
X30 a_11666_n998# a_11666_622# vdd vdd sky130_fd_pr__pfet_01v8 ad=0.5104 pd=4.1 as=0.5104 ps=4.1 w=1.76 l=0.15
X31 a_16536_1016# a_458_484# vss vss sky130_fd_pr__nfet_01v8 ad=0.261 pd=2.38 as=0.261 ps=2.38 w=0.9 l=0.18
X32 a_3605_n1556# a_3231_n1476# vdd vdd sky130_fd_pr__pfet_01v8 ad=0.4455 pd=3.03 as=0.837 ps=6.02 w=2.7 l=0.15
X33 a_1653_n1476# a_859_n1456# vss vss sky130_fd_pr__nfet_01v8_lvt ad=0.522 pd=4.18 as=0.522 ps=4.18 w=1.8 l=0.15
X34 a_21484_1016# a_20422_n1316# vdd vdd sky130_fd_pr__pfet_01v8 ad=0.4158 pd=2.85 as=0.7812 ps=5.66 w=2.52 l=0.15
X35 a_5513_1016# a_1653_1016# vss vss sky130_fd_pr__nfet_01v8_lvt ad=0.231 pd=1.73 as=0.434 ps=3.42 w=1.4 l=0.15
X36 fb250 fb250_b vdd vdd sky130_fd_pr__pfet_01v8 ad=0.348 pd=2.98 as=0.348 ps=2.98 w=1.2 l=0.15
X37 vdd a_15607_n1656# a_26447_n1316# vdd sky130_fd_pr__pfet_01v8 ad=0.2475 pd=1.83 as=0.2475 ps=1.83 w=1.5 l=0.15
X38 vss a_15607_1016# a_26543_404# vss sky130_fd_pr__nfet_01v8_lvt ad=0.31 pd=2.62 as=0.165 ps=1.33 w=1 l=0.15
X39 a_25532_1016# a_25532_n1496# vdd vdd sky130_fd_pr__pfet_01v8 ad=0.5104 pd=4.1 as=0.5104 ps=4.1 w=1.76 l=0.15
X40 a_28730_1016# a_28730_n1356# vdd vdd sky130_fd_pr__pfet_01v8 ad=0.464 pd=3.78 as=0.464 ps=3.78 w=1.6 l=0.15
X41 a_26447_1016# mode_5g a_26543_404# vdd sky130_fd_pr__pfet_01v8 ad=0.33 pd=2.33 as=0.33 ps=2.33 w=2 l=0.15
X42 a_16536_n1316# a_10251_n1496# a_15607_n1656# vss sky130_fd_pr__nfet_01v8_lvt ad=0.348 pd=2.98 as=0.348 ps=2.98 w=1.2 l=0.15
X43 a_15607_n1656# a_14545_1016# vdd vdd sky130_fd_pr__pfet_01v8 ad=0.528 pd=3.53 as=0.992 ps=7.02 w=3.2 l=0.15
X44 a_26543_n604# a_25532_n1496# a_26447_n1316# vss sky130_fd_pr__nfet_01v8_lvt ad=0.465 pd=3.62 as=0.2475 ps=1.83 w=1.5 l=0.15
X45 a_13712_1016# a_13712_n1576# vdd vdd sky130_fd_pr__pfet_01v8 ad=0.5104 pd=4.1 as=0.5104 ps=4.1 w=1.76 l=0.15
X46 a_11292_n998# a_10251_1016# a_20422_n1316# vdd sky130_fd_pr__pfet_01v8 ad=0.465 pd=3.62 as=0.2475 ps=1.83 w=1.5 l=0.15
X47 vdd a_24470_1016# a_25532_n1496# vdd sky130_fd_pr__pfet_01v8 ad=0.744 pd=5.42 as=0.396 ps=2.73 w=2.4 l=0.15
X48 a_7535_622# a_7625_n1396# vdd vdd sky130_fd_pr__pfet_01v8 ad=0.396 pd=2.73 as=0.396 ps=2.73 w=2.4 l=0.15
X49 a_14545_1016# a_458_484# vss vss sky130_fd_pr__nfet_01v8 ad=0.261 pd=2.38 as=0.261 ps=2.38 w=0.9 l=0.18
X50 a_13712_n1576# a_10251_n1496# a_14545_n1416# vdd sky130_fd_pr__pfet_01v8 ad=0.62 pd=4.62 as=0.33 ps=2.33 w=2 l=0.15
X51 a_24470_n1456# a_24470_1016# vdd vdd sky130_fd_pr__pfet_01v8 ad=0.1218 pd=1.42 as=0.1218 ps=1.42 w=0.42 l=0.28
X52 vdd a_3979_n1426# a_4449_n1536# vdd sky130_fd_pr__pfet_01v8 ad=0.429 pd=2.93 as=0.429 ps=2.93 w=2.6 l=0.15
X53 a_24470_1016# a_10251_1016# a_15607_1016# vdd sky130_fd_pr__pfet_01v8 ad=0.363 pd=2.53 as=0.682 ps=5.02 w=2.2 l=0.15
X54 a_15607_1016# a_14545_n1416# vdd vdd sky130_fd_pr__pfet_01v8 ad=0.528 pd=3.53 as=0.992 ps=7.02 w=3.2 l=0.15
X55 a_26447_n1316# a_458_n1256# a_27013_n1516# vdd sky130_fd_pr__pfet_01v8 ad=0.4125 pd=2.83 as=0.4125 ps=2.83 w=2.5 l=0.15
X56 vdd a_15607_1016# a_26447_1016# vdd sky130_fd_pr__pfet_01v8 ad=0.62 pd=4.62 as=0.33 ps=2.33 w=2 l=0.15
X57 a_5513_1016# a_5513_n1556# vss vss sky130_fd_pr__nfet_01v8 ad=0.1305 pd=1.48 as=0.1305 ps=1.48 w=0.45 l=0.2
X58 a_29990_n1456# a_29990_344# vss vss sky130_fd_pr__nfet_01v8 ad=0.1595 pd=1.68 as=0.1595 ps=1.68 w=0.55 l=0.15
X59 a_27017_304# a_25532_1016# a_26543_404# vss sky130_fd_pr__nfet_01v8_lvt ad=0.465 pd=3.62 as=0.2475 ps=1.83 w=1.5 l=0.15
X60 a_10251_n1496# a_10251_1016# vss vss sky130_fd_pr__nfet_01v8 ad=0.1305 pd=1.48 as=0.1305 ps=1.48 w=0.45 l=0.2
X61 a_7625_n1396# a_7625_1016# a_7307_n1336# vss sky130_fd_pr__nfet_01v8_lvt ad=0.231 pd=1.73 as=0.434 ps=3.42 w=1.4 l=0.15
X62 a_26543_404# a_25532_1016# a_27017_304# vss sky130_fd_pr__nfet_01v8_lvt ad=0.2475 pd=1.83 as=0.465 ps=3.62 w=1.5 l=0.15
X63 vdd a_7625_1016# a_7535_n716# vdd sky130_fd_pr__pfet_01v8 ad=0.744 pd=5.42 as=0.396 ps=2.73 w=2.4 l=0.15
X64 a_12650_n1416# a_12650_1016# vdd vdd sky130_fd_pr__pfet_01v8 ad=0.1218 pd=1.42 as=0.1218 ps=1.42 w=0.42 l=0.28
X65 a_11666_622# a_22317_n1316# vdd vdd sky130_fd_pr__pfet_01v8 ad=0.3696 pd=2.57 as=0.6944 ps=5.1 w=2.24 l=0.15
X66 a_7535_n716# a_458_484# vss vss sky130_fd_pr__nfet_01v8 ad=0.348 pd=2.98 as=0.348 ps=2.98 w=1.2 l=0.18
X67 a_7625_1016# a_7625_n1396# a_7307_1016# vss sky130_fd_pr__nfet_01v8_lvt ad=0.231 pd=1.73 as=0.434 ps=3.42 w=1.4 l=0.15
X68 vdd a_7535_622# a_10251_1016# vdd sky130_fd_pr__pfet_01v8 ad=0.744 pd=5.42 as=0.396 ps=2.73 w=2.4 l=0.15
X69 a_1653_1016# a_859_1016# vdd vdd sky130_fd_pr__pfet_01v8 ad=0.713 pd=5.22 as=0.3795 ps=2.63 w=2.3 l=0.15
X70 a_11292_n998# a_18431_1016# vdd vdd sky130_fd_pr__pfet_01v8 ad=0.3696 pd=2.57 as=0.6944 ps=5.1 w=2.24 l=0.15
X71 a_15607_1016# a_10251_1016# a_16536_1016# vdd sky130_fd_pr__pfet_01v8 ad=0.465 pd=3.62 as=0.2475 ps=1.83 w=1.5 l=0.15
X72 a_21484_n1520# a_21484_1016# vdd vdd sky130_fd_pr__pfet_01v8 ad=0.5104 pd=4.1 as=0.5104 ps=4.1 w=1.76 l=0.15
X73 a_18431_n1316# a_10251_1016# a_17598_n1520# vss sky130_fd_pr__nfet_01v8_lvt ad=0.348 pd=2.98 as=0.348 ps=2.98 w=1.2 l=0.15
X74 a_1653_n1476# a_1653_1016# vdd vdd sky130_fd_pr__pfet_01v8 ad=0.406 pd=3.38 as=0.406 ps=3.38 w=1.4 l=0.2
X75 a_20422_n1316# a_10251_n1496# a_11292_n998# vss sky130_fd_pr__nfet_01v8_lvt ad=0.348 pd=2.98 as=0.348 ps=2.98 w=1.2 l=0.15
X76 vdd a_3231_n1476# a_3605_n1556# vdd sky130_fd_pr__pfet_01v8 ad=0.837 pd=6.02 as=0.4455 ps=3.03 w=2.7 l=0.15
X77 vss a_1653_n1476# a_5513_n1556# vss sky130_fd_pr__nfet_01v8_lvt ad=0.434 pd=3.42 as=0.231 ps=1.73 w=1.4 l=0.15
X78 a_26447_1016# a_25532_1016# a_26543_404# vdd sky130_fd_pr__pfet_01v8 ad=0.62 pd=4.62 as=0.33 ps=2.33 w=2 l=0.15
X79 a_5513_1016# a_1653_1016# vdd vdd sky130_fd_pr__pfet_01v8 ad=0.4455 pd=3.03 as=0.837 ps=6.02 w=2.7 l=0.15
X80 vdd a_14545_1016# a_15607_n1656# vdd sky130_fd_pr__pfet_01v8 ad=0.528 pd=3.53 as=0.528 ps=3.53 w=3.2 l=0.15
X81 a_12650_1016# a_458_484# vss vss sky130_fd_pr__nfet_01v8 ad=0.261 pd=2.38 as=0.261 ps=2.38 w=0.9 l=0.18
X82 a_7535_622# a_8591_494# vss vss sky130_fd_pr__nfet_01v8_lvt ad=0.198 pd=1.53 as=0.372 ps=3.02 w=1.2 l=0.15
X83 a_15607_n1656# a_10251_1016# a_24470_n1456# vdd sky130_fd_pr__pfet_01v8 ad=0.682 pd=5.02 as=0.363 ps=2.53 w=2.2 l=0.15
X84 a_15607_1016# a_15607_n1656# vss vss sky130_fd_pr__nfet_01v8_lvt ad=0.1218 pd=1.42 as=0.1218 ps=1.42 w=0.42 l=0.15
X85 a_3231_n1476# a_2857_n1396# vss vss sky130_fd_pr__nfet_01v8_lvt ad=0.348 pd=2.98 as=0.348 ps=2.98 w=1.2 l=0.15
X86 a_29990_344# a_29990_n1456# vss vss sky130_fd_pr__nfet_01v8 ad=0.1595 pd=1.68 as=0.1595 ps=1.68 w=0.55 l=0.15
X87 a_458_484# rst_n vss vss sky130_fd_pr__nfet_01v8 ad=0.174 pd=1.78 as=0.174 ps=1.78 w=0.6 l=0.18
X88 a_12650_n1416# a_10251_1016# a_11382_n1376# vdd sky130_fd_pr__pfet_01v8 ad=0.33 pd=2.33 as=0.62 ps=4.62 w=2 l=0.15
X89 a_16536_n1316# a_10251_1016# a_15607_n1656# vdd sky130_fd_pr__pfet_01v8 ad=0.2475 pd=1.83 as=0.465 ps=3.62 w=1.5 l=0.15
X90 vdd a_7625_n1396# a_7535_622# vdd sky130_fd_pr__pfet_01v8 ad=0.744 pd=5.42 as=0.396 ps=2.73 w=2.4 l=0.15
X91 vss a_5513_n1556# a_7259_n604# vss sky130_fd_pr__nfet_01v8_lvt ad=0.434 pd=3.42 as=0.231 ps=1.73 w=1.4 l=0.15
X92 a_1653_n1476# a_1653_1016# vss vss sky130_fd_pr__nfet_01v8 ad=0.1218 pd=1.42 as=0.1218 ps=1.42 w=0.42 l=0.2
X93 a_4449_n1536# a_3979_n1426# vdd vdd sky130_fd_pr__pfet_01v8 ad=0.806 pd=5.82 as=0.429 ps=2.93 w=2.6 l=0.15
X94 a_14545_n1416# a_10251_1016# a_13712_n1576# vss sky130_fd_pr__nfet_01v8_lvt ad=0.464 pd=3.78 as=0.464 ps=3.78 w=1.6 l=0.15
X95 a_28730_1016# a_4919_n1556# vdd vdd sky130_fd_pr__pfet_01v8 ad=0.2805 pd=2.03 as=0.527 ps=4.02 w=1.7 l=0.15
X96 vdd a_7535_n716# a_10251_n1496# vdd sky130_fd_pr__pfet_01v8 ad=0.396 pd=2.73 as=0.396 ps=2.73 w=2.4 l=0.15
X97 a_22317_1016# a_458_484# vss vss sky130_fd_pr__nfet_01v8 ad=0.261 pd=2.38 as=0.261 ps=2.38 w=0.9 l=0.18
X98 a_4919_n1556# a_4449_n1536# vss vss sky130_fd_pr__nfet_01v8_lvt ad=0.231 pd=1.73 as=0.434 ps=3.42 w=1.4 l=0.15
X99 a_11292_622# a_10251_1016# a_20422_1016# vdd sky130_fd_pr__pfet_01v8 ad=0.465 pd=3.62 as=0.2475 ps=1.83 w=1.5 l=0.15
X100 vdd a_24470_n1456# a_25532_1016# vdd sky130_fd_pr__pfet_01v8 ad=0.396 pd=2.73 as=0.396 ps=2.73 w=2.4 l=0.15
X101 a_24470_n1456# rst_n vdd vdd sky130_fd_pr__pfet_01v8 ad=0.464 pd=3.78 as=0.464 ps=3.78 w=1.6 l=0.18
X102 a_24470_1016# a_24470_n1456# vdd vdd sky130_fd_pr__pfet_01v8 ad=0.1218 pd=1.42 as=0.1218 ps=1.42 w=0.42 l=0.28
X103 a_11430_364# mode_5g a_11382_1016# vdd sky130_fd_pr__pfet_01v8 ad=0.396 pd=2.73 as=0.744 ps=5.42 w=2.4 l=0.15
X104 a_13712_1016# a_13712_n1576# vss vss sky130_fd_pr__nfet_01v8_lvt ad=0.1218 pd=1.42 as=0.1218 ps=1.42 w=0.42 l=0.15
X105 a_22317_n1316# a_10251_1016# a_21484_n1520# vss sky130_fd_pr__nfet_01v8_lvt ad=0.348 pd=2.98 as=0.348 ps=2.98 w=1.2 l=0.15
X106 a_7307_n1336# a_7625_1016# a_7625_n1396# vss sky130_fd_pr__nfet_01v8_lvt ad=0.434 pd=3.42 as=0.231 ps=1.73 w=1.4 l=0.15
X107 fb250 a_29990_n1456# vdd vdd sky130_fd_pr__pfet_01v8 ad=0.651 pd=4.82 as=0.3465 ps=2.43 w=2.1 l=0.15
X108 vdd a_1653_1016# a_5513_1016# vdd sky130_fd_pr__pfet_01v8 ad=0.837 pd=6.02 as=0.4455 ps=3.03 w=2.7 l=0.15
X109 vss a_8591_n1536# a_7535_n716# vss sky130_fd_pr__nfet_01v8_lvt ad=0.372 pd=3.02 as=0.198 ps=1.53 w=1.2 l=0.15
X110 a_11666_n998# a_22317_1016# vdd vdd sky130_fd_pr__pfet_01v8 ad=0.3696 pd=2.57 as=0.6944 ps=5.1 w=2.24 l=0.15
X111 a_16536_n1316# a_16536_1016# vss vss sky130_fd_pr__nfet_01v8 ad=0.1218 pd=1.42 as=0.1218 ps=1.42 w=0.42 l=0.28
X112 vdd a_5513_1016# a_6439_1016# vdd sky130_fd_pr__pfet_01v8 ad=0.62 pd=4.62 as=0.33 ps=2.33 w=2 l=0.15
X113 vss a_29696_464# a_29990_n1456# vss sky130_fd_pr__nfet_01v8_lvt ad=0.403 pd=3.22 as=0.2145 ps=1.63 w=1.3 l=0.15
X114 a_28412_1016# a_4919_n1556# vdd vdd sky130_fd_pr__pfet_01v8 ad=0.435 pd=3.58 as=0.435 ps=3.58 w=1.5 l=0.15
X115 fb250 fb250_b vss vss sky130_fd_pr__nfet_01v8_lvt ad=0.1305 pd=1.48 as=0.1305 ps=1.48 w=0.45 l=0.15
X116 a_13712_1016# a_10251_n1496# a_14545_1016# vdd sky130_fd_pr__pfet_01v8 ad=0.62 pd=4.62 as=0.33 ps=2.33 w=2 l=0.15
X117 a_26543_404# mode_5g a_26447_1016# vdd sky130_fd_pr__pfet_01v8 ad=0.33 pd=2.33 as=0.62 ps=4.62 w=2 l=0.15
X118 a_28730_n1356# a_28730_1016# vdd vdd sky130_fd_pr__pfet_01v8 ad=0.464 pd=3.78 as=0.464 ps=3.78 w=1.6 l=0.15
X119 a_11430_n604# a_11292_n998# vss vss sky130_fd_pr__nfet_01v8_lvt ad=0.522 pd=4.18 as=0.522 ps=4.18 w=1.8 l=0.15
X120 a_26447_n1316# a_25532_n1496# a_26543_n604# vss sky130_fd_pr__nfet_01v8_lvt ad=0.2475 pd=1.83 as=0.465 ps=3.62 w=1.5 l=0.15
X121 a_20422_1016# a_458_484# vss vss sky130_fd_pr__nfet_01v8 ad=0.261 pd=2.38 as=0.261 ps=2.38 w=0.9 l=0.18
X122 a_7535_622# rst_n vdd vdd sky130_fd_pr__pfet_01v8 ad=0.696 pd=5.38 as=0.696 ps=5.38 w=2.4 l=0.18
X123 vss a_3979_n1426# a_4449_n1536# vss sky130_fd_pr__nfet_01v8_lvt ad=0.31 pd=2.62 as=0.165 ps=1.33 w=1 l=0.15
X124 a_11292_622# a_11292_n998# vss vss sky130_fd_pr__nfet_01v8_lvt ad=0.1218 pd=1.42 as=0.1218 ps=1.42 w=0.42 l=0.15
X125 a_11292_622# a_18431_n1316# vdd vdd sky130_fd_pr__pfet_01v8 ad=0.3696 pd=2.57 as=0.6944 ps=5.1 w=2.24 l=0.15
X126 a_15607_n1656# a_10251_1016# a_16536_n1316# vdd sky130_fd_pr__pfet_01v8 ad=0.465 pd=3.62 as=0.2475 ps=1.83 w=1.5 l=0.15
X127 vss a_7535_n716# a_10251_n1496# vss sky130_fd_pr__nfet_01v8_lvt ad=0.372 pd=3.02 as=0.198 ps=1.53 w=1.2 l=0.15
X128 a_24470_1016# a_10251_n1496# a_15607_1016# vss sky130_fd_pr__nfet_01v8_lvt ad=0.522 pd=4.18 as=0.522 ps=4.18 w=1.8 l=0.15
X129 a_5513_n1556# a_5513_1016# vss vss sky130_fd_pr__nfet_01v8 ad=0.1305 pd=1.48 as=0.1305 ps=1.48 w=0.45 l=0.2
X130 a_4919_n1556# a_4449_n1536# vdd vdd sky130_fd_pr__pfet_01v8 ad=0.4455 pd=3.03 as=0.837 ps=6.02 w=2.7 l=0.15
X131 a_10251_1016# a_7535_622# vdd vdd sky130_fd_pr__pfet_01v8 ad=0.396 pd=2.73 as=0.744 ps=5.42 w=2.4 l=0.15
X132 a_29990_n1456# rst_n vdd vdd sky130_fd_pr__pfet_01v8 ad=0.696 pd=5.38 as=0.696 ps=5.38 w=2.4 l=0.18
X133 a_10251_n1496# a_7535_n716# vdd vdd sky130_fd_pr__pfet_01v8 ad=0.396 pd=2.73 as=0.396 ps=2.73 w=2.4 l=0.15
X134 a_11666_n998# a_11666_622# vss vss sky130_fd_pr__nfet_01v8_lvt ad=0.1218 pd=1.42 as=0.1218 ps=1.42 w=0.42 l=0.15
X135 a_859_1016# a_859_n1456# vss vss sky130_fd_pr__nfet_01v8 ad=0.1218 pd=1.42 as=0.1218 ps=1.42 w=0.42 l=0.28
X136 a_458_n1256# mode_5g vdd vdd sky130_fd_pr__pfet_01v8 ad=0.348 pd=2.98 as=0.348 ps=2.98 w=1.2 l=0.18
X137 vdd a_12650_1016# a_13712_n1576# vdd sky130_fd_pr__pfet_01v8 ad=0.868 pd=6.22 as=0.462 ps=3.13 w=2.8 l=0.15
X138 a_26447_1016# a_15607_1016# vdd vdd sky130_fd_pr__pfet_01v8 ad=0.33 pd=2.33 as=0.33 ps=2.33 w=2 l=0.15
X139 a_29696_n1576# a_28730_n1356# vdd vdd sky130_fd_pr__pfet_01v8 ad=0.812 pd=6.18 as=0.812 ps=6.18 w=2.8 l=0.15
X140 a_2483_1016# a_1653_1016# vdd vdd sky130_fd_pr__pfet_01v8 ad=0.3135 pd=2.23 as=0.589 ps=4.42 w=1.9 l=0.15
X141 vss a_4449_n1536# a_4919_n1556# vss sky130_fd_pr__nfet_01v8_lvt ad=0.434 pd=3.42 as=0.231 ps=1.73 w=1.4 l=0.15
X142 a_29990_344# a_29990_n1456# vdd vdd sky130_fd_pr__pfet_01v8 ad=0.1885 pd=1.88 as=0.1885 ps=1.88 w=0.65 l=0.15
X143 vss a_5513_1016# a_6439_1016# vss sky130_fd_pr__nfet_01v8_lvt ad=0.496 pd=3.82 as=0.264 ps=1.93 w=1.6 l=0.15
X144 vss a_7535_622# a_10251_1016# vss sky130_fd_pr__nfet_01v8_lvt ad=0.372 pd=3.02 as=0.198 ps=1.53 w=1.2 l=0.15
X145 a_10251_1016# a_10251_n1496# vdd vdd sky130_fd_pr__pfet_01v8 ad=0.464 pd=3.78 as=0.464 ps=3.78 w=1.6 l=0.2
X146 a_3605_n1556# a_3231_n1476# vss vss sky130_fd_pr__nfet_01v8_lvt ad=0.406 pd=3.38 as=0.406 ps=3.38 w=1.4 l=0.15
X147 a_7535_n716# a_7625_1016# vdd vdd sky130_fd_pr__pfet_01v8 ad=0.396 pd=2.73 as=0.396 ps=2.73 w=2.4 l=0.15
X148 vdd a_11292_622# a_11382_1016# vdd sky130_fd_pr__pfet_01v8 ad=0.744 pd=5.42 as=0.396 ps=2.73 w=2.4 l=0.15
X149 a_20422_n1316# a_20422_1016# vss vss sky130_fd_pr__nfet_01v8 ad=0.1218 pd=1.42 as=0.1218 ps=1.42 w=0.42 l=0.28
X150 a_24470_1016# a_24470_n1456# vss vss sky130_fd_pr__nfet_01v8 ad=0.1218 pd=1.42 as=0.1218 ps=1.42 w=0.42 l=0.28
X151 a_17598_1016# a_17598_n1520# vss vss sky130_fd_pr__nfet_01v8_lvt ad=0.1218 pd=1.42 as=0.1218 ps=1.42 w=0.42 l=0.15
X152 a_6439_1016# a_5513_1016# vss vss sky130_fd_pr__nfet_01v8_lvt ad=0.264 pd=1.93 as=0.496 ps=3.82 w=1.6 l=0.15
X153 a_10251_1016# a_7535_622# vss vss sky130_fd_pr__nfet_01v8_lvt ad=0.198 pd=1.53 as=0.372 ps=3.02 w=1.2 l=0.15
X154 a_16536_1016# a_10251_1016# a_15607_1016# vdd sky130_fd_pr__pfet_01v8 ad=0.2475 pd=1.83 as=0.465 ps=3.62 w=1.5 l=0.15
X155 vdd a_859_1016# a_1653_1016# vdd sky130_fd_pr__pfet_01v8 ad=0.3795 pd=2.63 as=0.3795 ps=2.63 w=2.3 l=0.15
X156 a_26447_1016# mode_5g a_26543_404# vdd sky130_fd_pr__pfet_01v8 ad=0.62 pd=4.62 as=0.33 ps=2.33 w=2 l=0.15
X157 vdd a_22317_1016# a_11666_n998# vdd sky130_fd_pr__pfet_01v8 ad=0.3696 pd=2.57 as=0.3696 ps=2.57 w=2.24 l=0.15
X158 a_1653_1016# a_1653_n1476# vss vss sky130_fd_pr__nfet_01v8 ad=0.1218 pd=1.42 as=0.1218 ps=1.42 w=0.42 l=0.2
X159 a_15607_n1656# a_15607_1016# vdd vdd sky130_fd_pr__pfet_01v8 ad=0.5104 pd=4.1 as=0.5104 ps=4.1 w=1.76 l=0.15
X160 a_29990_344# a_29696_n1576# vss vss sky130_fd_pr__nfet_01v8_lvt ad=0.2145 pd=1.63 as=0.403 ps=3.22 w=1.3 l=0.15
X161 vss mode_5g a_27017_304# vss sky130_fd_pr__nfet_01v8_lvt ad=0.465 pd=3.62 as=0.2475 ps=1.83 w=1.5 l=0.15
X162 a_27013_n1516# a_25532_n1496# vdd vdd sky130_fd_pr__pfet_01v8 ad=0.4125 pd=2.83 as=0.775 ps=5.62 w=2.5 l=0.15
X163 a_12650_n1416# rst_n vdd vdd sky130_fd_pr__pfet_01v8 ad=0.464 pd=3.78 as=0.464 ps=3.78 w=1.6 l=0.18
X164 a_5513_n1556# a_1653_n1476# vss vss sky130_fd_pr__nfet_01v8_lvt ad=0.231 pd=1.73 as=0.434 ps=3.42 w=1.4 l=0.15
X165 a_26543_404# a_25532_1016# a_26447_1016# vdd sky130_fd_pr__pfet_01v8 ad=0.33 pd=2.33 as=0.33 ps=2.33 w=2 l=0.15
X166 a_27017_304# mode_5g vss vss sky130_fd_pr__nfet_01v8_lvt ad=0.2475 pd=1.83 as=0.465 ps=3.62 w=1.5 l=0.15
X167 fb250_b a_29990_344# vss vss sky130_fd_pr__nfet_01v8_lvt ad=0.198 pd=1.53 as=0.372 ps=3.02 w=1.2 l=0.15
X168 a_7259_n604# a_7535_n716# a_7307_n1336# vss sky130_fd_pr__nfet_01v8_lvt ad=0.527 pd=4.02 as=0.2805 ps=2.03 w=1.7 l=0.15
X169 a_14545_n1416# a_14545_1016# vss vss sky130_fd_pr__nfet_01v8 ad=0.1218 pd=1.42 as=0.1218 ps=1.42 w=0.42 l=0.28
X170 a_15607_1016# a_14545_n1416# vdd vdd sky130_fd_pr__pfet_01v8 ad=0.992 pd=7.02 as=0.528 ps=3.53 w=3.2 l=0.15
X171 a_7259_n604# a_7535_622# a_7307_1016# vss sky130_fd_pr__nfet_01v8_lvt ad=0.527 pd=4.02 as=0.2805 ps=2.03 w=1.7 l=0.15
X172 a_4919_n1556# a_4449_n1536# vdd vdd sky130_fd_pr__pfet_01v8 ad=0.4455 pd=3.03 as=0.4455 ps=3.03 w=2.7 l=0.15
X173 a_26447_n1316# a_15607_n1656# vdd vdd sky130_fd_pr__pfet_01v8 ad=0.2475 pd=1.83 as=0.2475 ps=1.83 w=1.5 l=0.15
X174 a_17598_n1520# a_16536_1016# vss vss sky130_fd_pr__nfet_01v8_lvt ad=0.348 pd=2.98 as=0.348 ps=2.98 w=1.2 l=0.15
X175 a_29696_464# a_28730_1016# vss vss sky130_fd_pr__nfet_01v8_lvt ad=0.203 pd=1.98 as=0.203 ps=1.98 w=0.7 l=0.15
X176 a_12650_1016# a_10251_1016# a_11430_364# vdd sky130_fd_pr__pfet_01v8 ad=0.33 pd=2.33 as=0.62 ps=4.62 w=2 l=0.15
X177 vdd a_4449_n1536# a_4919_n1556# vdd sky130_fd_pr__pfet_01v8 ad=0.4455 pd=3.03 as=0.4455 ps=3.03 w=2.7 l=0.15
X178 a_7259_n604# a_5513_n1556# vss vss sky130_fd_pr__nfet_01v8_lvt ad=0.231 pd=1.73 as=0.434 ps=3.42 w=1.4 l=0.15
X179 a_7307_1016# a_7535_622# a_7259_n604# vss sky130_fd_pr__nfet_01v8_lvt ad=0.2805 pd=2.03 as=0.527 ps=4.02 w=1.7 l=0.15
X180 a_5513_n1556# a_5513_1016# vdd vdd sky130_fd_pr__pfet_01v8 ad=0.464 pd=3.78 as=0.464 ps=3.78 w=1.6 l=0.2
X181 a_1653_1016# a_1653_n1476# vdd vdd sky130_fd_pr__pfet_01v8 ad=0.406 pd=3.38 as=0.406 ps=3.38 w=1.4 l=0.2
X182 a_22317_n1316# a_22317_1016# vss vss sky130_fd_pr__nfet_01v8 ad=0.1218 pd=1.42 as=0.1218 ps=1.42 w=0.42 l=0.28
X183 a_11382_n1376# a_11666_n998# a_11430_n604# vss sky130_fd_pr__nfet_01v8_lvt ad=0.522 pd=4.18 as=0.522 ps=4.18 w=1.8 l=0.15
X184 vdd a_3605_n1556# a_3979_n1426# vdd sky130_fd_pr__pfet_01v8 ad=0.33825 pd=2.38 as=0.33825 ps=2.38 w=2.05 l=0.15
X185 vdd a_28730_n1356# a_29990_n1456# vdd sky130_fd_pr__pfet_01v8 ad=0.682 pd=5.02 as=0.363 ps=2.53 w=2.2 l=0.15
X186 a_3979_n1426# a_3605_n1556# vdd vdd sky130_fd_pr__pfet_01v8 ad=0.33825 pd=2.38 as=0.6355 ps=4.72 w=2.05 l=0.15
X187 a_7625_1016# a_7625_n1396# vdd vdd sky130_fd_pr__pfet_01v8 ad=0.464 pd=3.78 as=0.464 ps=3.78 w=1.6 l=0.15
X188 a_5513_n1556# a_1653_n1476# vdd vdd sky130_fd_pr__pfet_01v8 ad=0.4455 pd=3.03 as=0.837 ps=6.02 w=2.7 l=0.15
X189 a_2483_1016# a_1653_1016# vss vss sky130_fd_pr__nfet_01v8_lvt ad=0.29 pd=2.58 as=0.29 ps=2.58 w=1 l=0.15
X190 a_7625_n1396# a_5513_n1556# a_7625_1016# vdd sky130_fd_pr__pfet_01v8 ad=0.348 pd=2.98 as=0.348 ps=2.98 w=1.2 l=0.15
X191 a_8591_n1536# a_7625_n1396# vss vss sky130_fd_pr__nfet_01v8_lvt ad=0.1595 pd=1.68 as=0.1595 ps=1.68 w=0.55 l=0.15
X192 a_25532_1016# a_24470_n1456# vdd vdd sky130_fd_pr__pfet_01v8 ad=0.396 pd=2.73 as=0.744 ps=5.42 w=2.4 l=0.15
X193 a_21484_n1520# a_21484_1016# vss vss sky130_fd_pr__nfet_01v8_lvt ad=0.1218 pd=1.42 as=0.1218 ps=1.42 w=0.42 l=0.15
X194 a_27013_n1516# a_458_n1256# a_26447_n1316# vdd sky130_fd_pr__pfet_01v8 ad=0.775 pd=5.62 as=0.4125 ps=2.83 w=2.5 l=0.15
X195 a_5513_1016# a_1653_1016# vdd vdd sky130_fd_pr__pfet_01v8 ad=0.4455 pd=3.03 as=0.4455 ps=3.03 w=2.7 l=0.15
X196 a_13712_n1576# a_13712_1016# vdd vdd sky130_fd_pr__pfet_01v8 ad=0.5104 pd=4.1 as=0.5104 ps=4.1 w=1.76 l=0.15
X197 fb250_b fb250 vdd vdd sky130_fd_pr__pfet_01v8 ad=0.348 pd=2.98 as=0.348 ps=2.98 w=1.2 l=0.15
X198 a_7535_n716# a_8591_n1536# vss vss sky130_fd_pr__nfet_01v8_lvt ad=0.198 pd=1.53 as=0.372 ps=3.02 w=1.2 l=0.15
X199 a_11666_n998# a_22317_1016# vdd vdd sky130_fd_pr__pfet_01v8 ad=0.6944 pd=5.1 as=0.3696 ps=2.57 w=2.24 l=0.15
X200 a_17598_1016# a_10251_n1496# a_18431_1016# vdd sky130_fd_pr__pfet_01v8 ad=0.465 pd=3.62 as=0.2475 ps=1.83 w=1.5 l=0.15
X201 a_13712_n1576# a_12650_1016# vss vss sky130_fd_pr__nfet_01v8_lvt ad=0.406 pd=3.38 as=0.406 ps=3.38 w=1.4 l=0.15
X202 a_18431_n1316# a_18431_1016# vdd vdd sky130_fd_pr__pfet_01v8 ad=0.1218 pd=1.42 as=0.1218 ps=1.42 w=0.42 l=0.28
X203 a_7535_622# a_7535_n716# vdd vdd sky130_fd_pr__pfet_01v8 ad=0.464 pd=3.78 as=0.464 ps=3.78 w=1.6 l=0.15
X204 a_22317_n1316# rst_n vdd vdd sky130_fd_pr__pfet_01v8 ad=0.464 pd=3.78 as=0.464 ps=3.78 w=1.6 l=0.18
X205 a_11292_n998# a_11292_622# vss vss sky130_fd_pr__nfet_01v8_lvt ad=0.1218 pd=1.42 as=0.1218 ps=1.42 w=0.42 l=0.15
X206 vss a_29696_n1576# a_29990_344# vss sky130_fd_pr__nfet_01v8_lvt ad=0.403 pd=3.22 as=0.2145 ps=1.63 w=1.3 l=0.15
X207 vdd a_7625_1016# a_7535_n716# vdd sky130_fd_pr__pfet_01v8 ad=0.396 pd=2.73 as=0.396 ps=2.73 w=2.4 l=0.15
X208 a_14545_1016# a_10251_1016# a_13712_1016# vss sky130_fd_pr__nfet_01v8_lvt ad=0.464 pd=3.78 as=0.464 ps=3.78 w=1.6 l=0.15
X209 a_16536_1016# a_16536_n1316# vdd vdd sky130_fd_pr__pfet_01v8 ad=0.1218 pd=1.42 as=0.1218 ps=1.42 w=0.42 l=0.28
X210 a_6439_1016# a_5513_1016# vdd vdd sky130_fd_pr__pfet_01v8 ad=0.33 pd=2.33 as=0.33 ps=2.33 w=2 l=0.15
X211 a_26543_n604# a_15607_n1656# vss vss sky130_fd_pr__nfet_01v8_lvt ad=0.2475 pd=1.83 as=0.465 ps=3.62 w=1.5 l=0.15
X212 vdd a_18431_1016# a_11292_n998# vdd sky130_fd_pr__pfet_01v8 ad=0.3696 pd=2.57 as=0.3696 ps=2.57 w=2.24 l=0.15
X213 a_14545_1016# a_10251_n1496# a_13712_1016# vdd sky130_fd_pr__pfet_01v8 ad=0.33 pd=2.33 as=0.62 ps=4.62 w=2 l=0.15
X214 a_21484_n1520# a_20422_1016# vss vss sky130_fd_pr__nfet_01v8_lvt ad=0.348 pd=2.98 as=0.348 ps=2.98 w=1.2 l=0.15
X215 a_1653_n1476# a_859_n1456# vdd vdd sky130_fd_pr__pfet_01v8 ad=0.3795 pd=2.63 as=0.713 ps=5.22 w=2.3 l=0.15
X216 a_11382_1016# a_11666_622# a_11430_364# vdd sky130_fd_pr__pfet_01v8 ad=0.744 pd=5.42 as=0.396 ps=2.73 w=2.4 l=0.15
X217 a_11292_n998# a_18431_1016# vss vss sky130_fd_pr__nfet_01v8_lvt ad=0.464 pd=3.78 as=0.464 ps=3.78 w=1.6 l=0.15
X218 vdd a_15607_n1656# a_26447_n1316# vdd sky130_fd_pr__pfet_01v8 ad=0.465 pd=3.62 as=0.2475 ps=1.83 w=1.5 l=0.15
X219 a_11382_n1376# a_458_n1256# a_11756_n1616# vdd sky130_fd_pr__pfet_01v8 ad=0.495 pd=3.33 as=0.93 ps=6.62 w=3 l=0.15
X220 a_22317_n1316# a_10251_n1496# a_21484_n1520# vdd sky130_fd_pr__pfet_01v8 ad=0.2475 pd=1.83 as=0.465 ps=3.62 w=1.5 l=0.15
X221 a_4449_n1536# a_3979_n1426# vss vss sky130_fd_pr__nfet_01v8_lvt ad=0.165 pd=1.33 as=0.31 ps=2.62 w=1 l=0.15
X222 a_29990_n1456# a_29696_464# vss vss sky130_fd_pr__nfet_01v8_lvt ad=0.2145 pd=1.63 as=0.403 ps=3.22 w=1.3 l=0.15
X223 a_10251_n1496# a_7535_n716# vss vss sky130_fd_pr__nfet_01v8_lvt ad=0.198 pd=1.53 as=0.372 ps=3.02 w=1.2 l=0.15
X224 a_15607_n1656# a_14545_1016# vdd vdd sky130_fd_pr__pfet_01v8 ad=0.992 pd=7.02 as=0.528 ps=3.53 w=3.2 l=0.15
X225 a_26543_n604# a_458_n1256# a_26447_n1316# vss sky130_fd_pr__nfet_01v8_lvt ad=0.465 pd=3.62 as=0.2475 ps=1.83 w=1.5 l=0.15
X226 a_5513_1016# a_5513_n1556# vdd vdd sky130_fd_pr__pfet_01v8 ad=0.464 pd=3.78 as=0.464 ps=3.78 w=1.6 l=0.2
X227 a_11756_n1616# a_458_n1256# a_11382_n1376# vdd sky130_fd_pr__pfet_01v8 ad=0.93 pd=6.62 as=0.495 ps=3.33 w=3 l=0.15
X228 vdd a_12650_n1416# a_13712_1016# vdd sky130_fd_pr__pfet_01v8 ad=0.868 pd=6.22 as=0.462 ps=3.13 w=2.8 l=0.15
X229 a_7625_1016# a_5513_n1556# a_7625_n1396# vdd sky130_fd_pr__pfet_01v8 ad=0.348 pd=2.98 as=0.348 ps=2.98 w=1.2 l=0.15
X230 a_3979_n1426# a_3605_n1556# vdd vdd sky130_fd_pr__pfet_01v8 ad=0.6355 pd=4.72 as=0.33825 ps=2.38 w=2.05 l=0.15
X231 a_24470_n1456# a_10251_n1496# a_15607_n1656# vss sky130_fd_pr__nfet_01v8_lvt ad=0.522 pd=4.18 as=0.522 ps=4.18 w=1.8 l=0.15
X232 a_11666_622# a_11666_n998# vss vss sky130_fd_pr__nfet_01v8_lvt ad=0.1218 pd=1.42 as=0.1218 ps=1.42 w=0.42 l=0.15
X233 a_11382_n1376# a_10251_1016# a_12650_n1416# vdd sky130_fd_pr__pfet_01v8 ad=0.62 pd=4.62 as=0.33 ps=2.33 w=2 l=0.15
X234 a_21484_1016# a_10251_n1496# a_22317_1016# vdd sky130_fd_pr__pfet_01v8 ad=0.465 pd=3.62 as=0.2475 ps=1.83 w=1.5 l=0.15
X235 a_12650_1016# a_10251_n1496# a_11430_364# vss sky130_fd_pr__nfet_01v8_lvt ad=0.464 pd=3.78 as=0.464 ps=3.78 w=1.6 l=0.15
X236 a_15607_n1656# a_14545_1016# vss vss sky130_fd_pr__nfet_01v8_lvt ad=0.696 pd=5.38 as=0.696 ps=5.38 w=2.4 l=0.15
X237 vss a_24470_n1456# a_25532_1016# vss sky130_fd_pr__nfet_01v8_lvt ad=0.372 pd=3.02 as=0.198 ps=1.53 w=1.2 l=0.15
X238 a_859_n1456# a_859_1016# vss vss sky130_fd_pr__nfet_01v8 ad=0.1218 pd=1.42 as=0.1218 ps=1.42 w=0.42 l=0.28
X239 vdd a_28730_1016# a_29990_344# vdd sky130_fd_pr__pfet_01v8 ad=0.682 pd=5.02 as=0.363 ps=2.53 w=2.2 l=0.15
X240 a_20422_1016# a_20422_n1316# vdd vdd sky130_fd_pr__pfet_01v8 ad=0.1218 pd=1.42 as=0.1218 ps=1.42 w=0.42 l=0.28
X241 a_17598_1016# a_16536_n1316# vss vss sky130_fd_pr__nfet_01v8_lvt ad=0.348 pd=2.98 as=0.348 ps=2.98 w=1.2 l=0.15
X242 a_25532_1016# a_24470_n1456# vss vss sky130_fd_pr__nfet_01v8_lvt ad=0.198 pd=1.53 as=0.372 ps=3.02 w=1.2 l=0.15
X243 vdd a_29990_344# fb250_b vdd sky130_fd_pr__pfet_01v8 ad=0.3465 pd=2.43 as=0.3465 ps=2.43 w=2.1 l=0.15
X244 a_12650_1016# a_12650_n1416# vss vss sky130_fd_pr__nfet_01v8 ad=0.1218 pd=1.42 as=0.1218 ps=1.42 w=0.42 l=0.28
X245 fb250_b a_29990_344# vdd vdd sky130_fd_pr__pfet_01v8 ad=0.3465 pd=2.43 as=0.651 ps=4.82 w=2.1 l=0.15
X246 a_22317_n1316# a_22317_1016# vdd vdd sky130_fd_pr__pfet_01v8 ad=0.1218 pd=1.42 as=0.1218 ps=1.42 w=0.42 l=0.28
X247 a_28364_n604# a_26447_n1316# a_28412_1016# vss sky130_fd_pr__nfet_01v8_lvt ad=0.496 pd=3.82 as=0.264 ps=1.93 w=1.6 l=0.15
X248 a_26447_1016# a_25532_1016# a_26543_404# vdd sky130_fd_pr__pfet_01v8 ad=0.33 pd=2.33 as=0.33 ps=2.33 w=2 l=0.15
X249 a_11666_n998# a_22317_1016# vss vss sky130_fd_pr__nfet_01v8_lvt ad=0.464 pd=3.78 as=0.464 ps=3.78 w=1.6 l=0.15
X250 a_11292_622# a_18431_n1316# vss vss sky130_fd_pr__nfet_01v8_lvt ad=0.464 pd=3.78 as=0.464 ps=3.78 w=1.6 l=0.15
X251 a_11292_n998# a_18431_1016# vdd vdd sky130_fd_pr__pfet_01v8 ad=0.6944 pd=5.1 as=0.3696 ps=2.57 w=2.24 l=0.15
X252 a_18431_n1316# a_18431_1016# vss vss sky130_fd_pr__nfet_01v8 ad=0.1218 pd=1.42 as=0.1218 ps=1.42 w=0.42 l=0.28
X253 a_21484_1016# a_21484_n1520# vss vss sky130_fd_pr__nfet_01v8_lvt ad=0.1218 pd=1.42 as=0.1218 ps=1.42 w=0.42 l=0.15
X254 a_11292_622# a_18431_n1316# vdd vdd sky130_fd_pr__pfet_01v8 ad=0.6944 pd=5.1 as=0.3696 ps=2.57 w=2.24 l=0.15
X255 a_3979_n1426# a_3605_n1556# vss vss sky130_fd_pr__nfet_01v8_lvt ad=0.464 pd=3.78 as=0.464 ps=3.78 w=1.6 l=0.15
X256 fb250 a_29990_n1456# vdd vdd sky130_fd_pr__pfet_01v8 ad=0.3465 pd=2.43 as=0.651 ps=4.82 w=2.1 l=0.15
X257 a_18431_n1316# rst_n vdd vdd sky130_fd_pr__pfet_01v8 ad=0.464 pd=3.78 as=0.464 ps=3.78 w=1.6 l=0.18
X258 a_10251_1016# a_7535_622# vdd vdd sky130_fd_pr__pfet_01v8 ad=0.396 pd=2.73 as=0.396 ps=2.73 w=2.4 l=0.15
X259 vdd a_25532_n1496# a_27013_n1516# vdd sky130_fd_pr__pfet_01v8 ad=0.4125 pd=2.83 as=0.4125 ps=2.83 w=2.5 l=0.15
X260 a_7307_n1336# a_7535_n716# a_7259_n604# vss sky130_fd_pr__nfet_01v8_lvt ad=0.2805 pd=2.03 as=0.527 ps=4.02 w=1.7 l=0.15
X261 a_15607_1016# a_10251_1016# a_24470_1016# vdd sky130_fd_pr__pfet_01v8 ad=0.682 pd=5.02 as=0.363 ps=2.53 w=2.2 l=0.15
X262 a_15607_n1656# a_15607_1016# vss vss sky130_fd_pr__nfet_01v8_lvt ad=0.1218 pd=1.42 as=0.1218 ps=1.42 w=0.42 l=0.15
X263 a_17598_n1520# a_17598_1016# vss vss sky130_fd_pr__nfet_01v8_lvt ad=0.1218 pd=1.42 as=0.1218 ps=1.42 w=0.42 l=0.15
X264 a_11666_622# a_11666_n998# vdd vdd sky130_fd_pr__pfet_01v8 ad=0.5104 pd=4.1 as=0.5104 ps=4.1 w=1.76 l=0.15
X265 a_21484_n1520# a_10251_n1496# a_22317_n1316# vdd sky130_fd_pr__pfet_01v8 ad=0.465 pd=3.62 as=0.2475 ps=1.83 w=1.5 l=0.15
X266 a_14545_1016# a_14545_n1416# vdd vdd sky130_fd_pr__pfet_01v8 ad=0.1218 pd=1.42 as=0.1218 ps=1.42 w=0.42 l=0.28
X267 a_11382_n1376# a_11292_n998# vdd vdd sky130_fd_pr__pfet_01v8 ad=0.297 pd=2.13 as=0.558 ps=4.22 w=1.8 l=0.15
X268 a_28412_1016# a_28730_n1356# a_28730_1016# vss sky130_fd_pr__nfet_01v8_lvt ad=0.434 pd=3.42 as=0.231 ps=1.73 w=1.4 l=0.15
X269 a_2483_n1396# a_1653_n1476# vdd vdd sky130_fd_pr__pfet_01v8 ad=0.3135 pd=2.23 as=0.589 ps=4.42 w=1.9 l=0.15
X270 a_28730_1016# a_28730_n1356# a_28412_1016# vss sky130_fd_pr__nfet_01v8_lvt ad=0.231 pd=1.73 as=0.434 ps=3.42 w=1.4 l=0.15
X271 a_1653_1016# a_859_1016# vss vss sky130_fd_pr__nfet_01v8_lvt ad=0.522 pd=4.18 as=0.522 ps=4.18 w=1.8 l=0.15
X272 a_12650_n1416# a_12650_1016# vss vss sky130_fd_pr__nfet_01v8 ad=0.1218 pd=1.42 as=0.1218 ps=1.42 w=0.42 l=0.28
X273 a_22317_1016# a_22317_n1316# vdd vdd sky130_fd_pr__pfet_01v8 ad=0.1218 pd=1.42 as=0.1218 ps=1.42 w=0.42 l=0.28
X274 a_7535_622# a_7535_n716# vss vss sky130_fd_pr__nfet_01v8 ad=0.2175 pd=2.08 as=0.2175 ps=2.08 w=0.75 l=0.15
X275 a_28364_n604# a_26543_404# a_28412_n1316# vss sky130_fd_pr__nfet_01v8_lvt ad=0.496 pd=3.82 as=0.264 ps=1.93 w=1.6 l=0.15
X276 vdd a_7535_n716# a_10251_n1496# vdd sky130_fd_pr__pfet_01v8 ad=0.744 pd=5.42 as=0.396 ps=2.73 w=2.4 l=0.15
X277 a_18431_1016# a_18431_n1316# vss vss sky130_fd_pr__nfet_01v8 ad=0.1218 pd=1.42 as=0.1218 ps=1.42 w=0.42 l=0.28
X278 a_11382_n1376# a_458_n1256# a_11430_n604# vss sky130_fd_pr__nfet_01v8_lvt ad=0.522 pd=4.18 as=0.522 ps=4.18 w=1.8 l=0.15
X279 a_24470_1016# a_458_484# vss vss sky130_fd_pr__nfet_01v8 ad=0.261 pd=2.38 as=0.261 ps=2.38 w=0.9 l=0.18
X280 vdd a_1653_1016# a_5513_1016# vdd sky130_fd_pr__pfet_01v8 ad=0.4455 pd=3.03 as=0.4455 ps=3.03 w=2.7 l=0.15
X281 a_11666_622# a_22317_n1316# vdd vdd sky130_fd_pr__pfet_01v8 ad=0.6944 pd=5.1 as=0.3696 ps=2.57 w=2.24 l=0.15
X282 vss a_24470_1016# a_25532_n1496# vss sky130_fd_pr__nfet_01v8_lvt ad=0.372 pd=3.02 as=0.198 ps=1.53 w=1.2 l=0.15
X283 a_8591_494# a_7625_1016# vss vss sky130_fd_pr__nfet_01v8_lvt ad=0.1595 pd=1.68 as=0.1595 ps=1.68 w=0.55 l=0.15
X284 a_20422_1016# a_10251_1016# a_11292_622# vdd sky130_fd_pr__pfet_01v8 ad=0.2475 pd=1.83 as=0.465 ps=3.62 w=1.5 l=0.15
X285 a_18431_1016# a_10251_n1496# a_17598_1016# vdd sky130_fd_pr__pfet_01v8 ad=0.2475 pd=1.83 as=0.465 ps=3.62 w=1.5 l=0.15
X286 a_18431_1016# a_10251_1016# a_17598_1016# vss sky130_fd_pr__nfet_01v8_lvt ad=0.348 pd=2.98 as=0.348 ps=2.98 w=1.2 l=0.15
X287 a_7535_n716# a_7625_1016# vdd vdd sky130_fd_pr__pfet_01v8 ad=0.396 pd=2.73 as=0.744 ps=5.42 w=2.4 l=0.15
X288 vdd a_5513_n1556# a_7625_1016# vdd sky130_fd_pr__pfet_01v8 ad=0.589 pd=4.42 as=0.3135 ps=2.23 w=1.9 l=0.15
X289 vdd a_5513_1016# a_6439_1016# vdd sky130_fd_pr__pfet_01v8 ad=0.33 pd=2.33 as=0.33 ps=2.33 w=2 l=0.15
X290 a_29696_n1576# a_28730_n1356# vss vss sky130_fd_pr__nfet_01v8_lvt ad=0.203 pd=1.98 as=0.203 ps=1.98 w=0.7 l=0.15
X291 a_11756_n1616# a_11666_n998# vdd vdd sky130_fd_pr__pfet_01v8 ad=0.495 pd=3.33 as=0.93 ps=6.62 w=3 l=0.15
X292 a_28730_n1356# a_4919_n1556# a_28730_1016# vdd sky130_fd_pr__pfet_01v8 ad=0.319 pd=2.78 as=0.319 ps=2.78 w=1.1 l=0.15
X293 a_859_1016# clkp vdd vdd sky130_fd_pr__pfet_01v8_lvt ad=0.319 pd=2.49 as=0.638 ps=4.98 w=2.2 l=0.35
X294 a_27013_n1516# a_25532_n1496# vdd vdd sky130_fd_pr__pfet_01v8 ad=0.4125 pd=2.83 as=0.4125 ps=2.83 w=2.5 l=0.15
X295 vdd a_29990_n1456# fb250 vdd sky130_fd_pr__pfet_01v8 ad=0.3465 pd=2.43 as=0.3465 ps=2.43 w=2.1 l=0.15
X296 vss a_4919_n1556# a_28364_n604# vss sky130_fd_pr__nfet_01v8_lvt ad=0.403 pd=3.22 as=0.2145 ps=1.63 w=1.3 l=0.15
X297 a_20422_n1316# a_10251_1016# a_11292_n998# vdd sky130_fd_pr__pfet_01v8 ad=0.2475 pd=1.83 as=0.465 ps=3.62 w=1.5 l=0.15
X298 a_21484_n1520# a_20422_1016# vdd vdd sky130_fd_pr__pfet_01v8 ad=0.4158 pd=2.85 as=0.7812 ps=5.66 w=2.52 l=0.15
X299 vss a_5513_n1556# a_7259_n604# vss sky130_fd_pr__nfet_01v8_lvt ad=0.434 pd=3.42 as=0.231 ps=1.73 w=1.4 l=0.15
X300 a_11430_364# a_11666_622# a_11382_1016# vdd sky130_fd_pr__pfet_01v8 ad=0.396 pd=2.73 as=0.744 ps=5.42 w=2.4 l=0.15
X301 a_859_1016# clkp vss vss sky130_fd_pr__nfet_01v8_lvt ad=0.348 pd=2.98 as=0.348 ps=2.98 w=1.2 l=0.15
X302 a_18431_n1316# a_10251_n1496# a_17598_n1520# vdd sky130_fd_pr__pfet_01v8 ad=0.2475 pd=1.83 as=0.465 ps=3.62 w=1.5 l=0.15
X303 a_26543_404# a_25532_1016# a_26447_1016# vdd sky130_fd_pr__pfet_01v8 ad=0.33 pd=2.33 as=0.62 ps=4.62 w=2 l=0.15
X304 fb250_b fb250 vss vss sky130_fd_pr__nfet_01v8_lvt ad=0.1305 pd=1.48 as=0.1305 ps=1.48 w=0.45 l=0.15
X305 a_7625_n1396# a_7625_1016# vdd vdd sky130_fd_pr__pfet_01v8 ad=0.464 pd=3.78 as=0.464 ps=3.78 w=1.6 l=0.15
X306 a_7259_n604# a_5513_n1556# vss vss sky130_fd_pr__nfet_01v8_lvt ad=0.231 pd=1.73 as=0.434 ps=3.42 w=1.4 l=0.15
X307 vdd a_16536_n1316# a_17598_1016# vdd sky130_fd_pr__pfet_01v8 ad=0.7812 pd=5.66 as=0.4158 ps=2.85 w=2.52 l=0.15
X308 a_28730_n1356# a_4919_n1556# vdd vdd sky130_fd_pr__pfet_01v8 ad=0.2805 pd=2.03 as=0.527 ps=4.02 w=1.7 l=0.15
X309 a_7535_622# a_7625_n1396# vdd vdd sky130_fd_pr__pfet_01v8 ad=0.396 pd=2.73 as=0.744 ps=5.42 w=2.4 l=0.15
X310 a_16536_1016# a_10251_n1496# a_15607_1016# vss sky130_fd_pr__nfet_01v8_lvt ad=0.348 pd=2.98 as=0.348 ps=2.98 w=1.2 l=0.15
X311 a_7307_1016# a_5513_n1556# vdd vdd sky130_fd_pr__pfet_01v8 ad=0.464 pd=3.78 as=0.464 ps=3.78 w=1.6 l=0.15
X312 a_25532_n1496# a_25532_1016# vss vss sky130_fd_pr__nfet_01v8_lvt ad=0.1218 pd=1.42 as=0.1218 ps=1.42 w=0.42 l=0.15
X313 a_16536_1016# a_16536_n1316# vss vss sky130_fd_pr__nfet_01v8 ad=0.1218 pd=1.42 as=0.1218 ps=1.42 w=0.42 l=0.28
X314 a_26447_n1316# a_458_n1256# a_26543_n604# vss sky130_fd_pr__nfet_01v8_lvt ad=0.2475 pd=1.83 as=0.465 ps=3.62 w=1.5 l=0.15
X315 a_25532_1016# a_25532_n1496# vss vss sky130_fd_pr__nfet_01v8_lvt ad=0.1218 pd=1.42 as=0.1218 ps=1.42 w=0.42 l=0.15
X316 a_8591_494# a_7625_1016# vdd vdd sky130_fd_pr__pfet_01v8 ad=0.754 pd=5.78 as=0.754 ps=5.78 w=2.6 l=0.15
X317 a_17598_n1520# a_10251_n1496# a_18431_n1316# vdd sky130_fd_pr__pfet_01v8 ad=0.465 pd=3.62 as=0.2475 ps=1.83 w=1.5 l=0.15
X318 vdd a_4919_n1556# a_28730_n1356# vdd sky130_fd_pr__pfet_01v8 ad=0.527 pd=4.02 as=0.2805 ps=2.03 w=1.7 l=0.15
X319 a_13712_n1576# a_13712_1016# vss vss sky130_fd_pr__nfet_01v8_lvt ad=0.1218 pd=1.42 as=0.1218 ps=1.42 w=0.42 l=0.15
X320 a_21484_1016# a_21484_n1520# vdd vdd sky130_fd_pr__pfet_01v8 ad=0.5104 pd=4.1 as=0.5104 ps=4.1 w=1.76 l=0.15
X321 a_28412_n1316# a_28730_1016# a_28730_n1356# vss sky130_fd_pr__nfet_01v8_lvt ad=0.434 pd=3.42 as=0.231 ps=1.73 w=1.4 l=0.15
X322 vdd a_4449_n1536# a_4919_n1556# vdd sky130_fd_pr__pfet_01v8 ad=0.837 pd=6.02 as=0.4455 ps=3.03 w=2.7 l=0.15
X323 a_11430_364# a_11666_622# a_11716_244# vss sky130_fd_pr__nfet_01v8_lvt ad=0.522 pd=4.18 as=0.522 ps=4.18 w=1.8 l=0.15
X324 a_29990_n1456# a_28730_n1356# vdd vdd sky130_fd_pr__pfet_01v8 ad=0.363 pd=2.53 as=0.682 ps=5.02 w=2.2 l=0.15
X325 a_29990_344# a_458_484# vss vss sky130_fd_pr__nfet_01v8 ad=0.348 pd=2.98 as=0.348 ps=2.98 w=1.2 l=0.18
X326 a_22317_1016# a_10251_n1496# a_21484_1016# vdd sky130_fd_pr__pfet_01v8 ad=0.2475 pd=1.83 as=0.465 ps=3.62 w=1.5 l=0.15
X327 vdd a_24470_n1456# a_25532_1016# vdd sky130_fd_pr__pfet_01v8 ad=0.744 pd=5.42 as=0.396 ps=2.73 w=2.4 l=0.15
X328 a_25532_n1496# a_25532_1016# vdd vdd sky130_fd_pr__pfet_01v8 ad=0.5104 pd=4.1 as=0.5104 ps=4.1 w=1.76 l=0.15
X329 a_2483_n1396# a_1653_n1476# vss vss sky130_fd_pr__nfet_01v8_lvt ad=0.29 pd=2.58 as=0.29 ps=2.58 w=1 l=0.15
X330 a_21484_1016# a_20422_n1316# vss vss sky130_fd_pr__nfet_01v8_lvt ad=0.348 pd=2.98 as=0.348 ps=2.98 w=1.2 l=0.15
X331 a_28412_n1316# a_4919_n1556# vdd vdd sky130_fd_pr__pfet_01v8 ad=0.435 pd=3.58 as=0.435 ps=3.58 w=1.5 l=0.15
X332 a_11292_622# a_11292_n998# vdd vdd sky130_fd_pr__pfet_01v8 ad=0.5104 pd=4.1 as=0.5104 ps=4.1 w=1.76 l=0.15
X333 a_859_1016# a_859_n1456# vdd vdd sky130_fd_pr__pfet_01v8 ad=0.2436 pd=2.26 as=0.2436 ps=2.26 w=0.84 l=0.28
X334 a_14545_1016# a_14545_n1416# vss vss sky130_fd_pr__nfet_01v8 ad=0.1218 pd=1.42 as=0.1218 ps=1.42 w=0.42 l=0.28
X335 a_20422_n1316# a_20422_1016# vdd vdd sky130_fd_pr__pfet_01v8 ad=0.1218 pd=1.42 as=0.1218 ps=1.42 w=0.42 l=0.28
X336 a_2857_n1396# a_2483_n1396# vdd vdd sky130_fd_pr__pfet_01v8 ad=0.3135 pd=2.23 as=0.589 ps=4.42 w=1.9 l=0.15
X337 a_11716_244# mode_5g vss vss sky130_fd_pr__nfet_01v8_lvt ad=0.522 pd=4.18 as=0.522 ps=4.18 w=1.8 l=0.15
X338 a_29990_n1456# a_29990_344# vdd vdd sky130_fd_pr__pfet_01v8 ad=0.1885 pd=1.88 as=0.1885 ps=1.88 w=0.65 l=0.15
X339 vdd a_1653_n1476# a_5513_n1556# vdd sky130_fd_pr__pfet_01v8 ad=0.4455 pd=3.03 as=0.4455 ps=3.03 w=2.7 l=0.15
X340 vdd a_15607_1016# a_26447_1016# vdd sky130_fd_pr__pfet_01v8 ad=0.33 pd=2.33 as=0.33 ps=2.33 w=2 l=0.15
X341 a_11666_622# a_22317_n1316# vss vss sky130_fd_pr__nfet_01v8_lvt ad=0.464 pd=3.78 as=0.464 ps=3.78 w=1.6 l=0.15
X342 a_458_n1256# mode_5g vss vss sky130_fd_pr__nfet_01v8 ad=0.174 pd=1.78 as=0.174 ps=1.78 w=0.6 l=0.18
X343 a_16536_n1316# rst_n vdd vdd sky130_fd_pr__pfet_01v8 ad=0.464 pd=3.78 as=0.464 ps=3.78 w=1.6 l=0.18
X344 a_28730_1016# a_4919_n1556# a_28730_n1356# vdd sky130_fd_pr__pfet_01v8 ad=0.319 pd=2.78 as=0.319 ps=2.78 w=1.1 l=0.15
X345 vdd a_11666_n998# a_11756_n1616# vdd sky130_fd_pr__pfet_01v8 ad=0.93 pd=6.62 as=0.495 ps=3.33 w=3 l=0.15
X346 a_11430_364# a_11292_622# vss vss sky130_fd_pr__nfet_01v8_lvt ad=0.348 pd=2.98 as=0.348 ps=2.98 w=1.2 l=0.15
X347 vdd a_18431_n1316# a_11292_622# vdd sky130_fd_pr__pfet_01v8 ad=0.3696 pd=2.57 as=0.3696 ps=2.57 w=2.24 l=0.15
X348 a_24470_n1456# a_10251_1016# a_15607_n1656# vdd sky130_fd_pr__pfet_01v8 ad=0.363 pd=2.53 as=0.682 ps=5.02 w=2.2 l=0.15
X349 a_28412_1016# a_26447_n1316# a_28364_n604# vss sky130_fd_pr__nfet_01v8_lvt ad=0.264 pd=1.93 as=0.496 ps=3.82 w=1.6 l=0.15
X350 a_11382_1016# a_11292_622# vdd vdd sky130_fd_pr__pfet_01v8 ad=0.396 pd=2.73 as=0.744 ps=5.42 w=2.4 l=0.15
X351 vdd a_25532_n1496# a_27013_n1516# vdd sky130_fd_pr__pfet_01v8 ad=0.775 pd=5.62 as=0.4125 ps=2.83 w=2.5 l=0.15
X352 a_18431_1016# a_18431_n1316# vdd vdd sky130_fd_pr__pfet_01v8 ad=0.1218 pd=1.42 as=0.1218 ps=1.42 w=0.42 l=0.28
X353 a_29990_344# a_28730_1016# vdd vdd sky130_fd_pr__pfet_01v8 ad=0.363 pd=2.53 as=0.682 ps=5.02 w=2.2 l=0.15
X354 vdd a_20422_n1316# a_21484_1016# vdd sky130_fd_pr__pfet_01v8 ad=0.7812 pd=5.66 as=0.4158 ps=2.85 w=2.52 l=0.15
X355 vdd a_20422_1016# a_21484_n1520# vdd sky130_fd_pr__pfet_01v8 ad=0.7812 pd=5.66 as=0.4158 ps=2.85 w=2.52 l=0.15
X356 vdd a_7535_622# a_10251_1016# vdd sky130_fd_pr__pfet_01v8 ad=0.396 pd=2.73 as=0.396 ps=2.73 w=2.4 l=0.15
X357 a_1653_1016# a_859_1016# vdd vdd sky130_fd_pr__pfet_01v8 ad=0.3795 pd=2.63 as=0.713 ps=5.22 w=2.3 l=0.15
X358 a_15607_1016# a_14545_n1416# vss vss sky130_fd_pr__nfet_01v8_lvt ad=0.696 pd=5.38 as=0.696 ps=5.38 w=2.4 l=0.15
X359 vdd clkp a_859_1016# vdd sky130_fd_pr__pfet_01v8_lvt ad=0.638 pd=4.98 as=0.319 ps=2.49 w=2.2 l=0.35
X360 a_26543_404# mode_5g a_26447_1016# vdd sky130_fd_pr__pfet_01v8 ad=0.33 pd=2.33 as=0.33 ps=2.33 w=2 l=0.15
X361 vdd a_7625_n1396# a_7535_622# vdd sky130_fd_pr__pfet_01v8 ad=0.396 pd=2.73 as=0.396 ps=2.73 w=2.4 l=0.15
X362 a_10251_n1496# a_7535_n716# vdd vdd sky130_fd_pr__pfet_01v8 ad=0.396 pd=2.73 as=0.744 ps=5.42 w=2.4 l=0.15
X363 vdd a_1653_1016# a_2483_1016# vdd sky130_fd_pr__pfet_01v8 ad=0.589 pd=4.42 as=0.3135 ps=2.23 w=1.9 l=0.15
X364 a_25532_n1496# a_24470_1016# vdd vdd sky130_fd_pr__pfet_01v8 ad=0.396 pd=2.73 as=0.744 ps=5.42 w=2.4 l=0.15
X365 a_10251_n1496# a_10251_1016# vdd vdd sky130_fd_pr__pfet_01v8 ad=0.464 pd=3.78 as=0.464 ps=3.78 w=1.6 l=0.2
X366 a_17598_n1520# a_16536_1016# vdd vdd sky130_fd_pr__pfet_01v8 ad=0.4158 pd=2.85 as=0.7812 ps=5.66 w=2.52 l=0.15
X367 a_7625_n1396# a_5513_n1556# vdd vdd sky130_fd_pr__pfet_01v8 ad=0.3135 pd=2.23 as=0.589 ps=4.42 w=1.9 l=0.15
X368 a_7307_n1336# a_5513_n1556# vdd vdd sky130_fd_pr__pfet_01v8 ad=0.464 pd=3.78 as=0.464 ps=3.78 w=1.6 l=0.15
X369 a_12650_n1416# a_10251_n1496# a_11382_n1376# vss sky130_fd_pr__nfet_01v8_lvt ad=0.464 pd=3.78 as=0.464 ps=3.78 w=1.6 l=0.15
X370 vdd a_859_n1456# a_1653_n1476# vdd sky130_fd_pr__pfet_01v8 ad=0.3795 pd=2.63 as=0.3795 ps=2.63 w=2.3 l=0.15
X371 a_7307_1016# a_7625_n1396# a_7625_1016# vss sky130_fd_pr__nfet_01v8_lvt ad=0.434 pd=3.42 as=0.231 ps=1.73 w=1.4 l=0.15
X372 vdd a_24470_1016# a_25532_n1496# vdd sky130_fd_pr__pfet_01v8 ad=0.396 pd=2.73 as=0.396 ps=2.73 w=2.4 l=0.15
X373 a_859_n1456# clkn vdd vdd sky130_fd_pr__pfet_01v8_lvt ad=0.319 pd=2.49 as=0.638 ps=4.98 w=2.2 l=0.35
X374 vss a_4919_n1556# a_28364_n604# vss sky130_fd_pr__nfet_01v8_lvt ad=0.403 pd=3.22 as=0.2145 ps=1.63 w=1.3 l=0.15
X375 vdd a_14545_n1416# a_15607_1016# vdd sky130_fd_pr__pfet_01v8 ad=0.528 pd=3.53 as=0.528 ps=3.53 w=3.2 l=0.15
X376 a_12650_1016# a_12650_n1416# vdd vdd sky130_fd_pr__pfet_01v8 ad=0.1218 pd=1.42 as=0.1218 ps=1.42 w=0.42 l=0.28
X377 a_7535_n716# a_7535_622# vdd vdd sky130_fd_pr__pfet_01v8 ad=0.5365 pd=4.28 as=0.5365 ps=4.28 w=1.85 l=0.15
X378 a_28364_n604# a_4919_n1556# vss vss sky130_fd_pr__nfet_01v8_lvt ad=0.2145 pd=1.63 as=0.403 ps=3.22 w=1.3 l=0.15
X379 a_26447_n1316# a_458_n1256# a_27013_n1516# vdd sky130_fd_pr__pfet_01v8 ad=0.4125 pd=2.83 as=0.775 ps=5.62 w=2.5 l=0.15
X380 a_28412_n1316# a_26543_404# a_28364_n604# vss sky130_fd_pr__nfet_01v8_lvt ad=0.264 pd=1.93 as=0.496 ps=3.82 w=1.6 l=0.15
X381 a_10251_1016# a_10251_n1496# vss vss sky130_fd_pr__nfet_01v8 ad=0.1305 pd=1.48 as=0.1305 ps=1.48 w=0.45 l=0.2
X382 a_13712_1016# a_12650_n1416# vss vss sky130_fd_pr__nfet_01v8_lvt ad=0.406 pd=3.38 as=0.406 ps=3.38 w=1.4 l=0.15
X383 vdd a_2483_n1396# a_2857_n1396# vdd sky130_fd_pr__pfet_01v8 ad=0.589 pd=4.42 as=0.3135 ps=2.23 w=1.9 l=0.15
X384 a_5513_n1556# a_1653_n1476# vdd vdd sky130_fd_pr__pfet_01v8 ad=0.4455 pd=3.03 as=0.4455 ps=3.03 w=2.7 l=0.15
X385 vdd a_22317_n1316# a_11666_622# vdd sky130_fd_pr__pfet_01v8 ad=0.3696 pd=2.57 as=0.3696 ps=2.57 w=2.24 l=0.15
X386 a_25532_n1496# a_24470_1016# vss vss sky130_fd_pr__nfet_01v8_lvt ad=0.198 pd=1.53 as=0.372 ps=3.02 w=1.2 l=0.15
X387 a_3231_n1476# a_2857_n1396# vdd vdd sky130_fd_pr__pfet_01v8 ad=0.3795 pd=2.63 as=0.713 ps=5.22 w=2.3 l=0.15
X388 a_22317_1016# a_10251_1016# a_21484_1016# vss sky130_fd_pr__nfet_01v8_lvt ad=0.348 pd=2.98 as=0.348 ps=2.98 w=1.2 l=0.15
X389 a_14545_n1416# rst_n vdd vdd sky130_fd_pr__pfet_01v8 ad=0.464 pd=3.78 as=0.464 ps=3.78 w=1.6 l=0.18
X390 vss a_29990_344# fb250_b vss sky130_fd_pr__nfet_01v8_lvt ad=0.372 pd=3.02 as=0.198 ps=1.53 w=1.2 l=0.15
X391 a_22317_1016# a_22317_n1316# vss vss sky130_fd_pr__nfet_01v8 ad=0.1218 pd=1.42 as=0.1218 ps=1.42 w=0.42 l=0.28
X392 a_11292_n998# a_11292_622# vdd vdd sky130_fd_pr__pfet_01v8 ad=0.5104 pd=4.1 as=0.5104 ps=4.1 w=1.76 l=0.15
X393 a_7625_1016# a_5513_n1556# vdd vdd sky130_fd_pr__pfet_01v8 ad=0.3135 pd=2.23 as=0.589 ps=4.42 w=1.9 l=0.15
X394 vdd a_2857_n1396# a_3231_n1476# vdd sky130_fd_pr__pfet_01v8 ad=0.713 pd=5.22 as=0.3795 ps=2.63 w=2.3 l=0.15
X395 a_6439_1016# a_5513_1016# vdd vdd sky130_fd_pr__pfet_01v8 ad=0.33 pd=2.33 as=0.62 ps=4.62 w=2 l=0.15
X396 a_17598_1016# a_17598_n1520# vdd vdd sky130_fd_pr__pfet_01v8 ad=0.5104 pd=4.1 as=0.5104 ps=4.1 w=1.76 l=0.15
X397 a_15607_1016# a_15607_n1656# vdd vdd sky130_fd_pr__pfet_01v8 ad=0.5104 pd=4.1 as=0.5104 ps=4.1 w=1.76 l=0.15
X398 a_16536_n1316# a_16536_1016# vdd vdd sky130_fd_pr__pfet_01v8 ad=0.1218 pd=1.42 as=0.1218 ps=1.42 w=0.42 l=0.28
X399 a_20422_n1316# rst_n vdd vdd sky130_fd_pr__pfet_01v8 ad=0.464 pd=3.78 as=0.464 ps=3.78 w=1.6 l=0.18
X400 a_11430_364# a_10251_1016# a_12650_1016# vdd sky130_fd_pr__pfet_01v8 ad=0.62 pd=4.62 as=0.33 ps=2.33 w=2 l=0.15
X401 fb250 a_29990_n1456# vss vss sky130_fd_pr__nfet_01v8_lvt ad=0.198 pd=1.53 as=0.372 ps=3.02 w=1.2 l=0.15
X402 a_28364_n604# a_4919_n1556# vss vss sky130_fd_pr__nfet_01v8_lvt ad=0.2145 pd=1.63 as=0.403 ps=3.22 w=1.3 l=0.15
X403 fb250_b a_29990_344# vdd vdd sky130_fd_pr__pfet_01v8 ad=0.651 pd=4.82 as=0.3465 ps=2.43 w=2.1 l=0.15
X404 a_2857_n1396# a_2483_n1396# vss vss sky130_fd_pr__nfet_01v8_lvt ad=0.29 pd=2.58 as=0.29 ps=2.58 w=1 l=0.15
X405 a_26447_n1316# a_15607_n1656# vdd vdd sky130_fd_pr__pfet_01v8 ad=0.2475 pd=1.83 as=0.465 ps=3.62 w=1.5 l=0.15
X406 a_20422_1016# a_10251_n1496# a_11292_622# vss sky130_fd_pr__nfet_01v8_lvt ad=0.348 pd=2.98 as=0.348 ps=2.98 w=1.2 l=0.15
X407 a_20422_1016# a_20422_n1316# vss vss sky130_fd_pr__nfet_01v8 ad=0.1218 pd=1.42 as=0.1218 ps=1.42 w=0.42 l=0.28
X408 a_17598_1016# a_16536_n1316# vdd vdd sky130_fd_pr__pfet_01v8 ad=0.4158 pd=2.85 as=0.7812 ps=5.66 w=2.52 l=0.15
X409 vdd a_16536_1016# a_17598_n1520# vdd sky130_fd_pr__pfet_01v8 ad=0.7812 pd=5.66 as=0.4158 ps=2.85 w=2.52 l=0.15
X410 vss a_29990_n1456# fb250 vss sky130_fd_pr__nfet_01v8_lvt ad=0.372 pd=3.02 as=0.198 ps=1.53 w=1.2 l=0.15
X411 vdd a_5513_n1556# a_7625_n1396# vdd sky130_fd_pr__pfet_01v8 ad=0.589 pd=4.42 as=0.3135 ps=2.23 w=1.9 l=0.15
C0 a_11666_622# a_4919_n1556# 0.00198f
C1 vdd a_1653_1016# 2.40054f
C2 a_25532_1016# a_28364_n604# 0
C3 a_458_484# a_22317_n1316# 0.05587f
C4 fb250_b a_28730_1016# 0
C5 a_11666_n998# a_11430_n604# 0.04313f
C6 a_4919_n1556# a_26447_1016# 0
C7 a_26447_n1316# a_29990_344# 0
C8 a_11756_n1616# a_11292_n998# 0.03193f
C9 a_18431_1016# a_20422_n1316# 0
C10 rst_n a_26543_n604# 0.00155f
C11 a_458_n1256# a_21484_1016# 0
C12 vdd a_859_1016# 1.07036f
C13 a_8591_494# a_7259_n604# 0
C14 a_458_484# a_29990_n1456# 0.05881f
C15 a_17598_n1520# a_11292_622# 0.00349f
C16 mode_5g a_24470_n1456# 0.01211f
C17 a_28730_1016# fb250 0.00298f
C18 a_18431_n1316# rst_n 0.08068f
C19 a_7535_622# a_11430_n604# 0
C20 a_28730_1016# a_4919_n1556# 0.35563f
C21 a_5513_n1556# a_1653_1016# 0.01493f
C22 a_3605_n1556# a_4449_n1536# 0
C23 a_7625_n1396# a_458_n1256# 0.01979f
C24 vdd a_859_n1456# 1.07204f
C25 a_16536_n1316# rst_n 0.08119f
C26 vdd rst_n 11.6793f
C27 a_11666_n998# a_4919_n1556# 0.12367f
C28 a_14545_n1416# a_16536_n1316# 0
C29 rst_n a_21484_n1520# 0.02409f
C30 a_28364_n604# a_29990_344# 0
C31 vdd a_14545_n1416# 1.09566f
C32 a_18431_n1316# a_11666_622# 0.005f
C33 a_8591_494# a_7625_1016# 0.33638f
C34 a_29990_n1456# a_29696_464# 0.0652f
C35 a_7625_n1396# a_6439_1016# 0
C36 a_13712_n1576# a_12650_1016# 0.17932f
C37 vdd a_11666_622# 2.29536f
C38 a_16536_n1316# a_11666_622# 0.00578f
C39 a_11666_622# a_21484_n1520# 0.00186f
C40 vdd clkn 0.57999f
C41 a_24470_n1456# a_24470_1016# 0.84782f
C42 a_22317_1016# a_10251_n1496# 0.20786f
C43 a_11292_n998# a_11292_622# 0.6826f
C44 a_7535_622# a_4919_n1556# 0.03085f
C45 mode_5g a_7535_n716# 0.2163f
C46 a_4919_n1556# a_5513_1016# 0.00237f
C47 a_28730_1016# a_26543_n604# 0
C48 a_4919_n1556# a_15607_1016# 0.00178f
C49 a_7625_n1396# a_8591_n1536# 0.17629f
C50 vdd a_26447_1016# 0.98772f
C51 a_5513_n1556# rst_n 0.00481f
C52 a_28412_1016# a_28730_n1356# 0.1132f
C53 a_3231_n1476# a_3605_n1556# 0.15842f
C54 a_13712_n1576# mode_5g 0
C55 a_27017_304# a_28730_n1356# 0
C56 a_12650_1016# a_10251_n1496# 0.08269f
C57 a_458_484# a_22317_1016# 0.08212f
C58 a_29696_n1576# a_28730_n1356# 0.18041f
C59 a_13712_n1576# a_12650_n1416# 0.04182f
C60 a_21484_1016# a_20422_n1316# 0.12251f
C61 vdd a_28730_1016# 1.45123f
C62 a_15607_n1656# a_25532_n1496# 0.33731f
C63 a_18431_n1316# a_11666_n998# 0.00224f
C64 a_20422_1016# a_11292_622# 0.24013f
C65 a_10251_1016# a_24470_n1456# 0.34739f
C66 a_26543_404# a_24470_n1456# 0
C67 a_458_484# a_12650_1016# 0.0818f
C68 vdd a_11666_n998# 2.31977f
C69 a_16536_n1316# a_11666_n998# 0.00224f
C70 a_4919_n1556# a_14545_1016# 0.00883f
C71 a_11666_n998# a_21484_n1520# 0.01489f
C72 a_458_n1256# a_1653_1016# 0.00263f
C73 mode_5g a_10251_n1496# 0.02509f
C74 a_15607_1016# a_26543_n604# 0
C75 a_22317_n1316# a_21484_1016# 0.00434f
C76 a_28412_1016# a_27017_304# 0.0014f
C77 a_28412_1016# a_29696_n1576# 0
C78 a_8591_494# a_7307_n1336# 0
C79 a_10251_n1496# a_12650_n1416# 0.10796f
C80 a_10251_n1496# a_17598_1016# 0.161f
C81 a_18431_n1316# a_15607_1016# 0.00997f
C82 a_458_484# clkp 0.06892f
C83 a_25532_n1496# a_27017_304# 0
C84 a_1653_1016# a_6439_1016# 0.00151f
C85 a_458_n1256# a_859_1016# 0.00631f
C86 a_7535_622# vdd 2.31526f
C87 a_458_484# mode_5g 6.51563f
C88 vdd a_15607_1016# 2.97547f
C89 vdd a_5513_1016# 1.56679f
C90 a_21484_n1520# a_15607_1016# 0.00357f
C91 a_16536_n1316# a_15607_1016# 0.01045f
C92 a_458_484# a_12650_n1416# 0.05541f
C93 a_458_484# a_17598_1016# 0.02784f
C94 a_10251_1016# a_7535_n716# 0.0792f
C95 a_10251_n1496# a_24470_1016# 0.05614f
C96 a_859_n1456# a_458_n1256# 0.04928f
C97 rst_n a_458_n1256# 6.59093f
C98 a_14545_n1416# a_458_n1256# 0.00163f
C99 a_7259_n604# a_7535_n716# 0.16584f
C100 a_13712_n1576# a_10251_1016# 0.21872f
C101 mode_5g a_18431_1016# 0.00152f
C102 a_29696_464# a_28412_n1316# 0
C103 a_12650_1016# a_11382_1016# 0
C104 a_7535_622# a_5513_n1556# 0.20309f
C105 a_458_484# a_24470_1016# 0.08208f
C106 a_5513_n1556# a_5513_1016# 0.72105f
C107 a_11430_n604# a_4919_n1556# 0.0026f
C108 a_11666_622# a_458_n1256# 0.00144f
C109 vdd a_14545_1016# 0.9643f
C110 a_16536_n1316# a_14545_1016# 0
C111 a_18431_1016# a_17598_1016# 0.23915f
C112 a_458_n1256# clkn 0.09733f
C113 fb250_b fb250 0.63773f
C114 fb250_b a_4919_n1556# 0
C115 a_11716_244# a_11292_622# 0
C116 vdd a_11430_364# 0.55896f
C117 a_13712_1016# a_12650_1016# 0.03519f
C118 a_11382_n1376# a_11756_n1616# 0.30027f
C119 a_10251_1016# a_10251_n1496# 1.55218f
C120 a_7625_1016# a_7535_n716# 0.34041f
C121 a_25532_1016# a_15607_n1656# 0.03903f
C122 mode_5g a_11382_1016# 0.18579f
C123 rst_n a_8591_n1536# 0
C124 mode_5g a_16536_1016# 0.00152f
C125 a_22317_1016# a_21484_1016# 0.23915f
C126 a_7535_622# a_7307_1016# 0.1134f
C127 a_11382_1016# a_12650_n1416# 0
C128 a_7307_1016# a_5513_1016# 0.00269f
C129 a_4919_n1556# fb250 0
C130 a_16536_1016# a_17598_1016# 0.03497f
C131 a_28730_1016# a_458_n1256# 0
C132 a_458_484# a_10251_1016# 0.46867f
C133 a_458_484# a_26543_404# 0.1228f
C134 a_4449_n1536# a_1653_1016# 0
C135 a_25532_1016# a_28412_1016# 0
C136 mode_5g a_13712_1016# 0.00424f
C137 a_11666_n998# a_458_n1256# 2.80251f
C138 a_458_484# a_7259_n604# 0
C139 a_13712_1016# a_12650_n1416# 0.12951f
C140 a_25532_1016# a_27017_304# 0.05134f
C141 a_25532_1016# a_25532_n1496# 0.65384f
C142 a_28730_n1356# a_29990_344# 0.00888f
C143 rst_n a_20422_n1316# 0.08107f
C144 a_17598_n1520# a_10251_n1496# 0.30399f
C145 vdd a_11430_n604# 0.0064f
C146 a_7535_n716# a_11292_n998# 0.00345f
C147 a_15607_n1656# a_11292_622# 0.00839f
C148 a_10251_1016# a_18431_1016# 0.09443f
C149 a_29696_464# a_26543_404# 0.00146f
C150 fb250_b vdd 0.98615f
C151 a_458_484# a_2483_1016# 0
C152 a_7535_622# a_458_n1256# 0.21901f
C153 mode_5g a_21484_1016# 0.00358f
C154 a_11666_622# a_20422_n1316# 0.00908f
C155 a_458_n1256# a_5513_1016# 0
C156 a_458_n1256# a_15607_1016# 0
C157 a_4919_n1556# a_26543_n604# 0.01068f
C158 a_13712_n1576# a_11292_n998# 0.04059f
C159 vdd a_2857_n1396# 0.56225f
C160 a_26447_n1316# a_458_484# 0
C161 a_458_484# a_7625_1016# 0.00711f
C162 rst_n a_22317_n1316# 0.08068f
C163 a_458_484# a_17598_n1520# 0.00352f
C164 rst_n a_4449_n1536# 0.00138f
C165 a_28412_1016# a_29990_344# 0
C166 a_7307_n1336# a_7535_n716# 0.15364f
C167 a_3231_n1476# a_1653_1016# 0.00146f
C168 mode_5g a_7625_n1396# 0.00209f
C169 a_18431_n1316# a_4919_n1556# 0.0077f
C170 a_29696_n1576# a_29990_344# 0.06701f
C171 a_29990_n1456# rst_n 0.10523f
C172 vdd fb250 0.99964f
C173 a_11666_622# a_22317_n1316# 0.16791f
C174 a_6439_1016# a_5513_1016# 0.21277f
C175 a_10251_1016# a_11382_1016# 0.05743f
C176 a_10251_1016# a_16536_1016# 0.22648f
C177 rst_n a_27013_n1516# 0.00905f
C178 vdd a_4919_n1556# 11.6693f
C179 a_16536_n1316# a_4919_n1556# 0.0077f
C180 a_4919_n1556# a_21484_n1520# 0.01401f
C181 a_10251_n1496# a_11292_n998# 1.21782f
C182 a_458_484# a_28364_n604# 0
C183 a_26447_n1316# a_29696_464# 0
C184 a_7535_622# a_8591_n1536# 0.1091f
C185 a_458_n1256# a_14545_1016# 0.00754f
C186 a_17598_n1520# a_18431_1016# 0.00276f
C187 a_13712_1016# a_10251_1016# 0.62915f
C188 a_11666_n998# a_20422_n1316# 0.00464f
C189 a_458_484# a_11292_n998# 0.0027f
C190 a_3231_n1476# rst_n 0
C191 a_1653_n1476# a_3979_n1426# 0.06334f
C192 a_5513_n1556# a_4919_n1556# 0.06396f
C193 a_29696_464# a_28364_n604# 0
C194 vdd a_26543_n604# 0.00546f
C195 a_20422_1016# a_10251_n1496# 0.07393f
C196 a_17598_n1520# a_16536_1016# 0.1718f
C197 a_11666_n998# a_22317_n1316# 0.04417f
C198 a_10251_1016# a_21484_1016# 0.61316f
C199 a_29990_n1456# a_28730_1016# 0.00973f
C200 a_20422_n1316# a_15607_1016# 0.01054f
C201 a_28730_1016# a_27013_n1516# 0
C202 vdd a_18431_n1316# 1.05962f
C203 a_18431_1016# a_11292_n998# 0.21299f
C204 clkp a_1653_1016# 0.00902f
C205 rst_n a_22317_1016# 0.02364f
C206 a_458_484# a_20422_1016# 0.0812f
C207 vdd a_16536_n1316# 0.96852f
C208 mode_5g a_1653_1016# 0.2487f
C209 vdd a_21484_n1520# 1.02008f
C210 a_22317_n1316# a_15607_1016# 0.01524f
C211 a_11430_n604# a_458_n1256# 0.03614f
C212 a_11666_622# a_22317_1016# 0.03473f
C213 a_4449_n1536# a_5513_1016# 0
C214 a_7625_n1396# a_7259_n604# 0.00963f
C215 clkp a_859_1016# 0.19174f
C216 rst_n a_12650_1016# 0.02314f
C217 a_11716_244# a_7535_n716# 0
C218 a_14545_n1416# a_12650_1016# 0
C219 a_2483_n1396# a_3979_n1426# 0
C220 mode_5g a_859_1016# 0.0299f
C221 a_16536_1016# a_11292_n998# 0.00654f
C222 a_2857_n1396# a_458_n1256# 0.01187f
C223 a_20422_1016# a_18431_1016# 0
C224 a_15607_n1656# a_24470_n1456# 0.31845f
C225 a_11666_622# a_12650_1016# 0.00257f
C226 vdd a_5513_n1556# 3.32287f
C227 a_859_n1456# clkp 0.01579f
C228 rst_n clkp 0.01727f
C229 a_859_n1456# mode_5g 0.00608f
C230 a_13712_1016# a_11292_n998# 0.00492f
C231 mode_5g rst_n 0.42872f
C232 a_7625_n1396# a_7625_1016# 1.22388f
C233 mode_5g a_14545_n1416# 0.00754f
C234 a_458_n1256# a_4919_n1556# 0.52445f
C235 a_28412_n1316# rst_n 0.00204f
C236 rst_n a_12650_n1416# 0.0817f
C237 a_14545_n1416# a_12650_n1416# 0
C238 rst_n a_17598_1016# 0.00219f
C239 clkp clkn 0.00298f
C240 a_11666_n998# a_22317_1016# 0.21451f
C241 a_27017_304# a_24470_n1456# 0
C242 mode_5g a_11666_622# 2.82053f
C243 a_25532_n1496# a_24470_n1456# 0.03817f
C244 a_11716_244# a_10251_n1496# 0.01361f
C245 mode_5g clkn 0.01219f
C246 vdd a_7307_1016# 0.1836f
C247 a_11666_622# a_12650_n1416# 0.00531f
C248 a_11666_622# a_17598_1016# 0.00838f
C249 a_11382_n1376# a_7535_n716# 0
C250 a_21484_1016# a_11292_n998# 0
C251 mode_5g a_26447_1016# 0.24802f
C252 rst_n a_24470_1016# 0.02596f
C253 a_2483_n1396# a_1653_n1476# 0.18548f
C254 a_11666_n998# a_12650_1016# 0.00531f
C255 a_458_484# a_11716_244# 0
C256 a_4919_n1556# a_8591_n1536# 0.00442f
C257 a_11382_n1376# a_13712_n1576# 0
C258 a_13712_n1576# a_15607_n1656# 0
C259 a_458_n1256# a_26543_n604# 0.06321f
C260 a_1653_1016# a_7259_n604# 0
C261 a_22317_1016# a_15607_1016# 0.00926f
C262 mode_5g a_28730_1016# 0
C263 a_11666_622# a_24470_1016# 0.00777f
C264 a_28412_n1316# a_28730_1016# 0.09816f
C265 a_18431_n1316# a_458_n1256# 0.00161f
C266 a_5513_n1556# a_7307_1016# 0.13794f
C267 mode_5g a_11666_n998# 0
C268 a_20422_1016# a_21484_1016# 0.03497f
C269 vdd a_458_n1256# 3.80764f
C270 a_1653_1016# a_2483_1016# 0.15227f
C271 a_16536_n1316# a_458_n1256# 0.00161f
C272 a_7625_n1396# a_7307_n1336# 0.16874f
C273 a_15607_n1656# a_10251_n1496# 2.86231f
C274 a_458_n1256# a_21484_n1520# 0.00358f
C275 a_11666_n998# a_12650_n1416# 0.00269f
C276 a_11382_n1376# a_10251_n1496# 0.47462f
C277 rst_n a_10251_1016# 0.03898f
C278 a_11666_n998# a_17598_1016# 0
C279 a_14545_n1416# a_10251_1016# 0.08915f
C280 rst_n a_26543_404# 0.0015f
C281 a_4919_n1556# a_20422_n1316# 0.00773f
C282 a_2857_n1396# a_4449_n1536# 0
C283 a_458_484# a_28730_n1356# 0.01378f
C284 vdd a_6439_1016# 0.46291f
C285 rst_n a_7259_n604# 0
C286 fb250_b a_29990_n1456# 0.04421f
C287 a_7535_622# mode_5g 0.02496f
C288 a_458_484# a_15607_n1656# 0.00287f
C289 a_11666_622# a_10251_1016# 0.18935f
C290 mode_5g a_5513_1016# 0.04461f
C291 mode_5g a_15607_1016# 0.19141f
C292 a_11716_244# a_11382_1016# 0
C293 a_11666_n998# a_24470_1016# 0
C294 a_4919_n1556# a_22317_n1316# 0.00773f
C295 a_5513_n1556# a_458_n1256# 0.1761f
C296 a_12650_1016# a_14545_1016# 0
C297 a_25532_n1496# a_10251_n1496# 0
C298 a_17598_1016# a_15607_1016# 0.05071f
C299 a_4449_n1536# a_4919_n1556# 0.29099f
C300 vdd a_8591_n1536# 0.27594f
C301 a_859_n1456# a_2483_1016# 0
C302 a_26543_404# a_26447_1016# 0.85004f
C303 a_25532_1016# a_24470_n1456# 0.22331f
C304 a_29696_464# a_28730_n1356# 0.03425f
C305 a_29990_n1456# fb250 0.18699f
C306 a_458_484# a_28412_1016# 0.00179f
C307 a_29990_n1456# a_4919_n1556# 0
C308 a_7625_1016# rst_n 0.00101f
C309 a_12650_1016# a_11430_364# 0.28352f
C310 a_26447_n1316# rst_n 0.11377f
C311 a_13712_1016# a_11716_244# 0
C312 rst_n a_17598_n1520# 0.02409f
C313 a_4919_n1556# a_27013_n1516# 0.0149f
C314 a_458_484# a_27017_304# 0
C315 a_15607_n1656# a_18431_1016# 0.00997f
C316 a_458_484# a_25532_n1496# 0.00223f
C317 a_458_484# a_29696_n1576# 0.00254f
C318 a_5513_n1556# a_6439_1016# 0.00819f
C319 mode_5g a_14545_1016# 0.00154f
C320 a_2857_n1396# a_3231_n1476# 0.14934f
C321 a_28730_1016# a_26543_404# 0.10753f
C322 a_15607_1016# a_24470_1016# 0.31043f
C323 a_18431_n1316# a_20422_n1316# 0
C324 a_11666_622# a_17598_n1520# 0
C325 a_14545_1016# a_12650_n1416# 0
C326 a_11666_n998# a_10251_1016# 0.02114f
C327 a_5513_n1556# a_8591_n1536# 0
C328 vdd a_20422_n1316# 0.96881f
C329 a_21484_n1520# a_20422_n1316# 0.04152f
C330 mode_5g a_11430_364# 0.23709f
C331 a_29696_464# a_28412_1016# 0
C332 rst_n a_28364_n604# 0
C333 a_15607_n1656# a_16536_1016# 0.01123f
C334 a_11430_364# a_12650_n1416# 0.00238f
C335 a_3231_n1476# a_4919_n1556# 0.00107f
C336 a_11756_n1616# a_7535_n716# 0
C337 a_29696_464# a_29696_n1576# 0.47573f
C338 a_7307_1016# a_6439_1016# 0.00178f
C339 a_27013_n1516# a_26543_n604# 0.00201f
C340 rst_n a_11292_n998# 0.28047f
C341 a_7535_622# a_10251_1016# 0.2172f
C342 a_14545_n1416# a_11292_n998# 0.01277f
C343 vdd a_22317_n1316# 1.06008f
C344 a_11430_n604# a_12650_1016# 0
C345 a_22317_n1316# a_21484_n1520# 0.23835f
C346 vdd a_4449_n1536# 1.04617f
C347 a_13712_n1576# a_11756_n1616# 0
C348 a_10251_1016# a_15607_1016# 2.61846f
C349 a_26543_404# a_15607_1016# 0.07026f
C350 a_15607_n1656# a_13712_1016# 0
C351 a_26447_n1316# a_28730_1016# 0.02092f
C352 a_11382_n1376# a_13712_1016# 0
C353 a_8591_n1536# a_7307_1016# 0
C354 a_7535_622# a_7259_n604# 0.27074f
C355 vdd a_29990_n1456# 1.29869f
C356 a_11666_622# a_11292_n998# 0
C357 a_4919_n1556# a_22317_1016# 0.008f
C358 a_7259_n604# a_5513_1016# 0
C359 vdd a_27013_n1516# 0.8609f
C360 a_11666_n998# a_17598_n1520# 0.00838f
C361 rst_n a_7307_n1336# 0
C362 mode_5g a_11430_n604# 0
C363 a_11756_n1616# a_10251_n1496# 0.03852f
C364 a_25532_1016# a_10251_n1496# 0
C365 a_11430_n604# a_12650_n1416# 0
C366 rst_n a_20422_1016# 0.02247f
C367 a_15607_n1656# a_21484_1016# 0.00357f
C368 a_4919_n1556# a_12650_1016# 0.00714f
C369 a_28730_1016# a_28364_n604# 0.0048f
C370 a_7535_n716# a_11292_622# 0.0039f
C371 a_10251_1016# a_14545_1016# 0.10284f
C372 a_5513_n1556# a_4449_n1536# 0.00441f
C373 a_3605_n1556# a_3979_n1426# 0.17787f
C374 a_7535_622# a_7625_1016# 0.08367f
C375 a_7625_1016# a_5513_1016# 0
C376 a_17598_n1520# a_15607_1016# 0.00308f
C377 vdd a_3231_n1476# 0.60182f
C378 a_11666_622# a_20422_1016# 0.00323f
C379 a_13712_n1576# a_11292_622# 0.00492f
C380 a_458_484# a_25532_1016# 0.02938f
C381 a_458_n1256# a_8591_n1536# 0.00397f
C382 a_10251_1016# a_11430_364# 0.33208f
C383 mode_5g a_4919_n1556# 0.01301f
C384 a_11666_n998# a_11292_n998# 1.95369f
C385 a_28412_n1316# a_4919_n1556# 0.14155f
C386 a_8591_494# a_7535_n716# 0.04222f
C387 a_4919_n1556# a_12650_n1416# 0.00863f
C388 a_4919_n1556# a_17598_1016# 0.0023f
C389 a_458_484# a_1653_n1476# 0
C390 vdd a_22317_1016# 0.92877f
C391 a_10251_n1496# a_11292_622# 0.38596f
C392 a_22317_1016# a_21484_n1520# 0.00276f
C393 a_7535_622# a_11292_n998# 0.00388f
C394 a_458_n1256# a_20422_n1316# 0.00161f
C395 a_11292_n998# a_15607_1016# 0.00637f
C396 a_458_484# a_29990_344# 0.0971f
C397 a_4919_n1556# a_24470_1016# 0.01092f
C398 a_11666_n998# a_20422_1016# 0.00908f
C399 vdd a_12650_1016# 0.85196f
C400 a_458_484# a_11292_622# 0.25954f
C401 mode_5g a_26543_n604# 0
C402 a_11430_n604# a_10251_1016# 0.00602f
C403 a_3605_n1556# a_1653_n1476# 0.04692f
C404 a_28412_n1316# a_26543_n604# 0.00174f
C405 a_7535_622# a_7307_n1336# 0.06544f
C406 a_458_n1256# a_22317_n1316# 0.00161f
C407 a_458_n1256# a_4449_n1536# 0.03089f
C408 a_7307_n1336# a_5513_1016# 0.00153f
C409 mode_5g a_18431_n1316# 0
C410 vdd clkp 0.5796f
C411 a_29696_464# a_29990_344# 0.03088f
C412 vdd mode_5g 4.32153f
C413 mode_5g a_16536_n1316# 0
C414 a_18431_n1316# a_17598_1016# 0.00434f
C415 mode_5g a_21484_n1520# 0
C416 a_11292_n998# a_14545_1016# 0.01442f
C417 vdd a_28412_n1316# 0.17438f
C418 a_20422_1016# a_15607_1016# 0.00918f
C419 a_18431_1016# a_11292_622# 0.03595f
C420 a_458_n1256# a_27013_n1516# 0.2722f
C421 a_458_484# a_8591_494# 0
C422 vdd a_12650_n1416# 0.98183f
C423 a_11666_622# a_11716_244# 0.03346f
C424 vdd a_17598_1016# 1.00972f
C425 a_16536_n1316# a_17598_1016# 0.12251f
C426 a_4919_n1556# a_10251_1016# 0.02069f
C427 a_4919_n1556# a_26543_404# 0.14446f
C428 a_24470_1016# a_26543_n604# 0
C429 a_11430_364# a_11292_n998# 0
C430 a_4919_n1556# a_7259_n604# 0.00161f
C431 a_2483_n1396# a_3605_n1556# 0
C432 a_11382_1016# a_11292_622# 0.13253f
C433 a_16536_1016# a_11292_622# 0.00435f
C434 a_5513_n1556# mode_5g 0.02352f
C435 a_3231_n1476# a_458_n1256# 0.0149f
C436 rst_n a_28730_n1356# 0.03332f
C437 vdd a_24470_1016# 1.04646f
C438 a_11382_n1376# rst_n 0.01499f
C439 a_15607_n1656# rst_n 0.35488f
C440 a_14545_n1416# a_15607_n1656# 0.04099f
C441 a_26543_404# a_26543_n604# 0
C442 a_7625_1016# a_4919_n1556# 0.00729f
C443 a_13712_1016# a_11292_622# 0.04063f
C444 a_26447_n1316# a_4919_n1556# 0.34874f
C445 a_11666_n998# a_11716_244# 0
C446 a_4919_n1556# a_17598_n1520# 0.01342f
C447 a_15607_n1656# a_11666_622# 0.00567f
C448 a_11382_n1376# a_11666_622# 0
C449 a_458_n1256# a_22317_1016# 0
C450 a_11430_n604# a_11292_n998# 0.01874f
C451 a_18431_n1316# a_10251_1016# 0.07803f
C452 mode_5g a_7307_1016# 0.00469f
C453 a_28730_n1356# a_26447_1016# 0
C454 vdd a_10251_1016# 4.22357f
C455 vdd a_26543_404# 0.89547f
C456 a_16536_n1316# a_10251_1016# 0.35818f
C457 a_10251_1016# a_21484_n1520# 0.21047f
C458 a_25532_n1496# rst_n 0.02873f
C459 rst_n a_29696_n1576# 0.0084f
C460 a_10251_n1496# a_24470_n1456# 0.07072f
C461 a_7535_622# a_11716_244# 0
C462 a_21484_1016# a_11292_622# 0
C463 a_458_n1256# a_12650_1016# 0.00363f
C464 a_28364_n604# a_4919_n1556# 0.32157f
C465 vdd a_7259_n604# 0.01862f
C466 a_28730_1016# a_28730_n1356# 1.21055f
C467 a_1653_1016# a_3979_n1426# 0
C468 a_26447_n1316# a_26543_n604# 0.35808f
C469 a_458_484# a_24470_n1456# 0.05817f
C470 a_28412_1016# a_26447_1016# 0
C471 a_4919_n1556# a_11292_n998# 0.06402f
C472 a_11382_n1376# a_11666_n998# 0.15745f
C473 a_27017_304# a_26447_1016# 0.00105f
C474 a_15607_n1656# a_11666_n998# 0.55661f
C475 a_18431_n1316# a_17598_n1520# 0.23835f
C476 mode_5g a_458_n1256# 0.08701f
C477 vdd a_2483_1016# 0.23256f
C478 a_25532_n1496# a_26447_1016# 0
C479 a_28412_n1316# a_458_n1256# 0.00239f
C480 vdd a_7625_1016# 1.65636f
C481 a_458_n1256# a_12650_n1416# 0.00376f
C482 a_26447_n1316# vdd 1.06028f
C483 vdd a_17598_n1520# 1.01994f
C484 a_16536_n1316# a_17598_n1520# 0.04152f
C485 a_28412_1016# a_28730_1016# 0.16111f
C486 a_10251_n1496# a_7535_n716# 0.28874f
C487 a_458_n1256# a_17598_1016# 0
C488 a_5513_n1556# a_7259_n604# 0.32675f
C489 a_7307_n1336# a_4919_n1556# 0.00467f
C490 a_28364_n604# a_26543_n604# 0
C491 a_28730_1016# a_27017_304# 0
C492 mode_5g a_6439_1016# 0.01285f
C493 a_28730_1016# a_29696_n1576# 0.04888f
C494 a_8591_494# a_7625_n1396# 0.03448f
C495 rst_n a_3979_n1426# 0.00122f
C496 a_11382_n1376# a_7535_622# 0
C497 a_11716_244# a_11430_364# 0.15983f
C498 a_4919_n1556# a_20422_1016# 0.00681f
C499 a_13712_n1576# a_10251_n1496# 0.32719f
C500 a_3231_n1476# a_4449_n1536# 0
C501 a_15607_n1656# a_15607_1016# 0.68496f
C502 a_22317_1016# a_20422_n1316# 0
C503 a_458_484# a_7535_n716# 0.2332f
C504 a_458_n1256# a_24470_1016# 0.01211f
C505 mode_5g a_8591_n1536# 0
C506 vdd a_28364_n604# 0.01918f
C507 a_7307_1016# a_7259_n604# 0.31695f
C508 a_5513_n1556# a_7625_1016# 0.36233f
C509 a_1653_1016# a_1653_n1476# 0.70897f
C510 a_18431_n1316# a_11292_n998# 0.04583f
C511 a_458_484# a_13712_n1576# 0.00352f
C512 a_22317_1016# a_22317_n1316# 0.84645f
C513 vdd a_11292_n998# 2.22109f
C514 a_16536_n1316# a_11292_n998# 0.00614f
C515 a_21484_n1520# a_11292_n998# 0
C516 a_27017_304# a_15607_1016# 0
C517 rst_n a_11756_n1616# 0.00327f
C518 a_25532_n1496# a_15607_1016# 0.02558f
C519 a_25532_1016# rst_n 0
C520 a_859_1016# a_1653_n1476# 0.06682f
C521 a_15607_n1656# a_14545_1016# 0.23747f
C522 a_7625_1016# a_7307_1016# 0.16111f
C523 mode_5g a_20422_n1316# 0
C524 a_458_484# a_10251_n1496# 0.03469f
C525 vdd a_7307_n1336# 0.18104f
C526 a_458_n1256# a_10251_1016# 0.0154f
C527 a_458_n1256# a_26543_404# 0
C528 a_11382_n1376# a_11430_364# 0.00115f
C529 a_18431_n1316# a_20422_1016# 0
C530 a_859_n1456# a_1653_n1476# 0.19902f
C531 rst_n a_1653_n1476# 0.00261f
C532 a_458_n1256# a_7259_n604# 0.00118f
C533 vdd a_20422_1016# 0.83863f
C534 a_11382_1016# a_7535_n716# 0
C535 a_20422_1016# a_21484_n1520# 0.1718f
C536 a_2483_n1396# a_1653_1016# 0.00677f
C537 a_25532_1016# a_26447_1016# 0.2651f
C538 mode_5g a_22317_n1316# 0
C539 rst_n a_29990_344# 0.02509f
C540 a_1653_n1476# clkn 0.00993f
C541 a_10251_n1496# a_18431_1016# 0.20793f
C542 a_7259_n604# a_6439_1016# 0
C543 rst_n a_11292_622# 0
C544 a_14545_n1416# a_11292_622# 0.01442f
C545 a_5513_n1556# a_7307_n1336# 0.14547f
C546 a_2483_n1396# a_859_1016# 0
C547 a_5513_1016# a_3979_n1426# 0
C548 a_29990_n1456# a_28412_n1316# 0
C549 a_7625_1016# a_458_n1256# 0.00256f
C550 a_28412_n1316# a_27013_n1516# 0
C551 a_26447_n1316# a_458_n1256# 0.41265f
C552 a_458_n1256# a_17598_n1520# 0.00358f
C553 a_11666_n998# a_11756_n1616# 0.11588f
C554 a_11666_622# a_11292_622# 1.97688f
C555 a_458_484# a_18431_1016# 0.08213f
C556 a_458_484# a_29696_464# 0.00802f
C557 fb250_b a_28730_n1356# 0.00298f
C558 a_8591_n1536# a_7259_n604# 0
C559 a_11382_n1376# a_11430_n604# 0.23122f
C560 a_13712_n1576# a_13712_1016# 0.65682f
C561 a_11382_1016# a_10251_n1496# 0
C562 a_22317_n1316# a_24470_1016# 0
C563 a_16536_1016# a_10251_n1496# 0.07388f
C564 a_2483_n1396# rst_n 0
C565 a_7625_1016# a_6439_1016# 0
C566 a_8591_494# rst_n 0
C567 a_458_n1256# a_28364_n604# 0
C568 fb250 a_28730_n1356# 0
C569 a_10251_1016# a_20422_n1316# 0.35824f
C570 a_4919_n1556# a_28730_n1356# 0.39361f
C571 a_24470_1016# a_27013_n1516# 0
C572 a_458_484# a_11382_1016# 0.00429f
C573 a_458_484# a_16536_1016# 0.08131f
C574 a_13712_1016# a_10251_n1496# 0.17586f
C575 a_25532_1016# a_15607_1016# 0.33331f
C576 a_28730_1016# a_29990_344# 0.0773f
C577 a_7625_1016# a_8591_n1536# 0.04946f
C578 a_7625_n1396# a_7535_n716# 0.17684f
C579 a_15607_n1656# a_4919_n1556# 0.06484f
C580 a_11382_n1376# a_4919_n1556# 0.01583f
C581 a_458_n1256# a_11292_n998# 0.11243f
C582 fb250_b a_29696_n1576# 0
C583 vdd a_11716_244# 0.00497f
C584 a_22317_n1316# a_10251_1016# 0.07806f
C585 a_11666_n998# a_11292_622# 0.00163f
C586 a_458_484# a_13712_1016# 0.03017f
C587 mode_5g a_22317_1016# 0.00152f
C588 a_5513_1016# a_1653_n1476# 0.00839f
C589 a_10251_n1496# a_21484_1016# 0.16098f
C590 a_28412_1016# a_4919_n1556# 0.13548f
C591 a_7307_n1336# a_458_n1256# 0.00445f
C592 a_29990_n1456# a_26543_404# 0
C593 a_29696_n1576# fb250 0
C594 a_28730_n1356# a_26543_n604# 0
C595 a_29696_n1576# a_4919_n1556# 0
C596 a_4919_n1556# a_27017_304# 0.00395f
C597 a_25532_n1496# a_4919_n1556# 0.03066f
C598 a_7535_622# a_11292_622# 0.00389f
C599 mode_5g a_12650_1016# 0.00422f
C600 a_7625_n1396# a_10251_n1496# 0
C601 a_458_n1256# a_20422_1016# 0
C602 a_15607_1016# a_11292_622# 1.00136f
C603 a_15607_n1656# a_26543_n604# 0.04138f
C604 a_458_484# a_21484_1016# 0.02784f
C605 a_12650_1016# a_12650_n1416# 0.84575f
C606 a_22317_1016# a_24470_1016# 0
C607 a_18431_n1316# a_15607_n1656# 0.01465f
C608 vdd a_28730_n1356# 1.41172f
C609 mode_5g clkp 0.03454f
C610 a_458_484# a_7625_n1396# 0
C611 a_11382_n1376# vdd 0.70649f
C612 a_7307_n1336# a_8591_n1536# 0
C613 vdd a_15607_n1656# 2.86868f
C614 a_15607_n1656# a_16536_n1316# 0.2545f
C615 a_15607_n1656# a_21484_n1520# 0.05318f
C616 a_2857_n1396# a_3979_n1426# 0
C617 a_7535_622# a_8591_494# 0.08945f
C618 mode_5g a_12650_n1416# 0.00362f
C619 a_26447_n1316# a_29990_n1456# 0
C620 a_13712_1016# a_11382_1016# 0
C621 rst_n a_24470_n1456# 0.08197f
C622 a_26447_n1316# a_27013_n1516# 0.56099f
C623 mode_5g a_17598_1016# 0.00358f
C624 a_25532_n1496# a_26543_n604# 0.06392f
C625 a_20422_n1316# a_11292_n998# 0.24014f
C626 a_14545_1016# a_11292_622# 0.009f
C627 vdd a_28412_1016# 0.17507f
C628 a_11430_n604# a_11756_n1616# 0
C629 a_11666_622# a_24470_n1456# 0
C630 a_4919_n1556# a_3979_n1426# 0.01017f
C631 a_11430_364# a_11292_622# 0.09353f
C632 a_22317_1016# a_10251_1016# 0.09458f
C633 vdd a_27017_304# 0.00261f
C634 vdd a_29696_n1576# 0.28843f
C635 vdd a_25532_n1496# 1.79945f
C636 mode_5g a_24470_1016# 0.00438f
C637 a_29990_n1456# a_28364_n604# 0
C638 a_26447_1016# a_24470_n1456# 0
C639 a_12650_1016# a_10251_1016# 0.24123f
C640 a_20422_1016# a_20422_n1316# 0.84556f
C641 rst_n a_7535_n716# 0.01531f
C642 a_458_n1256# a_11716_244# 0
C643 a_4919_n1556# a_11756_n1616# 0.00775f
C644 a_25532_1016# a_4919_n1556# 0.00304f
C645 a_2857_n1396# a_1653_n1476# 0.04151f
C646 a_13712_n1576# rst_n 0.02647f
C647 a_11666_622# a_7535_n716# 0
C648 a_13712_n1576# a_14545_n1416# 0.2874f
C649 a_458_484# a_1653_1016# 0.00444f
C650 a_11666_n998# a_24470_n1456# 0.00708f
C651 a_22317_n1316# a_20422_1016# 0
C652 a_11430_n604# a_11292_622# 0
C653 mode_5g a_10251_1016# 0.134f
C654 mode_5g a_26543_404# 0.35315f
C655 fb250_b a_29990_344# 0.23056f
C656 a_28412_n1316# a_26543_404# 0.15049f
C657 a_10251_1016# a_12650_n1416# 0.37384f
C658 a_13712_n1576# a_11666_622# 0
C659 a_10251_1016# a_17598_1016# 0.61316f
C660 mode_5g a_7259_n604# 0.00128f
C661 vdd a_3979_n1426# 0.87183f
C662 a_4919_n1556# a_1653_n1476# 0.1518f
C663 a_458_484# a_859_1016# 0.02043f
C664 rst_n a_10251_n1496# 0.43337f
C665 a_14545_n1416# a_10251_n1496# 0.39831f
C666 a_3605_n1556# a_1653_1016# 0.00162f
C667 a_24470_n1456# a_15607_1016# 0.0466f
C668 fb250 a_29990_344# 0.03419f
C669 a_25532_1016# a_26543_n604# 0.00659f
C670 a_458_n1256# a_28730_n1356# 0
C671 a_4919_n1556# a_29990_344# 0
C672 mode_5g a_2483_1016# 0.0037f
C673 a_11666_622# a_10251_n1496# 0.10929f
C674 a_4919_n1556# a_11292_622# 0.00193f
C675 a_458_484# a_859_n1456# 0.00204f
C676 a_10251_1016# a_24470_1016# 0.21047f
C677 a_11382_n1376# a_458_n1256# 0.26319f
C678 a_15607_n1656# a_458_n1256# 0.18945f
C679 a_458_484# rst_n 0.11504f
C680 a_2483_n1396# a_2857_n1396# 0.1401f
C681 a_458_484# a_14545_n1416# 0.05936f
C682 a_11666_n998# a_7535_n716# 0
C683 a_26447_n1316# mode_5g 0
C684 mode_5g a_7625_1016# 0.02032f
C685 mode_5g a_17598_n1520# 0
C686 a_26447_n1316# a_28412_n1316# 0.07f
C687 a_5513_n1556# a_3979_n1426# 0
C688 vdd a_11756_n1616# 0.59542f
C689 vdd a_25532_1016# 1.63801f
C690 a_458_484# a_11666_622# 0.35917f
C691 a_17598_n1520# a_17598_1016# 0.65436f
C692 a_13712_n1576# a_11666_n998# 0.01059f
C693 a_12650_1016# a_11292_n998# 0.01004f
C694 a_7535_622# a_7535_n716# 1.56057f
C695 rst_n a_3605_n1556# 0
C696 a_8591_494# a_4919_n1556# 0.00227f
C697 a_29696_464# rst_n 0.0025f
C698 a_458_n1256# a_27017_304# 0
C699 a_7535_n716# a_5513_1016# 0.00321f
C700 rst_n a_18431_1016# 0.02381f
C701 a_25532_n1496# a_458_n1256# 0.21068f
C702 a_458_484# a_26447_1016# 0.00985f
C703 mode_5g a_28364_n604# 0
C704 a_28412_n1316# a_28364_n604# 0.30961f
C705 vdd a_1653_n1476# 2.26605f
C706 a_26447_n1316# a_24470_1016# 0
C707 a_11666_n998# a_10251_n1496# 0.21914f
C708 a_13712_n1576# a_15607_1016# 0
C709 mode_5g a_11292_n998# 0
C710 a_11666_622# a_18431_1016# 0.00212f
C711 a_18431_n1316# a_11292_622# 0.16668f
C712 a_458_484# a_28730_1016# 0.03165f
C713 vdd a_29990_344# 1.11199f
C714 a_11292_n998# a_12650_n1416# 0.01283f
C715 vdd a_11292_622# 2.27286f
C716 rst_n a_16536_1016# 0.02247f
C717 a_17598_1016# a_11292_n998# 0.00349f
C718 a_16536_n1316# a_11292_622# 0.00654f
C719 a_14545_n1416# a_16536_1016# 0
C720 a_21484_n1520# a_11292_622# 0
C721 a_458_484# a_11666_n998# 0.00269f
C722 a_7535_622# a_10251_n1496# 0.06115f
C723 a_5513_n1556# a_1653_n1476# 0.29869f
C724 a_15607_n1656# a_20422_n1316# 0.01474f
C725 a_10251_n1496# a_15607_1016# 0.54423f
C726 a_11666_622# a_11382_1016# 0.18584f
C727 a_11666_622# a_16536_1016# 0.00212f
C728 a_10251_1016# a_17598_n1520# 0.2105f
C729 a_13712_1016# rst_n 0.00219f
C730 a_26447_n1316# a_26543_404# 0.37618f
C731 a_13712_n1576# a_14545_1016# 0.00279f
C732 a_14545_n1416# a_13712_1016# 0.00437f
C733 a_11430_364# a_7535_n716# 0
C734 a_29696_464# a_28730_1016# 0.34085f
C735 mode_5g a_20422_1016# 0.00152f
C736 a_458_n1256# a_3979_n1426# 0.0221f
C737 a_7535_622# a_458_484# 0.03401f
C738 vdd a_2483_n1396# 0.55114f
C739 vdd a_8591_494# 0.26165f
C740 a_7625_1016# a_7259_n604# 0.00485f
C741 a_458_484# a_5513_1016# 0.0022f
C742 a_11666_n998# a_18431_1016# 0.005f
C743 a_458_484# a_15607_1016# 0.3309f
C744 a_15607_n1656# a_22317_n1316# 0.01485f
C745 a_13712_n1576# a_11430_364# 0
C746 a_13712_1016# a_11666_622# 0.01058f
C747 a_29990_n1456# a_28730_n1356# 0.07707f
C748 a_28730_n1356# a_27013_n1516# 0
C749 a_10251_n1496# a_14545_1016# 0.22598f
C750 a_28364_n604# a_26543_404# 0.16183f
C751 rst_n a_21484_1016# 0.00219f
C752 a_15607_n1656# a_27013_n1516# 0.00291f
C753 a_458_n1256# a_11756_n1616# 0.20223f
C754 a_4919_n1556# a_24470_n1456# 0.00929f
C755 a_11430_364# a_10251_n1496# 0.19389f
C756 a_25532_1016# a_458_n1256# 0
C757 a_10251_1016# a_11292_n998# 0.19497f
C758 a_11666_n998# a_16536_1016# 0.00578f
C759 a_18431_1016# a_15607_1016# 0.00918f
C760 a_8591_494# a_5513_n1556# 0
C761 a_11666_622# a_21484_1016# 0.01488f
C762 a_7625_n1396# rst_n 0.0072f
C763 a_11430_n604# a_7535_n716# 0
C764 a_458_484# a_14545_1016# 0.08296f
C765 a_29990_n1456# a_28412_1016# 0
C766 a_11716_244# a_12650_1016# 0
C767 a_29990_n1456# a_29696_n1576# 0.12333f
C768 a_458_484# a_11430_364# 0.00903f
C769 a_11666_n998# a_13712_1016# 0
C770 a_25532_n1496# a_27013_n1516# 0.16323f
C771 a_7535_622# a_11382_1016# 0
C772 a_458_n1256# a_1653_n1476# 0.2593f
C773 a_26447_n1316# a_28364_n604# 0.26605f
C774 a_16536_1016# a_15607_1016# 0.24887f
C775 a_8591_494# a_7307_1016# 0
C776 a_7307_n1336# a_7259_n604# 0.31695f
C777 a_10251_1016# a_20422_1016# 0.22648f
C778 a_24470_n1456# a_26543_n604# 0
C779 a_4919_n1556# a_7535_n716# 0.01234f
C780 mode_5g a_11716_244# 0.03745f
C781 a_17598_n1520# a_11292_n998# 0.02106f
C782 a_458_n1256# a_11292_622# 0
C783 a_11430_n604# a_10251_n1496# 0.01899f
C784 a_13712_1016# a_15607_1016# 0
C785 a_15607_n1656# a_22317_1016# 0.01525f
C786 a_11666_n998# a_21484_1016# 0.00186f
C787 a_11716_244# a_12650_n1416# 0
C788 a_859_1016# a_1653_1016# 0.19943f
C789 a_13712_n1576# a_4919_n1556# 0.01553f
C790 a_4449_n1536# a_3979_n1426# 0.21235f
C791 vdd a_24470_n1456# 1.17898f
C792 a_7625_1016# a_7307_n1336# 0.09816f
C793 a_16536_1016# a_14545_1016# 0
C794 a_11382_n1376# a_12650_1016# 0.00346f
C795 a_2483_n1396# a_458_n1256# 0.01011f
C796 a_859_n1456# a_1653_1016# 0.01055f
C797 a_458_484# fb250_b 0.00207f
C798 a_8591_494# a_458_n1256# 0
C799 rst_n a_1653_1016# 0
C800 a_21484_1016# a_15607_1016# 0.05322f
C801 a_11430_364# a_11382_1016# 0.4776f
C802 a_4919_n1556# a_10251_n1496# 0.06984f
C803 a_13712_1016# a_14545_1016# 0.2882f
C804 mode_5g a_28730_n1356# 0
C805 a_7535_622# a_7625_n1396# 0.29208f
C806 a_28412_n1316# a_28730_n1356# 0.16874f
C807 a_859_n1456# a_859_1016# 0.67408f
C808 a_7625_n1396# a_5513_1016# 0
C809 mode_5g a_15607_n1656# 0
C810 rst_n a_859_1016# 0.00437f
C811 a_11382_n1376# mode_5g 0
C812 a_1653_1016# clkn 0
C813 a_458_484# fb250 0.02161f
C814 a_13712_1016# a_11430_364# 0
C815 a_458_484# a_4919_n1556# 0.00594f
C816 vdd a_7535_n716# 2.1514f
C817 a_11382_n1376# a_12650_n1416# 0.28576f
C818 fb250_b a_29696_464# 0
C819 a_15607_n1656# a_17598_1016# 0.00307f
C820 a_2857_n1396# a_3605_n1556# 0
C821 a_3231_n1476# a_3979_n1426# 0
C822 a_25532_1016# a_27013_n1516# 0
C823 a_8591_494# a_8591_n1536# 0.46666f
C824 a_859_1016# clkn 0.01263f
C825 a_859_n1456# rst_n 0.04548f
C826 vdd a_13712_n1576# 1.06635f
C827 mode_5g a_28412_1016# 0.00251f
C828 a_11716_244# a_10251_1016# 0.00959f
C829 a_20422_n1316# a_11292_622# 0.00347f
C830 a_14545_n1416# rst_n 0.08154f
C831 a_20422_1016# a_11292_n998# 0.00411f
C832 a_4449_n1536# a_1653_n1476# 0.08227f
C833 mode_5g a_27017_304# 0.05653f
C834 mode_5g a_25532_n1496# 0.00155f
C835 a_3605_n1556# a_4919_n1556# 0.00331f
C836 a_29696_464# fb250 0
C837 a_28412_n1316# a_29696_n1576# 0
C838 a_15607_n1656# a_24470_1016# 0.04692f
C839 a_28412_n1316# a_25532_n1496# 0
C840 a_4919_n1556# a_18431_1016# 0.00751f
C841 a_29696_464# a_4919_n1556# 0
C842 a_18431_n1316# a_10251_n1496# 0.38091f
C843 a_859_n1456# clkn 0.19511f
C844 a_11666_622# rst_n 0
C845 a_14545_n1416# a_11666_622# 0.00902f
C846 a_5513_n1556# a_7535_n716# 0.12408f
C847 rst_n clkn 0.01126f
C848 vdd a_10251_n1496# 3.73871f
C849 a_21484_n1520# a_10251_n1496# 0.30399f
C850 a_16536_n1316# a_10251_n1496# 0.09802f
C851 a_29990_n1456# a_29990_344# 0.84652f
C852 a_458_484# a_18431_n1316# 0.05603f
C853 a_4919_n1556# a_16536_1016# 0.00648f
C854 a_28730_n1356# a_26543_404# 0.12304f
C855 a_458_484# vdd 11.5446f
C856 a_458_484# a_16536_n1316# 0.05474f
C857 a_25532_n1496# a_24470_1016# 0.26737f
C858 a_458_484# a_21484_n1520# 0.00352f
C859 a_7307_1016# a_7535_n716# 0.08147f
C860 a_3231_n1476# a_1653_n1476# 0.04299f
C861 a_15607_n1656# a_10251_1016# 0.3532f
C862 a_1653_1016# a_5513_1016# 0.27287f
C863 a_458_n1256# a_24470_n1456# 0.00551f
C864 a_15607_n1656# a_26543_404# 0
C865 a_11382_n1376# a_10251_1016# 0.16416f
C866 a_28730_1016# rst_n 0.01565f
C867 a_2483_n1396# a_4449_n1536# 0
C868 a_13712_1016# a_4919_n1556# 0.00244f
C869 a_11666_n998# rst_n 0.36199f
C870 a_14545_n1416# a_11666_n998# 0.00269f
C871 a_18431_n1316# a_18431_1016# 0.84645f
C872 vdd a_3605_n1556# 0.71528f
C873 a_12650_1016# a_11756_n1616# 0
C874 vdd a_18431_1016# 0.92892f
C875 vdd a_29696_464# 0.27185f
C876 a_28412_1016# a_26543_404# 0.08798f
C877 a_16536_n1316# a_18431_1016# 0
C878 a_11666_n998# a_11666_622# 0.66697f
C879 a_458_484# a_5513_n1556# 0.00281f
C880 a_25532_n1496# a_10251_1016# 0.00193f
C881 a_27017_304# a_26543_404# 0.18796f
C882 a_26447_n1316# a_28730_n1356# 0.05111f
C883 a_29696_n1576# a_26543_404# 0
C884 a_25532_n1496# a_26543_404# 0
C885 a_28730_1016# a_26447_1016# 0
C886 a_7535_622# rst_n 0.22838f
C887 rst_n a_15607_1016# 0
C888 a_4919_n1556# a_21484_1016# 0.00246f
C889 rst_n a_5513_1016# 0
C890 a_458_n1256# a_7535_n716# 0.02516f
C891 a_14545_n1416# a_15607_1016# 0.18982f
C892 a_26447_n1316# a_15607_n1656# 0.16363f
C893 a_15607_n1656# a_17598_n1520# 0.05065f
C894 a_18431_n1316# a_16536_1016# 0
C895 a_2483_n1396# a_3231_n1476# 0
C896 mode_5g a_25532_1016# 0.19037f
C897 a_7535_622# a_11666_622# 0
C898 vdd a_11382_1016# 0.68975f
C899 vdd a_16536_1016# 0.83863f
C900 a_11756_n1616# a_12650_n1416# 0
C901 a_16536_n1316# a_16536_1016# 0.84556f
C902 a_5513_n1556# a_3605_n1556# 0
C903 a_11666_622# a_15607_1016# 0.5728f
C904 a_13712_n1576# a_458_n1256# 0.00424f
C905 a_7625_n1396# a_4919_n1556# 0.01807f
C906 a_458_484# a_7307_1016# 0
C907 a_7535_n716# a_6439_1016# 0.0019f
C908 a_28364_n604# a_28730_n1356# 0.00919f
C909 a_26447_n1316# a_28412_1016# 0.11093f
C910 clkp a_1653_n1476# 0.00133f
C911 a_12650_1016# a_11292_622# 0.00906f
C912 a_26447_n1316# a_27017_304# 0
C913 mode_5g a_1653_n1476# 0.00601f
C914 a_26447_1016# a_15607_1016# 0.14131f
C915 vdd a_13712_1016# 1.05767f
C916 a_26447_n1316# a_25532_n1496# 0.20849f
C917 a_26447_n1316# a_29696_n1576# 0.0012f
C918 rst_n a_14545_1016# 0.02714f
C919 a_14545_n1416# a_14545_1016# 0.84769f
C920 a_8591_n1536# a_7535_n716# 0.08962f
C921 a_458_n1256# a_10251_n1496# 0.17177f
C922 a_25532_1016# a_24470_1016# 0.0293f
C923 a_15607_n1656# a_11292_n998# 1.0048f
C924 a_11382_n1376# a_11292_n998# 0.14474f
C925 a_11666_622# a_14545_1016# 0.00257f
C926 a_28412_1016# a_28364_n604# 0.30961f
C927 a_22317_n1316# a_24470_n1456# 0
C928 a_28412_n1316# a_29990_344# 0
C929 mode_5g a_11292_622# 0.11489f
C930 a_7535_622# a_11666_n998# 0
C931 vdd a_21484_1016# 1.01021f
C932 a_28364_n604# a_27017_304# 0
C933 a_25532_n1496# a_28364_n604# 0
C934 a_458_484# a_458_n1256# 0
C935 a_29696_n1576# a_28364_n604# 0
C936 a_12650_n1416# a_11292_622# 0.01004f
C937 a_11666_n998# a_15607_1016# 0.00508f
C938 a_21484_n1520# a_21484_1016# 0.65471f
C939 a_17598_1016# a_11292_622# 0.02104f
C940 a_11666_622# a_11430_364# 0.24182f
C941 a_2857_n1396# a_1653_1016# 0.0024f
C942 vdd a_7625_n1396# 1.609f
C943 a_10251_1016# a_11756_n1616# 0
C944 a_15607_n1656# a_20422_1016# 0.01054f
C945 a_458_484# a_6439_1016# 0
C946 a_25532_1016# a_10251_1016# 0.00215f
C947 a_25532_1016# a_26543_404# 0.32931f
C948 a_8591_494# mode_5g 0.00397f
C949 a_7535_622# a_5513_1016# 0
C950 a_2857_n1396# a_859_1016# 0
C951 a_4919_n1556# a_1653_1016# 0
C952 a_3605_n1556# a_458_n1256# 0.0165f
C953 a_458_n1256# a_18431_1016# 0
C954 rst_n a_11430_n604# 0
C955 a_11666_n998# a_14545_1016# 0.00902f
C956 a_458_484# a_8591_n1536# 0
C957 fb250_b rst_n 0.0189f
C958 a_859_n1456# a_2857_n1396# 0
C959 a_2857_n1396# rst_n 0
C960 a_5513_n1556# a_7625_n1396# 0.40246f
C961 a_11666_n998# a_11430_364# 0
C962 a_11666_622# a_11430_n604# 0
C963 a_10251_n1496# a_20422_n1316# 0.09802f
C964 a_7259_n604# a_1653_n1476# 0
C965 a_458_n1256# a_16536_1016# 0
C966 a_26447_n1316# a_25532_1016# 0.00132f
C967 a_26543_404# a_29990_344# 0
C968 a_14545_1016# a_15607_1016# 0.03258f
C969 rst_n fb250 0
C970 a_10251_1016# a_11292_622# 1.06233f
C971 a_22317_1016# a_24470_n1456# 0
C972 rst_n a_4919_n1556# 2.53555f
C973 a_14545_n1416# a_4919_n1556# 0.00863f
C974 a_458_484# a_20422_n1316# 0.05474f
C975 a_22317_n1316# a_10251_n1496# 0.38088f
C976 a_7535_622# a_11430_364# 0
C977 a_1653_n1476# a_2483_1016# 0
C978 a_13712_1016# a_458_n1256# 0
C979 a_7625_n1396# a_7307_1016# 0.1132f
C980 clkn vss 0.37699f
C981 fb250_b vss 1.11008f
C982 fb250 vss 1.25525f
C983 mode_5g vss 2.19705f
C984 rst_n vss 1.6885f
C985 clkp vss 0.37709f
C986 vdd vss 0.34498p
C987 a_28412_n1316# vss 0.29318f
C988 a_26543_n604# vss 0.63471f
C989 a_11382_n1376# vss 0.42504f
C990 a_11430_n604# vss 0.38049f
C991 a_7307_n1336# vss 0.30206f
C992 a_4449_n1536# vss 0.58975f
C993 a_3979_n1426# vss 0.57629f
C994 a_2483_n1396# vss 0.40987f
C995 a_2857_n1396# vss 0.42036f
C996 a_3231_n1476# vss 0.44107f
C997 a_3605_n1556# vss 0.48797f
C998 a_458_n1256# vss 1.17148f
C999 a_28364_n604# vss 0.79372f
C1000 a_29696_n1576# vss 0.70664f
C1001 a_26447_n1316# vss 0.8335f
C1002 a_27017_304# vss 0.41644f
C1003 a_29990_n1456# vss 1.30519f
C1004 a_29990_344# vss 1.47647f
C1005 a_29696_464# vss 0.64951f
C1006 a_28730_n1356# vss 0.99158f
C1007 a_28412_1016# vss 0.29802f
C1008 a_4919_n1556# vss 3.6244f
C1009 a_28730_1016# vss 0.99967f
C1010 a_11716_244# vss 0.31921f
C1011 a_26543_404# vss 0.98294f
C1012 a_25532_n1496# vss 1.37754f
C1013 a_25532_1016# vss 1.46051f
C1014 a_24470_1016# vss 1.48248f
C1015 a_24470_n1456# vss 1.26655f
C1016 a_7259_n604# vss 0.81641f
C1017 a_11666_n998# vss 1.20786f
C1018 a_22317_1016# vss 1.36095f
C1019 a_21484_n1520# vss 0.98623f
C1020 a_22317_n1316# vss 1.1511f
C1021 a_21484_1016# vss 0.88785f
C1022 a_20422_1016# vss 1.30702f
C1023 a_11292_n998# vss 1.39611f
C1024 a_18431_1016# vss 1.36091f
C1025 a_17598_n1520# vss 0.98569f
C1026 a_18431_n1316# vss 1.15015f
C1027 a_17598_1016# vss 0.88735f
C1028 a_16536_1016# vss 1.30858f
C1029 a_15607_n1656# vss 1.90801f
C1030 a_20422_n1316# vss 1.10491f
C1031 a_16536_n1316# vss 1.1059f
C1032 a_15607_1016# vss 1.81001f
C1033 a_14545_1016# vss 1.38427f
C1034 a_13712_n1576# vss 1.00853f
C1035 a_13712_1016# vss 0.91157f
C1036 a_12650_1016# vss 1.325f
C1037 a_11430_364# vss 0.47876f
C1038 a_11666_622# vss 1.19123f
C1039 a_11292_622# vss 1.29251f
C1040 a_12650_n1416# vss 1.12221f
C1041 a_14545_n1416# vss 1.17569f
C1042 a_8591_n1536# vss 0.75611f
C1043 a_10251_n1496# vss 6.61347f
C1044 a_10251_1016# vss 6.14852f
C1045 a_7535_n716# vss 2.59601f
C1046 a_7535_622# vss 2.44949f
C1047 a_8591_494# vss 0.67665f
C1048 a_7625_n1396# vss 1.01951f
C1049 a_7307_1016# vss 0.30299f
C1050 a_7625_1016# vss 1.02622f
C1051 a_6439_1016# vss 0.20335f
C1052 a_5513_n1556# vss 2.36976f
C1053 a_5513_1016# vss 1.43266f
C1054 a_2483_1016# vss 0.17204f
C1055 a_1653_n1476# vss 2.08333f
C1056 a_859_n1456# vss 1.19732f
C1057 a_458_484# vss 2.70884f
C1058 a_859_1016# vss 1.2119f
C1059 a_1653_1016# vss 2.32734f
.ends
