* Exact flattened LVS reference netlist for pll_div_ab_5g_v2_pdk
* Source: analog/pll/divider/spice/pll_div_ab_5g_v2.spice (.subckt pll_div_ab_5g_v2)
.subckt pll_div_ab_5g_v2_pdk clkp clkn mode_5g rst_n fb250 fb250_b vdd vss
X1 t_rst rst_n vss vss sky130_fd_pr__nfet_01v8 w=0.6 l=0.18
X2 t_rst rst_n vdd vdd sky130_fd_pr__pfet_01v8 w=1.2 l=0.18
X3 t_mode_5g_b mode_5g vss vss sky130_fd_pr__nfet_01v8 w=0.6 l=0.18
X4 t_mode_5g_b mode_5g vdd vdd sky130_fd_pr__pfet_01v8 w=1.2 l=0.18
X5 t_Xin_s1n clkp vss vss sky130_fd_pr__nfet_01v8_lvt w=1.2 l=0.15
X6 t_Xin_s1n clkp vdd vdd sky130_fd_pr__pfet_01v8_lvt w=4.4 l=0.35
X7 t_Xin_s1p clkn vss vss sky130_fd_pr__nfet_01v8_lvt w=1.2 l=0.15
X8 t_Xin_s1p clkn vdd vdd sky130_fd_pr__pfet_01v8_lvt w=4.4 l=0.35
X9 t_Xin_s1p t_Xin_s1n vss vss sky130_fd_pr__nfet_01v8 w=0.42 l=0.28
X10 t_Xin_s1p t_Xin_s1n vdd vdd sky130_fd_pr__pfet_01v8 w=0.84 l=0.28
X11 t_Xin_s1n t_Xin_s1p vss vss sky130_fd_pr__nfet_01v8 w=0.42 l=0.28
X12 t_Xin_s1n t_Xin_s1p vdd vdd sky130_fd_pr__pfet_01v8 w=0.84 l=0.28
X13 t_Xin_s2p t_Xin_s1n vss vss sky130_fd_pr__nfet_01v8_lvt w=1.8 l=0.15
X14 t_Xin_s2p t_Xin_s1n vdd vdd sky130_fd_pr__pfet_01v8 w=6.9 l=0.15
X15 t_Xin_s2n t_Xin_s1p vss vss sky130_fd_pr__nfet_01v8_lvt w=1.8 l=0.15
X16 t_Xin_s2n t_Xin_s1p vdd vdd sky130_fd_pr__pfet_01v8 w=6.9 l=0.15
X17 t_Xin_s2p t_Xin_s2n vss vss sky130_fd_pr__nfet_01v8 w=0.42 l=0.2
X18 t_Xin_s2p t_Xin_s2n vdd vdd sky130_fd_pr__pfet_01v8 w=1.4 l=0.2
X19 t_Xin_s2n t_Xin_s2p vss vss sky130_fd_pr__nfet_01v8 w=0.42 l=0.2
X20 t_Xin_s2n t_Xin_s2p vdd vdd sky130_fd_pr__pfet_01v8 w=1.4 l=0.2
X21 t_ckn t_Xin_s2p vss vss sky130_fd_pr__nfet_01v8_lvt w=2.8 l=0.15
X22 t_ckn t_Xin_s2p vdd vdd sky130_fd_pr__pfet_01v8 w=10.8 l=0.15
X23 t_ckp t_Xin_s2n vss vss sky130_fd_pr__nfet_01v8_lvt w=2.8 l=0.15
X24 t_ckp t_Xin_s2n vdd vdd sky130_fd_pr__pfet_01v8 w=10.8 l=0.15
X25 t_ckp t_ckn vss vss sky130_fd_pr__nfet_01v8 w=0.45 l=0.2
X26 t_ckp t_ckn vdd vdd sky130_fd_pr__pfet_01v8 w=1.6 l=0.2
X27 t_ckn t_ckp vss vss sky130_fd_pr__nfet_01v8 w=0.45 l=0.2
X28 t_ckn t_ckp vdd vdd sky130_fd_pr__pfet_01v8 w=1.6 l=0.2
X29 t_Xin_ckn_dum_out t_ckn vss vss sky130_fd_pr__nfet_01v8_lvt w=3.2 l=0.15
X30 t_Xin_ckn_dum_out t_ckn vdd vdd sky130_fd_pr__pfet_01v8 w=8 l=0.15
X31 t_Xin_rt_a t_Xin_s2n vss vss sky130_fd_pr__nfet_01v8_lvt w=1 l=0.15
X32 t_Xin_rt_a t_Xin_s2n vdd vdd sky130_fd_pr__pfet_01v8 w=3.8 l=0.15
X33 t_Xin_rt_a_dum t_Xin_s2p vss vss sky130_fd_pr__nfet_01v8_lvt w=1 l=0.15
X34 t_Xin_rt_a_dum t_Xin_s2p vdd vdd sky130_fd_pr__pfet_01v8 w=3.8 l=0.15
X35 t_Xin_rt_b t_Xin_rt_a vss vss sky130_fd_pr__nfet_01v8_lvt w=1 l=0.15
X36 t_Xin_rt_b t_Xin_rt_a vdd vdd sky130_fd_pr__pfet_01v8 w=3.8 l=0.15
X37 t_Xin_rt_c t_Xin_rt_b vss vss sky130_fd_pr__nfet_01v8_lvt w=1.2 l=0.15
X38 t_Xin_rt_c t_Xin_rt_b vdd vdd sky130_fd_pr__pfet_01v8 w=4.6 l=0.15
X39 t_Xin_rt_d t_Xin_rt_c vss vss sky130_fd_pr__nfet_01v8_lvt w=1.4 l=0.15
X40 t_Xin_rt_d t_Xin_rt_c vdd vdd sky130_fd_pr__pfet_01v8 w=5.4 l=0.15
X41 t_Xin_rt_e t_Xin_rt_d vss vss sky130_fd_pr__nfet_01v8_lvt w=1.6 l=0.15
X42 t_Xin_rt_e t_Xin_rt_d vdd vdd sky130_fd_pr__pfet_01v8 w=6.15 l=0.15
X43 t_Xin_rt_f t_Xin_rt_e vss vss sky130_fd_pr__nfet_01v8_lvt w=2 l=0.15
X44 t_Xin_rt_f t_Xin_rt_e vdd vdd sky130_fd_pr__pfet_01v8 w=7.8 l=0.15
X45 t_ck_rt t_Xin_rt_f vss vss sky130_fd_pr__nfet_01v8_lvt w=2.8 l=0.15
X46 t_ck_rt t_Xin_rt_f vdd vdd sky130_fd_pr__pfet_01v8 w=10.8 l=0.15
X47 t_Xdiv2_tail t_ckp vss vss sky130_fd_pr__nfet_01v8_lvt w=5.6 l=0.15
X48 t_Xdiv2_n_sp t_h0n t_Xdiv2_tail vss sky130_fd_pr__nfet_01v8_lvt w=3.4 l=0.15
X49 t_Xdiv2_n_sn t_h0p t_Xdiv2_tail vss sky130_fd_pr__nfet_01v8_lvt w=3.4 l=0.15
X50 t_Xdiv2_sp t_Xdiv2_sn t_Xdiv2_n_sp vss sky130_fd_pr__nfet_01v8_lvt w=2.8 l=0.15
X51 t_Xdiv2_sn t_Xdiv2_sp t_Xdiv2_n_sn vss sky130_fd_pr__nfet_01v8_lvt w=2.8 l=0.15
X52 t_Xdiv2_sp t_Xdiv2_sn vdd vdd sky130_fd_pr__pfet_01v8 w=1.6 l=0.15
X53 t_Xdiv2_sn t_Xdiv2_sp vdd vdd sky130_fd_pr__pfet_01v8 w=1.6 l=0.15
X54 t_Xdiv2_sp t_ckp vdd vdd sky130_fd_pr__pfet_01v8 w=3.8 l=0.15
X55 t_Xdiv2_sn t_ckp vdd vdd sky130_fd_pr__pfet_01v8 w=3.8 l=0.15
X56 t_Xdiv2_sp t_ckp t_Xdiv2_sn vdd sky130_fd_pr__pfet_01v8 w=2.4 l=0.15
X57 t_Xdiv2_n_sp t_ckp vdd vdd sky130_fd_pr__pfet_01v8 w=1.6 l=0.15
X58 t_Xdiv2_n_sn t_ckp vdd vdd sky130_fd_pr__pfet_01v8 w=1.6 l=0.15
X59 t_Xdiv2_sb t_Xdiv2_sp vss vss sky130_fd_pr__nfet_01v8_lvt w=0.55 l=0.15
X60 t_Xdiv2_sb t_Xdiv2_sp vdd vdd sky130_fd_pr__pfet_01v8 w=2.6 l=0.15
X61 t_Xdiv2_rb t_Xdiv2_sn vss vss sky130_fd_pr__nfet_01v8_lvt w=0.55 l=0.15
X62 t_Xdiv2_rb t_Xdiv2_sn vdd vdd sky130_fd_pr__pfet_01v8 w=2.6 l=0.15
X63 t_h0p t_Xdiv2_sp vdd vdd sky130_fd_pr__pfet_01v8 w=9.6 l=0.15
X64 t_h0p t_Xdiv2_rb vss vss sky130_fd_pr__nfet_01v8_lvt w=2.4 l=0.15
X65 t_h0n t_Xdiv2_sn vdd vdd sky130_fd_pr__pfet_01v8 w=9.6 l=0.15
X66 t_h0n t_Xdiv2_sb vss vss sky130_fd_pr__nfet_01v8_lvt w=2.4 l=0.15
X67 t_h0p t_h0n vdd vdd sky130_fd_pr__pfet_01v8 w=1.85 l=0.15
X68 t_h0p t_h0n vss vss sky130_fd_pr__nfet_01v8 w=0.5 l=0.15
X69 t_h0n t_h0p vdd vdd sky130_fd_pr__pfet_01v8 w=1.6 l=0.15
X70 t_h0n t_h0p vss vss sky130_fd_pr__nfet_01v8 w=0.75 l=0.15
X71 t_h0p t_rst vss vss sky130_fd_pr__nfet_01v8 w=1.2 l=0.18
X72 t_h0n rst_n vdd vdd sky130_fd_pr__pfet_01v8 w=2.4 l=0.18
X73 t_ckh_p t_h0n vss vss sky130_fd_pr__nfet_01v8_lvt w=2.4 l=0.15
X74 t_ckh_p t_h0n vdd vdd sky130_fd_pr__pfet_01v8 w=9.6 l=0.15
X75 t_ckh_n t_h0p vss vss sky130_fd_pr__nfet_01v8_lvt w=2.4 l=0.15
X76 t_ckh_n t_h0p vdd vdd sky130_fd_pr__pfet_01v8 w=9.6 l=0.15
X77 t_ckh_p t_ckh_n vss vss sky130_fd_pr__nfet_01v8 w=0.45 l=0.2
X78 t_ckh_p t_ckh_n vdd vdd sky130_fd_pr__pfet_01v8 w=1.6 l=0.2
X79 t_ckh_n t_ckh_p vss vss sky130_fd_pr__nfet_01v8 w=0.45 l=0.2
X80 t_ckh_n t_ckh_p vdd vdd sky130_fd_pr__pfet_01v8 w=1.6 l=0.2
X81 t_d0p t_q1p vss vss sky130_fd_pr__nfet_01v8_lvt w=1.2 l=0.15
X82 t_d0p t_q2p t_Xfb_p_mid vss sky130_fd_pr__nfet_01v8_lvt w=1.8 l=0.15
X83 t_Xfb_p_mid mode_5g vss vss sky130_fd_pr__nfet_01v8_lvt w=1.8 l=0.15
X84 t_Xfb_p_p1 t_q1p vdd vdd sky130_fd_pr__pfet_01v8 w=4.8 l=0.15
X85 t_d0p t_q2p t_Xfb_p_p1 vdd sky130_fd_pr__pfet_01v8 w=4.8 l=0.15
X86 t_d0p mode_5g t_Xfb_p_p1 vdd sky130_fd_pr__pfet_01v8 w=4.8 l=0.15
X87 t_Xfb_n_n1 t_q1n vss vss sky130_fd_pr__nfet_01v8_lvt w=1.8 l=0.15
X88 t_d0n t_q2n t_Xfb_n_n1 vss sky130_fd_pr__nfet_01v8_lvt w=1.8 l=0.15
X89 t_d0n t_mode_5g_b t_Xfb_n_n1 vss sky130_fd_pr__nfet_01v8_lvt w=1.8 l=0.15
X90 t_d0n t_q1n vdd vdd sky130_fd_pr__pfet_01v8 w=3.6 l=0.15
X91 t_Xfb_n_p1 t_q2n vdd vdd sky130_fd_pr__pfet_01v8 w=6 l=0.15
X92 t_d0n t_mode_5g_b t_Xfb_n_p1 vdd sky130_fd_pr__pfet_01v8 w=6 l=0.15
X93 t_d0p t_ckh_n t_Xff0_Xm_int_p vss sky130_fd_pr__nfet_01v8_lvt w=1.6 l=0.15
X94 t_d0p t_ckh_p t_Xff0_Xm_int_p vdd sky130_fd_pr__pfet_01v8 w=4 l=0.15
X95 t_d0n t_ckh_n t_Xff0_Xm_int_n vss sky130_fd_pr__nfet_01v8_lvt w=1.6 l=0.15
X96 t_d0n t_ckh_p t_Xff0_Xm_int_n vdd sky130_fd_pr__pfet_01v8 w=4 l=0.15
X97 t_Xff0_Xm_int_p t_Xff0_Xm_int_n vdd vdd sky130_fd_pr__pfet_01v8 w=0.42 l=0.28
X98 t_Xff0_Xm_int_p t_Xff0_Xm_int_n vss vss sky130_fd_pr__nfet_01v8 w=0.42 l=0.28
X99 t_Xff0_Xm_int_n t_Xff0_Xm_int_p vdd vdd sky130_fd_pr__pfet_01v8 w=0.42 l=0.28
X100 t_Xff0_Xm_int_n t_Xff0_Xm_int_p vss vss sky130_fd_pr__nfet_01v8 w=0.42 l=0.28
X101 t_Xff0_Xm_int_p t_rst vss vss sky130_fd_pr__nfet_01v8 w=0.9 l=0.18
X102 t_Xff0_Xm_int_n rst_n vdd vdd sky130_fd_pr__pfet_01v8 w=1.6 l=0.18
X103 t_Xff0_mp t_Xff0_Xm_int_n vss vss sky130_fd_pr__nfet_01v8_lvt w=1.4 l=0.15
X104 t_Xff0_mp t_Xff0_Xm_int_n vdd vdd sky130_fd_pr__pfet_01v8 w=5.6 l=0.15
X105 t_Xff0_mn t_Xff0_Xm_int_p vss vss sky130_fd_pr__nfet_01v8_lvt w=1.4 l=0.15
X106 t_Xff0_mn t_Xff0_Xm_int_p vdd vdd sky130_fd_pr__pfet_01v8 w=5.6 l=0.15
X107 t_Xff0_mn t_Xff0_mp vss vss sky130_fd_pr__nfet_01v8_lvt w=0.42 l=0.15
X108 t_Xff0_mn t_Xff0_mp vdd vdd sky130_fd_pr__pfet_01v8 w=1.76 l=0.15
X109 t_Xff0_mp t_Xff0_mn vss vss sky130_fd_pr__nfet_01v8_lvt w=0.42 l=0.15
X110 t_Xff0_mp t_Xff0_mn vdd vdd sky130_fd_pr__pfet_01v8 w=1.76 l=0.15
X111 t_Xff0_mp t_ckh_p t_Xff0_Xs_int_p vss sky130_fd_pr__nfet_01v8_lvt w=1.6 l=0.15
X112 t_Xff0_mp t_ckh_n t_Xff0_Xs_int_p vdd sky130_fd_pr__pfet_01v8 w=4 l=0.15
X113 t_Xff0_mn t_ckh_p t_Xff0_Xs_int_n vss sky130_fd_pr__nfet_01v8_lvt w=1.6 l=0.15
X114 t_Xff0_mn t_ckh_n t_Xff0_Xs_int_n vdd sky130_fd_pr__pfet_01v8 w=4 l=0.15
X115 t_Xff0_Xs_int_p t_Xff0_Xs_int_n vdd vdd sky130_fd_pr__pfet_01v8 w=0.42 l=0.28
X116 t_Xff0_Xs_int_p t_Xff0_Xs_int_n vss vss sky130_fd_pr__nfet_01v8 w=0.42 l=0.28
X117 t_Xff0_Xs_int_n t_Xff0_Xs_int_p vdd vdd sky130_fd_pr__pfet_01v8 w=0.42 l=0.28
X118 t_Xff0_Xs_int_n t_Xff0_Xs_int_p vss vss sky130_fd_pr__nfet_01v8 w=0.42 l=0.28
X119 t_Xff0_Xs_int_p t_rst vss vss sky130_fd_pr__nfet_01v8 w=0.9 l=0.18
X120 t_Xff0_Xs_int_n rst_n vdd vdd sky130_fd_pr__pfet_01v8 w=1.6 l=0.18
X121 t_q0p t_Xff0_Xs_int_n vss vss sky130_fd_pr__nfet_01v8_lvt w=2.4 l=0.15
X122 t_q0p t_Xff0_Xs_int_n vdd vdd sky130_fd_pr__pfet_01v8 w=9.6 l=0.15
X123 t_q0n t_Xff0_Xs_int_p vss vss sky130_fd_pr__nfet_01v8_lvt w=2.4 l=0.15
X124 t_q0n t_Xff0_Xs_int_p vdd vdd sky130_fd_pr__pfet_01v8 w=9.6 l=0.15
X125 t_q0n t_q0p vss vss sky130_fd_pr__nfet_01v8_lvt w=0.42 l=0.15
X126 t_q0n t_q0p vdd vdd sky130_fd_pr__pfet_01v8 w=1.76 l=0.15
X127 t_q0p t_q0n vss vss sky130_fd_pr__nfet_01v8_lvt w=0.42 l=0.15
X128 t_q0p t_q0n vdd vdd sky130_fd_pr__pfet_01v8 w=1.76 l=0.15
X129 t_q0p t_ckh_n t_Xff1_Xm_int_p vss sky130_fd_pr__nfet_01v8_lvt w=1.2 l=0.15
X130 t_q0p t_ckh_p t_Xff1_Xm_int_p vdd sky130_fd_pr__pfet_01v8 w=3 l=0.15
X131 t_q0n t_ckh_n t_Xff1_Xm_int_n vss sky130_fd_pr__nfet_01v8_lvt w=1.2 l=0.15
X132 t_q0n t_ckh_p t_Xff1_Xm_int_n vdd sky130_fd_pr__pfet_01v8 w=3 l=0.15
X133 t_Xff1_Xm_int_p t_Xff1_Xm_int_n vdd vdd sky130_fd_pr__pfet_01v8 w=0.42 l=0.28
X134 t_Xff1_Xm_int_p t_Xff1_Xm_int_n vss vss sky130_fd_pr__nfet_01v8 w=0.42 l=0.28
X135 t_Xff1_Xm_int_n t_Xff1_Xm_int_p vdd vdd sky130_fd_pr__pfet_01v8 w=0.42 l=0.28
X136 t_Xff1_Xm_int_n t_Xff1_Xm_int_p vss vss sky130_fd_pr__nfet_01v8 w=0.42 l=0.28
X137 t_Xff1_Xm_int_p t_rst vss vss sky130_fd_pr__nfet_01v8 w=0.9 l=0.18
X138 t_Xff1_Xm_int_n rst_n vdd vdd sky130_fd_pr__pfet_01v8 w=1.6 l=0.18
X139 t_Xff1_mp t_Xff1_Xm_int_n vss vss sky130_fd_pr__nfet_01v8_lvt w=1.2 l=0.15
X140 t_Xff1_mp t_Xff1_Xm_int_n vdd vdd sky130_fd_pr__pfet_01v8 w=5.04 l=0.15
X141 t_Xff1_mn t_Xff1_Xm_int_p vss vss sky130_fd_pr__nfet_01v8_lvt w=1.2 l=0.15
X142 t_Xff1_mn t_Xff1_Xm_int_p vdd vdd sky130_fd_pr__pfet_01v8 w=5.04 l=0.15
X143 t_Xff1_mn t_Xff1_mp vss vss sky130_fd_pr__nfet_01v8_lvt w=0.42 l=0.15
X144 t_Xff1_mn t_Xff1_mp vdd vdd sky130_fd_pr__pfet_01v8 w=1.76 l=0.15
X145 t_Xff1_mp t_Xff1_mn vss vss sky130_fd_pr__nfet_01v8_lvt w=0.42 l=0.15
X146 t_Xff1_mp t_Xff1_mn vdd vdd sky130_fd_pr__pfet_01v8 w=1.76 l=0.15
X147 t_Xff1_mp t_ckh_p t_Xff1_Xs_int_p vss sky130_fd_pr__nfet_01v8_lvt w=1.2 l=0.15
X148 t_Xff1_mp t_ckh_n t_Xff1_Xs_int_p vdd sky130_fd_pr__pfet_01v8 w=3 l=0.15
X149 t_Xff1_mn t_ckh_p t_Xff1_Xs_int_n vss sky130_fd_pr__nfet_01v8_lvt w=1.2 l=0.15
X150 t_Xff1_mn t_ckh_n t_Xff1_Xs_int_n vdd sky130_fd_pr__pfet_01v8 w=3 l=0.15
X151 t_Xff1_Xs_int_p t_Xff1_Xs_int_n vdd vdd sky130_fd_pr__pfet_01v8 w=0.42 l=0.28
X152 t_Xff1_Xs_int_p t_Xff1_Xs_int_n vss vss sky130_fd_pr__nfet_01v8 w=0.42 l=0.28
X153 t_Xff1_Xs_int_n t_Xff1_Xs_int_p vdd vdd sky130_fd_pr__pfet_01v8 w=0.42 l=0.28
X154 t_Xff1_Xs_int_n t_Xff1_Xs_int_p vss vss sky130_fd_pr__nfet_01v8 w=0.42 l=0.28
X155 t_Xff1_Xs_int_p t_rst vss vss sky130_fd_pr__nfet_01v8 w=0.9 l=0.18
X156 t_Xff1_Xs_int_n rst_n vdd vdd sky130_fd_pr__pfet_01v8 w=1.6 l=0.18
X157 t_q1p t_Xff1_Xs_int_n vss vss sky130_fd_pr__nfet_01v8_lvt w=1.6 l=0.15
X158 t_q1p t_Xff1_Xs_int_n vdd vdd sky130_fd_pr__pfet_01v8 w=6.72 l=0.15
X159 t_q1n t_Xff1_Xs_int_p vss vss sky130_fd_pr__nfet_01v8_lvt w=1.6 l=0.15
X160 t_q1n t_Xff1_Xs_int_p vdd vdd sky130_fd_pr__pfet_01v8 w=6.72 l=0.15
X161 t_q1n t_q1p vss vss sky130_fd_pr__nfet_01v8_lvt w=0.42 l=0.15
X162 t_q1n t_q1p vdd vdd sky130_fd_pr__pfet_01v8 w=1.76 l=0.15
X163 t_q1p t_q1n vss vss sky130_fd_pr__nfet_01v8_lvt w=0.42 l=0.15
X164 t_q1p t_q1n vdd vdd sky130_fd_pr__pfet_01v8 w=1.76 l=0.15
X165 t_q1p t_ckh_n t_Xff2_Xm_int_p vss sky130_fd_pr__nfet_01v8_lvt w=1.2 l=0.15
X166 t_q1p t_ckh_p t_Xff2_Xm_int_p vdd sky130_fd_pr__pfet_01v8 w=3 l=0.15
X167 t_q1n t_ckh_n t_Xff2_Xm_int_n vss sky130_fd_pr__nfet_01v8_lvt w=1.2 l=0.15
X168 t_q1n t_ckh_p t_Xff2_Xm_int_n vdd sky130_fd_pr__pfet_01v8 w=3 l=0.15
X169 t_Xff2_Xm_int_p t_Xff2_Xm_int_n vdd vdd sky130_fd_pr__pfet_01v8 w=0.42 l=0.28
X170 t_Xff2_Xm_int_p t_Xff2_Xm_int_n vss vss sky130_fd_pr__nfet_01v8 w=0.42 l=0.28
X171 t_Xff2_Xm_int_n t_Xff2_Xm_int_p vdd vdd sky130_fd_pr__pfet_01v8 w=0.42 l=0.28
X172 t_Xff2_Xm_int_n t_Xff2_Xm_int_p vss vss sky130_fd_pr__nfet_01v8 w=0.42 l=0.28
X173 t_Xff2_Xm_int_p t_rst vss vss sky130_fd_pr__nfet_01v8 w=0.9 l=0.18
X174 t_Xff2_Xm_int_n rst_n vdd vdd sky130_fd_pr__pfet_01v8 w=1.6 l=0.18
X175 t_Xff2_mp t_Xff2_Xm_int_n vss vss sky130_fd_pr__nfet_01v8_lvt w=1.2 l=0.15
X176 t_Xff2_mp t_Xff2_Xm_int_n vdd vdd sky130_fd_pr__pfet_01v8 w=5.04 l=0.15
X177 t_Xff2_mn t_Xff2_Xm_int_p vss vss sky130_fd_pr__nfet_01v8_lvt w=1.2 l=0.15
X178 t_Xff2_mn t_Xff2_Xm_int_p vdd vdd sky130_fd_pr__pfet_01v8 w=5.04 l=0.15
X179 t_Xff2_mn t_Xff2_mp vss vss sky130_fd_pr__nfet_01v8_lvt w=0.42 l=0.15
X180 t_Xff2_mn t_Xff2_mp vdd vdd sky130_fd_pr__pfet_01v8 w=1.76 l=0.15
X181 t_Xff2_mp t_Xff2_mn vss vss sky130_fd_pr__nfet_01v8_lvt w=0.42 l=0.15
X182 t_Xff2_mp t_Xff2_mn vdd vdd sky130_fd_pr__pfet_01v8 w=1.76 l=0.15
X183 t_Xff2_mp t_ckh_p t_Xff2_Xs_int_p vss sky130_fd_pr__nfet_01v8_lvt w=1.2 l=0.15
X184 t_Xff2_mp t_ckh_n t_Xff2_Xs_int_p vdd sky130_fd_pr__pfet_01v8 w=3 l=0.15
X185 t_Xff2_mn t_ckh_p t_Xff2_Xs_int_n vss sky130_fd_pr__nfet_01v8_lvt w=1.2 l=0.15
X186 t_Xff2_mn t_ckh_n t_Xff2_Xs_int_n vdd sky130_fd_pr__pfet_01v8 w=3 l=0.15
X187 t_Xff2_Xs_int_p t_Xff2_Xs_int_n vdd vdd sky130_fd_pr__pfet_01v8 w=0.42 l=0.28
X188 t_Xff2_Xs_int_p t_Xff2_Xs_int_n vss vss sky130_fd_pr__nfet_01v8 w=0.42 l=0.28
X189 t_Xff2_Xs_int_n t_Xff2_Xs_int_p vdd vdd sky130_fd_pr__pfet_01v8 w=0.42 l=0.28
X190 t_Xff2_Xs_int_n t_Xff2_Xs_int_p vss vss sky130_fd_pr__nfet_01v8 w=0.42 l=0.28
X191 t_Xff2_Xs_int_p t_rst vss vss sky130_fd_pr__nfet_01v8 w=0.9 l=0.18
X192 t_Xff2_Xs_int_n rst_n vdd vdd sky130_fd_pr__pfet_01v8 w=1.6 l=0.18
X193 t_q2p t_Xff2_Xs_int_n vss vss sky130_fd_pr__nfet_01v8_lvt w=1.6 l=0.15
X194 t_q2p t_Xff2_Xs_int_n vdd vdd sky130_fd_pr__pfet_01v8 w=6.72 l=0.15
X195 t_q2n t_Xff2_Xs_int_p vss vss sky130_fd_pr__nfet_01v8_lvt w=1.6 l=0.15
X196 t_q2n t_Xff2_Xs_int_p vdd vdd sky130_fd_pr__pfet_01v8 w=6.72 l=0.15
X197 t_q2n t_q2p vss vss sky130_fd_pr__nfet_01v8_lvt w=0.42 l=0.15
X198 t_q2n t_q2p vdd vdd sky130_fd_pr__pfet_01v8 w=1.76 l=0.15
X199 t_q2p t_q2n vss vss sky130_fd_pr__nfet_01v8_lvt w=0.42 l=0.15
X200 t_q2p t_q2n vdd vdd sky130_fd_pr__pfet_01v8 w=1.76 l=0.15
X201 t_q0p t_ckh_n t_Xdly_int_p vss sky130_fd_pr__nfet_01v8_lvt w=1.8 l=0.15
X202 t_q0p t_ckh_p t_Xdly_int_p vdd sky130_fd_pr__pfet_01v8 w=4.4 l=0.15
X203 t_q0n t_ckh_n t_Xdly_int_n vss sky130_fd_pr__nfet_01v8_lvt w=1.8 l=0.15
X204 t_q0n t_ckh_p t_Xdly_int_n vdd sky130_fd_pr__pfet_01v8 w=4.4 l=0.15
X205 t_Xdly_int_p t_Xdly_int_n vdd vdd sky130_fd_pr__pfet_01v8 w=0.42 l=0.28
X206 t_Xdly_int_p t_Xdly_int_n vss vss sky130_fd_pr__nfet_01v8 w=0.42 l=0.28
X207 t_Xdly_int_n t_Xdly_int_p vdd vdd sky130_fd_pr__pfet_01v8 w=0.42 l=0.28
X208 t_Xdly_int_n t_Xdly_int_p vss vss sky130_fd_pr__nfet_01v8 w=0.42 l=0.28
X209 t_Xdly_int_p t_rst vss vss sky130_fd_pr__nfet_01v8 w=0.9 l=0.18
X210 t_Xdly_int_n rst_n vdd vdd sky130_fd_pr__pfet_01v8 w=1.6 l=0.18
X211 t_q0dp t_Xdly_int_n vss vss sky130_fd_pr__nfet_01v8_lvt w=2.4 l=0.15
X212 t_q0dp t_Xdly_int_n vdd vdd sky130_fd_pr__pfet_01v8 w=9.6 l=0.15
X213 t_q0dn t_Xdly_int_p vss vss sky130_fd_pr__nfet_01v8_lvt w=2.4 l=0.15
X214 t_q0dn t_Xdly_int_p vdd vdd sky130_fd_pr__pfet_01v8 w=9.6 l=0.15
X215 t_q0dn t_q0dp vss vss sky130_fd_pr__nfet_01v8_lvt w=0.42 l=0.15
X216 t_q0dn t_q0dp vdd vdd sky130_fd_pr__pfet_01v8 w=1.76 l=0.15
X217 t_q0dp t_q0dn vss vss sky130_fd_pr__nfet_01v8_lvt w=0.42 l=0.15
X218 t_q0dp t_q0dn vdd vdd sky130_fd_pr__pfet_01v8 w=1.76 l=0.15
X219 t_qsh_n t_q0p vss vss sky130_fd_pr__nfet_01v8_lvt w=2 l=0.15
X220 t_qsh_n t_q0dp t_Xsh_n_mid vss sky130_fd_pr__nfet_01v8_lvt w=3 l=0.15
X221 t_Xsh_n_mid mode_5g vss vss sky130_fd_pr__nfet_01v8_lvt w=3 l=0.15
X222 t_Xsh_n_p1 t_q0p vdd vdd sky130_fd_pr__pfet_01v8 w=8 l=0.15
X223 t_qsh_n t_q0dp t_Xsh_n_p1 vdd sky130_fd_pr__pfet_01v8 w=8 l=0.15
X224 t_qsh_n mode_5g t_Xsh_n_p1 vdd sky130_fd_pr__pfet_01v8 w=8 l=0.15
X225 t_Xsh_p_n1 t_q0n vss vss sky130_fd_pr__nfet_01v8_lvt w=3 l=0.15
X226 t_qsh_p t_q0dn t_Xsh_p_n1 vss sky130_fd_pr__nfet_01v8_lvt w=3 l=0.15
X227 t_qsh_p t_mode_5g_b t_Xsh_p_n1 vss sky130_fd_pr__nfet_01v8_lvt w=3 l=0.15
X228 t_qsh_p t_q0n vdd vdd sky130_fd_pr__pfet_01v8 w=6 l=0.15
X229 t_Xsh_p_p1 t_q0dn vdd vdd sky130_fd_pr__pfet_01v8 w=10 l=0.15
X230 t_qsh_p t_mode_5g_b t_Xsh_p_p1 vdd sky130_fd_pr__pfet_01v8 w=10 l=0.15
X231 t_Xretime_tail t_ck_rt vss vss sky130_fd_pr__nfet_01v8_lvt w=5.2 l=0.15
X232 t_Xretime_n_sp t_qsh_p t_Xretime_tail vss sky130_fd_pr__nfet_01v8_lvt w=3.2 l=0.15
X233 t_Xretime_n_sn t_qsh_n t_Xretime_tail vss sky130_fd_pr__nfet_01v8_lvt w=3.2 l=0.15
X234 t_Xretime_sp t_Xretime_sn t_Xretime_n_sp vss sky130_fd_pr__nfet_01v8_lvt w=2.8 l=0.15
X235 t_Xretime_sn t_Xretime_sp t_Xretime_n_sn vss sky130_fd_pr__nfet_01v8_lvt w=2.8 l=0.15
X236 t_Xretime_sp t_Xretime_sn vdd vdd sky130_fd_pr__pfet_01v8 w=1.6 l=0.15
X237 t_Xretime_sn t_Xretime_sp vdd vdd sky130_fd_pr__pfet_01v8 w=1.6 l=0.15
X238 t_Xretime_sp t_ck_rt vdd vdd sky130_fd_pr__pfet_01v8 w=3.4 l=0.15
X239 t_Xretime_sn t_ck_rt vdd vdd sky130_fd_pr__pfet_01v8 w=3.4 l=0.15
X240 t_Xretime_sp t_ck_rt t_Xretime_sn vdd sky130_fd_pr__pfet_01v8 w=2.2 l=0.15
X241 t_Xretime_n_sp t_ck_rt vdd vdd sky130_fd_pr__pfet_01v8 w=1.5 l=0.15
X242 t_Xretime_n_sn t_ck_rt vdd vdd sky130_fd_pr__pfet_01v8 w=1.5 l=0.15
X243 t_Xretime_sb t_Xretime_sp vss vss sky130_fd_pr__nfet_01v8_lvt w=0.7 l=0.15
X244 t_Xretime_sb t_Xretime_sp vdd vdd sky130_fd_pr__pfet_01v8 w=2.8 l=0.15
X245 t_Xretime_rb t_Xretime_sn vss vss sky130_fd_pr__nfet_01v8_lvt w=0.7 l=0.15
X246 t_Xretime_rb t_Xretime_sn vdd vdd sky130_fd_pr__pfet_01v8 w=2.8 l=0.15
X247 t_rp t_Xretime_sp vdd vdd sky130_fd_pr__pfet_01v8 w=4.4 l=0.15
X248 t_rp t_Xretime_rb vss vss sky130_fd_pr__nfet_01v8_lvt w=2.6 l=0.15
X249 t_rn t_Xretime_sn vdd vdd sky130_fd_pr__pfet_01v8 w=4.4 l=0.15
X250 t_rn t_Xretime_sb vss vss sky130_fd_pr__nfet_01v8_lvt w=2.6 l=0.15
X251 t_rp t_rn vdd vdd sky130_fd_pr__pfet_01v8 w=0.65 l=0.15
X252 t_rp t_rn vss vss sky130_fd_pr__nfet_01v8 w=0.55 l=0.15
X253 t_rn t_rp vdd vdd sky130_fd_pr__pfet_01v8 w=0.65 l=0.15
X254 t_rn t_rp vss vss sky130_fd_pr__nfet_01v8 w=0.55 l=0.15
X255 t_rp t_rst vss vss sky130_fd_pr__nfet_01v8 w=1.2 l=0.18
X256 t_rn rst_n vdd vdd sky130_fd_pr__pfet_01v8 w=2.4 l=0.18
X257 fb250 t_rn vss vss sky130_fd_pr__nfet_01v8_lvt w=2.4 l=0.15
X258 fb250 t_rn vdd vdd sky130_fd_pr__pfet_01v8 w=6.3 l=0.15
X259 fb250_b t_rp vss vss sky130_fd_pr__nfet_01v8_lvt w=2.4 l=0.15
X260 fb250_b t_rp vdd vdd sky130_fd_pr__pfet_01v8 w=6.3 l=0.15
X261 fb250_b fb250 vss vss sky130_fd_pr__nfet_01v8_lvt w=0.45 l=0.15
X262 fb250_b fb250 vdd vdd sky130_fd_pr__pfet_01v8 w=1.2 l=0.15
X263 fb250 fb250_b vss vss sky130_fd_pr__nfet_01v8_lvt w=0.45 l=0.15
X264 fb250 fb250_b vdd vdd sky130_fd_pr__pfet_01v8 w=1.2 l=0.15
.ends pll_div_ab_5g_v2_pdk
