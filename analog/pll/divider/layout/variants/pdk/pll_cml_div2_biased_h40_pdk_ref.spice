.subckt pll_cml_latch_h40_pdk dp dn qp qn clk_track clk_hold vbias vdd vss
Xrp vdd qp vss sky130_fd_pr__res_high_po_2p85 l=4.14
Xrn vdd qn vss sky130_fd_pr__res_high_po_2p85 l=4.14
Xdp qn dp track vss sky130_fd_pr__nfet_01v8_lvt w=20 l=0.15
Xdn qp dn track vss sky130_fd_pr__nfet_01v8_lvt w=20 l=0.15
Xhp qn qp hold vss sky130_fd_pr__nfet_01v8_lvt w=40 l=0.15
Xhn qp qn hold vss sky130_fd_pr__nfet_01v8_lvt w=40 l=0.15
Xct track clk_track tail vss sky130_fd_pr__nfet_01v8_lvt w=64 l=0.15
Xch hold clk_hold tail vss sky130_fd_pr__nfet_01v8_lvt w=64 l=0.15
Xtail tail vbias vss vss sky130_fd_pr__nfet_01v8 w=72 l=0.5
.ends pll_cml_latch_h40_pdk

.subckt pll_cml_div2_biased_h40_pdk clkp clkn qp qn mp mn vbias vbias_logic vdd vss
Xfp vdd clkp ckp vss sky130_fd_pr__nfet_01v8_lvt w=80 l=0.15
Xfn vdd clkn ckn vss sky130_fd_pr__nfet_01v8_lvt w=80 l=0.15
Xsp ckp vbias vss vss sky130_fd_pr__nfet_01v8 w=4 l=0.5
Xsn ckn vbias vss vss sky130_fd_pr__nfet_01v8 w=4 l=0.5
Xmaster qn qp mp mn ckp ckn vbias_logic vdd vss pll_cml_latch_h40_pdk
Xslave mp mn qp qn ckn ckp vbias_logic vdd vss pll_cml_latch_h40_pdk
.ends pll_cml_div2_biased_h40_pdk
