* NGSPICE file created from pll_cml_latch_h40_pdk.ext - technology: sky130A

.subckt pll_cml_latch_h40_pdk dp dn qp qn clk_track clk_hold vbias vdd vss
X0 a_n1767_n300# clk_track a_n1587_614# vss sky130_fd_pr__nfet_01v8_lvt ad=0.66 pd=4.33 as=0.66 ps=4.33 w=4 l=0.15
X1 a_n1587_614# clk_track a_n1767_n300# vss sky130_fd_pr__nfet_01v8_lvt ad=0.66 pd=4.33 as=0.66 ps=4.33 w=4 l=0.15
X2 a_n1587_614# clk_track a_n1767_n300# vss sky130_fd_pr__nfet_01v8_lvt ad=0.66 pd=4.33 as=0.66 ps=4.33 w=4 l=0.15
X3 a_n1767_n300# clk_track a_n1587_614# vss sky130_fd_pr__nfet_01v8_lvt ad=0.66 pd=4.33 as=0.66 ps=4.33 w=4 l=0.15
X4 vss vbias a_n1767_n300# vss sky130_fd_pr__nfet_01v8 ad=0.435 pd=3.29 as=0.435 ps=3.29 w=3 l=0.5
X5 a_n1767_n300# vbias vss vss sky130_fd_pr__nfet_01v8 ad=0.435 pd=3.29 as=0.435 ps=3.29 w=3 l=0.5
X6 a_n1587_614# clk_track a_n1767_n300# vss sky130_fd_pr__nfet_01v8_lvt ad=0.66 pd=4.33 as=1.24 ps=8.62 w=4 l=0.15
X7 a_n1767_n300# clk_track a_n1587_614# vss sky130_fd_pr__nfet_01v8_lvt ad=0.66 pd=4.33 as=0.66 ps=4.33 w=4 l=0.15
X8 a_n1767_n300# clk_track a_n1587_614# vss sky130_fd_pr__nfet_01v8_lvt ad=0.66 pd=4.33 as=0.66 ps=4.33 w=4 l=0.15
X9 a_n1587_614# clk_track a_n1767_n300# vss sky130_fd_pr__nfet_01v8_lvt ad=0.66 pd=4.33 as=0.66 ps=4.33 w=4 l=0.15
X10 a_n1767_n300# clk_hold a_n1295_1728# vss sky130_fd_pr__nfet_01v8_lvt ad=0.66 pd=4.33 as=0.66 ps=4.33 w=4 l=0.15
X11 a_n1767_n300# clk_hold a_n1295_1728# vss sky130_fd_pr__nfet_01v8_lvt ad=0.66 pd=4.33 as=0.66 ps=4.33 w=4 l=0.15
X12 vss vbias a_n1767_n300# vss sky130_fd_pr__nfet_01v8 ad=0.435 pd=3.29 as=0.435 ps=3.29 w=3 l=0.5
X13 a_n1767_n300# clk_track a_n1587_614# vss sky130_fd_pr__nfet_01v8_lvt ad=0.66 pd=4.33 as=0.66 ps=4.33 w=4 l=0.15
X14 a_n1767_n300# clk_track a_n1587_614# vss sky130_fd_pr__nfet_01v8_lvt ad=0.66 pd=4.33 as=0.66 ps=4.33 w=4 l=0.15
X15 a_n1587_614# clk_track a_n1767_n300# vss sky130_fd_pr__nfet_01v8_lvt ad=0.66 pd=4.33 as=0.66 ps=4.33 w=4 l=0.15
X16 a_n1587_614# clk_track a_n1767_n300# vss sky130_fd_pr__nfet_01v8_lvt ad=0.66 pd=4.33 as=0.66 ps=4.33 w=4 l=0.15
X17 a_n1767_n300# clk_track a_n1587_614# vss sky130_fd_pr__nfet_01v8_lvt ad=0.66 pd=4.33 as=0.66 ps=4.33 w=4 l=0.15
X18 a_n1767_n300# clk_track a_n1587_614# vss sky130_fd_pr__nfet_01v8_lvt ad=1.24 pd=8.62 as=0.66 ps=4.33 w=4 l=0.15
X19 a_n1295_1728# clk_hold a_n1767_n300# vss sky130_fd_pr__nfet_01v8_lvt ad=0.66 pd=4.33 as=0.66 ps=4.33 w=4 l=0.15
X20 a_n1587_614# dn qp vss sky130_fd_pr__nfet_01v8_lvt ad=1.55 pd=10.62 as=0.825 ps=5.33 w=5 l=0.15
X21 qn qp a_n1295_1728# vss sky130_fd_pr__nfet_01v8_lvt ad=0.825 pd=5.33 as=1.55 ps=10.62 w=5 l=0.15
X22 qp qn a_n1295_1728# vss sky130_fd_pr__nfet_01v8_lvt ad=0.825 pd=5.33 as=1.55 ps=10.62 w=5 l=0.15
X23 a_n1587_614# clk_track a_n1767_n300# vss sky130_fd_pr__nfet_01v8_lvt ad=0.66 pd=4.33 as=0.66 ps=4.33 w=4 l=0.15
X24 vss vbias a_n1767_n300# vss sky130_fd_pr__nfet_01v8 ad=0.435 pd=3.29 as=0.435 ps=3.29 w=3 l=0.5
X25 qn qp a_n1295_1728# vss sky130_fd_pr__nfet_01v8_lvt ad=0.825 pd=5.33 as=0.825 ps=5.33 w=5 l=0.15
X26 a_n1767_n300# vbias vss vss sky130_fd_pr__nfet_01v8 ad=0.435 pd=3.29 as=0.435 ps=3.29 w=3 l=0.5
X27 a_n1767_n300# vbias vss vss sky130_fd_pr__nfet_01v8 ad=0.435 pd=3.29 as=0.435 ps=3.29 w=3 l=0.5
X28 vss vbias a_n1767_n300# vss sky130_fd_pr__nfet_01v8 ad=0.435 pd=3.29 as=0.435 ps=3.29 w=3 l=0.5
X29 a_n1767_n300# vbias vss vss sky130_fd_pr__nfet_01v8 ad=0.435 pd=3.29 as=0.435 ps=3.29 w=3 l=0.5
X30 a_n1767_n300# vbias vss vss sky130_fd_pr__nfet_01v8 ad=0.435 pd=3.29 as=0.435 ps=3.29 w=3 l=0.5
X31 vss vbias a_n1767_n300# vss sky130_fd_pr__nfet_01v8 ad=0.435 pd=3.29 as=0.435 ps=3.29 w=3 l=0.5
X32 vdd qp vss sky130_fd_pr__res_high_po_2p85 l=4.14
X33 a_n1587_614# dp qn vss sky130_fd_pr__nfet_01v8_lvt ad=1.55 pd=10.62 as=0.825 ps=5.33 w=5 l=0.15
X34 qp dn a_n1587_614# vss sky130_fd_pr__nfet_01v8_lvt ad=0.825 pd=5.33 as=1.55 ps=10.62 w=5 l=0.15
X35 a_n1295_1728# qp qn vss sky130_fd_pr__nfet_01v8_lvt ad=0.825 pd=5.33 as=0.825 ps=5.33 w=5 l=0.15
X36 vss vbias a_n1767_n300# vss sky130_fd_pr__nfet_01v8 ad=0.435 pd=3.29 as=0.435 ps=3.29 w=3 l=0.5
X37 a_n1295_1728# qp qn vss sky130_fd_pr__nfet_01v8_lvt ad=1.55 pd=10.62 as=0.825 ps=5.33 w=5 l=0.15
X38 a_n1767_n300# vbias vss vss sky130_fd_pr__nfet_01v8 ad=0.435 pd=3.29 as=0.435 ps=3.29 w=3 l=0.5
X39 a_n1767_n300# vbias vss vss sky130_fd_pr__nfet_01v8 ad=0.435 pd=3.29 as=0.435 ps=3.29 w=3 l=0.5
X40 qn dp a_n1587_614# vss sky130_fd_pr__nfet_01v8_lvt ad=0.825 pd=5.33 as=1.55 ps=10.62 w=5 l=0.15
X41 qp qn a_n1295_1728# vss sky130_fd_pr__nfet_01v8_lvt ad=0.825 pd=5.33 as=0.825 ps=5.33 w=5 l=0.15
X42 a_n1295_1728# qn qp vss sky130_fd_pr__nfet_01v8_lvt ad=0.825 pd=5.33 as=0.825 ps=5.33 w=5 l=0.15
X43 vss vbias a_n1767_n300# vss sky130_fd_pr__nfet_01v8 ad=0.435 pd=3.29 as=0.435 ps=3.29 w=3 l=0.5
X44 vss vbias a_n1767_n300# vss sky130_fd_pr__nfet_01v8 ad=0.435 pd=3.29 as=0.435 ps=3.29 w=3 l=0.5
X45 a_n1767_n300# vbias vss vss sky130_fd_pr__nfet_01v8 ad=0.435 pd=3.29 as=0.435 ps=3.29 w=3 l=0.5
X46 vss vbias a_n1767_n300# vss sky130_fd_pr__nfet_01v8 ad=0.435 pd=3.29 as=0.435 ps=3.29 w=3 l=0.5
X47 qp dn a_n1587_614# vss sky130_fd_pr__nfet_01v8_lvt ad=0.825 pd=5.33 as=0.825 ps=5.33 w=5 l=0.15
X48 a_n1587_614# dp qn vss sky130_fd_pr__nfet_01v8_lvt ad=0.825 pd=5.33 as=0.825 ps=5.33 w=5 l=0.15
X49 a_n1295_1728# qn qp vss sky130_fd_pr__nfet_01v8_lvt ad=0.825 pd=5.33 as=0.825 ps=5.33 w=5 l=0.15
X50 a_n1295_1728# qp qn vss sky130_fd_pr__nfet_01v8_lvt ad=0.825 pd=5.33 as=0.825 ps=5.33 w=5 l=0.15
X51 qp qn a_n1295_1728# vss sky130_fd_pr__nfet_01v8_lvt ad=0.825 pd=5.33 as=0.825 ps=5.33 w=5 l=0.15
X52 a_n1767_n300# vbias vss vss sky130_fd_pr__nfet_01v8 ad=0.435 pd=3.29 as=0.87 ps=6.58 w=3 l=0.5
X53 vss vbias a_n1767_n300# vss sky130_fd_pr__nfet_01v8 ad=0.87 pd=6.58 as=0.435 ps=3.29 w=3 l=0.5
X54 a_n1295_1728# qn qp vss sky130_fd_pr__nfet_01v8_lvt ad=1.55 pd=10.62 as=0.825 ps=5.33 w=5 l=0.15
X55 a_n1587_614# dn qp vss sky130_fd_pr__nfet_01v8_lvt ad=0.825 pd=5.33 as=0.825 ps=5.33 w=5 l=0.15
X56 qn qp a_n1295_1728# vss sky130_fd_pr__nfet_01v8_lvt ad=0.825 pd=5.33 as=0.825 ps=5.33 w=5 l=0.15
X57 a_n1767_n300# clk_hold a_n1295_1728# vss sky130_fd_pr__nfet_01v8_lvt ad=0.66 pd=4.33 as=0.66 ps=4.33 w=4 l=0.15
X58 a_n1295_1728# clk_hold a_n1767_n300# vss sky130_fd_pr__nfet_01v8_lvt ad=0.66 pd=4.33 as=0.66 ps=4.33 w=4 l=0.15
X59 a_n1767_n300# vbias vss vss sky130_fd_pr__nfet_01v8 ad=0.435 pd=3.29 as=0.435 ps=3.29 w=3 l=0.5
X60 qn dp a_n1587_614# vss sky130_fd_pr__nfet_01v8_lvt ad=0.825 pd=5.33 as=0.825 ps=5.33 w=5 l=0.15
X61 a_n1295_1728# clk_hold a_n1767_n300# vss sky130_fd_pr__nfet_01v8_lvt ad=0.66 pd=4.33 as=0.66 ps=4.33 w=4 l=0.15
X62 a_n1767_n300# clk_hold a_n1295_1728# vss sky130_fd_pr__nfet_01v8_lvt ad=1.24 pd=8.62 as=0.66 ps=4.33 w=4 l=0.15
X63 vss vbias a_n1767_n300# vss sky130_fd_pr__nfet_01v8 ad=0.435 pd=3.29 as=0.435 ps=3.29 w=3 l=0.5
X64 vdd qn vss sky130_fd_pr__res_high_po_2p85 l=4.14
X65 qn qp a_n1295_1728# vss sky130_fd_pr__nfet_01v8_lvt ad=0.825 pd=5.33 as=0.825 ps=5.33 w=5 l=0.15
X66 vss vbias a_n1767_n300# vss sky130_fd_pr__nfet_01v8 ad=0.435 pd=3.29 as=0.435 ps=3.29 w=3 l=0.5
X67 a_n1295_1728# qn qp vss sky130_fd_pr__nfet_01v8_lvt ad=0.825 pd=5.33 as=0.825 ps=5.33 w=5 l=0.15
X68 a_n1767_n300# clk_hold a_n1295_1728# vss sky130_fd_pr__nfet_01v8_lvt ad=0.66 pd=4.33 as=0.66 ps=4.33 w=4 l=0.15
X69 a_n1767_n300# vbias vss vss sky130_fd_pr__nfet_01v8 ad=0.435 pd=3.29 as=0.435 ps=3.29 w=3 l=0.5
X70 a_n1767_n300# vbias vss vss sky130_fd_pr__nfet_01v8 ad=0.435 pd=3.29 as=0.435 ps=3.29 w=3 l=0.5
X71 a_n1295_1728# clk_hold a_n1767_n300# vss sky130_fd_pr__nfet_01v8_lvt ad=0.66 pd=4.33 as=1.24 ps=8.62 w=4 l=0.15
X72 a_n1295_1728# clk_hold a_n1767_n300# vss sky130_fd_pr__nfet_01v8_lvt ad=0.66 pd=4.33 as=0.66 ps=4.33 w=4 l=0.15
X73 a_n1767_n300# clk_hold a_n1295_1728# vss sky130_fd_pr__nfet_01v8_lvt ad=0.66 pd=4.33 as=0.66 ps=4.33 w=4 l=0.15
X74 a_n1295_1728# clk_hold a_n1767_n300# vss sky130_fd_pr__nfet_01v8_lvt ad=0.66 pd=4.33 as=0.66 ps=4.33 w=4 l=0.15
X75 a_n1767_n300# clk_hold a_n1295_1728# vss sky130_fd_pr__nfet_01v8_lvt ad=0.66 pd=4.33 as=0.66 ps=4.33 w=4 l=0.15
X76 a_n1295_1728# clk_hold a_n1767_n300# vss sky130_fd_pr__nfet_01v8_lvt ad=0.66 pd=4.33 as=0.66 ps=4.33 w=4 l=0.15
X77 a_n1295_1728# clk_hold a_n1767_n300# vss sky130_fd_pr__nfet_01v8_lvt ad=0.66 pd=4.33 as=0.66 ps=4.33 w=4 l=0.15
X78 a_n1295_1728# qp qn vss sky130_fd_pr__nfet_01v8_lvt ad=0.825 pd=5.33 as=0.825 ps=5.33 w=5 l=0.15
X79 qp qn a_n1295_1728# vss sky130_fd_pr__nfet_01v8_lvt ad=0.825 pd=5.33 as=0.825 ps=5.33 w=5 l=0.15
X80 a_n1587_614# clk_track a_n1767_n300# vss sky130_fd_pr__nfet_01v8_lvt ad=0.66 pd=4.33 as=0.66 ps=4.33 w=4 l=0.15
X81 a_n1767_n300# clk_hold a_n1295_1728# vss sky130_fd_pr__nfet_01v8_lvt ad=0.66 pd=4.33 as=0.66 ps=4.33 w=4 l=0.15
C0 a_n400_3042# a_n1587_614# 0.08263f
C1 a_n1295_1728# clk_track 0.01281f
C2 a_n1295_1728# a_1314_1728# 0.07762f
C3 a_n910_3042# dp 0.00899f
C4 a_880_3042# a_n1295_1728# 0
C5 qp a_n450_1728# 0.01608f
C6 qn a_n1295_1728# 2.94085f
C7 a_420_1728# a_n1295_1728# 0.08425f
C8 dn qp 0.47609f
C9 clk_hold clk_track 0.00755f
C10 clk_hold a_1314_1728# 0
C11 a_n1767_n300# a_n450_1728# 0
C12 vdd dp 0.00203f
C13 a_n1344_1728# a_n1295_1728# 0.07452f
C14 qn clk_hold 0.05116f
C15 dn a_n1767_n300# 0
C16 clk_hold a_420_1728# 0
C17 a_n400_3042# dp 0
C18 qp a_n1295_1728# 2.89459f
C19 vbias a_n1587_614# 0.00382f
C20 vbias a_36_614# 0.00128f
C21 a_880_3042# a_370_3042# 0.01667f
C22 a_n1767_n300# a_n1295_1728# 3.30043f
C23 a_36_614# a_n1587_614# 0.00676f
C24 dn a_1698_614# 0
C25 qn a_370_3042# 0.00529f
C26 qp clk_hold 0.01309f
C27 dn vdd 0
C28 vbias a_n1728_614# 0
C29 a_n1587_614# a_n1728_614# 0.02418f
C30 a_n910_3042# a_n1295_1728# 0
C31 a_n1767_n300# clk_hold 1.27296f
C32 a_n1587_614# dp 0.35226f
C33 a_n1295_1728# a_1698_614# 0.02418f
C34 dp a_n1728_614# 0
C35 a_n400_3042# a_n1295_1728# 0
C36 qn a_n66_614# 0
C37 qp a_370_3042# 0.0369f
C38 clk_hold a_1698_614# 0.00955f
C39 a_n1587_614# a_n450_1728# 0.01161f
C40 qn clk_track 0.00463f
C41 qn a_1314_1728# 0
C42 qn a_880_3042# 0
C43 a_420_1728# a_1314_1728# 0.00926f
C44 dn a_n1587_614# 0.34892f
C45 qn a_420_1728# 0.01913f
C46 a_n1344_1728# clk_track 0
C47 qp a_n66_614# 0.00137f
C48 qn a_n1344_1728# 0.03123f
C49 a_n450_1728# dp 0
C50 vbias a_n1295_1728# 0.00388f
C51 vdd a_370_3042# 0
C52 a_n1587_614# a_n1295_1728# 0.27773f
C53 a_n1767_n300# a_n66_614# 0.07182f
C54 qp clk_track 0.05755f
C55 dn dp 0.0022f
C56 qp a_1314_1728# 0.03209f
C57 a_370_3042# a_n400_3042# 0.01081f
C58 a_n1767_n300# a_n2048_n300# 0.02042f
C59 qp a_880_3042# 0.03618f
C60 a_n1767_n300# a_1948_n300# 0.01952f
C61 qn qp 2.05887f
C62 a_36_614# a_n1295_1728# 0.02702f
C63 qp a_420_1728# 0.03412f
C64 a_n1767_n300# clk_track 1.28217f
C65 a_n1767_n300# a_1314_1728# 0
C66 vbias clk_hold 0.1342f
C67 clk_hold a_n1587_614# 0.00514f
C68 qn a_n1767_n300# 0.03331f
C69 a_n1767_n300# a_420_1728# 0
C70 qp a_n1344_1728# 0.00116f
C71 a_n1295_1728# dp 0.03112f
C72 qn a_n910_3042# 0.03618f
C73 a_n1767_n300# a_n1344_1728# 0
C74 a_370_3042# a_n1587_614# 0.08239f
C75 qn vdd 0.02547f
C76 a_n1295_1728# a_n450_1728# 0.08402f
C77 a_n1767_n300# qp 0.04947f
C78 qn a_n400_3042# 0.03812f
C79 dn a_n1295_1728# 0.03177f
C80 qp a_n910_3042# 0
C81 dn clk_hold 0
C82 vbias a_n66_614# 0.00128f
C83 a_n1587_614# a_n66_614# 0.02509f
C84 vbias a_n2048_n300# 0.02071f
C85 vdd qp 0.02547f
C86 qp a_n400_3042# 0.00357f
C87 a_36_614# a_n66_614# 0.08889f
C88 vbias clk_track 0.13438f
C89 a_n1587_614# clk_track 1.22762f
C90 a_n1767_n300# a_1698_614# 0.06415f
C91 a_880_3042# a_n1587_614# 0.07294f
C92 qn vbias 0.00101f
C93 qn a_n1587_614# 1.43584f
C94 clk_hold a_n1295_1728# 1.22763f
C95 a_420_1728# a_n1587_614# 0.00728f
C96 clk_track a_n1728_614# 0.01213f
C97 a_n400_3042# a_n910_3042# 0.01667f
C98 qn a_36_614# 0
C99 dn a_370_3042# 0
C100 a_n1587_614# a_n1344_1728# 0.0033f
C101 clk_track dp 0
C102 qn dp 0.47675f
C103 vdd a_n400_3042# 0
C104 vbias qp 0.00101f
C105 qp a_n1587_614# 1.4939f
C106 a_370_3042# a_n1295_1728# 0
C107 qp a_36_614# 0.00137f
C108 a_n1767_n300# vbias 3.27773f
C109 a_n1344_1728# dp 0.00274f
C110 a_n1767_n300# a_n1587_614# 3.27283f
C111 clk_track a_n450_1728# 0
C112 qn a_n450_1728# 0.03703f
C113 a_n910_3042# a_n1587_614# 0.07294f
C114 a_n1767_n300# a_36_614# 0.07182f
C115 dn a_1314_1728# 0.00274f
C116 a_420_1728# a_n450_1728# 0.00952f
C117 dn a_880_3042# 0.00899f
C118 a_n1767_n300# a_n1728_614# 0.06415f
C119 qp dp 0.0391f
C120 qn dn 0.03948f
C121 dn a_420_1728# 0
C122 a_n1295_1728# a_n66_614# 0.00869f
C123 a_n1344_1728# a_n450_1728# 0.00926f
C124 vbias a_1698_614# 0
C125 a_n1767_n300# dp 0
C126 vbias vss 8.08208f
C127 clk_hold vss 2.259f
C128 clk_track vss 2.32337f
C129 dn vss 2.01498f
C130 dp vss 2.11333f
C131 qp vss 3.1686f
C132 qn vss 3.18071f
C133 vdd vss 4.27479f
C134 a_1948_n300# vss 0.79698f ; **FLOATING
C135 a_n2048_n300# vss 0.74632f ; **FLOATING
C136 a_1698_614# vss 0.59403f ; **FLOATING
C137 a_36_614# vss 0.44925f ; **FLOATING
C138 a_n66_614# vss 0.44925f ; **FLOATING
C139 a_n1767_n300# vss 3.70693f
C140 a_n1728_614# vss 0.59403f ; **FLOATING
C141 a_1314_1728# vss 0.70327f ; **FLOATING
C142 a_420_1728# vss 0.68032f ; **FLOATING
C143 a_n450_1728# vss 0.68032f ; **FLOATING
C144 a_n1295_1728# vss 1.39955f
C145 a_n1344_1728# vss 0.70319f ; **FLOATING
C146 a_880_3042# vss 0.68694f ; **FLOATING
C147 a_370_3042# vss 0.66519f ; **FLOATING
C148 a_n400_3042# vss 0.66519f ; **FLOATING
C149 a_n1587_614# vss 1.66798f
C150 a_n910_3042# vss 0.68694f ; **FLOATING
.ends
