* NGSPICE file created from pll_cml_prescaler8_pdk.ext - technology: sky130A

.subckt pll_cml_prescaler8_pdk clkp clkn q2p q2n q4p q4n q8p q8n vbias vdd vss
X0 a_21824_n300# a_n3862_n388# vss vss sky130_fd_pr__nfet_01v8 ad=0.435 pd=3.29 as=0.435 ps=3.29 w=3 l=0.5
X1 vdd clkp a_n4996_714# vss sky130_fd_pr__nfet_01v8_lvt ad=0.825 pd=5.33 as=1.55 ps=10.62 w=5 l=0.15
X2 vss a_n3862_n388# a_21824_n300# vss sky130_fd_pr__nfet_01v8 ad=0.435 pd=3.29 as=0.435 ps=3.29 w=3 l=0.5
X3 a_21824_n300# a_n3862_n388# vss vss sky130_fd_pr__nfet_01v8 ad=0.435 pd=3.29 as=0.435 ps=3.29 w=3 l=0.5
X4 a_n3198_1728# a_n3261_1640# a_n3290_1728# vss sky130_fd_pr__nfet_01v8_lvt ad=0.825 pd=5.33 as=0.825 ps=5.33 w=5 l=0.15
X5 vss a_n3862_n388# a_17834_n300# vss sky130_fd_pr__nfet_01v8 ad=0.435 pd=3.29 as=0.435 ps=3.29 w=3 l=0.5
X6 a_n3762_n300# a_n3862_n388# vss vss sky130_fd_pr__nfet_01v8 ad=0.435 pd=3.29 as=0.435 ps=3.29 w=3 l=0.5
X7 a_11026_n300# a_8917_526# a_11932_3042# vss sky130_fd_pr__nfet_01v8_lvt ad=0.66 pd=4.33 as=0.66 ps=4.33 w=4 l=0.15
X8 a_17834_n300# a_19715_526# a_17922_1728# vss sky130_fd_pr__nfet_01v8_lvt ad=0.66 pd=4.33 as=0.66 ps=4.33 w=4 l=0.15
X9 a_21912_1728# q8n q8p vss sky130_fd_pr__nfet_01v8_lvt ad=0.825 pd=5.33 as=0.825 ps=5.33 w=5 l=0.15
X10 vdd a_5831_626# a_5802_714# vss sky130_fd_pr__nfet_01v8_lvt ad=0.825 pd=5.33 as=1.55 ps=10.62 w=5 l=0.15
X11 q4p q4n a_11114_1728# vss sky130_fd_pr__nfet_01v8_lvt ad=0.825 pd=5.33 as=0.825 ps=5.33 w=5 l=0.15
X12 vss a_n3862_n388# a_228_n300# vss sky130_fd_pr__nfet_01v8 ad=0.435 pd=3.29 as=0.435 ps=3.29 w=3 l=0.5
X13 vss vbias a_8917_526# vss sky130_fd_pr__nfet_01v8 ad=1.16 pd=8.58 as=1.16 ps=8.58 w=4 l=0.5
X14 a_17922_1728# a_18014_1728# a_17951_1640# vss sky130_fd_pr__nfet_01v8_lvt ad=0.825 pd=5.33 as=0.825 ps=5.33 w=5 l=0.15
X15 a_7124_1728# a_7216_1728# a_7153_1640# vss sky130_fd_pr__nfet_01v8_lvt ad=0.825 pd=5.33 as=0.825 ps=5.33 w=5 l=0.15
X16 a_17922_1728# a_19715_526# a_17834_n300# vss sky130_fd_pr__nfet_01v8_lvt ad=0.66 pd=4.33 as=1.24 ps=8.62 w=4 l=0.15
X17 a_7124_1728# a_7216_1728# a_7153_1640# vss sky130_fd_pr__nfet_01v8_lvt ad=0.825 pd=5.33 as=0.825 ps=5.33 w=5 l=0.15
X18 a_17922_1728# a_18014_1728# a_17951_1640# vss sky130_fd_pr__nfet_01v8_lvt ad=0.825 pd=5.33 as=0.825 ps=5.33 w=5 l=0.15
X19 a_n4996_714# clkp vdd vss sky130_fd_pr__nfet_01v8_lvt ad=1.55 pd=10.62 as=0.825 ps=5.33 w=5 l=0.15
X20 a_n3290_1728# a_n3198_1728# a_n3261_1640# vss sky130_fd_pr__nfet_01v8_lvt ad=0.825 pd=5.33 as=0.825 ps=5.33 w=5 l=0.15
X21 a_5831_626# q2n a_5722_n300# vss sky130_fd_pr__nfet_01v8_lvt ad=0.495 pd=3.33 as=0.495 ps=3.33 w=3 l=0.15
X22 a_18014_614# q8n a_18014_1728# vss sky130_fd_pr__nfet_01v8_lvt ad=0.825 pd=5.33 as=0.825 ps=5.33 w=5 l=0.15
X23 a_5802_714# a_5831_626# vdd vss sky130_fd_pr__nfet_01v8_lvt ad=1.55 pd=10.62 as=0.825 ps=5.33 w=5 l=0.15
X24 a_11026_n300# a_n3862_n388# vss vss sky130_fd_pr__nfet_01v8 ad=0.435 pd=3.29 as=0.435 ps=3.29 w=3 l=0.5
X25 a_18014_614# q8p a_17951_1640# vss sky130_fd_pr__nfet_01v8_lvt ad=0.825 pd=5.33 as=0.825 ps=5.33 w=5 l=0.15
X26 q2p q2n a_408_614# vss sky130_fd_pr__nfet_01v8_lvt ad=0.825 pd=5.33 as=0.825 ps=5.33 w=5 l=0.15
X27 a_n4996_714# clkp vdd vss sky130_fd_pr__nfet_01v8_lvt ad=0.825 pd=5.33 as=0.825 ps=5.33 w=5 l=0.15
X28 a_228_n300# a_n3862_n388# vss vss sky130_fd_pr__nfet_01v8 ad=0.435 pd=3.29 as=0.435 ps=3.29 w=3 l=0.5
X29 a_5722_n300# vbias vss vss sky130_fd_pr__nfet_01v8 ad=0.435 pd=3.29 as=0.87 ps=6.58 w=3 l=0.5
X30 vdd clkp a_n4996_714# vss sky130_fd_pr__nfet_01v8_lvt ad=0.825 pd=5.33 as=0.825 ps=5.33 w=5 l=0.15
X31 q4p q4n a_11114_1728# vss sky130_fd_pr__nfet_01v8_lvt ad=0.825 pd=5.33 as=1.55 ps=10.62 w=5 l=0.15
X32 a_24235_4312# q4p a_16520_n300# vss sky130_fd_pr__nfet_01v8_lvt ad=0.495 pd=3.33 as=0.495 ps=3.33 w=3 l=0.15
X33 vss a_n3862_n388# a_n3762_n300# vss sky130_fd_pr__nfet_01v8 ad=0.435 pd=3.29 as=0.435 ps=3.29 w=3 l=0.5
X34 a_21824_n300# a_n3862_n388# vss vss sky130_fd_pr__nfet_01v8 ad=0.435 pd=3.29 as=0.435 ps=3.29 w=3 l=0.5
X35 a_n1881_526# clkn vdd vss sky130_fd_pr__nfet_01v8_lvt ad=0.825 pd=5.33 as=0.825 ps=5.33 w=5 l=0.15
X36 vdd clkp a_n4996_714# vss sky130_fd_pr__nfet_01v8_lvt ad=0.825 pd=5.33 as=0.825 ps=5.33 w=5 l=0.15
X37 vdd clkp a_n4996_714# vss sky130_fd_pr__nfet_01v8_lvt ad=0.825 pd=5.33 as=1.55 ps=10.62 w=5 l=0.15
X38 a_n4996_714# clkp vdd vss sky130_fd_pr__nfet_01v8_lvt ad=0.825 pd=5.33 as=0.825 ps=5.33 w=5 l=0.15
X39 vdd a_n5001_4543# a_n3862_n388# vdd sky130_fd_pr__pfet_01v8 ad=1.74 pd=12.58 as=0.87 ps=6.29 w=6 l=0.5
X40 q2n a_n3261_1640# a_1134_3042# vss sky130_fd_pr__nfet_01v8_lvt ad=0.825 pd=5.33 as=0.825 ps=5.33 w=5 l=0.15
X41 a_1134_3042# a_n3198_1728# q2p vss sky130_fd_pr__nfet_01v8_lvt ad=1.55 pd=10.62 as=0.825 ps=5.33 w=5 l=0.15
X42 vdd a_16629_626# a_16600_714# vss sky130_fd_pr__nfet_01v8_lvt ad=0.825 pd=5.33 as=0.825 ps=5.33 w=5 l=0.15
X43 vdd a_24235_4312# a_19715_526# vss sky130_fd_pr__nfet_01v8_lvt ad=0.825 pd=5.33 as=1.55 ps=10.62 w=5 l=0.15
X44 vss vbias a_16520_n300# vss sky130_fd_pr__nfet_01v8 ad=0.87 pd=6.58 as=0.435 ps=3.29 w=3 l=0.5
X45 vss a_n3862_n388# a_7036_n300# vss sky130_fd_pr__nfet_01v8 ad=0.435 pd=3.29 as=0.435 ps=3.29 w=3 l=0.5
X46 vdd clkn a_n1881_526# vss sky130_fd_pr__nfet_01v8_lvt ad=0.825 pd=5.33 as=1.55 ps=10.62 w=5 l=0.15
X47 a_7036_n300# a_n3862_n388# vss vss sky130_fd_pr__nfet_01v8 ad=0.435 pd=3.29 as=0.435 ps=3.29 w=3 l=0.5
X48 q8n q8p a_21912_1728# vss sky130_fd_pr__nfet_01v8_lvt ad=0.825 pd=5.33 as=1.55 ps=10.62 w=5 l=0.15
X49 vdd clkp a_n4996_714# vss sky130_fd_pr__nfet_01v8_lvt ad=0.825 pd=5.33 as=0.825 ps=5.33 w=5 l=0.15
X50 a_n1881_526# clkn vdd vss sky130_fd_pr__nfet_01v8_lvt ad=0.825 pd=5.33 as=0.825 ps=5.33 w=5 l=0.15
X51 a_17834_n300# a_n3862_n388# vss vss sky130_fd_pr__nfet_01v8 ad=0.435 pd=3.29 as=0.435 ps=3.29 w=3 l=0.5
X52 a_n4996_714# clkp vdd vss sky130_fd_pr__nfet_01v8_lvt ad=0.825 pd=5.33 as=0.825 ps=5.33 w=5 l=0.15
X53 a_7124_1728# a_7153_1640# a_7216_1728# vss sky130_fd_pr__nfet_01v8_lvt ad=0.825 pd=5.33 as=0.825 ps=5.33 w=5 l=0.15
X54 a_n3582_614# q2p a_n3261_1640# vss sky130_fd_pr__nfet_01v8_lvt ad=1.55 pd=10.62 as=0.825 ps=5.33 w=5 l=0.15
X55 q2n q2p a_408_614# vss sky130_fd_pr__nfet_01v8_lvt ad=0.825 pd=5.33 as=0.825 ps=5.33 w=5 l=0.15
X56 q4n q4p a_11114_1728# vss sky130_fd_pr__nfet_01v8_lvt ad=0.825 pd=5.33 as=0.825 ps=5.33 w=5 l=0.15
X57 vdd a_13437_4312# a_8917_526# vss sky130_fd_pr__nfet_01v8_lvt ad=0.825 pd=5.33 as=0.825 ps=5.33 w=5 l=0.15
X58 vdd clkn a_n1881_526# vss sky130_fd_pr__nfet_01v8_lvt ad=0.825 pd=5.33 as=0.825 ps=5.33 w=5 l=0.15
X59 a_n1881_526# clkn vdd vss sky130_fd_pr__nfet_01v8_lvt ad=0.825 pd=5.33 as=0.825 ps=5.33 w=5 l=0.15
X60 a_21824_n300# a_n3862_n388# vss vss sky130_fd_pr__nfet_01v8 ad=0.435 pd=3.29 as=0.435 ps=3.29 w=3 l=0.5
X61 vss a_n3862_n388# a_228_n300# vss sky130_fd_pr__nfet_01v8 ad=0.435 pd=3.29 as=0.435 ps=3.29 w=3 l=0.5
X62 q4p a_7216_1728# a_11932_3042# vss sky130_fd_pr__nfet_01v8_lvt ad=0.825 pd=5.33 as=0.825 ps=5.33 w=5 l=0.15
X63 a_228_n300# a_n3862_n388# vss vss sky130_fd_pr__nfet_01v8 ad=0.435 pd=3.29 as=0.435 ps=3.29 w=3 l=0.5
X64 a_5831_626# q2n a_5722_n300# vss sky130_fd_pr__nfet_01v8_lvt ad=0.495 pd=3.33 as=0.93 ps=6.62 w=3 l=0.15
X65 a_n3762_n300# a_n3862_n388# vss vss sky130_fd_pr__nfet_01v8 ad=0.435 pd=3.29 as=0.435 ps=3.29 w=3 l=0.5
X66 q8p q8n a_21912_1728# vss sky130_fd_pr__nfet_01v8_lvt ad=0.825 pd=5.33 as=0.825 ps=5.33 w=5 l=0.15
X67 a_17922_1728# a_17951_1640# a_18014_1728# vss sky130_fd_pr__nfet_01v8_lvt ad=0.825 pd=5.33 as=0.825 ps=5.33 w=5 l=0.15
X68 a_n1881_526# clkn vdd vss sky130_fd_pr__nfet_01v8_lvt ad=0.825 pd=5.33 as=0.825 ps=5.33 w=5 l=0.15
X69 vdd clkn a_n1881_526# vss sky130_fd_pr__nfet_01v8_lvt ad=0.825 pd=5.33 as=0.825 ps=5.33 w=5 l=0.15
X70 a_17834_n300# a_n3862_n388# vss vss sky130_fd_pr__nfet_01v8 ad=0.435 pd=3.29 as=0.435 ps=3.29 w=3 l=0.5
X71 a_n1881_526# clkn vdd vss sky130_fd_pr__nfet_01v8_lvt ad=1.55 pd=10.62 as=0.825 ps=5.33 w=5 l=0.15
X72 vss a_n3862_n388# a_17834_n300# vss sky130_fd_pr__nfet_01v8 ad=0.435 pd=3.29 as=0.435 ps=3.29 w=3 l=0.5
X73 a_17922_1728# a_19715_526# a_17834_n300# vss sky130_fd_pr__nfet_01v8_lvt ad=0.66 pd=4.33 as=0.66 ps=4.33 w=4 l=0.15
X74 a_17834_n300# a_19715_526# a_17922_1728# vss sky130_fd_pr__nfet_01v8_lvt ad=0.66 pd=4.33 as=0.66 ps=4.33 w=4 l=0.15
X75 vdd clkn a_n1881_526# vss sky130_fd_pr__nfet_01v8_lvt ad=0.825 pd=5.33 as=0.825 ps=5.33 w=5 l=0.15
X76 a_17834_n300# a_19715_526# a_17922_1728# vss sky130_fd_pr__nfet_01v8_lvt ad=0.66 pd=4.33 as=0.66 ps=4.33 w=4 l=0.15
X77 a_17834_n300# a_19715_526# a_17922_1728# vss sky130_fd_pr__nfet_01v8_lvt ad=0.66 pd=4.33 as=0.66 ps=4.33 w=4 l=0.15
X78 a_17922_1728# a_19715_526# a_17834_n300# vss sky130_fd_pr__nfet_01v8_lvt ad=0.66 pd=4.33 as=0.66 ps=4.33 w=4 l=0.15
X79 a_5722_n300# q2n a_5831_626# vss sky130_fd_pr__nfet_01v8_lvt ad=0.93 pd=6.62 as=0.495 ps=3.33 w=3 l=0.15
X80 a_17922_1728# a_19715_526# a_17834_n300# vss sky130_fd_pr__nfet_01v8_lvt ad=0.66 pd=4.33 as=0.66 ps=4.33 w=4 l=0.15
X81 vss a_n3862_n388# a_7036_n300# vss sky130_fd_pr__nfet_01v8 ad=0.435 pd=3.29 as=0.435 ps=3.29 w=3 l=0.5
X82 a_21912_1728# q8n q8p vss sky130_fd_pr__nfet_01v8_lvt ad=0.825 pd=5.33 as=0.825 ps=5.33 w=5 l=0.15
X83 a_11026_n300# a_n3862_n388# vss vss sky130_fd_pr__nfet_01v8 ad=0.435 pd=3.29 as=0.435 ps=3.29 w=3 l=0.5
X84 a_11026_n300# a_n3862_n388# vss vss sky130_fd_pr__nfet_01v8 ad=0.435 pd=3.29 as=0.435 ps=3.29 w=3 l=0.5
X85 a_408_614# q2n q2p vss sky130_fd_pr__nfet_01v8_lvt ad=1.55 pd=10.62 as=0.825 ps=5.33 w=5 l=0.15
X86 vdd a_16629_626# a_16600_714# vss sky130_fd_pr__nfet_01v8_lvt ad=0.825 pd=5.33 as=0.825 ps=5.33 w=5 l=0.15
X87 a_7153_1640# q4p a_7216_614# vss sky130_fd_pr__nfet_01v8_lvt ad=0.825 pd=5.33 as=0.825 ps=5.33 w=5 l=0.15
X88 a_n3290_1728# a_n1881_526# a_n3762_n300# vss sky130_fd_pr__nfet_01v8_lvt ad=0.66 pd=4.33 as=0.66 ps=4.33 w=4 l=0.15
X89 a_7216_614# q4n a_7216_1728# vss sky130_fd_pr__nfet_01v8_lvt ad=1.55 pd=10.62 as=0.825 ps=5.33 w=5 l=0.15
X90 a_11114_1728# q4n q4p vss sky130_fd_pr__nfet_01v8_lvt ad=0.825 pd=5.33 as=0.825 ps=5.33 w=5 l=0.15
X91 a_17834_n300# a_19715_526# a_17922_1728# vss sky130_fd_pr__nfet_01v8_lvt ad=0.66 pd=4.33 as=0.66 ps=4.33 w=4 l=0.15
X92 a_17922_1728# a_19715_526# a_17834_n300# vss sky130_fd_pr__nfet_01v8_lvt ad=0.66 pd=4.33 as=0.66 ps=4.33 w=4 l=0.15
X93 a_17834_n300# a_19715_526# a_17922_1728# vss sky130_fd_pr__nfet_01v8_lvt ad=0.66 pd=4.33 as=0.66 ps=4.33 w=4 l=0.15
X94 a_7036_n300# a_5802_714# a_7216_614# vss sky130_fd_pr__nfet_01v8_lvt ad=0.66 pd=4.33 as=0.66 ps=4.33 w=4 l=0.15
X95 a_21824_n300# a_n3862_n388# vss vss sky130_fd_pr__nfet_01v8 ad=0.435 pd=3.29 as=0.435 ps=3.29 w=3 l=0.5
X96 a_n3762_n300# a_n1881_526# a_n3290_1728# vss sky130_fd_pr__nfet_01v8_lvt ad=1.24 pd=8.62 as=0.66 ps=4.33 w=4 l=0.15
X97 a_n3862_n388# a_n5001_4543# vdd vdd sky130_fd_pr__pfet_01v8 ad=0.87 pd=6.29 as=0.87 ps=6.29 w=6 l=0.5
X98 a_22730_3042# a_19715_526# a_21824_n300# vss sky130_fd_pr__nfet_01v8_lvt ad=0.66 pd=4.33 as=0.66 ps=4.33 w=4 l=0.15
X99 a_17922_1728# a_19715_526# a_17834_n300# vss sky130_fd_pr__nfet_01v8_lvt ad=0.66 pd=4.33 as=0.66 ps=4.33 w=4 l=0.15
X100 vdd a_n5001_4543# a_n3862_n388# vdd sky130_fd_pr__pfet_01v8 ad=0.87 pd=6.29 as=0.87 ps=6.29 w=6 l=0.5
X101 vdd clkp a_n4996_714# vss sky130_fd_pr__nfet_01v8_lvt ad=0.825 pd=5.33 as=0.825 ps=5.33 w=5 l=0.15
X102 a_16629_626# q4n a_16520_n300# vss sky130_fd_pr__nfet_01v8_lvt ad=0.495 pd=3.33 as=0.495 ps=3.33 w=3 l=0.15
X103 a_24235_4312# q4p a_16520_n300# vss sky130_fd_pr__nfet_01v8_lvt ad=0.495 pd=3.33 as=0.93 ps=6.62 w=3 l=0.15
X104 vdd a_n5001_4543# a_n5001_4543# vdd sky130_fd_pr__pfet_01v8 ad=0.87 pd=6.29 as=0.87 ps=6.29 w=6 l=0.5
X105 a_21912_1728# q8p q8n vss sky130_fd_pr__nfet_01v8_lvt ad=1.55 pd=10.62 as=0.825 ps=5.33 w=5 l=0.15
X106 q4p q4n a_11114_1728# vss sky130_fd_pr__nfet_01v8_lvt ad=0.825 pd=5.33 as=0.825 ps=5.33 w=5 l=0.15
X107 a_7216_614# a_5802_714# a_7036_n300# vss sky130_fd_pr__nfet_01v8_lvt ad=0.66 pd=4.33 as=0.66 ps=4.33 w=4 l=0.15
X108 a_7036_n300# a_5802_714# a_7216_614# vss sky130_fd_pr__nfet_01v8_lvt ad=0.66 pd=4.33 as=0.66 ps=4.33 w=4 l=0.15
X109 a_17834_n300# a_n3862_n388# vss vss sky130_fd_pr__nfet_01v8 ad=0.435 pd=3.29 as=0.435 ps=3.29 w=3 l=0.5
X110 a_21824_n300# a_19715_526# a_22730_3042# vss sky130_fd_pr__nfet_01v8_lvt ad=0.66 pd=4.33 as=0.66 ps=4.33 w=4 l=0.15
X111 a_7036_n300# a_n3862_n388# vss vss sky130_fd_pr__nfet_01v8 ad=0.435 pd=3.29 as=0.435 ps=3.29 w=3 l=0.5
X112 vss a_n3862_n388# a_7036_n300# vss sky130_fd_pr__nfet_01v8 ad=0.435 pd=3.29 as=0.435 ps=3.29 w=3 l=0.5
X113 a_13437_4312# q2p a_5722_n300# vss sky130_fd_pr__nfet_01v8_lvt ad=0.495 pd=3.33 as=0.495 ps=3.33 w=3 l=0.15
X114 a_7216_1728# a_7153_1640# a_7124_1728# vss sky130_fd_pr__nfet_01v8_lvt ad=0.825 pd=5.33 as=0.825 ps=5.33 w=5 l=0.15
X115 vss a_n3862_n388# a_n3762_n300# vss sky130_fd_pr__nfet_01v8 ad=0.435 pd=3.29 as=0.435 ps=3.29 w=3 l=0.5
X116 a_n3261_1640# q2p a_n3582_614# vss sky130_fd_pr__nfet_01v8_lvt ad=0.825 pd=5.33 as=1.55 ps=10.62 w=5 l=0.15
X117 a_16600_714# a_16629_626# vdd vss sky130_fd_pr__nfet_01v8_lvt ad=0.825 pd=5.33 as=0.825 ps=5.33 w=5 l=0.15
X118 vdd a_16629_626# a_16600_714# vss sky130_fd_pr__nfet_01v8_lvt ad=0.825 pd=5.33 as=1.55 ps=10.62 w=5 l=0.15
X119 a_7216_614# a_5802_714# a_7036_n300# vss sky130_fd_pr__nfet_01v8_lvt ad=0.66 pd=4.33 as=0.66 ps=4.33 w=4 l=0.15
X120 a_11114_1728# q4p q4n vss sky130_fd_pr__nfet_01v8_lvt ad=0.825 pd=5.33 as=0.825 ps=5.33 w=5 l=0.15
X121 a_8917_526# a_13437_4312# vdd vss sky130_fd_pr__nfet_01v8_lvt ad=0.825 pd=5.33 as=0.825 ps=5.33 w=5 l=0.15
X122 a_7036_n300# a_5802_714# a_7216_614# vss sky130_fd_pr__nfet_01v8_lvt ad=0.66 pd=4.33 as=0.66 ps=4.33 w=4 l=0.15
X123 a_22730_3042# a_19715_526# a_21824_n300# vss sky130_fd_pr__nfet_01v8_lvt ad=0.66 pd=4.33 as=0.66 ps=4.33 w=4 l=0.15
X124 a_n3261_1640# a_n3198_1728# a_n3290_1728# vss sky130_fd_pr__nfet_01v8_lvt ad=0.825 pd=5.33 as=0.825 ps=5.33 w=5 l=0.15
X125 a_21824_n300# a_19715_526# a_22730_3042# vss sky130_fd_pr__nfet_01v8_lvt ad=0.66 pd=4.33 as=0.66 ps=4.33 w=4 l=0.15
X126 a_18014_614# a_16600_714# a_17834_n300# vss sky130_fd_pr__nfet_01v8_lvt ad=0.66 pd=4.33 as=1.24 ps=8.62 w=4 l=0.15
X127 vss a_n3862_n388# a_228_n300# vss sky130_fd_pr__nfet_01v8 ad=0.435 pd=3.29 as=0.435 ps=3.29 w=3 l=0.5
X128 vdd a_16629_626# a_16600_714# vss sky130_fd_pr__nfet_01v8_lvt ad=0.825 pd=5.33 as=0.825 ps=5.33 w=5 l=0.15
X129 a_7216_614# a_5802_714# a_7036_n300# vss sky130_fd_pr__nfet_01v8_lvt ad=0.66 pd=4.33 as=0.66 ps=4.33 w=4 l=0.15
X130 a_n3762_n300# a_n3862_n388# vss vss sky130_fd_pr__nfet_01v8 ad=0.435 pd=3.29 as=0.435 ps=3.29 w=3 l=0.5
X131 a_7036_n300# a_5802_714# a_7216_614# vss sky130_fd_pr__nfet_01v8_lvt ad=1.24 pd=8.62 as=0.66 ps=4.33 w=4 l=0.15
X132 a_17834_n300# a_n3862_n388# vss vss sky130_fd_pr__nfet_01v8 ad=0.435 pd=3.29 as=0.435 ps=3.29 w=3 l=0.5
X133 vss a_n3862_n388# a_17834_n300# vss sky130_fd_pr__nfet_01v8 ad=0.435 pd=3.29 as=0.435 ps=3.29 w=3 l=0.5
X134 a_7124_1728# a_7153_1640# a_7216_1728# vss sky130_fd_pr__nfet_01v8_lvt ad=0.825 pd=5.33 as=0.825 ps=5.33 w=5 l=0.15
X135 a_7036_n300# a_n3862_n388# vss vss sky130_fd_pr__nfet_01v8 ad=0.435 pd=3.29 as=0.435 ps=3.29 w=3 l=0.5
X136 a_17922_1728# a_17951_1640# a_18014_1728# vss sky130_fd_pr__nfet_01v8_lvt ad=0.825 pd=5.33 as=0.825 ps=5.33 w=5 l=0.15
X137 a_16600_714# a_16629_626# vdd vss sky130_fd_pr__nfet_01v8_lvt ad=0.825 pd=5.33 as=0.825 ps=5.33 w=5 l=0.15
X138 a_n3198_1728# q2n a_n3582_614# vss sky130_fd_pr__nfet_01v8_lvt ad=0.825 pd=5.33 as=1.55 ps=10.62 w=5 l=0.15
X139 a_16629_626# q4n a_16520_n300# vss sky130_fd_pr__nfet_01v8_lvt ad=0.495 pd=3.33 as=0.495 ps=3.33 w=3 l=0.15
X140 a_11026_n300# a_n3862_n388# vss vss sky130_fd_pr__nfet_01v8 ad=0.435 pd=3.29 as=0.435 ps=3.29 w=3 l=0.5
X141 vss a_n3862_n388# a_11026_n300# vss sky130_fd_pr__nfet_01v8 ad=0.435 pd=3.29 as=0.435 ps=3.29 w=3 l=0.5
X142 a_21912_1728# q8p q8n vss sky130_fd_pr__nfet_01v8_lvt ad=0.825 pd=5.33 as=0.825 ps=5.33 w=5 l=0.15
X143 a_7124_1728# a_8917_526# a_7036_n300# vss sky130_fd_pr__nfet_01v8_lvt ad=0.66 pd=4.33 as=0.66 ps=4.33 w=4 l=0.15
X144 a_7036_n300# a_8917_526# a_7124_1728# vss sky130_fd_pr__nfet_01v8_lvt ad=0.66 pd=4.33 as=0.66 ps=4.33 w=4 l=0.15
X145 q4p q4n a_11114_1728# vss sky130_fd_pr__nfet_01v8_lvt ad=0.825 pd=5.33 as=0.825 ps=5.33 w=5 l=0.15
X146 a_17922_1728# a_18014_1728# a_17951_1640# vss sky130_fd_pr__nfet_01v8_lvt ad=1.55 pd=10.62 as=0.825 ps=5.33 w=5 l=0.15
X147 a_n4996_714# vbias vss vss sky130_fd_pr__nfet_01v8 ad=1.16 pd=8.58 as=1.16 ps=8.58 w=4 l=0.5
X148 vss a_n3862_n388# a_21824_n300# vss sky130_fd_pr__nfet_01v8 ad=0.87 pd=6.58 as=0.435 ps=3.29 w=3 l=0.5
X149 a_7036_n300# a_8917_526# a_7124_1728# vss sky130_fd_pr__nfet_01v8_lvt ad=0.66 pd=4.33 as=0.66 ps=4.33 w=4 l=0.15
X150 a_21824_n300# a_n3862_n388# vss vss sky130_fd_pr__nfet_01v8 ad=0.435 pd=3.29 as=0.435 ps=3.29 w=3 l=0.5
X151 a_7036_n300# a_8917_526# a_7124_1728# vss sky130_fd_pr__nfet_01v8_lvt ad=0.66 pd=4.33 as=0.66 ps=4.33 w=4 l=0.15
X152 a_7124_1728# a_8917_526# a_7036_n300# vss sky130_fd_pr__nfet_01v8_lvt ad=0.66 pd=4.33 as=0.66 ps=4.33 w=4 l=0.15
X153 a_7124_1728# a_8917_526# a_7036_n300# vss sky130_fd_pr__nfet_01v8_lvt ad=0.66 pd=4.33 as=0.66 ps=4.33 w=4 l=0.15
X154 a_n3862_n388# a_n5001_4543# vdd vdd sky130_fd_pr__pfet_01v8 ad=0.87 pd=6.29 as=1.74 ps=12.58 w=6 l=0.5
X155 a_n4996_714# clkp vdd vss sky130_fd_pr__nfet_01v8_lvt ad=0.825 pd=5.33 as=0.825 ps=5.33 w=5 l=0.15
X156 a_n3290_1728# a_n3261_1640# a_n3198_1728# vss sky130_fd_pr__nfet_01v8_lvt ad=0.825 pd=5.33 as=0.825 ps=5.33 w=5 l=0.15
X157 vss a_n3862_n388# a_21824_n300# vss sky130_fd_pr__nfet_01v8 ad=0.435 pd=3.29 as=0.435 ps=3.29 w=3 l=0.5
X158 a_228_n300# a_n3862_n388# vss vss sky130_fd_pr__nfet_01v8 ad=0.435 pd=3.29 as=0.435 ps=3.29 w=3 l=0.5
X159 vdd a_n5001_4543# a_n5001_4543# vdd sky130_fd_pr__pfet_01v8 ad=1.74 pd=12.58 as=0.87 ps=6.29 w=6 l=0.5
X160 a_17834_n300# a_n3862_n388# vss vss sky130_fd_pr__nfet_01v8 ad=0.435 pd=3.29 as=0.435 ps=3.29 w=3 l=0.5
X161 q8p q8n a_21912_1728# vss sky130_fd_pr__nfet_01v8_lvt ad=0.825 pd=5.33 as=0.825 ps=5.33 w=5 l=0.15
X162 vdd a_16629_626# vss sky130_fd_pr__res_high_po_2p85 l=4.14
X163 a_11114_1728# q4n q4p vss sky130_fd_pr__nfet_01v8_lvt ad=0.825 pd=5.33 as=0.825 ps=5.33 w=5 l=0.15
X164 vss a_n3862_n388# a_n3762_n300# vss sky130_fd_pr__nfet_01v8 ad=0.435 pd=3.29 as=0.435 ps=3.29 w=3 l=0.5
X165 a_7036_n300# a_8917_526# a_7124_1728# vss sky130_fd_pr__nfet_01v8_lvt ad=0.66 pd=4.33 as=0.66 ps=4.33 w=4 l=0.15
X166 a_7124_1728# a_8917_526# a_7036_n300# vss sky130_fd_pr__nfet_01v8_lvt ad=0.66 pd=4.33 as=0.66 ps=4.33 w=4 l=0.15
X167 a_7036_n300# a_8917_526# a_7124_1728# vss sky130_fd_pr__nfet_01v8_lvt ad=0.66 pd=4.33 as=0.66 ps=4.33 w=4 l=0.15
X168 a_17951_1640# a_18014_1728# a_17922_1728# vss sky130_fd_pr__nfet_01v8_lvt ad=0.825 pd=5.33 as=0.825 ps=5.33 w=5 l=0.15
X169 a_228_n300# a_n3862_n388# vss vss sky130_fd_pr__nfet_01v8 ad=0.435 pd=3.29 as=0.435 ps=3.29 w=3 l=0.5
X170 a_5722_n300# q2p a_13437_4312# vss sky130_fd_pr__nfet_01v8_lvt ad=0.495 pd=3.33 as=0.495 ps=3.33 w=3 l=0.15
X171 a_7153_1640# a_7216_1728# a_7124_1728# vss sky130_fd_pr__nfet_01v8_lvt ad=0.825 pd=5.33 as=0.825 ps=5.33 w=5 l=0.15
X172 a_17951_1640# a_18014_1728# a_17922_1728# vss sky130_fd_pr__nfet_01v8_lvt ad=0.825 pd=5.33 as=1.55 ps=10.62 w=5 l=0.15
X173 vdd q8n vss sky130_fd_pr__res_high_po_2p85 l=4.14
X174 a_11026_n300# a_8917_526# a_11932_3042# vss sky130_fd_pr__nfet_01v8_lvt ad=0.66 pd=4.33 as=0.66 ps=4.33 w=4 l=0.15
X175 a_7124_1728# a_8917_526# a_7036_n300# vss sky130_fd_pr__nfet_01v8_lvt ad=0.66 pd=4.33 as=0.66 ps=4.33 w=4 l=0.15
X176 a_n3261_1640# a_n3198_1728# a_n3290_1728# vss sky130_fd_pr__nfet_01v8_lvt ad=0.825 pd=5.33 as=0.825 ps=5.33 w=5 l=0.15
X177 a_7153_1640# a_7216_1728# a_7124_1728# vss sky130_fd_pr__nfet_01v8_lvt ad=0.825 pd=5.33 as=0.825 ps=5.33 w=5 l=0.15
X178 vdd a_7216_1728# vss sky130_fd_pr__res_high_po_2p85 l=4.14
X179 a_18014_1728# q8n a_18014_614# vss sky130_fd_pr__nfet_01v8_lvt ad=0.825 pd=5.33 as=1.55 ps=10.62 w=5 l=0.15
X180 a_228_n300# a_n3862_n388# vss vss sky130_fd_pr__nfet_01v8 ad=0.435 pd=3.29 as=0.435 ps=3.29 w=3 l=0.5
X181 a_7216_1728# a_7153_1640# a_7124_1728# vss sky130_fd_pr__nfet_01v8_lvt ad=0.825 pd=5.33 as=0.825 ps=5.33 w=5 l=0.15
X182 vss a_n3862_n388# a_228_n300# vss sky130_fd_pr__nfet_01v8 ad=0.435 pd=3.29 as=0.435 ps=3.29 w=3 l=0.5
X183 vss a_n3862_n388# a_n3762_n300# vss sky130_fd_pr__nfet_01v8 ad=0.435 pd=3.29 as=0.435 ps=3.29 w=3 l=0.5
X184 vdd a_24235_4312# a_19715_526# vss sky130_fd_pr__nfet_01v8_lvt ad=0.825 pd=5.33 as=0.825 ps=5.33 w=5 l=0.15
X185 q8n q8p a_21912_1728# vss sky130_fd_pr__nfet_01v8_lvt ad=0.825 pd=5.33 as=0.825 ps=5.33 w=5 l=0.15
X186 a_18014_1728# a_17951_1640# a_17922_1728# vss sky130_fd_pr__nfet_01v8_lvt ad=0.825 pd=5.33 as=0.825 ps=5.33 w=5 l=0.15
X187 vdd clkn a_n1881_526# vss sky130_fd_pr__nfet_01v8_lvt ad=0.825 pd=5.33 as=0.825 ps=5.33 w=5 l=0.15
X188 vss a_n3862_n388# a_17834_n300# vss sky130_fd_pr__nfet_01v8 ad=0.87 pd=6.58 as=0.435 ps=3.29 w=3 l=0.5
X189 q2p a_n3198_1728# a_1134_3042# vss sky130_fd_pr__nfet_01v8_lvt ad=0.825 pd=5.33 as=0.825 ps=5.33 w=5 l=0.15
X190 vdd q8p vss sky130_fd_pr__res_high_po_2p85 l=4.14
X191 a_17834_n300# a_n3862_n388# vss vss sky130_fd_pr__nfet_01v8 ad=0.435 pd=3.29 as=0.435 ps=3.29 w=3 l=0.5
X192 a_7036_n300# a_n3862_n388# vss vss sky130_fd_pr__nfet_01v8 ad=0.435 pd=3.29 as=0.435 ps=3.29 w=3 l=0.5
X193 a_17922_1728# a_17951_1640# a_18014_1728# vss sky130_fd_pr__nfet_01v8_lvt ad=0.825 pd=5.33 as=0.825 ps=5.33 w=5 l=0.15
X194 vdd q2p vss sky130_fd_pr__res_high_po_2p85 l=4.14
X195 a_408_614# q2p q2n vss sky130_fd_pr__nfet_01v8_lvt ad=0.825 pd=5.33 as=0.825 ps=5.33 w=5 l=0.15
X196 a_7216_1728# a_7153_1640# a_7124_1728# vss sky130_fd_pr__nfet_01v8_lvt ad=0.825 pd=5.33 as=1.55 ps=10.62 w=5 l=0.15
X197 a_8917_526# a_13437_4312# vdd vss sky130_fd_pr__nfet_01v8_lvt ad=0.825 pd=5.33 as=0.825 ps=5.33 w=5 l=0.15
X198 a_11114_1728# q4p q4n vss sky130_fd_pr__nfet_01v8_lvt ad=0.825 pd=5.33 as=0.825 ps=5.33 w=5 l=0.15
X199 vss a_n3862_n388# a_21824_n300# vss sky130_fd_pr__nfet_01v8 ad=0.435 pd=3.29 as=0.435 ps=3.29 w=3 l=0.5
X200 a_21912_1728# q8n q8p vss sky130_fd_pr__nfet_01v8_lvt ad=0.825 pd=5.33 as=0.825 ps=5.33 w=5 l=0.15
X201 a_228_n300# a_n3862_n388# vss vss sky130_fd_pr__nfet_01v8 ad=0.435 pd=3.29 as=0.435 ps=3.29 w=3 l=0.5
X202 a_21824_n300# a_16600_714# a_21912_1728# vss sky130_fd_pr__nfet_01v8_lvt ad=0.66 pd=4.33 as=0.66 ps=4.33 w=4 l=0.15
X203 a_17834_n300# a_n3862_n388# vss vss sky130_fd_pr__nfet_01v8 ad=0.435 pd=3.29 as=0.435 ps=3.29 w=3 l=0.5
X204 vss a_n3862_n388# a_n3762_n300# vss sky130_fd_pr__nfet_01v8 ad=0.435 pd=3.29 as=0.435 ps=3.29 w=3 l=0.5
X205 a_n4996_714# clkp vdd vss sky130_fd_pr__nfet_01v8_lvt ad=1.55 pd=10.62 as=0.825 ps=5.33 w=5 l=0.15
X206 a_11114_1728# q4p q4n vss sky130_fd_pr__nfet_01v8_lvt ad=0.825 pd=5.33 as=0.825 ps=5.33 w=5 l=0.15
X207 vdd a_17951_1640# vss sky130_fd_pr__res_high_po_2p85 l=4.14
X208 a_21824_n300# a_16600_714# a_21912_1728# vss sky130_fd_pr__nfet_01v8_lvt ad=0.66 pd=4.33 as=0.66 ps=4.33 w=4 l=0.15
X209 a_17951_1640# a_18014_1728# a_17922_1728# vss sky130_fd_pr__nfet_01v8_lvt ad=0.825 pd=5.33 as=0.825 ps=5.33 w=5 l=0.15
X210 a_7153_1640# a_7216_1728# a_7124_1728# vss sky130_fd_pr__nfet_01v8_lvt ad=0.825 pd=5.33 as=0.825 ps=5.33 w=5 l=0.15
X211 vss vbias a_16520_n300# vss sky130_fd_pr__nfet_01v8 ad=0.87 pd=6.58 as=0.435 ps=3.29 w=3 l=0.5
X212 q8p q8n a_21912_1728# vss sky130_fd_pr__nfet_01v8_lvt ad=0.825 pd=5.33 as=0.825 ps=5.33 w=5 l=0.15
X213 q8p a_18014_1728# a_22730_3042# vss sky130_fd_pr__nfet_01v8_lvt ad=0.825 pd=5.33 as=1.55 ps=10.62 w=5 l=0.15
X214 q2p q2n a_408_614# vss sky130_fd_pr__nfet_01v8_lvt ad=0.825 pd=5.33 as=0.825 ps=5.33 w=5 l=0.15
X215 a_21912_1728# a_16600_714# a_21824_n300# vss sky130_fd_pr__nfet_01v8_lvt ad=0.66 pd=4.33 as=0.66 ps=4.33 w=4 l=0.15
X216 a_21824_n300# a_16600_714# a_21912_1728# vss sky130_fd_pr__nfet_01v8_lvt ad=1.24 pd=8.62 as=0.66 ps=4.33 w=4 l=0.15
X217 vss a_n3862_n388# a_11026_n300# vss sky130_fd_pr__nfet_01v8 ad=0.435 pd=3.29 as=0.435 ps=3.29 w=3 l=0.5
X218 a_16600_714# a_16629_626# vdd vss sky130_fd_pr__nfet_01v8_lvt ad=0.825 pd=5.33 as=0.825 ps=5.33 w=5 l=0.15
X219 a_7216_1728# q4n a_7216_614# vss sky130_fd_pr__nfet_01v8_lvt ad=0.825 pd=5.33 as=0.825 ps=5.33 w=5 l=0.15
X220 q4p q4n a_11114_1728# vss sky130_fd_pr__nfet_01v8_lvt ad=0.825 pd=5.33 as=0.825 ps=5.33 w=5 l=0.15
X221 a_228_n300# a_n3862_n388# vss vss sky130_fd_pr__nfet_01v8 ad=0.435 pd=3.29 as=0.435 ps=3.29 w=3 l=0.5
X222 a_24235_4312# q4p a_16520_n300# vss sky130_fd_pr__nfet_01v8_lvt ad=0.495 pd=3.33 as=0.495 ps=3.33 w=3 l=0.15
X223 a_11932_3042# a_7153_1640# q4n vss sky130_fd_pr__nfet_01v8_lvt ad=0.825 pd=5.33 as=0.825 ps=5.33 w=5 l=0.15
X224 vss a_n3862_n388# a_n3762_n300# vss sky130_fd_pr__nfet_01v8 ad=0.435 pd=3.29 as=0.435 ps=3.29 w=3 l=0.5
X225 a_19715_526# a_24235_4312# vdd vss sky130_fd_pr__nfet_01v8_lvt ad=1.55 pd=10.62 as=0.825 ps=5.33 w=5 l=0.15
X226 a_21912_1728# q8p q8n vss sky130_fd_pr__nfet_01v8_lvt ad=0.825 pd=5.33 as=0.825 ps=5.33 w=5 l=0.15
X227 a_n1881_526# clkn vdd vss sky130_fd_pr__nfet_01v8_lvt ad=0.825 pd=5.33 as=0.825 ps=5.33 w=5 l=0.15
X228 a_21912_1728# a_16600_714# a_21824_n300# vss sky130_fd_pr__nfet_01v8_lvt ad=0.66 pd=4.33 as=0.66 ps=4.33 w=4 l=0.15
X229 a_408_614# q2p q2n vss sky130_fd_pr__nfet_01v8_lvt ad=0.825 pd=5.33 as=0.825 ps=5.33 w=5 l=0.15
X230 vdd q4n vss sky130_fd_pr__res_high_po_2p85 l=4.14
X231 a_7036_n300# a_5802_714# a_7216_614# vss sky130_fd_pr__nfet_01v8_lvt ad=0.66 pd=4.33 as=0.66 ps=4.33 w=4 l=0.15
X232 a_5802_714# a_5831_626# vdd vss sky130_fd_pr__nfet_01v8_lvt ad=0.825 pd=5.33 as=0.825 ps=5.33 w=5 l=0.15
X233 vdd a_5831_626# a_5802_714# vss sky130_fd_pr__nfet_01v8_lvt ad=0.825 pd=5.33 as=0.825 ps=5.33 w=5 l=0.15
X234 a_7216_614# a_5802_714# a_7036_n300# vss sky130_fd_pr__nfet_01v8_lvt ad=0.66 pd=4.33 as=0.66 ps=4.33 w=4 l=0.15
X235 a_7036_n300# a_n3862_n388# vss vss sky130_fd_pr__nfet_01v8 ad=0.435 pd=3.29 as=0.435 ps=3.29 w=3 l=0.5
X236 vss a_n3862_n388# a_17834_n300# vss sky130_fd_pr__nfet_01v8 ad=0.435 pd=3.29 as=0.435 ps=3.29 w=3 l=0.5
X237 vss a_n3862_n388# a_11026_n300# vss sky130_fd_pr__nfet_01v8 ad=0.435 pd=3.29 as=0.435 ps=3.29 w=3 l=0.5
X238 a_5722_n300# q2p a_13437_4312# vss sky130_fd_pr__nfet_01v8_lvt ad=0.495 pd=3.33 as=0.495 ps=3.33 w=3 l=0.15
X239 a_7124_1728# a_7153_1640# a_7216_1728# vss sky130_fd_pr__nfet_01v8_lvt ad=0.825 pd=5.33 as=0.825 ps=5.33 w=5 l=0.15
X240 a_n3582_614# q2p a_n3261_1640# vss sky130_fd_pr__nfet_01v8_lvt ad=0.825 pd=5.33 as=0.825 ps=5.33 w=5 l=0.15
X241 vdd a_5831_626# a_5802_714# vss sky130_fd_pr__nfet_01v8_lvt ad=0.825 pd=5.33 as=0.825 ps=5.33 w=5 l=0.15
X242 a_n3762_n300# a_n3862_n388# vss vss sky130_fd_pr__nfet_01v8 ad=0.435 pd=3.29 as=0.435 ps=3.29 w=3 l=0.5
X243 vdd a_13437_4312# a_8917_526# vss sky130_fd_pr__nfet_01v8_lvt ad=0.825 pd=5.33 as=0.825 ps=5.33 w=5 l=0.15
X244 a_7036_n300# a_5802_714# a_7216_614# vss sky130_fd_pr__nfet_01v8_lvt ad=0.66 pd=4.33 as=0.66 ps=4.33 w=4 l=0.15
X245 a_7216_614# a_5802_714# a_7036_n300# vss sky130_fd_pr__nfet_01v8_lvt ad=0.66 pd=4.33 as=1.24 ps=8.62 w=4 l=0.15
X246 a_5802_714# a_5831_626# vdd vss sky130_fd_pr__nfet_01v8_lvt ad=0.825 pd=5.33 as=0.825 ps=5.33 w=5 l=0.15
X247 q4n q4p a_11114_1728# vss sky130_fd_pr__nfet_01v8_lvt ad=0.825 pd=5.33 as=0.825 ps=5.33 w=5 l=0.15
X248 a_22730_3042# a_19715_526# a_21824_n300# vss sky130_fd_pr__nfet_01v8_lvt ad=0.66 pd=4.33 as=0.66 ps=4.33 w=4 l=0.15
X249 a_7216_614# a_5802_714# a_7036_n300# vss sky130_fd_pr__nfet_01v8_lvt ad=0.66 pd=4.33 as=0.66 ps=4.33 w=4 l=0.15
X250 a_21824_n300# a_19715_526# a_22730_3042# vss sky130_fd_pr__nfet_01v8_lvt ad=0.66 pd=4.33 as=0.66 ps=4.33 w=4 l=0.15
X251 a_n3290_1728# a_n3198_1728# a_n3261_1640# vss sky130_fd_pr__nfet_01v8_lvt ad=0.825 pd=5.33 as=0.825 ps=5.33 w=5 l=0.15
X252 a_11026_n300# a_5802_714# a_11114_1728# vss sky130_fd_pr__nfet_01v8_lvt ad=0.66 pd=4.33 as=0.66 ps=4.33 w=4 l=0.15
X253 vss a_n3862_n388# a_21824_n300# vss sky130_fd_pr__nfet_01v8 ad=0.435 pd=3.29 as=0.435 ps=3.29 w=3 l=0.5
X254 q8p q8n a_21912_1728# vss sky130_fd_pr__nfet_01v8_lvt ad=0.825 pd=5.33 as=0.825 ps=5.33 w=5 l=0.15
X255 vdd a_5831_626# a_5802_714# vss sky130_fd_pr__nfet_01v8_lvt ad=0.825 pd=5.33 as=0.825 ps=5.33 w=5 l=0.15
X256 a_21824_n300# a_19715_526# a_22730_3042# vss sky130_fd_pr__nfet_01v8_lvt ad=0.66 pd=4.33 as=0.66 ps=4.33 w=4 l=0.15
X257 a_7216_614# a_5802_714# a_7036_n300# vss sky130_fd_pr__nfet_01v8_lvt ad=0.66 pd=4.33 as=0.66 ps=4.33 w=4 l=0.15
X258 a_228_n300# a_n3862_n388# vss vss sky130_fd_pr__nfet_01v8 ad=0.435 pd=3.29 as=0.435 ps=3.29 w=3 l=0.5
X259 a_5802_714# a_5831_626# vdd vss sky130_fd_pr__nfet_01v8_lvt ad=1.55 pd=10.62 as=0.825 ps=5.33 w=5 l=0.15
X260 a_n3762_n300# a_n3862_n388# vss vss sky130_fd_pr__nfet_01v8 ad=0.435 pd=3.29 as=0.435 ps=3.29 w=3 l=0.5
X261 a_22730_3042# a_19715_526# a_21824_n300# vss sky130_fd_pr__nfet_01v8_lvt ad=0.66 pd=4.33 as=0.66 ps=4.33 w=4 l=0.15
X262 a_7216_614# a_5802_714# a_7036_n300# vss sky130_fd_pr__nfet_01v8_lvt ad=0.66 pd=4.33 as=0.66 ps=4.33 w=4 l=0.15
X263 a_7036_n300# a_5802_714# a_7216_614# vss sky130_fd_pr__nfet_01v8_lvt ad=0.66 pd=4.33 as=0.66 ps=4.33 w=4 l=0.15
X264 vdd q4p vss sky130_fd_pr__res_high_po_2p85 l=4.14
X265 vss a_n3862_n388# a_n3762_n300# vss sky130_fd_pr__nfet_01v8 ad=0.435 pd=3.29 as=0.435 ps=3.29 w=3 l=0.5
X266 a_21824_n300# a_19715_526# a_22730_3042# vss sky130_fd_pr__nfet_01v8_lvt ad=0.66 pd=4.33 as=0.66 ps=4.33 w=4 l=0.15
X267 a_n5001_4543# a_n5001_4543# vdd vdd sky130_fd_pr__pfet_01v8 ad=0.87 pd=6.29 as=1.74 ps=12.58 w=6 l=0.5
X268 a_7216_1728# a_7153_1640# a_7124_1728# vss sky130_fd_pr__nfet_01v8_lvt ad=0.825 pd=5.33 as=0.825 ps=5.33 w=5 l=0.15
X269 vss a_n3862_n388# a_17834_n300# vss sky130_fd_pr__nfet_01v8 ad=0.435 pd=3.29 as=0.435 ps=3.29 w=3 l=0.5
X270 a_11026_n300# a_5802_714# a_11114_1728# vss sky130_fd_pr__nfet_01v8_lvt ad=0.66 pd=4.33 as=0.66 ps=4.33 w=4 l=0.15
X271 a_18014_1728# a_17951_1640# a_17922_1728# vss sky130_fd_pr__nfet_01v8_lvt ad=0.825 pd=5.33 as=0.825 ps=5.33 w=5 l=0.15
X272 a_11114_1728# a_5802_714# a_11026_n300# vss sky130_fd_pr__nfet_01v8_lvt ad=0.66 pd=4.33 as=0.66 ps=4.33 w=4 l=0.15
X273 a_n3582_614# q2n a_n3198_1728# vss sky130_fd_pr__nfet_01v8_lvt ad=0.825 pd=5.33 as=0.825 ps=5.33 w=5 l=0.15
X274 a_21824_n300# a_19715_526# a_22730_3042# vss sky130_fd_pr__nfet_01v8_lvt ad=0.66 pd=4.33 as=0.66 ps=4.33 w=4 l=0.15
X275 a_22730_3042# a_19715_526# a_21824_n300# vss sky130_fd_pr__nfet_01v8_lvt ad=0.66 pd=4.33 as=0.66 ps=4.33 w=4 l=0.15
X276 a_7036_n300# a_5802_714# a_7216_614# vss sky130_fd_pr__nfet_01v8_lvt ad=0.66 pd=4.33 as=0.66 ps=4.33 w=4 l=0.15
X277 a_17922_1728# a_18014_1728# a_17951_1640# vss sky130_fd_pr__nfet_01v8_lvt ad=0.825 pd=5.33 as=0.825 ps=5.33 w=5 l=0.15
X278 a_n5001_4543# vbias vss vss sky130_fd_pr__nfet_01v8 ad=0.9686 pd=7.26 as=0.9686 ps=7.26 w=3.34 l=0.5
X279 a_7124_1728# a_7216_1728# a_7153_1640# vss sky130_fd_pr__nfet_01v8_lvt ad=0.825 pd=5.33 as=0.825 ps=5.33 w=5 l=0.15
X280 a_21912_1728# q8n q8p vss sky130_fd_pr__nfet_01v8_lvt ad=1.55 pd=10.62 as=0.825 ps=5.33 w=5 l=0.15
X281 a_11026_n300# a_5802_714# a_11114_1728# vss sky130_fd_pr__nfet_01v8_lvt ad=0.66 pd=4.33 as=0.66 ps=4.33 w=4 l=0.15
X282 a_11114_1728# a_5802_714# a_11026_n300# vss sky130_fd_pr__nfet_01v8_lvt ad=0.66 pd=4.33 as=0.66 ps=4.33 w=4 l=0.15
X283 a_16520_n300# q4n a_16629_626# vss sky130_fd_pr__nfet_01v8_lvt ad=0.495 pd=3.33 as=0.495 ps=3.33 w=3 l=0.15
X284 a_n3862_n388# a_n3862_n388# vss vss sky130_fd_pr__nfet_01v8 ad=0.58 pd=4.29 as=0.58 ps=4.29 w=4 l=0.5
X285 q8n q8p a_21912_1728# vss sky130_fd_pr__nfet_01v8_lvt ad=0.825 pd=5.33 as=0.825 ps=5.33 w=5 l=0.15
X286 vdd a_5831_626# vss sky130_fd_pr__res_high_po_2p85 l=4.14
X287 vss a_n3862_n388# a_11026_n300# vss sky130_fd_pr__nfet_01v8 ad=0.435 pd=3.29 as=0.435 ps=3.29 w=3 l=0.5
X288 a_n3290_1728# a_n3261_1640# a_n3198_1728# vss sky130_fd_pr__nfet_01v8_lvt ad=0.825 pd=5.33 as=0.825 ps=5.33 w=5 l=0.15
X289 a_11114_1728# q4n q4p vss sky130_fd_pr__nfet_01v8_lvt ad=0.825 pd=5.33 as=0.825 ps=5.33 w=5 l=0.15
X290 a_16520_n300# q4p a_24235_4312# vss sky130_fd_pr__nfet_01v8_lvt ad=0.93 pd=6.62 as=0.495 ps=3.33 w=3 l=0.15
X291 a_228_n300# a_n1881_526# a_1134_3042# vss sky130_fd_pr__nfet_01v8_lvt ad=0.66 pd=4.33 as=0.66 ps=4.33 w=4 l=0.15
X292 a_11114_1728# a_5802_714# a_11026_n300# vss sky130_fd_pr__nfet_01v8_lvt ad=0.66 pd=4.33 as=0.66 ps=4.33 w=4 l=0.15
X293 a_5802_714# a_5831_626# vdd vss sky130_fd_pr__nfet_01v8_lvt ad=0.825 pd=5.33 as=0.825 ps=5.33 w=5 l=0.15
X294 vss a_n3862_n388# a_n3762_n300# vss sky130_fd_pr__nfet_01v8 ad=0.435 pd=3.29 as=0.435 ps=3.29 w=3 l=0.5
X295 a_11026_n300# a_5802_714# a_11114_1728# vss sky130_fd_pr__nfet_01v8_lvt ad=1.24 pd=8.62 as=0.66 ps=4.33 w=4 l=0.15
X296 q2n q2p a_408_614# vss sky130_fd_pr__nfet_01v8_lvt ad=0.825 pd=5.33 as=0.825 ps=5.33 w=5 l=0.15
X297 q4n q4p a_11114_1728# vss sky130_fd_pr__nfet_01v8_lvt ad=0.825 pd=5.33 as=0.825 ps=5.33 w=5 l=0.15
X298 a_1134_3042# a_n1881_526# a_228_n300# vss sky130_fd_pr__nfet_01v8_lvt ad=0.66 pd=4.33 as=0.66 ps=4.33 w=4 l=0.15
X299 a_228_n300# a_n1881_526# a_1134_3042# vss sky130_fd_pr__nfet_01v8_lvt ad=1.24 pd=8.62 as=0.66 ps=4.33 w=4 l=0.15
X300 q4n q4p a_11114_1728# vss sky130_fd_pr__nfet_01v8_lvt ad=0.825 pd=5.33 as=1.55 ps=10.62 w=5 l=0.15
X301 a_7124_1728# a_8917_526# a_7036_n300# vss sky130_fd_pr__nfet_01v8_lvt ad=0.66 pd=4.33 as=1.24 ps=8.62 w=4 l=0.15
X302 vdd a_n5001_4543# a_n3862_n388# vdd sky130_fd_pr__pfet_01v8 ad=0.87 pd=6.29 as=0.87 ps=6.29 w=6 l=0.5
X303 a_n5001_4543# a_n5001_4543# vdd vdd sky130_fd_pr__pfet_01v8 ad=0.87 pd=6.29 as=0.87 ps=6.29 w=6 l=0.5
X304 q4p a_7216_1728# a_11932_3042# vss sky130_fd_pr__nfet_01v8_lvt ad=0.825 pd=5.33 as=1.55 ps=10.62 w=5 l=0.15
X305 q4p q4n a_11114_1728# vss sky130_fd_pr__nfet_01v8_lvt ad=0.825 pd=5.33 as=0.825 ps=5.33 w=5 l=0.15
X306 vss vbias a_5722_n300# vss sky130_fd_pr__nfet_01v8 ad=0.87 pd=6.58 as=0.435 ps=3.29 w=3 l=0.5
X307 q8n a_17951_1640# a_22730_3042# vss sky130_fd_pr__nfet_01v8_lvt ad=0.825 pd=5.33 as=1.55 ps=10.62 w=5 l=0.15
X308 a_228_n300# a_n1881_526# a_1134_3042# vss sky130_fd_pr__nfet_01v8_lvt ad=0.66 pd=4.33 as=0.66 ps=4.33 w=4 l=0.15
X309 a_1134_3042# a_n1881_526# a_228_n300# vss sky130_fd_pr__nfet_01v8_lvt ad=0.66 pd=4.33 as=0.66 ps=4.33 w=4 l=0.15
X310 a_7036_n300# a_n3862_n388# vss vss sky130_fd_pr__nfet_01v8 ad=0.435 pd=3.29 as=0.435 ps=3.29 w=3 l=0.5
X311 vss a_n3862_n388# a_7036_n300# vss sky130_fd_pr__nfet_01v8 ad=0.435 pd=3.29 as=0.435 ps=3.29 w=3 l=0.5
X312 vss a_n3862_n388# a_11026_n300# vss sky130_fd_pr__nfet_01v8 ad=0.435 pd=3.29 as=0.435 ps=3.29 w=3 l=0.5
X313 a_13437_4312# q2p a_5722_n300# vss sky130_fd_pr__nfet_01v8_lvt ad=0.495 pd=3.33 as=0.495 ps=3.33 w=3 l=0.15
X314 a_7216_1728# a_7153_1640# a_7124_1728# vss sky130_fd_pr__nfet_01v8_lvt ad=0.825 pd=5.33 as=0.825 ps=5.33 w=5 l=0.15
X315 vss a_n3862_n388# a_228_n300# vss sky130_fd_pr__nfet_01v8 ad=0.435 pd=3.29 as=0.435 ps=3.29 w=3 l=0.5
X316 a_11026_n300# a_8917_526# a_11932_3042# vss sky130_fd_pr__nfet_01v8_lvt ad=0.66 pd=4.33 as=0.66 ps=4.33 w=4 l=0.15
X317 a_11932_3042# a_8917_526# a_11026_n300# vss sky130_fd_pr__nfet_01v8_lvt ad=0.66 pd=4.33 as=0.66 ps=4.33 w=4 l=0.15
X318 q2p q2n a_408_614# vss sky130_fd_pr__nfet_01v8_lvt ad=0.825 pd=5.33 as=1.55 ps=10.62 w=5 l=0.15
X319 vss a_n3862_n388# a_n3762_n300# vss sky130_fd_pr__nfet_01v8 ad=0.87 pd=6.58 as=0.435 ps=3.29 w=3 l=0.5
X320 a_8917_526# a_13437_4312# vdd vss sky130_fd_pr__nfet_01v8_lvt ad=1.55 pd=10.62 as=0.825 ps=5.33 w=5 l=0.15
X321 a_11114_1728# q4p q4n vss sky130_fd_pr__nfet_01v8_lvt ad=0.825 pd=5.33 as=0.825 ps=5.33 w=5 l=0.15
X322 vss vbias a_n1881_526# vss sky130_fd_pr__nfet_01v8 ad=1.16 pd=8.58 as=1.16 ps=8.58 w=4 l=0.5
X323 vdd a_18014_1728# vss sky130_fd_pr__res_high_po_2p85 l=4.14
X324 a_n3261_1640# a_n3198_1728# a_n3290_1728# vss sky130_fd_pr__nfet_01v8_lvt ad=0.825 pd=5.33 as=1.55 ps=10.62 w=5 l=0.15
X325 a_7124_1728# a_7216_1728# a_7153_1640# vss sky130_fd_pr__nfet_01v8_lvt ad=0.825 pd=5.33 as=0.825 ps=5.33 w=5 l=0.15
X326 a_11026_n300# a_8917_526# a_11932_3042# vss sky130_fd_pr__nfet_01v8_lvt ad=0.66 pd=4.33 as=0.66 ps=4.33 w=4 l=0.15
X327 a_11932_3042# a_8917_526# a_11026_n300# vss sky130_fd_pr__nfet_01v8_lvt ad=0.66 pd=4.33 as=0.66 ps=4.33 w=4 l=0.15
X328 a_11026_n300# a_8917_526# a_11932_3042# vss sky130_fd_pr__nfet_01v8_lvt ad=0.66 pd=4.33 as=0.66 ps=4.33 w=4 l=0.15
X329 a_11932_3042# a_8917_526# a_11026_n300# vss sky130_fd_pr__nfet_01v8_lvt ad=0.66 pd=4.33 as=0.66 ps=4.33 w=4 l=0.15
X330 a_n5001_4543# a_n5001_4543# vdd vdd sky130_fd_pr__pfet_01v8 ad=0.87 pd=6.29 as=0.87 ps=6.29 w=6 l=0.5
X331 a_7124_1728# a_7153_1640# a_7216_1728# vss sky130_fd_pr__nfet_01v8_lvt ad=0.825 pd=5.33 as=0.825 ps=5.33 w=5 l=0.15
X332 a_19715_526# a_24235_4312# vdd vss sky130_fd_pr__nfet_01v8_lvt ad=0.825 pd=5.33 as=0.825 ps=5.33 w=5 l=0.15
X333 a_21912_1728# q8p q8n vss sky130_fd_pr__nfet_01v8_lvt ad=0.825 pd=5.33 as=0.825 ps=5.33 w=5 l=0.15
X334 a_17922_1728# a_17951_1640# a_18014_1728# vss sky130_fd_pr__nfet_01v8_lvt ad=0.825 pd=5.33 as=0.825 ps=5.33 w=5 l=0.15
X335 a_11932_3042# a_8917_526# a_11026_n300# vss sky130_fd_pr__nfet_01v8_lvt ad=0.66 pd=4.33 as=0.66 ps=4.33 w=4 l=0.15
X336 a_11026_n300# a_8917_526# a_11932_3042# vss sky130_fd_pr__nfet_01v8_lvt ad=0.66 pd=4.33 as=0.66 ps=4.33 w=4 l=0.15
X337 a_n1881_526# clkn vdd vss sky130_fd_pr__nfet_01v8_lvt ad=0.825 pd=5.33 as=0.825 ps=5.33 w=5 l=0.15
X338 a_11026_n300# a_8917_526# a_11932_3042# vss sky130_fd_pr__nfet_01v8_lvt ad=0.66 pd=4.33 as=0.66 ps=4.33 w=4 l=0.15
X339 a_21912_1728# q8p q8n vss sky130_fd_pr__nfet_01v8_lvt ad=0.825 pd=5.33 as=0.825 ps=5.33 w=5 l=0.15
X340 a_11932_3042# a_8917_526# a_11026_n300# vss sky130_fd_pr__nfet_01v8_lvt ad=0.66 pd=4.33 as=0.66 ps=4.33 w=4 l=0.15
X341 a_11026_n300# a_n3862_n388# vss vss sky130_fd_pr__nfet_01v8 ad=0.435 pd=3.29 as=0.435 ps=3.29 w=3 l=0.5
X342 q4p q4n a_11114_1728# vss sky130_fd_pr__nfet_01v8_lvt ad=0.825 pd=5.33 as=0.825 ps=5.33 w=5 l=0.15
X343 vss a_n3862_n388# a_11026_n300# vss sky130_fd_pr__nfet_01v8 ad=0.435 pd=3.29 as=0.435 ps=3.29 w=3 l=0.5
X344 a_5722_n300# q2n a_5831_626# vss sky130_fd_pr__nfet_01v8_lvt ad=0.495 pd=3.33 as=0.495 ps=3.33 w=3 l=0.15
X345 a_18014_1728# a_17951_1640# a_17922_1728# vss sky130_fd_pr__nfet_01v8_lvt ad=0.825 pd=5.33 as=0.825 ps=5.33 w=5 l=0.15
X346 vdd a_5831_626# a_5802_714# vss sky130_fd_pr__nfet_01v8_lvt ad=0.825 pd=5.33 as=0.825 ps=5.33 w=5 l=0.15
X347 vss vbias a_5722_n300# vss sky130_fd_pr__nfet_01v8 ad=0.87 pd=6.58 as=0.435 ps=3.29 w=3 l=0.5
X348 a_17951_1640# q8p a_18014_614# vss sky130_fd_pr__nfet_01v8_lvt ad=0.825 pd=5.33 as=1.55 ps=10.62 w=5 l=0.15
X349 a_408_614# q2n q2p vss sky130_fd_pr__nfet_01v8_lvt ad=0.825 pd=5.33 as=0.825 ps=5.33 w=5 l=0.15
X350 a_11114_1728# q4p q4n vss sky130_fd_pr__nfet_01v8_lvt ad=1.55 pd=10.62 as=0.825 ps=5.33 w=5 l=0.15
X351 a_21824_n300# a_n3862_n388# vss vss sky130_fd_pr__nfet_01v8 ad=0.435 pd=3.29 as=0.435 ps=3.29 w=3 l=0.5
X352 a_n3290_1728# a_n3261_1640# a_n3198_1728# vss sky130_fd_pr__nfet_01v8_lvt ad=0.825 pd=5.33 as=0.825 ps=5.33 w=5 l=0.15
X353 vdd a_24235_4312# a_19715_526# vss sky130_fd_pr__nfet_01v8_lvt ad=0.825 pd=5.33 as=0.825 ps=5.33 w=5 l=0.15
X354 a_21824_n300# a_n3862_n388# vss vss sky130_fd_pr__nfet_01v8 ad=0.435 pd=3.29 as=0.87 ps=6.58 w=3 l=0.5
X355 q8p q8n a_21912_1728# vss sky130_fd_pr__nfet_01v8_lvt ad=0.825 pd=5.33 as=0.825 ps=5.33 w=5 l=0.15
X356 a_11114_1728# q4n q4p vss sky130_fd_pr__nfet_01v8_lvt ad=1.55 pd=10.62 as=0.825 ps=5.33 w=5 l=0.15
X357 a_21824_n300# a_16600_714# a_21912_1728# vss sky130_fd_pr__nfet_01v8_lvt ad=0.66 pd=4.33 as=0.66 ps=4.33 w=4 l=0.15
X358 a_22730_3042# a_17951_1640# q8n vss sky130_fd_pr__nfet_01v8_lvt ad=1.55 pd=10.62 as=0.825 ps=5.33 w=5 l=0.15
X359 a_1134_3042# a_n3261_1640# q2n vss sky130_fd_pr__nfet_01v8_lvt ad=0.825 pd=5.33 as=0.825 ps=5.33 w=5 l=0.15
X360 a_5722_n300# q2p a_13437_4312# vss sky130_fd_pr__nfet_01v8_lvt ad=0.93 pd=6.62 as=0.495 ps=3.33 w=3 l=0.15
X361 a_228_n300# a_n3862_n388# vss vss sky130_fd_pr__nfet_01v8 ad=0.435 pd=3.29 as=0.87 ps=6.58 w=3 l=0.5
X362 a_16600_714# a_16629_626# vdd vss sky130_fd_pr__nfet_01v8_lvt ad=0.825 pd=5.33 as=0.825 ps=5.33 w=5 l=0.15
X363 vdd a_24235_4312# a_19715_526# vss sky130_fd_pr__nfet_01v8_lvt ad=0.825 pd=5.33 as=0.825 ps=5.33 w=5 l=0.15
X364 a_19715_526# a_24235_4312# vdd vss sky130_fd_pr__nfet_01v8_lvt ad=1.55 pd=10.62 as=0.825 ps=5.33 w=5 l=0.15
X365 a_21824_n300# a_16600_714# a_21912_1728# vss sky130_fd_pr__nfet_01v8_lvt ad=0.66 pd=4.33 as=0.66 ps=4.33 w=4 l=0.15
X366 q4n q4p a_11114_1728# vss sky130_fd_pr__nfet_01v8_lvt ad=0.825 pd=5.33 as=0.825 ps=5.33 w=5 l=0.15
X367 a_21912_1728# a_16600_714# a_21824_n300# vss sky130_fd_pr__nfet_01v8_lvt ad=0.66 pd=4.33 as=0.66 ps=4.33 w=4 l=0.15
X368 a_17922_1728# a_18014_1728# a_17951_1640# vss sky130_fd_pr__nfet_01v8_lvt ad=0.825 pd=5.33 as=0.825 ps=5.33 w=5 l=0.15
X369 a_7124_1728# a_7216_1728# a_7153_1640# vss sky130_fd_pr__nfet_01v8_lvt ad=0.825 pd=5.33 as=0.825 ps=5.33 w=5 l=0.15
X370 a_19715_526# a_24235_4312# vdd vss sky130_fd_pr__nfet_01v8_lvt ad=0.825 pd=5.33 as=0.825 ps=5.33 w=5 l=0.15
X371 vdd a_24235_4312# a_19715_526# vss sky130_fd_pr__nfet_01v8_lvt ad=0.825 pd=5.33 as=0.825 ps=5.33 w=5 l=0.15
X372 a_21912_1728# a_16600_714# a_21824_n300# vss sky130_fd_pr__nfet_01v8_lvt ad=0.66 pd=4.33 as=0.66 ps=4.33 w=4 l=0.15
X373 a_21912_1728# a_16600_714# a_21824_n300# vss sky130_fd_pr__nfet_01v8_lvt ad=0.66 pd=4.33 as=0.66 ps=4.33 w=4 l=0.15
X374 vss vbias a_19715_526# vss sky130_fd_pr__nfet_01v8 ad=1.16 pd=8.58 as=1.16 ps=8.58 w=4 l=0.5
X375 a_21824_n300# a_16600_714# a_21912_1728# vss sky130_fd_pr__nfet_01v8_lvt ad=0.66 pd=4.33 as=0.66 ps=4.33 w=4 l=0.15
X376 a_21824_n300# a_n3862_n388# vss vss sky130_fd_pr__nfet_01v8 ad=0.435 pd=3.29 as=0.435 ps=3.29 w=3 l=0.5
X377 a_16520_n300# q4p a_24235_4312# vss sky130_fd_pr__nfet_01v8_lvt ad=0.495 pd=3.33 as=0.495 ps=3.33 w=3 l=0.15
X378 q4n a_7153_1640# a_11932_3042# vss sky130_fd_pr__nfet_01v8_lvt ad=0.825 pd=5.33 as=1.55 ps=10.62 w=5 l=0.15
X379 vss a_n3862_n388# a_228_n300# vss sky130_fd_pr__nfet_01v8 ad=0.435 pd=3.29 as=0.435 ps=3.29 w=3 l=0.5
X380 vdd a_24235_4312# a_19715_526# vss sky130_fd_pr__nfet_01v8_lvt ad=0.825 pd=5.33 as=0.825 ps=5.33 w=5 l=0.15
X381 a_11932_3042# a_7216_1728# q4p vss sky130_fd_pr__nfet_01v8_lvt ad=0.825 pd=5.33 as=0.825 ps=5.33 w=5 l=0.15
X382 q8n q8p a_21912_1728# vss sky130_fd_pr__nfet_01v8_lvt ad=0.825 pd=5.33 as=0.825 ps=5.33 w=5 l=0.15
X383 a_17922_1728# a_18014_1728# a_17951_1640# vss sky130_fd_pr__nfet_01v8_lvt ad=0.825 pd=5.33 as=0.825 ps=5.33 w=5 l=0.15
X384 a_n3762_n300# a_n3862_n388# vss vss sky130_fd_pr__nfet_01v8 ad=0.435 pd=3.29 as=0.435 ps=3.29 w=3 l=0.5
X385 vss a_n3862_n388# a_17834_n300# vss sky130_fd_pr__nfet_01v8 ad=0.435 pd=3.29 as=0.435 ps=3.29 w=3 l=0.5
X386 a_18014_1728# a_17951_1640# a_17922_1728# vss sky130_fd_pr__nfet_01v8_lvt ad=0.825 pd=5.33 as=0.825 ps=5.33 w=5 l=0.15
X387 vdd clkn a_n1881_526# vss sky130_fd_pr__nfet_01v8_lvt ad=0.825 pd=5.33 as=0.825 ps=5.33 w=5 l=0.15
X388 a_7216_614# q4n a_7216_1728# vss sky130_fd_pr__nfet_01v8_lvt ad=0.825 pd=5.33 as=0.825 ps=5.33 w=5 l=0.15
X389 a_19715_526# a_24235_4312# vdd vss sky130_fd_pr__nfet_01v8_lvt ad=0.825 pd=5.33 as=0.825 ps=5.33 w=5 l=0.15
X390 a_21912_1728# a_16600_714# a_21824_n300# vss sky130_fd_pr__nfet_01v8_lvt ad=0.66 pd=4.33 as=0.66 ps=4.33 w=4 l=0.15
X391 q2n q2p a_408_614# vss sky130_fd_pr__nfet_01v8_lvt ad=0.825 pd=5.33 as=1.55 ps=10.62 w=5 l=0.15
X392 a_21824_n300# a_16600_714# a_21912_1728# vss sky130_fd_pr__nfet_01v8_lvt ad=0.66 pd=4.33 as=0.66 ps=4.33 w=4 l=0.15
X393 a_21912_1728# a_16600_714# a_21824_n300# vss sky130_fd_pr__nfet_01v8_lvt ad=0.66 pd=4.33 as=0.66 ps=4.33 w=4 l=0.15
X394 vdd a_n3198_1728# vss sky130_fd_pr__res_high_po_2p85 l=4.14
X395 a_7124_1728# a_7216_1728# a_7153_1640# vss sky130_fd_pr__nfet_01v8_lvt ad=1.55 pd=10.62 as=0.825 ps=5.33 w=5 l=0.15
X396 a_21824_n300# a_16600_714# a_21912_1728# vss sky130_fd_pr__nfet_01v8_lvt ad=0.66 pd=4.33 as=0.66 ps=4.33 w=4 l=0.15
X397 a_17834_n300# a_n3862_n388# vss vss sky130_fd_pr__nfet_01v8 ad=0.435 pd=3.29 as=0.435 ps=3.29 w=3 l=0.5
X398 q8p q8n a_21912_1728# vss sky130_fd_pr__nfet_01v8_lvt ad=0.825 pd=5.33 as=1.55 ps=10.62 w=5 l=0.15
X399 vss a_n3862_n388# a_11026_n300# vss sky130_fd_pr__nfet_01v8 ad=0.87 pd=6.58 as=0.435 ps=3.29 w=3 l=0.5
X400 a_5831_626# q2n a_5722_n300# vss sky130_fd_pr__nfet_01v8_lvt ad=0.495 pd=3.33 as=0.495 ps=3.33 w=3 l=0.15
X401 vss a_n3862_n388# a_7036_n300# vss sky130_fd_pr__nfet_01v8 ad=0.435 pd=3.29 as=0.435 ps=3.29 w=3 l=0.5
X402 a_17922_1728# a_17951_1640# a_18014_1728# vss sky130_fd_pr__nfet_01v8_lvt ad=1.55 pd=10.62 as=0.825 ps=5.33 w=5 l=0.15
X403 vss a_n3862_n388# a_n3762_n300# vss sky130_fd_pr__nfet_01v8 ad=0.435 pd=3.29 as=0.435 ps=3.29 w=3 l=0.5
X404 a_7216_1728# a_7153_1640# a_7124_1728# vss sky130_fd_pr__nfet_01v8_lvt ad=0.825 pd=5.33 as=0.825 ps=5.33 w=5 l=0.15
X405 a_18014_614# q8p a_17951_1640# vss sky130_fd_pr__nfet_01v8_lvt ad=1.55 pd=10.62 as=0.825 ps=5.33 w=5 l=0.15
X406 a_7216_614# q4p a_7153_1640# vss sky130_fd_pr__nfet_01v8_lvt ad=0.825 pd=5.33 as=0.825 ps=5.33 w=5 l=0.15
X407 a_11114_1728# q4p q4n vss sky130_fd_pr__nfet_01v8_lvt ad=0.825 pd=5.33 as=0.825 ps=5.33 w=5 l=0.15
X408 a_8917_526# a_13437_4312# vdd vss sky130_fd_pr__nfet_01v8_lvt ad=0.825 pd=5.33 as=0.825 ps=5.33 w=5 l=0.15
X409 a_5802_714# a_5831_626# vdd vss sky130_fd_pr__nfet_01v8_lvt ad=0.825 pd=5.33 as=0.825 ps=5.33 w=5 l=0.15
X410 a_n3261_1640# a_n3198_1728# a_n3290_1728# vss sky130_fd_pr__nfet_01v8_lvt ad=0.825 pd=5.33 as=0.825 ps=5.33 w=5 l=0.15
X411 vdd a_13437_4312# a_8917_526# vss sky130_fd_pr__nfet_01v8_lvt ad=0.825 pd=5.33 as=1.55 ps=10.62 w=5 l=0.15
X412 a_21912_1728# q8n q8p vss sky130_fd_pr__nfet_01v8_lvt ad=0.825 pd=5.33 as=0.825 ps=5.33 w=5 l=0.15
X413 vdd a_n5001_4543# a_n3862_n388# vdd sky130_fd_pr__pfet_01v8 ad=0.87 pd=6.29 as=0.87 ps=6.29 w=6 l=0.5
X414 a_21824_n300# a_n3862_n388# vss vss sky130_fd_pr__nfet_01v8 ad=0.435 pd=3.29 as=0.435 ps=3.29 w=3 l=0.5
X415 a_n5001_4543# a_n5001_4543# vdd vdd sky130_fd_pr__pfet_01v8 ad=0.87 pd=6.29 as=0.87 ps=6.29 w=6 l=0.5
X416 vdd a_5831_626# a_5802_714# vss sky130_fd_pr__nfet_01v8_lvt ad=0.825 pd=5.33 as=1.55 ps=10.62 w=5 l=0.15
X417 vss a_n3862_n388# a_228_n300# vss sky130_fd_pr__nfet_01v8 ad=0.435 pd=3.29 as=0.435 ps=3.29 w=3 l=0.5
X418 a_22730_3042# a_19715_526# a_21824_n300# vss sky130_fd_pr__nfet_01v8_lvt ad=0.66 pd=4.33 as=0.66 ps=4.33 w=4 l=0.15
X419 a_17922_1728# a_19715_526# a_17834_n300# vss sky130_fd_pr__nfet_01v8_lvt ad=0.66 pd=4.33 as=0.66 ps=4.33 w=4 l=0.15
X420 a_n4996_714# clkp vdd vss sky130_fd_pr__nfet_01v8_lvt ad=0.825 pd=5.33 as=0.825 ps=5.33 w=5 l=0.15
X421 a_16520_n300# q4n a_16629_626# vss sky130_fd_pr__nfet_01v8_lvt ad=0.495 pd=3.33 as=0.495 ps=3.33 w=3 l=0.15
X422 a_n3762_n300# a_n3862_n388# vss vss sky130_fd_pr__nfet_01v8 ad=0.435 pd=3.29 as=0.435 ps=3.29 w=3 l=0.5
X423 q8n q8p a_21912_1728# vss sky130_fd_pr__nfet_01v8_lvt ad=0.825 pd=5.33 as=0.825 ps=5.33 w=5 l=0.15
X424 a_8917_526# a_13437_4312# vdd vss sky130_fd_pr__nfet_01v8_lvt ad=0.825 pd=5.33 as=0.825 ps=5.33 w=5 l=0.15
X425 vdd a_13437_4312# a_8917_526# vss sky130_fd_pr__nfet_01v8_lvt ad=0.825 pd=5.33 as=0.825 ps=5.33 w=5 l=0.15
X426 a_11026_n300# a_5802_714# a_11114_1728# vss sky130_fd_pr__nfet_01v8_lvt ad=0.66 pd=4.33 as=0.66 ps=4.33 w=4 l=0.15
X427 a_11114_1728# a_5802_714# a_11026_n300# vss sky130_fd_pr__nfet_01v8_lvt ad=0.66 pd=4.33 as=0.66 ps=4.33 w=4 l=0.15
X428 a_11114_1728# q4n q4p vss sky130_fd_pr__nfet_01v8_lvt ad=0.825 pd=5.33 as=0.825 ps=5.33 w=5 l=0.15
X429 q8n q8p a_21912_1728# vss sky130_fd_pr__nfet_01v8_lvt ad=0.825 pd=5.33 as=0.825 ps=5.33 w=5 l=0.15
X430 vss a_n3862_n388# a_7036_n300# vss sky130_fd_pr__nfet_01v8 ad=0.435 pd=3.29 as=0.435 ps=3.29 w=3 l=0.5
X431 a_21824_n300# a_19715_526# a_22730_3042# vss sky130_fd_pr__nfet_01v8_lvt ad=0.66 pd=4.33 as=0.66 ps=4.33 w=4 l=0.15
X432 a_17951_1640# a_18014_1728# a_17922_1728# vss sky130_fd_pr__nfet_01v8_lvt ad=0.825 pd=5.33 as=0.825 ps=5.33 w=5 l=0.15
X433 q8p a_18014_1728# a_22730_3042# vss sky130_fd_pr__nfet_01v8_lvt ad=0.825 pd=5.33 as=0.825 ps=5.33 w=5 l=0.15
X434 a_8917_526# a_13437_4312# vdd vss sky130_fd_pr__nfet_01v8_lvt ad=0.825 pd=5.33 as=0.825 ps=5.33 w=5 l=0.15
X435 a_7153_1640# a_7216_1728# a_7124_1728# vss sky130_fd_pr__nfet_01v8_lvt ad=0.825 pd=5.33 as=0.825 ps=5.33 w=5 l=0.15
X436 q8p q8n a_21912_1728# vss sky130_fd_pr__nfet_01v8_lvt ad=0.825 pd=5.33 as=0.825 ps=5.33 w=5 l=0.15
X437 vdd a_13437_4312# a_8917_526# vss sky130_fd_pr__nfet_01v8_lvt ad=0.825 pd=5.33 as=0.825 ps=5.33 w=5 l=0.15
X438 a_11114_1728# a_5802_714# a_11026_n300# vss sky130_fd_pr__nfet_01v8_lvt ad=0.66 pd=4.33 as=1.24 ps=8.62 w=4 l=0.15
X439 a_n3198_1728# q2n a_n3582_614# vss sky130_fd_pr__nfet_01v8_lvt ad=0.825 pd=5.33 as=0.825 ps=5.33 w=5 l=0.15
X440 a_8917_526# a_13437_4312# vdd vss sky130_fd_pr__nfet_01v8_lvt ad=1.55 pd=10.62 as=0.825 ps=5.33 w=5 l=0.15
X441 a_11114_1728# a_5802_714# a_11026_n300# vss sky130_fd_pr__nfet_01v8_lvt ad=0.66 pd=4.33 as=0.66 ps=4.33 w=4 l=0.15
X442 a_11026_n300# a_5802_714# a_11114_1728# vss sky130_fd_pr__nfet_01v8_lvt ad=0.66 pd=4.33 as=0.66 ps=4.33 w=4 l=0.15
X443 vss a_n3862_n388# a_n3862_n388# vss sky130_fd_pr__nfet_01v8 ad=0.58 pd=4.29 as=0.58 ps=4.29 w=4 l=0.5
X444 a_22730_3042# a_19715_526# a_21824_n300# vss sky130_fd_pr__nfet_01v8_lvt ad=0.66 pd=4.33 as=1.24 ps=8.62 w=4 l=0.15
X445 a_n3198_1728# a_n3261_1640# a_n3290_1728# vss sky130_fd_pr__nfet_01v8_lvt ad=0.825 pd=5.33 as=0.825 ps=5.33 w=5 l=0.15
X446 a_n3762_n300# a_n4996_714# a_n3582_614# vss sky130_fd_pr__nfet_01v8_lvt ad=0.66 pd=4.33 as=0.66 ps=4.33 w=4 l=0.15
X447 a_17834_n300# a_19715_526# a_17922_1728# vss sky130_fd_pr__nfet_01v8_lvt ad=1.24 pd=8.62 as=0.66 ps=4.33 w=4 l=0.15
X448 a_11026_n300# a_n3862_n388# vss vss sky130_fd_pr__nfet_01v8 ad=0.435 pd=3.29 as=0.87 ps=6.58 w=3 l=0.5
X449 a_24235_4312# q4p a_16520_n300# vss sky130_fd_pr__nfet_01v8_lvt ad=0.495 pd=3.33 as=0.495 ps=3.33 w=3 l=0.15
X450 a_11932_3042# a_7153_1640# q4n vss sky130_fd_pr__nfet_01v8_lvt ad=1.55 pd=10.62 as=0.825 ps=5.33 w=5 l=0.15
X451 a_21912_1728# q8p q8n vss sky130_fd_pr__nfet_01v8_lvt ad=0.825 pd=5.33 as=0.825 ps=5.33 w=5 l=0.15
X452 vdd a_13437_4312# a_8917_526# vss sky130_fd_pr__nfet_01v8_lvt ad=0.825 pd=5.33 as=0.825 ps=5.33 w=5 l=0.15
X453 a_8917_526# a_13437_4312# vdd vss sky130_fd_pr__nfet_01v8_lvt ad=0.825 pd=5.33 as=0.825 ps=5.33 w=5 l=0.15
X454 a_11114_1728# a_5802_714# a_11026_n300# vss sky130_fd_pr__nfet_01v8_lvt ad=0.66 pd=4.33 as=0.66 ps=4.33 w=4 l=0.15
X455 vss a_n3862_n388# a_228_n300# vss sky130_fd_pr__nfet_01v8 ad=0.435 pd=3.29 as=0.435 ps=3.29 w=3 l=0.5
X456 vdd a_5831_626# a_5802_714# vss sky130_fd_pr__nfet_01v8_lvt ad=0.825 pd=5.33 as=0.825 ps=5.33 w=5 l=0.15
X457 a_11026_n300# a_5802_714# a_11114_1728# vss sky130_fd_pr__nfet_01v8_lvt ad=0.66 pd=4.33 as=0.66 ps=4.33 w=4 l=0.15
X458 a_n1881_526# clkn vdd vss sky130_fd_pr__nfet_01v8_lvt ad=1.55 pd=10.62 as=0.825 ps=5.33 w=5 l=0.15
X459 a_11114_1728# a_5802_714# a_11026_n300# vss sky130_fd_pr__nfet_01v8_lvt ad=0.66 pd=4.33 as=0.66 ps=4.33 w=4 l=0.15
X460 a_408_614# q2p q2n vss sky130_fd_pr__nfet_01v8_lvt ad=0.825 pd=5.33 as=0.825 ps=5.33 w=5 l=0.15
X461 vss a_n3862_n388# a_7036_n300# vss sky130_fd_pr__nfet_01v8 ad=0.87 pd=6.58 as=0.435 ps=3.29 w=3 l=0.5
X462 a_n3582_614# a_n4996_714# a_n3762_n300# vss sky130_fd_pr__nfet_01v8_lvt ad=0.66 pd=4.33 as=0.66 ps=4.33 w=4 l=0.15
X463 a_n3762_n300# a_n4996_714# a_n3582_614# vss sky130_fd_pr__nfet_01v8_lvt ad=0.66 pd=4.33 as=0.66 ps=4.33 w=4 l=0.15
X464 a_n3582_614# a_n4996_714# a_n3762_n300# vss sky130_fd_pr__nfet_01v8_lvt ad=0.66 pd=4.33 as=1.24 ps=8.62 w=4 l=0.15
X465 a_11026_n300# a_5802_714# a_11114_1728# vss sky130_fd_pr__nfet_01v8_lvt ad=0.66 pd=4.33 as=0.66 ps=4.33 w=4 l=0.15
X466 a_n3762_n300# a_n4996_714# a_n3582_614# vss sky130_fd_pr__nfet_01v8_lvt ad=0.66 pd=4.33 as=0.66 ps=4.33 w=4 l=0.15
X467 a_n3582_614# a_n4996_714# a_n3762_n300# vss sky130_fd_pr__nfet_01v8_lvt ad=0.66 pd=4.33 as=0.66 ps=4.33 w=4 l=0.15
X468 a_11026_n300# a_n3862_n388# vss vss sky130_fd_pr__nfet_01v8 ad=0.435 pd=3.29 as=0.435 ps=3.29 w=3 l=0.5
X469 vss a_n3862_n388# a_17834_n300# vss sky130_fd_pr__nfet_01v8 ad=0.435 pd=3.29 as=0.435 ps=3.29 w=3 l=0.5
X470 vss a_n3862_n388# a_7036_n300# vss sky130_fd_pr__nfet_01v8 ad=0.435 pd=3.29 as=0.435 ps=3.29 w=3 l=0.5
X471 a_5722_n300# q2p a_13437_4312# vss sky130_fd_pr__nfet_01v8_lvt ad=0.495 pd=3.33 as=0.495 ps=3.33 w=3 l=0.15
X472 a_7124_1728# a_7153_1640# a_7216_1728# vss sky130_fd_pr__nfet_01v8_lvt ad=0.825 pd=5.33 as=0.825 ps=5.33 w=5 l=0.15
X473 a_11026_n300# a_n3862_n388# vss vss sky130_fd_pr__nfet_01v8 ad=0.435 pd=3.29 as=0.435 ps=3.29 w=3 l=0.5
X474 q4n q4p a_11114_1728# vss sky130_fd_pr__nfet_01v8_lvt ad=0.825 pd=5.33 as=0.825 ps=5.33 w=5 l=0.15
X475 vdd a_13437_4312# a_8917_526# vss sky130_fd_pr__nfet_01v8_lvt ad=0.825 pd=5.33 as=0.825 ps=5.33 w=5 l=0.15
X476 a_1134_3042# a_n1881_526# a_228_n300# vss sky130_fd_pr__nfet_01v8_lvt ad=0.66 pd=4.33 as=0.66 ps=4.33 w=4 l=0.15
X477 a_n3582_614# a_n4996_714# a_n3762_n300# vss sky130_fd_pr__nfet_01v8_lvt ad=0.66 pd=4.33 as=0.66 ps=4.33 w=4 l=0.15
X478 a_17951_1640# a_18014_1728# a_17922_1728# vss sky130_fd_pr__nfet_01v8_lvt ad=0.825 pd=5.33 as=0.825 ps=5.33 w=5 l=0.15
X479 a_n3290_1728# a_n3198_1728# a_n3261_1640# vss sky130_fd_pr__nfet_01v8_lvt ad=0.825 pd=5.33 as=0.825 ps=5.33 w=5 l=0.15
X480 a_17834_n300# a_16600_714# a_18014_614# vss sky130_fd_pr__nfet_01v8_lvt ad=0.66 pd=4.33 as=0.66 ps=4.33 w=4 l=0.15
X481 a_7153_1640# a_7216_1728# a_7124_1728# vss sky130_fd_pr__nfet_01v8_lvt ad=0.825 pd=5.33 as=1.55 ps=10.62 w=5 l=0.15
X482 q8p q8n a_21912_1728# vss sky130_fd_pr__nfet_01v8_lvt ad=0.825 pd=5.33 as=0.825 ps=5.33 w=5 l=0.15
X483 vss a_n3862_n388# a_21824_n300# vss sky130_fd_pr__nfet_01v8 ad=0.435 pd=3.29 as=0.435 ps=3.29 w=3 l=0.5
X484 a_228_n300# a_n1881_526# a_1134_3042# vss sky130_fd_pr__nfet_01v8_lvt ad=0.66 pd=4.33 as=0.66 ps=4.33 w=4 l=0.15
X485 a_21824_n300# a_n3862_n388# vss vss sky130_fd_pr__nfet_01v8 ad=0.435 pd=3.29 as=0.435 ps=3.29 w=3 l=0.5
X486 a_11932_3042# a_8917_526# a_11026_n300# vss sky130_fd_pr__nfet_01v8_lvt ad=0.66 pd=4.33 as=1.24 ps=8.62 w=4 l=0.15
X487 vss a_n3862_n388# a_228_n300# vss sky130_fd_pr__nfet_01v8 ad=0.435 pd=3.29 as=0.435 ps=3.29 w=3 l=0.5
X488 a_7036_n300# a_8917_526# a_7124_1728# vss sky130_fd_pr__nfet_01v8_lvt ad=1.24 pd=8.62 as=0.66 ps=4.33 w=4 l=0.15
X489 vss a_n3862_n388# a_n3762_n300# vss sky130_fd_pr__nfet_01v8 ad=0.435 pd=3.29 as=0.435 ps=3.29 w=3 l=0.5
X490 a_n3862_n388# a_n5001_4543# vdd vdd sky130_fd_pr__pfet_01v8 ad=0.87 pd=6.29 as=0.87 ps=6.29 w=6 l=0.5
X491 vdd clkp a_n4996_714# vss sky130_fd_pr__nfet_01v8_lvt ad=0.825 pd=5.33 as=0.825 ps=5.33 w=5 l=0.15
X492 a_7216_1728# a_7153_1640# a_7124_1728# vss sky130_fd_pr__nfet_01v8_lvt ad=0.825 pd=5.33 as=0.825 ps=5.33 w=5 l=0.15
X493 a_n3762_n300# a_n3862_n388# vss vss sky130_fd_pr__nfet_01v8 ad=0.435 pd=3.29 as=0.435 ps=3.29 w=3 l=0.5
X494 a_17834_n300# a_16600_714# a_18014_614# vss sky130_fd_pr__nfet_01v8_lvt ad=0.66 pd=4.33 as=0.66 ps=4.33 w=4 l=0.15
X495 a_n3198_1728# a_n3261_1640# a_n3290_1728# vss sky130_fd_pr__nfet_01v8_lvt ad=0.825 pd=5.33 as=0.825 ps=5.33 w=5 l=0.15
X496 vss a_n3862_n388# a_17834_n300# vss sky130_fd_pr__nfet_01v8 ad=0.435 pd=3.29 as=0.435 ps=3.29 w=3 l=0.5
X497 vdd a_n5001_4543# a_n5001_4543# vdd sky130_fd_pr__pfet_01v8 ad=0.87 pd=6.29 as=0.87 ps=6.29 w=6 l=0.5
X498 a_17834_n300# a_n3862_n388# vss vss sky130_fd_pr__nfet_01v8 ad=0.435 pd=3.29 as=0.87 ps=6.58 w=3 l=0.5
X499 a_21912_1728# q8n q8p vss sky130_fd_pr__nfet_01v8_lvt ad=0.825 pd=5.33 as=0.825 ps=5.33 w=5 l=0.15
X500 a_18014_1728# a_17951_1640# a_17922_1728# vss sky130_fd_pr__nfet_01v8_lvt ad=0.825 pd=5.33 as=0.825 ps=5.33 w=5 l=0.15
X501 vss a_n3862_n388# a_7036_n300# vss sky130_fd_pr__nfet_01v8 ad=0.435 pd=3.29 as=0.435 ps=3.29 w=3 l=0.5
X502 a_7124_1728# a_8917_526# a_7036_n300# vss sky130_fd_pr__nfet_01v8_lvt ad=0.66 pd=4.33 as=0.66 ps=4.33 w=4 l=0.15
X503 a_17922_1728# a_18014_1728# a_17951_1640# vss sky130_fd_pr__nfet_01v8_lvt ad=0.825 pd=5.33 as=0.825 ps=5.33 w=5 l=0.15
X504 a_17834_n300# a_16600_714# a_18014_614# vss sky130_fd_pr__nfet_01v8_lvt ad=1.24 pd=8.62 as=0.66 ps=4.33 w=4 l=0.15
X505 a_18014_614# a_16600_714# a_17834_n300# vss sky130_fd_pr__nfet_01v8_lvt ad=0.66 pd=4.33 as=0.66 ps=4.33 w=4 l=0.15
X506 a_7124_1728# a_7216_1728# a_7153_1640# vss sky130_fd_pr__nfet_01v8_lvt ad=0.825 pd=5.33 as=0.825 ps=5.33 w=5 l=0.15
X507 a_7036_n300# a_8917_526# a_7124_1728# vss sky130_fd_pr__nfet_01v8_lvt ad=0.66 pd=4.33 as=0.66 ps=4.33 w=4 l=0.15
X508 a_n3290_1728# a_n3198_1728# a_n3261_1640# vss sky130_fd_pr__nfet_01v8_lvt ad=1.55 pd=10.62 as=0.825 ps=5.33 w=5 l=0.15
X509 a_11114_1728# q4n q4p vss sky130_fd_pr__nfet_01v8_lvt ad=0.825 pd=5.33 as=0.825 ps=5.33 w=5 l=0.15
X510 a_18014_614# a_16600_714# a_17834_n300# vss sky130_fd_pr__nfet_01v8_lvt ad=0.66 pd=4.33 as=0.66 ps=4.33 w=4 l=0.15
X511 a_11026_n300# a_n3862_n388# vss vss sky130_fd_pr__nfet_01v8 ad=0.435 pd=3.29 as=0.435 ps=3.29 w=3 l=0.5
X512 a_5831_626# q2n a_5722_n300# vss sky130_fd_pr__nfet_01v8_lvt ad=0.495 pd=3.33 as=0.495 ps=3.33 w=3 l=0.15
X513 a_408_614# a_n4996_714# a_228_n300# vss sky130_fd_pr__nfet_01v8_lvt ad=0.66 pd=4.33 as=0.66 ps=4.33 w=4 l=0.15
X514 a_5802_714# a_5831_626# vdd vss sky130_fd_pr__nfet_01v8_lvt ad=0.825 pd=5.33 as=0.825 ps=5.33 w=5 l=0.15
X515 vss a_n3862_n388# a_228_n300# vss sky130_fd_pr__nfet_01v8 ad=0.435 pd=3.29 as=0.435 ps=3.29 w=3 l=0.5
X516 a_n3762_n300# a_n3862_n388# vss vss sky130_fd_pr__nfet_01v8 ad=0.435 pd=3.29 as=0.435 ps=3.29 w=3 l=0.5
X517 a_7036_n300# a_n3862_n388# vss vss sky130_fd_pr__nfet_01v8 ad=0.435 pd=3.29 as=0.435 ps=3.29 w=3 l=0.5
X518 q4n q4p a_11114_1728# vss sky130_fd_pr__nfet_01v8_lvt ad=0.825 pd=5.33 as=0.825 ps=5.33 w=5 l=0.15
X519 a_17834_n300# a_n3862_n388# vss vss sky130_fd_pr__nfet_01v8 ad=0.435 pd=3.29 as=0.435 ps=3.29 w=3 l=0.5
X520 a_228_n300# a_n4996_714# a_408_614# vss sky130_fd_pr__nfet_01v8_lvt ad=0.66 pd=4.33 as=0.66 ps=4.33 w=4 l=0.15
X521 a_16600_714# vbias vss vss sky130_fd_pr__nfet_01v8 ad=1.16 pd=8.58 as=1.16 ps=8.58 w=4 l=0.5
X522 vss a_n3862_n388# a_21824_n300# vss sky130_fd_pr__nfet_01v8 ad=0.435 pd=3.29 as=0.435 ps=3.29 w=3 l=0.5
X523 a_408_614# a_n4996_714# a_228_n300# vss sky130_fd_pr__nfet_01v8_lvt ad=0.66 pd=4.33 as=0.66 ps=4.33 w=4 l=0.15
X524 q8n a_17951_1640# a_22730_3042# vss sky130_fd_pr__nfet_01v8_lvt ad=0.825 pd=5.33 as=0.825 ps=5.33 w=5 l=0.15
X525 a_22730_3042# a_18014_1728# q8p vss sky130_fd_pr__nfet_01v8_lvt ad=1.55 pd=10.62 as=0.825 ps=5.33 w=5 l=0.15
X526 q2n a_n3261_1640# a_1134_3042# vss sky130_fd_pr__nfet_01v8_lvt ad=0.825 pd=5.33 as=1.55 ps=10.62 w=5 l=0.15
X527 a_408_614# a_n4996_714# a_228_n300# vss sky130_fd_pr__nfet_01v8_lvt ad=0.66 pd=4.33 as=1.24 ps=8.62 w=4 l=0.15
X528 a_228_n300# a_n4996_714# a_408_614# vss sky130_fd_pr__nfet_01v8_lvt ad=0.66 pd=4.33 as=0.66 ps=4.33 w=4 l=0.15
X529 a_7036_n300# a_n3862_n388# vss vss sky130_fd_pr__nfet_01v8 ad=0.435 pd=3.29 as=0.435 ps=3.29 w=3 l=0.5
X530 a_1134_3042# a_n3198_1728# q2p vss sky130_fd_pr__nfet_01v8_lvt ad=0.825 pd=5.33 as=0.825 ps=5.33 w=5 l=0.15
X531 a_408_614# a_n4996_714# a_228_n300# vss sky130_fd_pr__nfet_01v8_lvt ad=0.66 pd=4.33 as=0.66 ps=4.33 w=4 l=0.15
X532 a_13437_4312# q2p a_5722_n300# vss sky130_fd_pr__nfet_01v8_lvt ad=0.495 pd=3.33 as=0.495 ps=3.33 w=3 l=0.15
X533 a_7216_1728# a_7153_1640# a_7124_1728# vss sky130_fd_pr__nfet_01v8_lvt ad=0.825 pd=5.33 as=0.825 ps=5.33 w=5 l=0.15
X534 vss a_n3862_n388# a_7036_n300# vss sky130_fd_pr__nfet_01v8 ad=0.435 pd=3.29 as=0.435 ps=3.29 w=3 l=0.5
X535 vdd a_16629_626# a_16600_714# vss sky130_fd_pr__nfet_01v8_lvt ad=0.825 pd=5.33 as=0.825 ps=5.33 w=5 l=0.15
X536 q2p q2n a_408_614# vss sky130_fd_pr__nfet_01v8_lvt ad=0.825 pd=5.33 as=0.825 ps=5.33 w=5 l=0.15
X537 a_11114_1728# q4p q4n vss sky130_fd_pr__nfet_01v8_lvt ad=0.825 pd=5.33 as=0.825 ps=5.33 w=5 l=0.15
X538 a_18014_1728# a_17951_1640# a_17922_1728# vss sky130_fd_pr__nfet_01v8_lvt ad=0.825 pd=5.33 as=1.55 ps=10.62 w=5 l=0.15
X539 vdd a_7153_1640# vss sky130_fd_pr__res_high_po_2p85 l=4.14
X540 a_228_n300# a_n4996_714# a_408_614# vss sky130_fd_pr__nfet_01v8_lvt ad=0.66 pd=4.33 as=0.66 ps=4.33 w=4 l=0.15
X541 vdd a_13437_4312# a_8917_526# vss sky130_fd_pr__nfet_01v8_lvt ad=0.825 pd=5.33 as=1.55 ps=10.62 w=5 l=0.15
X542 vss a_n3862_n388# a_21824_n300# vss sky130_fd_pr__nfet_01v8 ad=0.435 pd=3.29 as=0.435 ps=3.29 w=3 l=0.5
X543 vss a_n3862_n388# a_21824_n300# vss sky130_fd_pr__nfet_01v8 ad=0.435 pd=3.29 as=0.435 ps=3.29 w=3 l=0.5
X544 vss a_n3862_n388# a_228_n300# vss sky130_fd_pr__nfet_01v8 ad=0.87 pd=6.58 as=0.435 ps=3.29 w=3 l=0.5
X545 a_7124_1728# a_7153_1640# a_7216_1728# vss sky130_fd_pr__nfet_01v8_lvt ad=1.55 pd=10.62 as=0.825 ps=5.33 w=5 l=0.15
X546 a_n3762_n300# a_n3862_n388# vss vss sky130_fd_pr__nfet_01v8 ad=0.435 pd=3.29 as=0.87 ps=6.58 w=3 l=0.5
X547 a_19715_526# a_24235_4312# vdd vss sky130_fd_pr__nfet_01v8_lvt ad=0.825 pd=5.33 as=0.825 ps=5.33 w=5 l=0.15
X548 a_21912_1728# q8p q8n vss sky130_fd_pr__nfet_01v8_lvt ad=0.825 pd=5.33 as=0.825 ps=5.33 w=5 l=0.15
X549 a_17922_1728# a_17951_1640# a_18014_1728# vss sky130_fd_pr__nfet_01v8_lvt ad=0.825 pd=5.33 as=0.825 ps=5.33 w=5 l=0.15
X550 a_7216_1728# q4n a_7216_614# vss sky130_fd_pr__nfet_01v8_lvt ad=0.825 pd=5.33 as=1.55 ps=10.62 w=5 l=0.15
X551 a_17834_n300# a_n3862_n388# vss vss sky130_fd_pr__nfet_01v8 ad=0.435 pd=3.29 as=0.435 ps=3.29 w=3 l=0.5
X552 a_5802_714# a_5831_626# vdd vss sky130_fd_pr__nfet_01v8_lvt ad=0.825 pd=5.33 as=0.825 ps=5.33 w=5 l=0.15
X553 a_19715_526# a_24235_4312# vdd vss sky130_fd_pr__nfet_01v8_lvt ad=0.825 pd=5.33 as=0.825 ps=5.33 w=5 l=0.15
X554 a_21912_1728# a_16600_714# a_21824_n300# vss sky130_fd_pr__nfet_01v8_lvt ad=0.66 pd=4.33 as=1.24 ps=8.62 w=4 l=0.15
X555 a_17951_1640# a_18014_1728# a_17922_1728# vss sky130_fd_pr__nfet_01v8_lvt ad=0.825 pd=5.33 as=0.825 ps=5.33 w=5 l=0.15
X556 a_7153_1640# a_7216_1728# a_7124_1728# vss sky130_fd_pr__nfet_01v8_lvt ad=0.825 pd=5.33 as=0.825 ps=5.33 w=5 l=0.15
X557 a_7153_1640# a_7216_1728# a_7124_1728# vss sky130_fd_pr__nfet_01v8_lvt ad=0.825 pd=5.33 as=0.825 ps=5.33 w=5 l=0.15
X558 a_17951_1640# a_18014_1728# a_17922_1728# vss sky130_fd_pr__nfet_01v8_lvt ad=0.825 pd=5.33 as=0.825 ps=5.33 w=5 l=0.15
X559 vdd a_24235_4312# a_19715_526# vss sky130_fd_pr__nfet_01v8_lvt ad=0.825 pd=5.33 as=1.55 ps=10.62 w=5 l=0.15
X560 a_n3290_1728# a_n1881_526# a_n3762_n300# vss sky130_fd_pr__nfet_01v8_lvt ad=0.66 pd=4.33 as=0.66 ps=4.33 w=4 l=0.15
X561 vss a_n3862_n388# a_17834_n300# vss sky130_fd_pr__nfet_01v8 ad=0.435 pd=3.29 as=0.435 ps=3.29 w=3 l=0.5
X562 a_5722_n300# q2n a_5831_626# vss sky130_fd_pr__nfet_01v8_lvt ad=0.495 pd=3.33 as=0.495 ps=3.33 w=3 l=0.15
X563 vss a_n3862_n388# a_11026_n300# vss sky130_fd_pr__nfet_01v8 ad=0.435 pd=3.29 as=0.435 ps=3.29 w=3 l=0.5
X564 a_11026_n300# a_n3862_n388# vss vss sky130_fd_pr__nfet_01v8 ad=0.435 pd=3.29 as=0.435 ps=3.29 w=3 l=0.5
X565 a_21912_1728# q8n q8p vss sky130_fd_pr__nfet_01v8_lvt ad=0.825 pd=5.33 as=0.825 ps=5.33 w=5 l=0.15
X566 a_18014_1728# a_17951_1640# a_17922_1728# vss sky130_fd_pr__nfet_01v8_lvt ad=0.825 pd=5.33 as=0.825 ps=5.33 w=5 l=0.15
X567 a_18014_1728# q8n a_18014_614# vss sky130_fd_pr__nfet_01v8_lvt ad=0.825 pd=5.33 as=0.825 ps=5.33 w=5 l=0.15
X568 a_17951_1640# q8p a_18014_614# vss sky130_fd_pr__nfet_01v8_lvt ad=0.825 pd=5.33 as=0.825 ps=5.33 w=5 l=0.15
X569 a_408_614# q2n q2p vss sky130_fd_pr__nfet_01v8_lvt ad=0.825 pd=5.33 as=0.825 ps=5.33 w=5 l=0.15
X570 a_7153_1640# q4p a_7216_614# vss sky130_fd_pr__nfet_01v8_lvt ad=0.825 pd=5.33 as=1.55 ps=10.62 w=5 l=0.15
X571 vdd a_16629_626# a_16600_714# vss sky130_fd_pr__nfet_01v8_lvt ad=0.825 pd=5.33 as=1.55 ps=10.62 w=5 l=0.15
X572 vdd a_24235_4312# vss sky130_fd_pr__res_high_po_2p85 l=4.14
X573 a_n3762_n300# a_n1881_526# a_n3290_1728# vss sky130_fd_pr__nfet_01v8_lvt ad=0.66 pd=4.33 as=0.66 ps=4.33 w=4 l=0.15
X574 a_11114_1728# q4n q4p vss sky130_fd_pr__nfet_01v8_lvt ad=0.825 pd=5.33 as=0.825 ps=5.33 w=5 l=0.15
X575 a_n3762_n300# a_n1881_526# a_n3290_1728# vss sky130_fd_pr__nfet_01v8_lvt ad=0.66 pd=4.33 as=0.66 ps=4.33 w=4 l=0.15
X576 a_n3290_1728# a_n1881_526# a_n3762_n300# vss sky130_fd_pr__nfet_01v8_lvt ad=0.66 pd=4.33 as=0.66 ps=4.33 w=4 l=0.15
X577 vss a_n3862_n388# a_21824_n300# vss sky130_fd_pr__nfet_01v8 ad=0.435 pd=3.29 as=0.435 ps=3.29 w=3 l=0.5
X578 a_n3290_1728# a_n1881_526# a_n3762_n300# vss sky130_fd_pr__nfet_01v8_lvt ad=0.66 pd=4.33 as=0.66 ps=4.33 w=4 l=0.15
X579 a_228_n300# a_n4996_714# a_408_614# vss sky130_fd_pr__nfet_01v8_lvt ad=0.66 pd=4.33 as=0.66 ps=4.33 w=4 l=0.15
X580 a_n3862_n388# a_n5001_4543# vdd vdd sky130_fd_pr__pfet_01v8 ad=0.87 pd=6.29 as=0.87 ps=6.29 w=6 l=0.5
X581 a_n3762_n300# a_n1881_526# a_n3290_1728# vss sky130_fd_pr__nfet_01v8_lvt ad=0.66 pd=4.33 as=0.66 ps=4.33 w=4 l=0.15
X582 a_n3290_1728# a_n1881_526# a_n3762_n300# vss sky130_fd_pr__nfet_01v8_lvt ad=0.66 pd=4.33 as=0.66 ps=4.33 w=4 l=0.15
X583 vdd a_n5001_4543# a_n5001_4543# vdd sky130_fd_pr__pfet_01v8 ad=0.87 pd=6.29 as=0.87 ps=6.29 w=6 l=0.5
X584 vdd clkp a_n4996_714# vss sky130_fd_pr__nfet_01v8_lvt ad=0.825 pd=5.33 as=0.825 ps=5.33 w=5 l=0.15
X585 a_1134_3042# a_n3261_1640# q2n vss sky130_fd_pr__nfet_01v8_lvt ad=1.55 pd=10.62 as=0.825 ps=5.33 w=5 l=0.15
X586 a_16629_626# q4n a_16520_n300# vss sky130_fd_pr__nfet_01v8_lvt ad=0.495 pd=3.33 as=0.495 ps=3.33 w=3 l=0.15
X587 a_19715_526# a_24235_4312# vdd vss sky130_fd_pr__nfet_01v8_lvt ad=0.825 pd=5.33 as=0.825 ps=5.33 w=5 l=0.15
X588 a_16600_714# a_16629_626# vdd vss sky130_fd_pr__nfet_01v8_lvt ad=1.55 pd=10.62 as=0.825 ps=5.33 w=5 l=0.15
X589 vss a_n3862_n388# a_17834_n300# vss sky130_fd_pr__nfet_01v8 ad=0.435 pd=3.29 as=0.435 ps=3.29 w=3 l=0.5
X590 a_21912_1728# q8p q8n vss sky130_fd_pr__nfet_01v8_lvt ad=0.825 pd=5.33 as=0.825 ps=5.33 w=5 l=0.15
X591 a_228_n300# a_n4996_714# a_408_614# vss sky130_fd_pr__nfet_01v8_lvt ad=0.66 pd=4.33 as=0.66 ps=4.33 w=4 l=0.15
X592 a_11026_n300# a_n3862_n388# vss vss sky130_fd_pr__nfet_01v8 ad=0.435 pd=3.29 as=0.435 ps=3.29 w=3 l=0.5
X593 a_408_614# q2p q2n vss sky130_fd_pr__nfet_01v8_lvt ad=1.55 pd=10.62 as=0.825 ps=5.33 w=5 l=0.15
X594 a_n3762_n300# a_n1881_526# a_n3290_1728# vss sky130_fd_pr__nfet_01v8_lvt ad=0.66 pd=4.33 as=0.66 ps=4.33 w=4 l=0.15
X595 a_408_614# a_n4996_714# a_228_n300# vss sky130_fd_pr__nfet_01v8_lvt ad=0.66 pd=4.33 as=0.66 ps=4.33 w=4 l=0.15
X596 a_16520_n300# vbias vss vss sky130_fd_pr__nfet_01v8 ad=0.435 pd=3.29 as=0.87 ps=6.58 w=3 l=0.5
X597 a_n3290_1728# a_n1881_526# a_n3762_n300# vss sky130_fd_pr__nfet_01v8_lvt ad=0.66 pd=4.33 as=1.24 ps=8.62 w=4 l=0.15
X598 a_7036_n300# a_n3862_n388# vss vss sky130_fd_pr__nfet_01v8 ad=0.435 pd=3.29 as=0.435 ps=3.29 w=3 l=0.5
X599 a_17922_1728# a_18014_1728# a_17951_1640# vss sky130_fd_pr__nfet_01v8_lvt ad=0.825 pd=5.33 as=0.825 ps=5.33 w=5 l=0.15
X600 a_7124_1728# a_7216_1728# a_7153_1640# vss sky130_fd_pr__nfet_01v8_lvt ad=0.825 pd=5.33 as=0.825 ps=5.33 w=5 l=0.15
X601 a_22730_3042# a_18014_1728# q8p vss sky130_fd_pr__nfet_01v8_lvt ad=0.825 pd=5.33 as=0.825 ps=5.33 w=5 l=0.15
X602 a_n3582_614# q2n a_n3198_1728# vss sky130_fd_pr__nfet_01v8_lvt ad=1.55 pd=10.62 as=0.825 ps=5.33 w=5 l=0.15
X603 a_13437_4312# q2p a_5722_n300# vss sky130_fd_pr__nfet_01v8_lvt ad=0.495 pd=3.33 as=0.93 ps=6.62 w=3 l=0.15
X604 a_n3261_1640# q2p a_n3582_614# vss sky130_fd_pr__nfet_01v8_lvt ad=0.825 pd=5.33 as=0.825 ps=5.33 w=5 l=0.15
X605 a_408_614# a_n4996_714# a_228_n300# vss sky130_fd_pr__nfet_01v8_lvt ad=0.66 pd=4.33 as=0.66 ps=4.33 w=4 l=0.15
X606 a_16520_n300# vbias vss vss sky130_fd_pr__nfet_01v8 ad=0.435 pd=3.29 as=0.87 ps=6.58 w=3 l=0.5
X607 vss a_n3862_n388# a_11026_n300# vss sky130_fd_pr__nfet_01v8 ad=0.435 pd=3.29 as=0.435 ps=3.29 w=3 l=0.5
X608 a_228_n300# a_n4996_714# a_408_614# vss sky130_fd_pr__nfet_01v8_lvt ad=0.66 pd=4.33 as=0.66 ps=4.33 w=4 l=0.15
X609 a_408_614# a_n4996_714# a_228_n300# vss sky130_fd_pr__nfet_01v8_lvt ad=0.66 pd=4.33 as=0.66 ps=4.33 w=4 l=0.15
X610 vss a_n3862_n388# a_21824_n300# vss sky130_fd_pr__nfet_01v8 ad=0.435 pd=3.29 as=0.435 ps=3.29 w=3 l=0.5
X611 a_n3762_n300# a_n4996_714# a_n3582_614# vss sky130_fd_pr__nfet_01v8_lvt ad=1.24 pd=8.62 as=0.66 ps=4.33 w=4 l=0.15
X612 a_16520_n300# q4p a_24235_4312# vss sky130_fd_pr__nfet_01v8_lvt ad=0.495 pd=3.33 as=0.495 ps=3.33 w=3 l=0.15
X613 a_228_n300# a_n3862_n388# vss vss sky130_fd_pr__nfet_01v8 ad=0.435 pd=3.29 as=0.435 ps=3.29 w=3 l=0.5
X614 a_n3862_n388# a_n3862_n388# vss vss sky130_fd_pr__nfet_01v8 ad=1.16 pd=8.58 as=0.58 ps=4.29 w=4 l=0.5
X615 a_n3762_n300# a_n1881_526# a_n3290_1728# vss sky130_fd_pr__nfet_01v8_lvt ad=0.66 pd=4.33 as=0.66 ps=4.33 w=4 l=0.15
X616 q4n a_7153_1640# a_11932_3042# vss sky130_fd_pr__nfet_01v8_lvt ad=0.825 pd=5.33 as=0.825 ps=5.33 w=5 l=0.15
X617 vss a_n3862_n388# a_n3762_n300# vss sky130_fd_pr__nfet_01v8 ad=0.435 pd=3.29 as=0.435 ps=3.29 w=3 l=0.5
X618 q8n q8p a_21912_1728# vss sky130_fd_pr__nfet_01v8_lvt ad=0.825 pd=5.33 as=0.825 ps=5.33 w=5 l=0.15
X619 a_5722_n300# q2n a_5831_626# vss sky130_fd_pr__nfet_01v8_lvt ad=0.495 pd=3.33 as=0.495 ps=3.33 w=3 l=0.15
X620 a_11932_3042# a_7216_1728# q4p vss sky130_fd_pr__nfet_01v8_lvt ad=1.55 pd=10.62 as=0.825 ps=5.33 w=5 l=0.15
X621 a_18014_1728# a_17951_1640# a_17922_1728# vss sky130_fd_pr__nfet_01v8_lvt ad=0.825 pd=5.33 as=0.825 ps=5.33 w=5 l=0.15
X622 vss a_n3862_n388# a_17834_n300# vss sky130_fd_pr__nfet_01v8 ad=0.435 pd=3.29 as=0.435 ps=3.29 w=3 l=0.5
X623 vdd clkn a_n1881_526# vss sky130_fd_pr__nfet_01v8_lvt ad=0.825 pd=5.33 as=0.825 ps=5.33 w=5 l=0.15
X624 a_408_614# a_n4996_714# a_228_n300# vss sky130_fd_pr__nfet_01v8_lvt ad=0.66 pd=4.33 as=0.66 ps=4.33 w=4 l=0.15
X625 a_n3762_n300# a_n3862_n388# vss vss sky130_fd_pr__nfet_01v8 ad=0.435 pd=3.29 as=0.435 ps=3.29 w=3 l=0.5
X626 a_17834_n300# a_n3862_n388# vss vss sky130_fd_pr__nfet_01v8 ad=0.435 pd=3.29 as=0.435 ps=3.29 w=3 l=0.5
X627 q2n q2p a_408_614# vss sky130_fd_pr__nfet_01v8_lvt ad=0.825 pd=5.33 as=0.825 ps=5.33 w=5 l=0.15
X628 a_228_n300# a_n4996_714# a_408_614# vss sky130_fd_pr__nfet_01v8_lvt ad=0.66 pd=4.33 as=0.66 ps=4.33 w=4 l=0.15
X629 a_n3762_n300# a_n4996_714# a_n3582_614# vss sky130_fd_pr__nfet_01v8_lvt ad=0.66 pd=4.33 as=0.66 ps=4.33 w=4 l=0.15
X630 a_n3290_1728# a_n1881_526# a_n3762_n300# vss sky130_fd_pr__nfet_01v8_lvt ad=0.66 pd=4.33 as=0.66 ps=4.33 w=4 l=0.15
X631 a_n3582_614# a_n4996_714# a_n3762_n300# vss sky130_fd_pr__nfet_01v8_lvt ad=0.66 pd=4.33 as=0.66 ps=4.33 w=4 l=0.15
X632 a_n3762_n300# a_n1881_526# a_n3290_1728# vss sky130_fd_pr__nfet_01v8_lvt ad=0.66 pd=4.33 as=0.66 ps=4.33 w=4 l=0.15
X633 a_7124_1728# a_7153_1640# a_7216_1728# vss sky130_fd_pr__nfet_01v8_lvt ad=0.825 pd=5.33 as=0.825 ps=5.33 w=5 l=0.15
X634 a_17834_n300# a_19715_526# a_17922_1728# vss sky130_fd_pr__nfet_01v8_lvt ad=0.66 pd=4.33 as=0.66 ps=4.33 w=4 l=0.15
X635 a_17922_1728# a_17951_1640# a_18014_1728# vss sky130_fd_pr__nfet_01v8_lvt ad=0.825 pd=5.33 as=0.825 ps=5.33 w=5 l=0.15
X636 a_228_n300# a_n4996_714# a_408_614# vss sky130_fd_pr__nfet_01v8_lvt ad=1.24 pd=8.62 as=0.66 ps=4.33 w=4 l=0.15
X637 vdd q2n vss sky130_fd_pr__res_high_po_2p85 l=4.14
X638 a_n3582_614# a_n4996_714# a_n3762_n300# vss sky130_fd_pr__nfet_01v8_lvt ad=0.66 pd=4.33 as=0.66 ps=4.33 w=4 l=0.15
X639 a_n3762_n300# a_n1881_526# a_n3290_1728# vss sky130_fd_pr__nfet_01v8_lvt ad=0.66 pd=4.33 as=0.66 ps=4.33 w=4 l=0.15
X640 a_n3582_614# a_n4996_714# a_n3762_n300# vss sky130_fd_pr__nfet_01v8_lvt ad=0.66 pd=4.33 as=0.66 ps=4.33 w=4 l=0.15
X641 a_n3762_n300# a_n4996_714# a_n3582_614# vss sky130_fd_pr__nfet_01v8_lvt ad=0.66 pd=4.33 as=0.66 ps=4.33 w=4 l=0.15
X642 a_n3290_1728# a_n1881_526# a_n3762_n300# vss sky130_fd_pr__nfet_01v8_lvt ad=0.66 pd=4.33 as=0.66 ps=4.33 w=4 l=0.15
X643 vss a_n3862_n388# a_11026_n300# vss sky130_fd_pr__nfet_01v8 ad=0.435 pd=3.29 as=0.435 ps=3.29 w=3 l=0.5
X644 vdd a_n3261_1640# vss sky130_fd_pr__res_high_po_2p85 l=4.14
X645 a_16629_626# q4n a_16520_n300# vss sky130_fd_pr__nfet_01v8_lvt ad=0.495 pd=3.33 as=0.93 ps=6.62 w=3 l=0.15
X646 vss a_n3862_n388# a_228_n300# vss sky130_fd_pr__nfet_01v8 ad=0.435 pd=3.29 as=0.435 ps=3.29 w=3 l=0.5
X647 a_11026_n300# a_n3862_n388# vss vss sky130_fd_pr__nfet_01v8 ad=0.435 pd=3.29 as=0.435 ps=3.29 w=3 l=0.5
X648 a_7036_n300# a_n3862_n388# vss vss sky130_fd_pr__nfet_01v8 ad=0.435 pd=3.29 as=0.87 ps=6.58 w=3 l=0.5
X649 a_7216_614# q4p a_7153_1640# vss sky130_fd_pr__nfet_01v8_lvt ad=1.55 pd=10.62 as=0.825 ps=5.33 w=5 l=0.15
X650 vss a_n3862_n388# a_11026_n300# vss sky130_fd_pr__nfet_01v8 ad=0.435 pd=3.29 as=0.435 ps=3.29 w=3 l=0.5
X651 a_16600_714# a_16629_626# vdd vss sky130_fd_pr__nfet_01v8_lvt ad=0.825 pd=5.33 as=0.825 ps=5.33 w=5 l=0.15
X652 a_1134_3042# a_n1881_526# a_228_n300# vss sky130_fd_pr__nfet_01v8_lvt ad=0.66 pd=4.33 as=1.24 ps=8.62 w=4 l=0.15
X653 q4p q4n a_11114_1728# vss sky130_fd_pr__nfet_01v8_lvt ad=0.825 pd=5.33 as=0.825 ps=5.33 w=5 l=0.15
X654 a_22730_3042# a_19715_526# a_21824_n300# vss sky130_fd_pr__nfet_01v8_lvt ad=0.66 pd=4.33 as=0.66 ps=4.33 w=4 l=0.15
X655 a_n3582_614# a_n4996_714# a_n3762_n300# vss sky130_fd_pr__nfet_01v8_lvt ad=0.66 pd=4.33 as=0.66 ps=4.33 w=4 l=0.15
X656 a_228_n300# a_n1881_526# a_1134_3042# vss sky130_fd_pr__nfet_01v8_lvt ad=0.66 pd=4.33 as=0.66 ps=4.33 w=4 l=0.15
X657 a_n3762_n300# a_n4996_714# a_n3582_614# vss sky130_fd_pr__nfet_01v8_lvt ad=0.66 pd=4.33 as=0.66 ps=4.33 w=4 l=0.15
X658 a_17834_n300# a_16600_714# a_18014_614# vss sky130_fd_pr__nfet_01v8_lvt ad=0.66 pd=4.33 as=0.66 ps=4.33 w=4 l=0.15
X659 a_21912_1728# q8n q8p vss sky130_fd_pr__nfet_01v8_lvt ad=0.825 pd=5.33 as=0.825 ps=5.33 w=5 l=0.15
X660 vdd a_n5001_4543# a_n3862_n388# vdd sky130_fd_pr__pfet_01v8 ad=0.87 pd=6.29 as=0.87 ps=6.29 w=6 l=0.5
X661 a_21824_n300# a_n3862_n388# vss vss sky130_fd_pr__nfet_01v8 ad=0.435 pd=3.29 as=0.435 ps=3.29 w=3 l=0.5
X662 a_n3862_n388# a_n5001_4543# vdd vdd sky130_fd_pr__pfet_01v8 ad=0.87 pd=6.29 as=0.87 ps=6.29 w=6 l=0.5
X663 a_1134_3042# a_n1881_526# a_228_n300# vss sky130_fd_pr__nfet_01v8_lvt ad=0.66 pd=4.33 as=0.66 ps=4.33 w=4 l=0.15
X664 a_228_n300# a_n1881_526# a_1134_3042# vss sky130_fd_pr__nfet_01v8_lvt ad=0.66 pd=4.33 as=0.66 ps=4.33 w=4 l=0.15
X665 vss a_n3862_n388# a_21824_n300# vss sky130_fd_pr__nfet_01v8 ad=0.435 pd=3.29 as=0.435 ps=3.29 w=3 l=0.5
X666 a_n5001_4543# a_n5001_4543# vdd vdd sky130_fd_pr__pfet_01v8 ad=0.87 pd=6.29 as=0.87 ps=6.29 w=6 l=0.5
X667 a_n4996_714# clkp vdd vss sky130_fd_pr__nfet_01v8_lvt ad=0.825 pd=5.33 as=0.825 ps=5.33 w=5 l=0.15
X668 a_n3762_n300# a_n4996_714# a_n3582_614# vss sky130_fd_pr__nfet_01v8_lvt ad=0.66 pd=4.33 as=0.66 ps=4.33 w=4 l=0.15
X669 a_1134_3042# a_n1881_526# a_228_n300# vss sky130_fd_pr__nfet_01v8_lvt ad=0.66 pd=4.33 as=0.66 ps=4.33 w=4 l=0.15
X670 vdd a_n5001_4543# a_n5001_4543# vdd sky130_fd_pr__pfet_01v8 ad=0.87 pd=6.29 as=0.87 ps=6.29 w=6 l=0.5
X671 a_n3290_1728# a_n3261_1640# a_n3198_1728# vss sky130_fd_pr__nfet_01v8_lvt ad=1.55 pd=10.62 as=0.825 ps=5.33 w=5 l=0.15
X672 a_16520_n300# q4n a_16629_626# vss sky130_fd_pr__nfet_01v8_lvt ad=0.93 pd=6.62 as=0.495 ps=3.33 w=3 l=0.15
X673 a_18014_614# a_16600_714# a_17834_n300# vss sky130_fd_pr__nfet_01v8_lvt ad=0.66 pd=4.33 as=0.66 ps=4.33 w=4 l=0.15
X674 a_17834_n300# a_16600_714# a_18014_614# vss sky130_fd_pr__nfet_01v8_lvt ad=0.66 pd=4.33 as=0.66 ps=4.33 w=4 l=0.15
X675 a_16600_714# a_16629_626# vdd vss sky130_fd_pr__nfet_01v8_lvt ad=0.825 pd=5.33 as=0.825 ps=5.33 w=5 l=0.15
X676 a_16520_n300# q4p a_24235_4312# vss sky130_fd_pr__nfet_01v8_lvt ad=0.495 pd=3.33 as=0.495 ps=3.33 w=3 l=0.15
X677 a_11114_1728# q4n q4p vss sky130_fd_pr__nfet_01v8_lvt ad=0.825 pd=5.33 as=0.825 ps=5.33 w=5 l=0.15
X678 a_21824_n300# a_19715_526# a_22730_3042# vss sky130_fd_pr__nfet_01v8_lvt ad=1.24 pd=8.62 as=0.66 ps=4.33 w=4 l=0.15
X679 a_228_n300# a_n1881_526# a_1134_3042# vss sky130_fd_pr__nfet_01v8_lvt ad=0.66 pd=4.33 as=0.66 ps=4.33 w=4 l=0.15
X680 a_18014_614# q8n a_18014_1728# vss sky130_fd_pr__nfet_01v8_lvt ad=1.55 pd=10.62 as=0.825 ps=5.33 w=5 l=0.15
X681 a_1134_3042# a_n1881_526# a_228_n300# vss sky130_fd_pr__nfet_01v8_lvt ad=0.66 pd=4.33 as=0.66 ps=4.33 w=4 l=0.15
X682 a_7036_n300# a_n3862_n388# vss vss sky130_fd_pr__nfet_01v8 ad=0.435 pd=3.29 as=0.435 ps=3.29 w=3 l=0.5
X683 a_17951_1640# a_18014_1728# a_17922_1728# vss sky130_fd_pr__nfet_01v8_lvt ad=0.825 pd=5.33 as=0.825 ps=5.33 w=5 l=0.15
X684 a_228_n300# a_n1881_526# a_1134_3042# vss sky130_fd_pr__nfet_01v8_lvt ad=0.66 pd=4.33 as=0.66 ps=4.33 w=4 l=0.15
X685 a_n3762_n300# a_n3862_n388# vss vss sky130_fd_pr__nfet_01v8 ad=0.435 pd=3.29 as=0.435 ps=3.29 w=3 l=0.5
X686 a_228_n300# a_n3862_n388# vss vss sky130_fd_pr__nfet_01v8 ad=0.435 pd=3.29 as=0.435 ps=3.29 w=3 l=0.5
X687 a_18014_614# a_16600_714# a_17834_n300# vss sky130_fd_pr__nfet_01v8_lvt ad=0.66 pd=4.33 as=0.66 ps=4.33 w=4 l=0.15
X688 a_7153_1640# a_7216_1728# a_7124_1728# vss sky130_fd_pr__nfet_01v8_lvt ad=0.825 pd=5.33 as=0.825 ps=5.33 w=5 l=0.15
X689 a_17834_n300# a_16600_714# a_18014_614# vss sky130_fd_pr__nfet_01v8_lvt ad=0.66 pd=4.33 as=0.66 ps=4.33 w=4 l=0.15
X690 a_16600_714# a_16629_626# vdd vss sky130_fd_pr__nfet_01v8_lvt ad=1.55 pd=10.62 as=0.825 ps=5.33 w=5 l=0.15
X691 vdd a_16629_626# a_16600_714# vss sky130_fd_pr__nfet_01v8_lvt ad=0.825 pd=5.33 as=0.825 ps=5.33 w=5 l=0.15
X692 vdd a_13437_4312# vss sky130_fd_pr__res_high_po_2p85 l=4.14
X693 a_18014_614# a_16600_714# a_17834_n300# vss sky130_fd_pr__nfet_01v8_lvt ad=0.66 pd=4.33 as=0.66 ps=4.33 w=4 l=0.15
X694 a_5802_714# vbias vss vss sky130_fd_pr__nfet_01v8 ad=1.16 pd=8.58 as=1.16 ps=8.58 w=4 l=0.5
X695 a_n3198_1728# a_n3261_1640# a_n3290_1728# vss sky130_fd_pr__nfet_01v8_lvt ad=0.825 pd=5.33 as=1.55 ps=10.62 w=5 l=0.15
X696 a_1134_3042# a_n1881_526# a_228_n300# vss sky130_fd_pr__nfet_01v8_lvt ad=0.66 pd=4.33 as=0.66 ps=4.33 w=4 l=0.15
X697 vss a_n3862_n388# a_n3862_n388# vss sky130_fd_pr__nfet_01v8 ad=0.58 pd=4.29 as=0.58 ps=4.29 w=4 l=0.5
X698 a_18014_614# a_16600_714# a_17834_n300# vss sky130_fd_pr__nfet_01v8_lvt ad=0.66 pd=4.33 as=0.66 ps=4.33 w=4 l=0.15
X699 a_17834_n300# a_16600_714# a_18014_614# vss sky130_fd_pr__nfet_01v8_lvt ad=0.66 pd=4.33 as=0.66 ps=4.33 w=4 l=0.15
X700 vdd a_16629_626# a_16600_714# vss sky130_fd_pr__nfet_01v8_lvt ad=0.825 pd=5.33 as=0.825 ps=5.33 w=5 l=0.15
X701 vdd a_5831_626# a_5802_714# vss sky130_fd_pr__nfet_01v8_lvt ad=0.825 pd=5.33 as=0.825 ps=5.33 w=5 l=0.15
X702 a_18014_614# a_16600_714# a_17834_n300# vss sky130_fd_pr__nfet_01v8_lvt ad=0.66 pd=4.33 as=0.66 ps=4.33 w=4 l=0.15
X703 a_7124_1728# a_8917_526# a_7036_n300# vss sky130_fd_pr__nfet_01v8_lvt ad=0.66 pd=4.33 as=0.66 ps=4.33 w=4 l=0.15
X704 a_228_n300# a_n3862_n388# vss vss sky130_fd_pr__nfet_01v8 ad=0.435 pd=3.29 as=0.435 ps=3.29 w=3 l=0.5
X705 a_11114_1728# q4p q4n vss sky130_fd_pr__nfet_01v8_lvt ad=0.825 pd=5.33 as=0.825 ps=5.33 w=5 l=0.15
X706 vss a_n3862_n388# a_7036_n300# vss sky130_fd_pr__nfet_01v8 ad=0.435 pd=3.29 as=0.435 ps=3.29 w=3 l=0.5
X707 vdd a_24235_4312# a_19715_526# vss sky130_fd_pr__nfet_01v8_lvt ad=0.825 pd=5.33 as=0.825 ps=5.33 w=5 l=0.15
X708 a_17834_n300# a_16600_714# a_18014_614# vss sky130_fd_pr__nfet_01v8_lvt ad=0.66 pd=4.33 as=0.66 ps=4.33 w=4 l=0.15
X709 vdd clkn a_n1881_526# vss sky130_fd_pr__nfet_01v8_lvt ad=0.825 pd=5.33 as=1.55 ps=10.62 w=5 l=0.15
X710 a_7036_n300# a_8917_526# a_7124_1728# vss sky130_fd_pr__nfet_01v8_lvt ad=0.66 pd=4.33 as=0.66 ps=4.33 w=4 l=0.15
X711 a_22730_3042# a_17951_1640# q8n vss sky130_fd_pr__nfet_01v8_lvt ad=0.825 pd=5.33 as=0.825 ps=5.33 w=5 l=0.15
X712 a_5722_n300# vbias vss vss sky130_fd_pr__nfet_01v8 ad=0.435 pd=3.29 as=0.87 ps=6.58 w=3 l=0.5
X713 vss a_n3862_n388# a_11026_n300# vss sky130_fd_pr__nfet_01v8 ad=0.435 pd=3.29 as=0.435 ps=3.29 w=3 l=0.5
X714 q2p a_n3198_1728# a_1134_3042# vss sky130_fd_pr__nfet_01v8_lvt ad=0.825 pd=5.33 as=1.55 ps=10.62 w=5 l=0.15
X715 a_16520_n300# q4n a_16629_626# vss sky130_fd_pr__nfet_01v8_lvt ad=0.495 pd=3.33 as=0.495 ps=3.33 w=3 l=0.15
X716 a_7124_1728# a_7153_1640# a_7216_1728# vss sky130_fd_pr__nfet_01v8_lvt ad=0.825 pd=5.33 as=0.825 ps=5.33 w=5 l=0.15
X717 vss a_n3862_n388# a_7036_n300# vss sky130_fd_pr__nfet_01v8 ad=0.435 pd=3.29 as=0.435 ps=3.29 w=3 l=0.5
X718 q8n q8p a_21912_1728# vss sky130_fd_pr__nfet_01v8_lvt ad=0.825 pd=5.33 as=0.825 ps=5.33 w=5 l=0.15
X719 a_11026_n300# a_8917_526# a_11932_3042# vss sky130_fd_pr__nfet_01v8_lvt ad=1.24 pd=8.62 as=0.66 ps=4.33 w=4 l=0.15
X720 a_11932_3042# a_8917_526# a_11026_n300# vss sky130_fd_pr__nfet_01v8_lvt ad=0.66 pd=4.33 as=0.66 ps=4.33 w=4 l=0.15
X721 a_408_614# q2n q2p vss sky130_fd_pr__nfet_01v8_lvt ad=0.825 pd=5.33 as=0.825 ps=5.33 w=5 l=0.15
X722 a_7036_n300# a_n3862_n388# vss vss sky130_fd_pr__nfet_01v8 ad=0.435 pd=3.29 as=0.435 ps=3.29 w=3 l=0.5
X723 a_n3862_n388# a_n3862_n388# vss vss sky130_fd_pr__nfet_01v8 ad=0.58 pd=4.29 as=1.16 ps=8.58 w=4 l=0.5
X724 q4n q4p a_11114_1728# vss sky130_fd_pr__nfet_01v8_lvt ad=0.825 pd=5.33 as=0.825 ps=5.33 w=5 l=0.15
X725 a_17922_1728# a_17951_1640# a_18014_1728# vss sky130_fd_pr__nfet_01v8_lvt ad=0.825 pd=5.33 as=0.825 ps=5.33 w=5 l=0.15
X726 a_17922_1728# a_19715_526# a_17834_n300# vss sky130_fd_pr__nfet_01v8_lvt ad=0.66 pd=4.33 as=0.66 ps=4.33 w=4 l=0.15
X727 a_11932_3042# a_8917_526# a_11026_n300# vss sky130_fd_pr__nfet_01v8_lvt ad=0.66 pd=4.33 as=0.66 ps=4.33 w=4 l=0.15
C0 clkn a_4521_n400# 0.01158f
C1 a_5961_n300# vbias 0
C2 a_n4621_n400# a_n3862_n388# 0.01782f
C3 a_5722_n300# a_7153_1640# 0.29523f
C4 q4n a_16520_n300# 0.59446f
C5 q2n a_3309_1728# 0.03123f
C6 a_n4151_714# a_n4996_714# 0.08499f
C7 a_5753_2028# q2n 0
C8 q8n a_19715_526# 0.06643f
C9 a_5722_n300# a_14741_n300# 0.00257f
C10 a_16239_n300# a_16759_n300# 0.01143f
C11 a_n5001_4543# a_n3339_1728# 0
C12 a_16600_714# a_16551_714# 0.08301f
C13 a_23525_614# a_19715_526# 0.00637f
C14 a_n5045_714# a_n4151_714# 0.00926f
C15 a_7124_1728# a_8839_1728# 0.08529f
C16 a_11114_1728# a_11065_1728# 0.07561f
C17 a_26611_714# a_26611_2028# 0
C18 a_8737_1728# a_8839_1728# 0.11111f
C19 vbias a_14741_n300# 0
C20 a_12829_614# a_12727_614# 0.08889f
C21 a_n5001_4543# a_3298_4640# 0.00325f
C22 a_n1881_526# a_5015_2028# 0.07542f
C23 vbias a_21299_614# 0
C24 a_n3862_n388# a_16629_626# 0.00876f
C25 q4n a_14491_1728# 0.03189f
C26 a_228_n300# q2p 0.05539f
C27 vbias a_n4996_714# 0.52653f
C28 a_10501_1728# a_7216_1728# 0
C29 a_16551_2028# a_8917_526# 0
C30 a_11932_3042# a_n3862_n388# 0.00407f
C31 a_5722_n300# a_5753_714# 0.00648f
C32 q4p a_24235_4312# 0.70483f
C33 a_6755_n300# a_5802_714# 0.01709f
C34 a_11065_614# a_11026_n300# 0.06415f
C35 vbias a_n5045_714# 0.00457f
C36 a_n3862_n388# a_16239_n300# 0.01001f
C37 a_n3290_1728# vbias 0.00115f
C38 a_n1575_1728# a_n3762_n300# 0
C39 a_21299_1728# a_21912_1728# 0
C40 a_n297_614# a_n1881_526# 0.01082f
C41 a_8737_614# a_7124_1728# 0.00857f
C42 q4n a_13437_4312# 0.15107f
C43 a_5753_2028# a_5753_3442# 0
C44 vbias a_5753_714# 0
C45 a_n3862_n388# a_10501_614# 0
C46 a_n3862_n388# a_16759_n300# 0.00957f
C47 a_7036_n300# a_11026_n300# 0.02002f
C48 a_8737_614# a_8737_1728# 0
C49 a_17951_1640# q8p 1.58747f
C50 vdd a_3943_n300# 0
C51 q4n a_11114_1728# 5.71011f
C52 a_9173_3042# q4p 0
C53 q4n a_11883_3042# 0.00294f
C54 a_n4996_714# a_n4151_2028# 0.07323f
C55 a_21299_614# a_21912_1728# 0
C56 a_20481_3042# a_17951_1640# 0.04864f
C57 a_14919_3442# q2p 0
C58 vbias a_25289_614# 0
C59 q8n a_22730_3042# 1.63814f
C60 a_12829_1728# a_8917_526# 0
C61 a_5753_2028# a_6647_2028# 0.00926f
C62 a_23525_614# a_22730_3042# 0.00676f
C63 a_16520_n300# a_21299_1728# 0.0013f
C64 a_18014_614# a_19535_614# 0.02509f
C65 clkn a_408_614# 0
C66 q8n a_18691_3042# 0.01738f
C67 q4p a_8917_526# 0.15591f
C68 a_n3290_1728# a_n4151_2028# 0
C69 a_n3582_614# a_n4996_714# 1.51483f
C70 a_n2445_1728# a_n4996_714# 0
C71 a_19637_1728# a_19637_614# 0
C72 a_7075_614# a_n3862_n388# 0
C73 a_12393_3042# q4p 0.03382f
C74 a_25539_n300# vdd 0
C75 a_5722_n300# a_5015_714# 0.002f
C76 a_n3862_n388# a_2365_3042# 0
C77 a_14491_614# vdd 0
C78 vdd q2p 1.24107f
C79 a_n5045_714# a_n3582_614# 0
C80 a_16629_626# a_8917_526# 0.00956f
C81 a_n3862_n388# a_n2061_614# 0.00168f
C82 a_n3198_1728# a_1595_3042# 0
C83 a_n3290_1728# a_n3582_614# 0.27937f
C84 q2n a_5722_n300# 0.59446f
C85 a_3309_1728# a_1134_3042# 0.0033f
C86 a_23627_614# q8p 0.00121f
C87 a_16600_714# q8p 0.01503f
C88 a_267_614# a_228_n300# 0.06415f
C89 a_n5001_4543# a_n4814_3408# 0.02226f
C90 a_n3261_1640# q2p 1.56447f
C91 a_n3290_1728# a_n2445_1728# 0.08402f
C92 vdd a_228_n300# 0
C93 vbias a_5015_714# 0
C94 a_26333_n300# a_26117_n400# 0.02069f
C95 a_n3862_n388# a_4159_n400# 0.02887f
C96 a_n3261_1640# a_228_n300# 0
C97 a_n3198_1728# a_n2395_3042# 0.03607f
C98 a_n3198_1728# a_n1881_526# 0.04888f
C99 q2n vbias 0
C100 vdd a_6647_714# 0.02753f
C101 a_11932_3042# a_8917_526# 1.42884f
C102 a_7216_1728# a_5802_714# 0.08889f
C103 a_23191_3042# a_17951_1640# 0.00175f
C104 a_16239_n300# a_8917_526# 0
C105 a_5722_n300# a_6539_n400# 0.00444f
C106 a_n5001_4543# a_n2905_3042# 0.00356f
C107 q4n a_18691_3042# 0
C108 a_5722_n300# a_7216_614# 0.09608f
C109 a_11932_3042# a_12393_3042# 0.08239f
C110 a_n1881_526# a_4121_2028# 0.07306f
C111 a_10501_614# a_8917_526# 0.01082f
C112 a_n3862_n388# a_24235_4312# 0.00703f
C113 a_17873_1728# a_17951_1640# 0
C114 a_21299_1728# a_19715_526# 0
C115 vbias a_6539_n400# 0
C116 a_n297_614# a_n3762_n300# 0.06415f
C117 a_9683_3042# vdd 0
C118 a_7153_1640# a_13437_4312# 0.49307f
C119 a_n5001_4543# clkn 0
C120 q2p a_13673_3042# 0
C121 a_17873_614# a_18014_614# 0.02418f
C122 a_25717_3442# a_17951_1640# 0
C123 a_6177_n400# a_5802_714# 0.03973f
C124 a_3298_4640# q2p 0.01192f
C125 a_16520_n300# a_25289_614# 0.00123f
C126 a_11114_1728# a_7153_1640# 0.02888f
C127 a_14919_3442# vdd 0.00339f
C128 a_21299_614# a_19715_526# 0.01082f
C129 a_5753_3442# a_5722_n300# 0.04902f
C130 a_6647_3442# a_7216_1728# 0
C131 q2n a_n4151_2028# 0
C132 a_11883_3042# a_7153_1640# 0
C133 a_18014_614# vdd 0.00134f
C134 a_15813_2028# q2p 0
C135 a_21824_n300# q8n 0.0571f
C136 a_17873_614# vdd 0.00179f
C137 a_21824_n300# a_23525_614# 0.07182f
C138 q8p a_18014_1728# 1.28324f
C139 a_n3862_n388# a_8917_526# 0.73687f
C140 a_23627_614# a_23627_1728# 0
C141 a_n1959_614# a_n4996_714# 0.0066f
C142 q2n a_n3582_614# 0.37498f
C143 q2n a_n2445_1728# 0
C144 a_17834_n300# a_17873_1728# 0
C145 a_5722_n300# a_6647_2028# 0.00289f
C146 q4p a_10501_1728# 0.00773f
C147 a_17873_1728# a_16600_714# 0.00548f
C148 a_20481_3042# a_18014_1728# 0.00344f
C149 a_1545_1728# a_2415_1728# 0.00952f
C150 a_n3261_1640# vdd 0.42319f
C151 a_25755_n400# a_n3862_n388# 0.0226f
C152 vbias a_n5045_2028# 0.00455f
C153 a_n3290_1728# a_n1959_614# 0.02702f
C154 a_14919_3442# a_13673_3042# 0.00395f
C155 a_n681_1728# a_n4996_714# 0.00166f
C156 vdd a_14957_n400# 0
C157 a_n3198_1728# a_n3762_n300# 0.03252f
C158 a_4884_3342# a_n3862_n388# 0.17195f
C159 a_11026_n300# a_12727_614# 0.07182f
C160 a_25289_614# a_19715_526# 0.01914f
C161 a_5753_2028# a_5015_2028# 0.0113f
C162 a_7124_1728# a_7216_1728# 5.709f
C163 a_7216_1728# a_8737_1728# 0.03627f
C164 a_n3290_1728# a_n681_1728# 0.07762f
C165 vbias a_11065_614# 0
C166 a_7036_n300# a_5722_n300# 0.01116f
C167 vdd a_n3339_1728# 0.00795f
C168 a_n3261_1640# a_n3339_1728# 0.00116f
C169 vdd a_13673_3042# 0.0031f
C170 a_25755_n400# a_24235_4312# 0.00696f
C171 a_n5045_2028# a_n4151_2028# 0.00926f
C172 a_3298_4640# vdd 1.25024f
C173 a_7036_n300# vbias 0
C174 a_4121_714# vbias 0
C175 a_10501_1728# a_10501_614# 0
C176 a_n3261_1640# a_3298_4640# 0.00399f
C177 a_n5001_4543# a_5831_626# 0
C178 clkp a_n3762_n300# 0
C179 a_23191_3042# a_18014_1728# 0
C180 a_22681_3042# q8p 0.04919f
C181 a_17922_1728# q8p 0.04786f
C182 a_15813_2028# vdd 0.03035f
C183 a_17873_1728# a_18014_1728# 0.03189f
C184 a_19535_1728# a_17951_1640# 0.01139f
C185 a_n4996_714# a_408_614# 1.2375f
C186 a_2875_3042# a_408_614# 0
C187 a_1545_1728# a_408_614# 0.08425f
C188 a_20481_3042# a_17922_1728# 0
C189 a_8403_3042# a_7124_1728# 0
C190 a_5722_n300# a_16600_714# 0.00559f
C191 a_12829_1728# a_12829_614# 0
C192 a_3890_3342# a_n5001_4543# 0.00551f
C193 a_n3290_1728# a_408_614# 0.00331f
C194 q4p a_5802_714# 0.01503f
C195 a_17834_n300# vbias 0
C196 a_5722_n300# a_8839_1728# 0
C197 q4p a_12829_614# 0.00121f
C198 a_25289_614# a_22730_3042# 0.02418f
C199 vbias a_16600_714# 0.1834f
C200 q2n a_2415_1728# 0.03703f
C201 clkn q2p 0
C202 a_17951_1640# a_21912_1728# 0.02888f
C203 a_n3862_n388# a_19637_614# 0.00168f
C204 a_24235_4312# a_25717_2028# 0
C205 a_n1881_526# a_3693_614# 0.01914f
C206 a_14919_2028# a_5722_n300# 0.00289f
C207 clkn a_228_n300# 0
C208 a_n3862_n388# a_8839_614# 0.00168f
C209 a_17834_n300# a_19535_1728# 0
C210 a_19535_1728# a_16600_714# 0.0014f
C211 a_n3762_n300# a_n4043_n300# 0.02042f
C212 a_21863_614# vbias 0
C213 q8p a_26611_3442# 0
C214 a_n3582_614# a_n1625_3042# 0.08239f
C215 a_16520_n300# a_17445_3442# 0.05202f
C216 a_11932_3042# a_5802_714# 0.00514f
C217 a_23961_3042# a_17951_1640# 0.00303f
C218 a_16520_n300# a_17951_1640# 0.29523f
C219 a_11932_3042# a_12829_614# 0.02509f
C220 a_n5001_4543# a_2875_3042# 0.00245f
C221 a_n3862_n388# a_15319_n400# 0.0174f
C222 a_n5001_4543# a_1545_1728# 0
C223 a_n5001_4543# a_n4996_714# 0
C224 a_22681_3042# a_23191_3042# 0.01667f
C225 a_17834_n300# a_21912_1728# 0
C226 a_16551_2028# a_16551_714# 0
C227 vdd a_n4814_3408# 0.00764f
C228 a_3309_1728# a_4121_2028# 0.00716f
C229 a_n1575_1728# a_n3582_614# 0.00728f
C230 a_16600_714# a_21912_1728# 1.23968f
C231 a_23627_614# a_21912_1728# 0.00857f
C232 a_10501_614# a_5802_714# 0.01035f
C233 a_17873_1728# a_17922_1728# 0.07559f
C234 a_n1575_1728# a_n2445_1728# 0.00952f
C235 a_n4259_n400# a_n3762_n300# 0.00887f
C236 a_n3290_1728# a_n5001_4543# 0.00109f
C237 a_15813_714# a_16600_714# 0.00187f
C238 q4n q2p 1.16594f
C239 q2n a_408_614# 2.94395f
C240 a_25717_714# a_n3862_n388# 0
C241 vdd a_n2905_3042# 0.00309f
C242 a_21863_614# a_21912_1728# 0.02418f
C243 a_n3261_1640# a_n2905_3042# 0
C244 q8n a_18014_614# 0.37498f
C245 a_17834_n300# a_16520_n300# 0.01116f
C246 a_16520_n300# a_16600_714# 0.53674f
C247 a_10501_1728# a_8917_526# 0
C248 a_n297_614# vbias 0
C249 clkn vdd 1.56416f
C250 a_11114_1728# a_11065_614# 0.02418f
C251 a_n3261_1640# clkn 0
C252 a_1085_3042# a_408_614# 0
C253 q4p a_7124_1728# 0.04786f
C254 a_n3862_n388# a_5802_714# 0.66496f
C255 a_19715_526# a_17951_1640# 0.01409f
C256 a_1929_614# a_408_614# 0.02702f
C257 a_19535_1728# a_18014_1728# 0.03627f
C258 a_n3862_n388# a_26333_n300# 0.00957f
C259 a_n3862_n388# a_12829_614# 0.00143f
C260 a_21824_n300# a_25289_614# 0.06415f
C261 a_7075_614# a_5802_714# 0.02622f
C262 a_17553_n300# vdd 0
C263 a_16520_n300# a_19201_3042# 0.0049f
C264 a_5831_626# q2p 0.08584f
C265 a_n3862_n388# a_26611_714# 0
C266 a_17445_714# a_17951_1640# 0.00123f
C267 q8n vdd 1.70807f
C268 a_7036_n300# a_11114_1728# 0
C269 a_12727_1728# a_12727_614# 0
C270 q4n a_9683_3042# 0
C271 a_2415_1728# a_1134_3042# 0.01161f
C272 a_5831_626# a_6647_714# 0
C273 q2n a_2031_614# 0
C274 a_25289_1728# a_24235_4312# 0.00168f
C275 a_25717_714# a_24235_4312# 0
C276 a_n681_1728# a_651_1728# 0.00614f
C277 a_24471_3042# q8p 0
C278 a_16551_714# a_16629_626# 0.01945f
C279 q4n a_14919_3442# 0
C280 vdd a_n3723_614# 0.00181f
C281 a_21912_1728# a_18014_1728# 0.04462f
C282 a_5722_n300# a_6755_n300# 0.00257f
C283 a_25717_3442# a_26611_3442# 0.00556f
C284 q4n a_18014_614# 0
C285 a_8917_526# a_15319_n400# 0.04131f
C286 a_3890_3342# q2p 0.00141f
C287 a_5722_n300# a_13163_3042# 0.0049f
C288 a_1929_614# a_2031_614# 0.08889f
C289 a_26333_n300# a_24235_4312# 0.00643f
C290 vbias a_6755_n300# 0
C291 q2n a_n5001_4543# 0.47716f
C292 a_14919_2028# a_14491_1728# 0.01407f
C293 a_17834_n300# a_19715_526# 1.28443f
C294 a_23627_614# a_19715_526# 0.00637f
C295 a_16600_714# a_13437_4312# 0.00956f
C296 a_16600_714# a_19715_526# 0.52016f
C297 a_26611_714# a_24235_4312# 0.01945f
C298 a_7124_1728# a_10501_614# 0.02418f
C299 a_17834_n300# a_17445_714# 0.00242f
C300 a_n4621_n400# a_n3762_n300# 0
C301 a_1595_3042# a_2365_3042# 0.01081f
C302 a_17445_714# a_16600_714# 0.08499f
C303 q4n vdd 1.74919f
C304 a_16520_n300# a_18014_1728# 0.32358f
C305 clkp a_n4151_714# 0
C306 a_n3862_n388# a_n1881_526# 1.09778f
C307 a_14919_2028# a_13437_4312# 0
C308 a_7153_1640# q2p 0.03419f
C309 vdd a_7075_1728# 0.01232f
C310 a_22730_3042# a_17951_1640# 0.38418f
C311 a_n1575_1728# a_n681_1728# 0.00926f
C312 a_21863_614# a_19715_526# 0.00851f
C313 a_19535_1728# a_17922_1728# 0.08513f
C314 a_651_1728# a_408_614# 0.07762f
C315 a_6647_714# a_7153_1640# 0.00123f
C316 a_14919_2028# a_11114_1728# 0
C317 a_17951_1640# a_18691_3042# 0
C318 a_4159_n400# a_n1881_526# 0.15026f
C319 a_17445_3442# a_18691_3042# 0.00197f
C320 q2p a_2875_3042# 0
C321 a_8917_526# a_5802_714# 0.52016f
C322 a_12829_614# a_8917_526# 0.00637f
C323 q2p a_n4996_714# 0.01536f
C324 a_1545_1728# q2p 0.03344f
C325 a_1134_3042# a_408_614# 0.27937f
C326 clkp vbias 0.16407f
C327 a_16520_n300# a_26611_2028# 0.00448f
C328 vdd a_5831_626# 1.7766f
C329 a_12829_1728# a_11026_n300# 0
C330 a_1545_1728# a_228_n300# 0
C331 a_n3862_n388# a_7124_1728# 0.00781f
C332 a_228_n300# a_n4996_714# 1.29365f
C333 a_n3198_1728# a_n4151_2028# 0.00179f
C334 q4p a_11026_n300# 0.07495f
C335 a_n3862_n388# a_16551_714# 0
C336 q4n a_13673_3042# 0.03618f
C337 q4p q8p 0.20021f
C338 a_22681_3042# a_21912_1728# 0
C339 a_n3290_1728# q2p 0.0325f
C340 a_17922_1728# a_21912_1728# 0.00472f
C341 a_9683_3042# a_7153_1640# 0.04864f
C342 a_5722_n300# a_7216_1728# 0.32358f
C343 a_5441_n300# a_n3862_n388# 0.01597f
C344 vbias a_26117_n400# 0.02839f
C345 a_24471_3042# a_25717_3442# 0.00395f
C346 a_n3290_1728# a_228_n300# 0
C347 a_n5001_4543# a_n5045_2028# 0
C348 a_n3198_1728# a_n3582_614# 1.45456f
C349 a_23627_614# a_22730_3042# 0.02509f
C350 a_16600_714# a_22730_3042# 0.00514f
C351 a_14919_3442# a_7153_1640# 0
C352 a_19715_526# a_18014_1728# 0.08674f
C353 a_n3198_1728# a_n2445_1728# 0.03703f
C354 a_3890_3342# vdd 0.01297f
C355 a_7893_3042# a_6647_3442# 0.00197f
C356 a_6647_714# a_5753_714# 0.00926f
C357 a_2031_614# a_1134_3042# 0.02509f
C358 a_3890_3342# a_n3261_1640# 0.00138f
C359 a_25289_1728# a_25717_2028# 0.01407f
C360 a_25717_714# a_25717_2028# 0
C361 a_11932_3042# a_11026_n300# 3.27181f
C362 a_16520_n300# a_22681_3042# 0.00195f
C363 a_16520_n300# a_17922_1728# 0.04617f
C364 a_n4452_3408# a_n3582_614# 0
C365 a_5722_n300# a_6177_n400# 0.01446f
C366 a_n5001_4543# a_651_1728# 0
C367 a_19201_3042# a_18691_3042# 0.01667f
C368 a_19715_526# a_26611_2028# 0.07542f
C369 a_n5001_4543# a_1134_3042# 0.03466f
C370 vbias a_n4043_n300# 0.00445f
C371 clkp a_n3582_614# 0.00225f
C372 vdd a_7153_1640# 0.41284f
C373 vbias a_6177_n400# 0.02839f
C374 a_n3862_n388# a_n3762_n300# 3.40787f
C375 a_5722_n300# a_15813_3442# 0.04902f
C376 a_9173_3042# a_7124_1728# 0
C377 vdd a_14741_n300# 0
C378 a_8403_3042# a_5722_n300# 0.0049f
C379 a_11114_1728# a_12727_614# 0.0269f
C380 a_n3762_n300# a_n2061_614# 0.07182f
C381 a_267_614# a_n4996_714# 0.01358f
C382 a_21863_1728# q8p 0.03365f
C383 vdd a_2875_3042# 0.00309f
C384 vdd a_n4996_714# 4.39347f
C385 a_16551_3442# a_5722_n300# 0
C386 a_n3261_1640# a_2875_3042# 0.01858f
C387 a_n3261_1640# a_n4996_714# 0.11255f
C388 a_4884_3342# a_n1881_526# 0
C389 a_7124_1728# a_8917_526# 1.23071f
C390 q2n q2p 3.69463f
C391 a_n5001_4543# a_n1625_3042# 0.00229f
C392 a_14957_n400# a_14741_n300# 0.02069f
C393 a_16551_714# a_8917_526# 0.00187f
C394 a_7893_3042# a_7124_1728# 0
C395 q2n a_228_n300# 0.03262f
C396 vdd a_n5045_714# 0.02911f
C397 a_n3290_1728# a_267_614# 0
C398 a_10501_1728# a_5802_714# 0.00165f
C399 a_n3290_1728# vdd 0.01395f
C400 a_22730_3042# a_18014_1728# 0.3509f
C401 a_14919_2028# a_14919_714# 0
C402 vbias a_n4259_n400# 0.00652f
C403 a_n1575_1728# a_n5001_4543# 0
C404 a_16520_n300# a_26117_n400# 0.01446f
C405 a_16520_n300# a_26611_3442# 0.04902f
C406 a_n3290_1728# a_n3261_1640# 2.9359f
C407 a_n3862_n388# a_11026_n300# 3.39846f
C408 a_7153_1640# a_13673_3042# 0.01742f
C409 a_17922_1728# a_19715_526# 1.23071f
C410 vbias a_17337_n400# 0
C411 q4p a_25717_3442# 0
C412 vdd a_5753_714# 0.02911f
C413 q2p a_1085_3042# 0.04919f
C414 a_1929_614# q2p 0.00124f
C415 a_18691_3042# a_18014_1728# 0.03618f
C416 a_17873_1728# a_16629_626# 0.00194f
C417 a_11114_1728# a_13163_3042# 0
C418 a_8839_614# a_5802_714# 0.0066f
C419 a_19637_1728# a_19535_1728# 0.11111f
C420 a_n3198_1728# a_n1959_614# 0
C421 a_1929_614# a_228_n300# 0.07182f
C422 a_n3339_1728# a_n4996_714# 0.00405f
C423 a_21824_n300# a_23627_614# 0.07182f
C424 a_17834_n300# a_21824_n300# 0.02002f
C425 a_25289_614# vdd 0
C426 a_21824_n300# a_16600_714# 1.29365f
C427 a_7216_614# a_6647_714# 0.00279f
C428 a_23525_1728# q8p 0.03478f
C429 a_n297_614# a_408_614# 0
C430 a_n3290_1728# a_n3339_1728# 0.07452f
C431 vbias a_3693_614# 0
C432 a_n3198_1728# a_n681_1728# 0
C433 a_21824_n300# a_21863_614# 0.06415f
C434 a_24235_4312# q8p 0.0683f
C435 a_24471_3042# a_21912_1728# 0
C436 a_9683_3042# a_7216_614# 0.07294f
C437 q4n q8n 0
C438 a_19715_526# a_26117_n400# 0.04131f
C439 a_16520_n300# a_15813_3442# 0
C440 q4n a_11065_1728# 0
C441 a_n3862_n388# a_3309_1728# 0.00117f
C442 a_n5001_4543# a_5015_2028# 0
C443 vdd a_5015_714# 0.02911f
C444 a_5722_n300# a_12829_1728# 0
C445 q2n vdd 1.81406f
C446 a_22681_3042# a_22730_3042# 0.07294f
C447 a_16551_3442# a_16520_n300# 0.04902f
C448 a_n3261_1640# q2n 0.82132f
C449 a_25717_714# a_26611_714# 0.00926f
C450 a_5722_n300# q4p 0.30616f
C451 a_16520_n300# a_19637_1728# 0
C452 a_6647_714# a_6647_2028# 0
C453 a_12727_1728# a_12829_1728# 0.11111f
C454 clkn a_5831_626# 0.07343f
C455 a_n4621_n400# vbias 0.03388f
C456 a_11114_1728# a_7216_1728# 0.04462f
C457 a_16520_n300# a_17337_n400# 0.00444f
C458 a_12727_1728# q4p 0.03478f
C459 a_17922_1728# a_18691_3042# 0
C460 a_16520_n300# a_24471_3042# 0.00553f
C461 a_8917_526# a_11026_n300# 2.06042f
C462 a_11883_3042# a_7216_1728# 0.00896f
C463 a_24471_3042# a_23961_3042# 0.01667f
C464 q2p a_651_1728# 0.03436f
C465 a_10501_1728# a_7124_1728# 0.07561f
C466 vdd a_1085_3042# 0
C467 a_228_n300# a_651_1728# 0
C468 a_n3261_1640# a_1085_3042# 0
C469 q2p a_1134_3042# 1.42291f
C470 a_5722_n300# a_16629_626# 0.01006f
C471 vdd a_6539_n400# 0
C472 a_n3198_1728# a_408_614# 0.03242f
C473 a_7216_614# vdd 0.00134f
C474 a_19535_614# a_17951_1640# 0.00118f
C475 a_228_n300# a_1134_3042# 3.27189f
C476 a_6177_n400# a_4521_n400# 0.00411f
C477 a_8839_614# a_7124_1728# 0.0269f
C478 vbias a_16629_626# 0.02602f
C479 a_23525_1728# a_23627_1728# 0.11111f
C480 a_4121_714# q2p 0
C481 a_4121_714# a_228_n300# 0
C482 a_5722_n300# a_11932_3042# 0.09607f
C483 a_15813_3442# a_13437_4312# 0.02163f
C484 a_n4996_714# a_n4814_3408# 0.0013f
C485 a_n3862_n388# a_26853_n300# 0.01001f
C486 a_16520_n300# a_16551_2028# 0.00448f
C487 a_7036_n300# a_6647_714# 0.00242f
C488 a_4121_2028# a_408_614# 0
C489 q2n a_3298_4640# 0.01286f
C490 a_5722_n300# a_16239_n300# 0.00338f
C491 a_12727_1728# a_11932_3042# 0.0074f
C492 q2p a_n1625_3042# 0
C493 a_16551_3442# a_13437_4312# 0
C494 vbias a_16239_n300# 0
C495 a_16520_n300# a_17445_2028# 0.00289f
C496 a_n1575_1728# q2p 0
C497 a_24235_4312# a_25717_3442# 0.02168f
C498 q4n a_5831_626# 0.43024f
C499 vbias a_10501_614# 0
C500 vbias a_16759_n300# 0
C501 vdd a_n5045_2028# 0.03028f
C502 vdd a_6647_2028# 0.03616f
C503 a_17834_n300# a_19535_614# 0.07182f
C504 a_16600_714# a_19535_614# 0.0066f
C505 a_n1881_526# a_5802_714# 0.04862f
C506 a_11065_1728# a_7153_1640# 0.00119f
C507 a_n3862_n388# a_n4151_714# 0
C508 clkn a_2875_3042# 0
C509 a_5831_626# a_7075_1728# 0.00194f
C510 a_n5001_4543# a_n3198_1728# 0.31335f
C511 a_n3290_1728# a_n2905_3042# 0
C512 q8p a_25717_2028# 0
C513 a_18014_614# a_17951_1640# 1.54854f
C514 a_21824_n300# a_17922_1728# 0
C515 a_16520_n300# q4p 0.59446f
C516 a_5722_n300# a_n3862_n388# 0.12562f
C517 a_7075_614# a_5722_n300# 0.00159f
C518 a_15813_714# a_16629_626# 0.00126f
C519 a_n3261_1640# a_651_1728# 0
C520 a_16551_2028# a_13437_4312# 0
C521 vdd a_1134_3042# 0.00596f
C522 a_7124_1728# a_5802_714# 0.36474f
C523 a_n3261_1640# a_1134_3042# 0.38418f
C524 a_n5001_4543# a_n4452_3408# 0.13203f
C525 clkn a_5753_714# 0.00126f
C526 vbias a_n3862_n388# 9.20702f
C527 vdd a_17951_1640# 0.41284f
C528 a_8737_1728# a_5802_714# 0.0014f
C529 a_15535_n300# a_n3862_n388# 0.00957f
C530 a_7075_614# vbias 0
C531 a_16520_n300# a_16629_626# 1.86748f
C532 vdd a_17445_3442# 0.00339f
C533 a_5722_n300# a_4159_n400# 0
C534 a_4121_714# vdd 0.02753f
C535 a_11932_3042# a_15813_714# 0
C536 a_n4996_714# a_n3723_614# 0.02622f
C537 clkp a_n5001_4543# 0.0014f
C538 a_5441_n300# a_5802_714# 0
C539 a_14491_1728# q4p 0
C540 a_21863_1728# a_21912_1728# 0.07561f
C541 q4n a_7153_1640# 0.82663f
C542 vbias a_4159_n400# 0
C543 a_19971_3042# q8p 0
C544 a_17445_714# a_17445_2028# 0
C545 vdd a_n1625_3042# 0
C546 a_17834_n300# a_18014_614# 3.27155f
C547 a_16600_714# a_18014_614# 1.51373f
C548 a_n3261_1640# a_n1625_3042# 0.03117f
C549 a_19971_3042# a_20481_3042# 0.01667f
C550 a_16520_n300# a_16239_n300# 0.02016f
C551 a_24471_3042# a_22730_3042# 0.07294f
C552 a_17834_n300# a_17873_614# 0.06415f
C553 a_7153_1640# a_7075_1728# 0
C554 a_17873_614# a_16600_714# 0.02622f
C555 a_5961_n300# a_5831_626# 0.00765f
C556 a_16520_n300# a_16759_n300# 0.04153f
C557 vbias a_24235_4312# 0.02542f
C558 a_n1575_1728# a_n3261_1640# 0.03344f
C559 a_14919_2028# a_14919_3442# 0
C560 a_18014_614# a_19201_3042# 0.08263f
C561 q4p a_13437_4312# 0.0683f
C562 a_11114_1728# a_12829_1728# 0.08513f
C563 a_21824_n300# a_26117_n400# 0
C564 q4p a_19715_526# 0.01941f
C565 a_15319_n400# a_11026_n300# 0
C566 a_n297_614# q2p 0
C567 a_16520_n300# a_21863_1728# 0.0013f
C568 a_n3862_n388# a_21912_1728# 0.00419f
C569 a_16600_714# vdd 4.3961f
C570 q2n a_n2905_3042# 0.01751f
C571 a_9173_3042# a_5722_n300# 0.00496f
C572 a_5831_626# a_7153_1640# 0
C573 a_11114_1728# q4p 5.64587f
C574 a_11932_3042# a_14491_1728# 0
C575 clkn a_5015_714# 0.01945f
C576 a_n3862_n388# a_n3582_614# 0.00768f
C577 a_11883_3042# q4p 0.04919f
C578 a_16629_626# a_13437_4312# 0.26528f
C579 a_15813_714# a_n3862_n388# 0
C580 q2n clkn 0
C581 a_25717_3442# a_25717_2028# 0
C582 a_n2061_614# a_n3582_614# 0.02509f
C583 a_5722_n300# a_8917_526# 0.5314f
C584 a_14919_2028# vdd 0.03616f
C585 a_17445_714# a_16629_626# 0
C586 a_23525_1728# a_21912_1728# 0.08529f
C587 a_5441_n300# a_n1881_526# 0
C588 a_5722_n300# a_7893_3042# 0.00588f
C589 a_11932_3042# a_13437_4312# 0.01035f
C590 a_12727_1728# a_8917_526# 0
C591 a_16520_n300# a_n3862_n388# 0.04263f
C592 a_25289_1728# q8p 0
C593 a_5722_n300# a_12393_3042# 0.00496f
C594 a_25717_714# q8p 0.00115f
C595 vbias a_8917_526# 0.18605f
C596 a_15535_n300# a_8917_526# 0.01148f
C597 a_11114_1728# a_11932_3042# 0.34219f
C598 a_24235_4312# a_21912_1728# 0
C599 a_7124_1728# a_8737_1728# 0.08513f
C600 a_11932_3042# a_11883_3042# 0.07294f
C601 a_25755_n400# vbias 0
C602 a_18014_614# a_18014_1728# 1.6415f
C603 a_5831_626# a_5753_714# 0.01945f
C604 a_5722_n300# a_4884_3342# 0.00181f
C605 vdd a_5015_2028# 0.0304f
C606 a_11026_n300# a_5802_714# 1.29365f
C607 a_12829_614# a_11026_n300# 0.07182f
C608 a_3890_3342# a_2875_3042# 0.00569f
C609 a_19715_526# a_21863_1728# 0.00114f
C610 a_11114_1728# a_10501_614# 0
C611 a_16520_n300# a_23525_1728# 0
C612 a_n3198_1728# q2p 1.24498f
C613 a_17922_1728# a_19535_614# 0.00857f
C614 q4p a_22730_3042# 0
C615 a_15813_2028# a_16600_714# 0
C616 a_21299_614# a_21299_1728# 0
C617 a_n3762_n300# a_n1881_526# 1.28443f
C618 a_16520_n300# a_24235_4312# 1.86877f
C619 a_n3198_1728# a_228_n300# 0
C620 vdd a_18014_1728# 0.1184f
C621 a_17834_n300# a_16975_n400# 0
C622 a_16600_714# a_16975_n400# 0.03973f
C623 a_n297_614# a_267_614# 0.01199f
C624 q2n q4n 0
C625 q2p a_4121_2028# 0
C626 a_n3862_n388# a_13437_4312# 0.00703f
C627 a_5082_4640# q2p 0.01343f
C628 a_n3862_n388# a_19715_526# 0.73687f
C629 a_15813_2028# a_14919_2028# 0.00926f
C630 a_n3862_n388# a_4521_n400# 0.0277f
C631 a_16629_626# a_18691_3042# 0.00845f
C632 a_11114_1728# a_n3862_n388# 0.00419f
C633 a_17445_714# a_n3862_n388# 0
C634 vdd a_26611_2028# 0.03023f
C635 a_15813_714# a_8917_526# 0.08247f
C636 a_1545_1728# a_n4996_714# 0
C637 a_n3862_n388# a_n1959_614# 0.00168f
C638 a_16055_n300# a_16600_714# 0
C639 a_5831_626# a_5015_714# 0.00126f
C640 q4n a_7216_614# 0.37498f
C641 a_4159_n400# a_4521_n400# 0.02443f
C642 a_14919_714# q4p 0.00115f
C643 a_n2061_614# a_n1959_614# 0.08889f
C644 q2n a_5831_626# 0.62014f
C645 a_5753_2028# a_5802_714# 0.07542f
C646 a_23525_1728# a_19715_526# 0
C647 a_16520_n300# a_8917_526# 0.00559f
C648 a_n5045_714# a_n4996_714# 0.08301f
C649 a_n3290_1728# a_n4996_714# 0.33437f
C650 a_5722_n300# a_10501_1728# 0.0013f
C651 a_7216_614# a_7075_1728# 0
C652 clkn a_1134_3042# 0.00239f
C653 a_17922_1728# a_18014_614# 0.34219f
C654 a_16520_n300# a_25755_n400# 0.00444f
C655 a_19715_526# a_24235_4312# 1.72027f
C656 a_7216_1728# q2p 0.04333f
C657 vdd a_6755_n300# 0
C658 a_5831_626# a_6539_n400# 0.00696f
C659 a_11065_1728# a_11065_614# 0
C660 a_4121_714# clkn 0
C661 a_n5001_4543# a_n3398_4640# 0.05977f
C662 a_7124_1728# a_11026_n300# 0
C663 a_7216_614# a_5831_626# 0.01021f
C664 a_3890_3342# q2n 0.00549f
C665 a_267_614# a_n3198_1728# 0
C666 q8n a_17951_1640# 0.82663f
C667 a_14491_1728# a_8917_526# 0.00216f
C668 a_17922_1728# vdd 0.04128f
C669 a_n3198_1728# vdd 0.10774f
C670 q8n a_17445_3442# 0
C671 vdd a_22681_3042# 0
C672 a_n3261_1640# a_n3198_1728# 2.64343f
C673 a_11932_3042# a_14919_714# 0
C674 a_21912_1728# a_25717_2028# 0
C675 q4n a_6647_2028# 0
C676 a_n1115_3042# a_n3582_614# 0.07294f
C677 a_n3862_n388# a_22730_3042# 0.00407f
C678 a_26333_n300# a_26853_n300# 0.01143f
C679 a_5722_n300# a_15319_n400# 0.01446f
C680 a_5753_3442# a_5831_626# 0.02163f
C681 vdd a_4121_2028# 0.03624f
C682 a_n1881_526# a_3309_1728# 0.00238f
C683 a_5082_4640# vdd 1.25445f
C684 a_n3261_1640# a_4121_2028# 0
C685 vdd a_n4452_3408# 0.01151f
C686 a_9683_3042# a_7216_1728# 0.00344f
C687 a_8917_526# a_13437_4312# 1.72027f
C688 a_5753_2028# a_n1881_526# 0
C689 vbias a_15319_n400# 0.02852f
C690 q2p a_15813_3442# 0.01318f
C691 a_15535_n300# a_15319_n400# 0.02069f
C692 a_11114_1728# a_8917_526# 0.26469f
C693 a_n3862_n388# a_408_614# 0.00527f
C694 clkp vdd 1.56414f
C695 a_16520_n300# a_25717_2028# 0.00289f
C696 a_25755_n400# a_19715_526# 0.15026f
C697 a_n3198_1728# a_n3339_1728# 0.03123f
C698 a_23525_1728# a_22730_3042# 0.0074f
C699 clkp a_n3261_1640# 0
C700 a_2365_3042# a_408_614# 0
C701 a_5831_626# a_6647_2028# 0
C702 q2n a_2875_3042# 0.0362f
C703 a_17834_n300# a_17553_n300# 0.02042f
C704 a_13163_3042# a_13673_3042# 0.01667f
C705 a_16551_3442# q2p 0.00132f
C706 q2n a_n4996_714# 0.05006f
C707 a_17553_n300# a_16600_714# 0.01709f
C708 a_11114_1728# a_12393_3042# 0
C709 q8n a_16600_714# 0.0878f
C710 q2n a_1545_1728# 0.01913f
C711 q4n a_17445_3442# 0
C712 a_23627_614# a_23525_614# 0.08889f
C713 a_22730_3042# a_24235_4312# 0.01035f
C714 a_11883_3042# a_12393_3042# 0.01667f
C715 a_7216_614# a_7153_1640# 1.54854f
C716 a_25717_714# vbias 0
C717 a_14919_714# a_n3862_n388# 0
C718 q8n a_19201_3042# 0.00187f
C719 a_n3290_1728# q2n 0.02554f
C720 a_5015_714# a_5753_714# 0.0113f
C721 a_7036_n300# a_7075_1728# 0
C722 a_5722_n300# a_5802_714# 0.53674f
C723 vdd a_7216_1728# 0.1184f
C724 clkp a_n3339_1728# 0
C725 a_n3862_n388# a_2031_614# 0.00143f
C726 a_21824_n300# a_21863_1728# 0
C727 clkn a_5015_2028# 0.0057f
C728 a_19971_3042# a_16520_n300# 0.00496f
C729 vbias a_26333_n300# 0
C730 vbias a_5802_714# 0.1822f
C731 a_14919_3442# a_15813_3442# 0.00556f
C732 a_7036_n300# a_5831_626# 0
C733 vbias a_26611_714# 0
C734 a_19715_526# a_25717_2028# 0.07306f
C735 q4n a_16600_714# 0.01941f
C736 vdd a_n4043_n300# 0
C737 a_228_n300# a_3693_614# 0.06415f
C738 a_n5001_4543# a_n3862_n388# 2.77631f
C739 a_7216_614# a_5753_714# 0
C740 a_n5001_4543# a_2365_3042# 0.00228f
C741 a_5722_n300# a_6647_3442# 0.05202f
C742 a_7153_1640# a_6647_2028# 0
C743 a_3890_3342# a_1134_3042# 0
C744 a_19637_1728# a_18014_614# 0.0074f
C745 a_21824_n300# a_n3862_n388# 3.39846f
C746 a_25289_1728# a_21912_1728# 0.07559f
C747 a_16520_n300# a_15319_n400# 0
C748 q4n a_14919_2028# 0
C749 q8n a_18014_1728# 0.8005f
C750 a_20481_3042# q8p 0.00896f
C751 a_n5045_2028# a_n4996_714# 0.07542f
C752 a_5722_n300# a_n1881_526# 0.00479f
C753 a_5961_n300# a_7036_n300# 0
C754 a_n4259_n400# vdd 0
C755 a_21824_n300# a_23525_1728# 0
C756 a_11114_1728# a_10501_1728# 0
C757 a_21299_1728# a_17951_1640# 0.03365f
C758 a_n5045_714# a_n5045_2028# 0
C759 vdd a_24471_3042# 0.0031f
C760 a_25289_1728# a_16520_n300# 0.00317f
C761 a_17337_n400# vdd 0
C762 a_25717_714# a_16520_n300# 0.00184f
C763 q4p q2p 0.24995f
C764 vbias a_n1881_526# 0.1778f
C765 a_651_1728# a_n4996_714# 0
C766 a_7036_n300# a_7153_1640# 0.07375f
C767 a_14919_714# a_8917_526# 0.08177f
C768 a_1545_1728# a_651_1728# 0.00926f
C769 a_21824_n300# a_24235_4312# 0
C770 a_2875_3042# a_1134_3042# 0.07294f
C771 a_n4996_714# a_1134_3042# 0.00514f
C772 a_1545_1728# a_1134_3042# 0.00728f
C773 q2n a_1929_614# 0
C774 q2n a_1085_3042# 0.00294f
C775 a_n4452_3408# a_n4814_3408# 0.0204f
C776 a_5722_n300# a_7124_1728# 0.04617f
C777 a_16629_626# q2p 0.01371f
C778 a_16520_n300# a_26333_n300# 0.04153f
C779 a_n3290_1728# a_651_1728# 0
C780 q4n a_18014_1728# 0.00132f
C781 q2n a_7216_614# 0
C782 a_5722_n300# a_8737_1728# 0
C783 a_n3198_1728# a_n2905_3042# 0.03618f
C784 a_15319_n400# a_13437_4312# 0.01158f
C785 a_5722_n300# a_16551_714# 0.002f
C786 a_16520_n300# a_26611_714# 0.00648f
C787 vdd a_3693_614# 0
C788 a_16551_2028# vdd 0.03035f
C789 clkp a_n4814_3408# 0.00117f
C790 a_5831_626# a_5015_2028# 0.00351f
C791 a_11932_3042# a_14491_614# 0.02418f
C792 a_23191_3042# q8p 0.03382f
C793 a_17834_n300# a_21299_1728# 0
C794 a_5441_n300# a_5722_n300# 0.02016f
C795 a_11932_3042# q2p 0
C796 a_21299_1728# a_16600_714# 0.00165f
C797 a_9683_3042# q4p 0.00896f
C798 vbias a_16551_714# 0
C799 a_23627_1728# q8p 0.01139f
C800 a_15813_2028# a_15813_3442# 0
C801 a_n2905_3042# a_n4452_3408# 0.00175f
C802 a_5441_n300# vbias 0
C803 a_5753_3442# q2n 0.01318f
C804 vdd a_17445_2028# 0.03616f
C805 a_n3862_n388# a_3943_n300# 0.01505f
C806 q4p a_14919_3442# 0
C807 q8n a_17922_1728# 0.02564f
C808 a_n1575_1728# a_n4996_714# 0
C809 q8n a_22681_3042# 0.00294f
C810 a_25717_3442# q8p 0
C811 a_17834_n300# a_21299_614# 0.06415f
C812 a_25289_1728# a_19715_526# 0.00216f
C813 a_25717_714# a_19715_526# 0.08177f
C814 clkp a_n2905_3042# 0
C815 a_7153_1640# a_8839_1728# 0.03478f
C816 a_n3582_614# a_n2395_3042# 0.08263f
C817 a_21299_614# a_16600_714# 0.01035f
C818 a_n1881_526# a_n3582_614# 0.00514f
C819 a_n3290_1728# a_n1625_3042# 0
C820 a_n3762_n300# a_n4151_714# 0.00242f
C821 a_21824_n300# a_25755_n400# 0.00887f
C822 a_n5001_4543# a_4884_3342# 0.00168f
C823 a_4159_n400# a_3943_n300# 0.02069f
C824 a_14919_2028# a_7153_1640# 0
C825 vdd a_n3398_4640# 1.25024f
C826 a_n1575_1728# a_n3290_1728# 0.08425f
C827 a_17337_n400# a_16975_n400# 0.02443f
C828 a_18014_614# a_16629_626# 0.01021f
C829 a_19715_526# a_26333_n300# 0.01148f
C830 a_21863_614# a_21299_614# 0.01199f
C831 q4p vdd 0.97481f
C832 a_26611_714# a_19715_526# 0.08247f
C833 a_17873_614# a_16629_626# 0.00175f
C834 a_11114_1728# a_12829_614# 0.00857f
C835 a_25539_n300# a_n3862_n388# 0.01088f
C836 a_11114_1728# a_5802_714# 1.23968f
C837 a_14491_614# a_n3862_n388# 0
C838 vbias a_n3762_n300# 0.00988f
C839 a_n3862_n388# q2p 0.34061f
C840 a_5015_714# a_1134_3042# 0
C841 q2n a_651_1728# 0
C842 a_n3862_n388# a_19535_614# 0.00168f
C843 q4n a_13163_3042# 0.03746f
C844 a_8737_614# a_7153_1640# 0.00118f
C845 a_15813_2028# a_16551_2028# 0.0113f
C846 a_2365_3042# q2p 0.00297f
C847 a_n3862_n388# a_228_n300# 3.40765f
C848 q2n a_1134_3042# 1.45119f
C849 vdd a_16629_626# 1.77401f
C850 a_15813_714# a_16551_714# 0.0113f
C851 a_n3862_n388# a_6647_714# 0
C852 a_21299_1728# a_18014_1728# 0
C853 clkp a_n3723_614# 0.00175f
C854 a_4121_714# a_5015_714# 0.00926f
C855 q8n a_26611_3442# 0
C856 a_11932_3042# vdd 0.00134f
C857 a_5722_n300# a_11026_n300# 0.01116f
C858 a_16520_n300# a_16551_714# 0.00648f
C859 a_4159_n400# a_228_n300# 0.00887f
C860 a_11065_1728# a_7216_1728# 0.00654f
C861 a_1085_3042# a_1134_3042# 0.07294f
C862 a_1929_614# a_1134_3042# 0.00676f
C863 a_25289_1728# a_22730_3042# 0
C864 q4p a_13673_3042# 0
C865 a_25717_714# a_22730_3042# 0
C866 a_12727_1728# a_11026_n300# 0
C867 vbias a_11026_n300# 0
C868 q2n a_n1625_3042# 0
C869 a_15535_n300# a_11026_n300# 0
C870 a_7036_n300# a_6539_n400# 0.00887f
C871 a_7036_n300# a_7216_614# 3.27155f
C872 a_n1881_526# a_4521_n400# 0.04131f
C873 a_n297_614# a_n4996_714# 0.01035f
C874 a_n3762_n300# a_n3582_614# 3.27162f
C875 a_n3862_n388# a_18014_614# 0.00768f
C876 a_26611_714# a_22730_3042# 0
C877 a_n3762_n300# a_n2445_1728# 0
C878 a_17873_614# a_n3862_n388# 0
C879 a_11932_3042# a_13673_3042# 0.07294f
C880 a_n1881_526# a_2415_1728# 0
C881 q4n a_7216_1728# 0.8005f
C882 a_n297_614# a_n3290_1728# 0.02418f
C883 a_15813_2028# a_16629_626# 0
C884 a_14491_614# a_8917_526# 0.01914f
C885 a_16551_714# a_13437_4312# 0.00126f
C886 a_267_614# a_n3862_n388# 0
C887 a_n1881_526# a_n681_1728# 0
C888 a_n3862_n388# vdd 3.27779f
C889 a_8917_526# q2p 0.01941f
C890 a_7075_614# vdd 0.00179f
C891 a_16629_626# a_16975_n400# 0.01158f
C892 a_n3261_1640# a_n3862_n388# 0.00727f
C893 a_11114_1728# a_7124_1728# 0.00472f
C894 a_5753_2028# a_5722_n300# 0.00448f
C895 a_7216_1728# a_7075_1728# 0.03189f
C896 a_n3261_1640# a_2365_3042# 0.00303f
C897 a_17445_714# a_16551_714# 0.00926f
C898 a_25539_n300# a_25755_n400# 0.02069f
C899 a_17922_1728# a_21299_1728# 0.07561f
C900 q8p a_21912_1728# 5.64587f
C901 a_5441_n300# a_4521_n400# 0.00293f
C902 a_7153_1640# a_13163_3042# 0.00303f
C903 q8n a_24471_3042# 0.03618f
C904 a_17553_n300# a_17337_n400# 0.02069f
C905 a_n3261_1640# a_n2061_614# 0.00122f
C906 a_n3862_n388# a_14957_n400# 0.0226f
C907 a_4159_n400# vdd 0
C908 a_9173_3042# a_9683_3042# 0.01667f
C909 a_7216_614# a_8839_1728# 0.0074f
C910 a_5831_626# a_7216_1728# 0.13234f
C911 a_5015_714# a_5015_2028# 0
C912 a_4884_3342# q2p 0
C913 a_21299_614# a_17922_1728# 0.02418f
C914 clkn a_3693_614# 0.00186f
C915 a_16975_n400# a_16759_n300# 0.02069f
C916 q4n a_15813_3442# 0.00133f
C917 a_n3198_1728# a_1545_1728# 0
C918 a_n3198_1728# a_n4996_714# 0.05603f
C919 vdd a_24235_4312# 1.76935f
C920 q4n a_8403_3042# 0.00187f
C921 a_16520_n300# q8p 0.30616f
C922 a_23961_3042# q8p 0.00312f
C923 a_4121_714# a_1134_3042# 0
C924 a_1595_3042# a_408_614# 0
C925 a_25717_714# a_21824_n300# 0
C926 a_21824_n300# a_25289_1728# 0
C927 a_n3862_n388# a_3298_4640# 0.04636f
C928 a_16551_3442# q4n 0.01318f
C929 a_6177_n400# a_5831_626# 0.01158f
C930 a_20481_3042# a_16520_n300# 0.00195f
C931 a_16055_n300# a_16239_n300# 0.05714f
C932 a_n3290_1728# a_n3198_1728# 2.94284f
C933 a_n1881_526# a_408_614# 0.24191f
C934 a_n4452_3408# a_n4996_714# 0
C935 a_7216_614# a_8737_614# 0.02509f
C936 a_n1115_3042# q2p 0.00896f
C937 q8n a_17445_2028# 0
C938 a_9173_3042# vdd 0
C939 a_14491_1728# a_11026_n300# 0
C940 a_n3762_n300# a_n1959_614# 0.07182f
C941 a_21824_n300# a_26333_n300# 0
C942 vbias a_26853_n300# 0
C943 clkp a_n4996_714# 1.72159f
C944 a_n3862_n388# a_16975_n400# 0.0174f
C945 a_23191_3042# a_21912_1728# 0
C946 a_23627_1728# a_21912_1728# 0.08513f
C947 vdd a_8917_526# 4.35263f
C948 a_7153_1640# a_7216_1728# 4.35454f
C949 clkp a_n5045_714# 0.01945f
C950 vdd a_7893_3042# 0.0031f
C951 clkp a_n3290_1728# 0
C952 a_n3762_n300# a_n681_1728# 0
C953 a_11026_n300# a_13437_4312# 0
C954 a_17834_n300# a_17951_1640# 0.07375f
C955 a_n1881_526# a_2031_614# 0.00637f
C956 a_16600_714# a_17951_1640# 0.17936f
C957 q4n a_16551_2028# 0
C958 a_12393_3042# vdd 0
C959 a_5961_n300# a_6177_n400# 0.02069f
C960 a_25755_n400# vdd 0
C961 q8n q4p 0.98799f
C962 a_19715_526# q8p 0.15591f
C963 a_11065_1728# q4p 0.03365f
C964 a_14957_n400# a_8917_526# 0.15026f
C965 a_16055_n300# a_n3862_n388# 0.01001f
C966 a_11114_1728# a_11026_n300# 3.31391f
C967 vbias a_n4151_714# 0.00169f
C968 a_19637_614# a_19535_614# 0.08889f
C969 a_n5001_4543# a_1595_3042# 0.00229f
C970 a_7036_n300# a_8839_1728# 0
C971 a_16520_n300# a_23191_3042# 0.00496f
C972 a_4884_3342# vdd 0.00512f
C973 a_23191_3042# a_23961_3042# 0.01081f
C974 a_19201_3042# a_17951_1640# 0.00312f
C975 a_16520_n300# a_23627_1728# 0
C976 a_n5001_4543# a_n2395_3042# 0.00228f
C977 q8n a_16629_626# 0.43024f
C978 a_n5001_4543# a_n1881_526# 0
C979 a_12727_1728# a_5722_n300# 0
C980 a_17873_1728# a_16520_n300# 0.0035f
C981 a_5722_n300# vbias 0.51465f
C982 a_15535_n300# a_5722_n300# 0.04153f
C983 q2n a_n3198_1728# 0.78179f
C984 a_n4043_n300# a_n4996_714# 0.01709f
C985 a_16520_n300# a_25717_3442# 0.05202f
C986 a_15535_n300# vbias 0
C987 q4n a_12829_1728# 0.03627f
C988 a_8403_3042# a_7153_1640# 0.00312f
C989 a_6755_n300# a_6539_n400# 0.02069f
C990 a_17834_n300# a_16600_714# 1.70894f
C991 a_n3198_1728# a_1085_3042# 0.00896f
C992 vdd a_n1115_3042# 0
C993 q4n q4p 5.40731f
C994 a_n4151_714# a_n4151_2028# 0
C995 q2n a_4121_2028# 0
C996 a_7036_n300# a_8737_614# 0.07182f
C997 q2n a_n4452_3408# 0
C998 a_15813_2028# a_8917_526# 0.07542f
C999 a_16520_n300# a_26853_n300# 0.02016f
C1000 a_n3261_1640# a_n1115_3042# 0.04864f
C1001 q2n a_5082_4640# 0.01166f
C1002 a_n3762_n300# a_408_614# 0
C1003 vdd a_25717_2028# 0.03616f
C1004 q8n a_21863_1728# 0
C1005 a_n3582_614# a_n4151_714# 0.00279f
C1006 clkp q2n 0
C1007 a_21863_614# a_16600_714# 0.01358f
C1008 a_17951_1640# a_18014_1728# 4.35454f
C1009 q4n a_16629_626# 0.62014f
C1010 a_18014_614# a_19637_614# 0.00676f
C1011 a_17445_3442# a_18014_1728# 0
C1012 a_19971_3042# a_18014_614# 0.08239f
C1013 a_n4259_n400# a_n4996_714# 0.14869f
C1014 a_19715_526# a_23627_1728# 0
C1015 a_22730_3042# q8p 1.54982f
C1016 vbias a_n4151_2028# 0.00178f
C1017 clkn a_n3862_n388# 0.16236f
C1018 a_2415_1728# a_3309_1728# 0.00926f
C1019 q4n a_11932_3042# 1.63814f
C1020 a_16055_n300# a_8917_526# 0
C1021 a_5722_n300# a_15813_714# 0.00648f
C1022 a_17553_n300# a_n3862_n388# 0.01088f
C1023 a_19971_3042# vdd 0
C1024 vbias a_n3582_614# 0.00386f
C1025 q2n a_7216_1728# 0.00132f
C1026 clkn a_4159_n400# 0.00696f
C1027 a_n3862_n388# a_23525_614# 0.00143f
C1028 vbias a_15813_714# 0
C1029 a_16520_n300# a_5722_n300# 0.08428f
C1030 a_6647_714# a_5802_714# 0.08499f
C1031 a_19715_526# a_26853_n300# 0
C1032 a_17834_n300# a_18014_1728# 0.057f
C1033 a_16600_714# a_18014_1728# 0.08889f
C1034 a_14919_714# a_11026_n300# 0
C1035 a_n3862_n388# a_n3723_614# 0
C1036 a_n1881_526# a_3943_n300# 0.01835f
C1037 a_16520_n300# vbias 0.51371f
C1038 q8n a_23525_1728# 0.01402f
C1039 a_7216_614# a_7216_1728# 1.6415f
C1040 a_23525_614# a_23525_1728# 0
C1041 a_n3198_1728# a_651_1728# 0.00274f
C1042 a_19201_3042# a_18014_1728# 0.03817f
C1043 q8n a_24235_4312# 0.13736f
C1044 a_5722_n300# a_14491_1728# 0.00317f
C1045 a_7036_n300# a_6755_n300# 0.02042f
C1046 a_n3198_1728# a_1134_3042# 0.3509f
C1047 a_21863_614# a_18014_1728# 0
C1048 clkp a_n5045_2028# 0.0057f
C1049 a_16520_n300# a_19535_1728# 0
C1050 a_23191_3042# a_22730_3042# 0.08239f
C1051 q4p a_7153_1640# 1.58747f
C1052 a_17922_1728# a_17951_1640# 5.64552f
C1053 a_22730_3042# a_23627_1728# 0.00972f
C1054 a_22681_3042# a_17951_1640# 0
C1055 a_14957_n400# a_15319_n400# 0.02443f
C1056 a_1595_3042# q2p 0.03119f
C1057 a_6177_n400# a_6539_n400# 0.02443f
C1058 a_3309_1728# a_408_614# 0.07452f
C1059 a_n4621_n400# a_n4996_714# 0.03973f
C1060 a_25717_714# vdd 0.02753f
C1061 a_n1881_526# q2p 0.09841f
C1062 a_7075_614# a_7075_1728# 0
C1063 a_25289_1728# vdd 0.0106f
C1064 a_n2445_1728# a_n3582_614# 0.01161f
C1065 a_5722_n300# a_13437_4312# 1.86877f
C1066 a_n3198_1728# a_n1625_3042# 0.00775f
C1067 a_5722_n300# a_4521_n400# 0.00112f
C1068 a_n1881_526# a_228_n300# 2.06042f
C1069 a_4121_714# a_4121_2028# 0
C1070 a_16520_n300# a_21912_1728# 0.04617f
C1071 a_23961_3042# a_21912_1728# 0
C1072 a_21824_n300# q8p 0.07495f
C1073 a_11114_1728# a_5722_n300# 0.04617f
C1074 a_7216_1728# a_6647_2028# 0.0035f
C1075 vbias a_13437_4312# 0.02542f
C1076 vbias a_19715_526# 0.18485f
C1077 a_n3862_n388# a_5831_626# 0.16201f
C1078 a_15535_n300# a_13437_4312# 0.00643f
C1079 a_8403_3042# a_7216_614# 0.08263f
C1080 a_n1575_1728# a_n3198_1728# 0.01913f
C1081 a_7075_614# a_5831_626# 0.00175f
C1082 vbias a_4521_n400# 0.02555f
C1083 a_11065_1728# a_8917_526# 0.00114f
C1084 a_5722_n300# a_11883_3042# 0.00195f
C1085 vdd a_5802_714# 4.3961f
C1086 a_11932_3042# a_7153_1640# 0.38418f
C1087 a_12727_1728# a_11114_1728# 0.08529f
C1088 a_16520_n300# a_15813_714# 0.002f
C1089 vbias a_17445_714# 0
C1090 vdd a_26611_714# 0.02911f
C1091 a_17834_n300# a_17922_1728# 3.31365f
C1092 a_17922_1728# a_16600_714# 0.36474f
C1093 clkn a_4884_3342# 0.00119f
C1094 a_21299_1728# a_21863_1728# 0.01498f
C1095 a_16520_n300# a_23961_3042# 0.0049f
C1096 a_11065_614# a_7216_1728# 0
C1097 a_16975_n400# a_15319_n400# 0.00411f
C1098 q4n a_9173_3042# 0
C1099 a_3890_3342# a_n3862_n388# 0.09457f
C1100 a_17922_1728# a_19201_3042# 0
C1101 a_n5001_4543# a_3309_1728# 0
C1102 a_7036_n300# a_7216_1728# 0.057f
C1103 vdd a_6647_3442# 0.00339f
C1104 a_21863_614# a_17922_1728# 0
C1105 a_5961_n300# a_n3862_n388# 0.01214f
C1106 a_19715_526# a_21912_1728# 0.26469f
C1107 q4n a_8917_526# 0.06643f
C1108 a_9683_3042# a_7124_1728# 0
C1109 a_1595_3042# vdd 0
C1110 q4n a_7893_3042# 0.01738f
C1111 a_n3261_1640# a_1595_3042# 0.00175f
C1112 a_267_614# a_n1881_526# 0.00851f
C1113 a_15813_714# a_13437_4312# 0.01945f
C1114 a_21824_n300# a_23627_1728# 0
C1115 vdd a_n1881_526# 4.35296f
C1116 q4n a_12393_3042# 0.00663f
C1117 a_n3261_1640# a_n2395_3042# 0.00297f
C1118 q2n a_n3398_4640# 0.0076f
C1119 a_7036_n300# a_6177_n400# 0
C1120 a_n3261_1640# a_n1881_526# 0.0145f
C1121 q8n a_25717_2028# 0
C1122 a_n3862_n388# a_14741_n300# 0.01088f
C1123 a_21299_614# a_n3862_n388# 0
C1124 a_n3582_614# a_n1959_614# 0.00676f
C1125 a_n3762_n300# q2p 0
C1126 a_18014_614# a_16551_714# 0
C1127 a_n3862_n388# a_2875_3042# 0.0016f
C1128 a_n3862_n388# a_n4996_714# 0.65886f
C1129 a_16520_n300# a_13437_4312# 0.01006f
C1130 a_2365_3042# a_2875_3042# 0.01667f
C1131 a_n3762_n300# a_228_n300# 0.02002f
C1132 a_16520_n300# a_19715_526# 0.5314f
C1133 a_5015_2028# a_4121_2028# 0.00926f
C1134 a_22681_3042# a_18014_1728# 0.00896f
C1135 a_17922_1728# a_18014_1728# 5.709f
C1136 a_7893_3042# a_5831_626# 0.00845f
C1137 a_n2061_614# a_n4996_714# 0.0066f
C1138 a_16520_n300# a_17445_714# 0.00184f
C1139 a_7216_1728# a_8839_1728# 0.01402f
C1140 vdd a_7124_1728# 0.04128f
C1141 a_19637_1728# a_17951_1640# 0.03478f
C1142 a_n3862_n388# a_n5045_714# 0
C1143 a_16551_3442# a_17445_3442# 0.00556f
C1144 a_n3290_1728# a_n3862_n388# 0.00774f
C1145 vdd a_16551_714# 0.02911f
C1146 a_11065_1728# a_10501_1728# 0.01498f
C1147 a_n3862_n388# a_5753_714# 0.00289f
C1148 a_7216_614# q4p 0.3509f
C1149 a_5722_n300# a_14919_714# 0.00184f
C1150 a_24471_3042# a_17951_1640# 0.01742f
C1151 a_14491_614# a_11026_n300# 0.06415f
C1152 a_14491_1728# a_13437_4312# 0.00168f
C1153 a_n3290_1728# a_n2061_614# 0.00869f
C1154 a_4884_3342# a_5831_626# 0.00469f
C1155 a_19971_3042# q8n 0
C1156 a_11114_1728# a_14491_1728# 0.07559f
C1157 vbias a_14919_714# 0
C1158 a_22730_3042# a_21912_1728# 0.34219f
C1159 a_9173_3042# a_7153_1640# 0.0338f
C1160 a_n3862_n388# a_25289_614# 0
C1161 a_3693_614# a_1134_3042# 0.02418f
C1162 a_17834_n300# a_19637_1728# 0
C1163 a_19637_1728# a_16600_714# 0.0014f
C1164 a_3890_3342# a_4884_3342# 0.00716f
C1165 a_7153_1640# a_8917_526# 0.01409f
C1166 a_4121_714# a_3693_614# 0.01407f
C1167 a_11114_1728# a_13437_4312# 0
C1168 a_7893_3042# a_7153_1640# 0
C1169 a_16520_n300# a_22730_3042# 0.09607f
C1170 a_17834_n300# a_17337_n400# 0.00887f
C1171 a_14741_n300# a_8917_526# 0.01835f
C1172 a_23961_3042# a_22730_3042# 0.08263f
C1173 a_n5001_4543# vbias 0.12989f
C1174 a_16600_714# a_17337_n400# 0.14869f
C1175 a_n3762_n300# vdd 0
C1176 a_12393_3042# a_7153_1640# 0.00175f
C1177 a_17445_2028# a_17951_1640# 0
C1178 a_17445_3442# a_17445_2028# 0
C1179 a_n3261_1640# a_n3762_n300# 0.05419f
C1180 a_16520_n300# a_18691_3042# 0.00588f
C1181 a_n3862_n388# a_5015_714# 0.0053f
C1182 a_11114_1728# a_11883_3042# 0
C1183 a_25289_614# a_24235_4312# 0.00186f
C1184 a_21824_n300# vbias 0
C1185 q2p a_3309_1728# 0.00116f
C1186 q2n a_n3862_n388# 0.44577f
C1187 a_26611_2028# a_26611_3442# 0
C1188 a_25289_1728# q8n 0.03189f
C1189 q2n a_2365_3042# 0.03536f
C1190 a_18014_614# q8p 0.3509f
C1191 a_228_n300# a_3309_1728# 0
C1192 clkn a_5802_714# 0.00898f
C1193 a_n3198_1728# a_n4452_3408# 0
C1194 a_15813_714# a_14919_714# 0.00926f
C1195 a_16551_2028# a_16600_714# 0.07542f
C1196 a_20481_3042# a_18014_614# 0.07294f
C1197 a_n3862_n388# a_1929_614# 0.00143f
C1198 q4p a_17951_1640# 0.03419f
C1199 a_n3862_n388# a_6539_n400# 0.02269f
C1200 a_n3762_n300# a_n3339_1728# 0
C1201 a_11065_1728# a_5802_714# 0
C1202 clkp a_n3198_1728# 0
C1203 a_n5001_4543# a_n4151_2028# 0
C1204 a_7216_614# a_n3862_n388# 0.00768f
C1205 a_7075_614# a_7216_614# 0.02418f
C1206 vdd q8p 0.22385f
C1207 a_16600_714# a_17445_2028# 0.07323f
C1208 a_19715_526# a_22730_3042# 1.42884f
C1209 a_16629_626# a_17951_1640# 0
C1210 a_17445_3442# a_16629_626# 0.02168f
C1211 a_14957_n400# a_11026_n300# 0.00887f
C1212 a_19637_1728# a_18014_1728# 0.01402f
C1213 a_20481_3042# vdd 0
C1214 a_21824_n300# a_21912_1728# 3.31391f
C1215 a_n5001_4543# a_n3582_614# 0.03528f
C1216 clkp a_n4452_3408# 0.00126f
C1217 a_n5001_4543# a_n2445_1728# 0
C1218 a_5753_3442# a_n3862_n388# 0
C1219 a_n2905_3042# a_n2395_3042# 0.01667f
C1220 a_11065_614# a_10501_614# 0.01199f
C1221 clkn a_n1881_526# 1.70461f
C1222 q4n a_5802_714# 0.0878f
C1223 a_10501_1728# a_7153_1640# 0.03365f
C1224 a_n3290_1728# a_n1115_3042# 0
C1225 a_21824_n300# a_16520_n300# 0.01116f
C1226 a_7036_n300# a_10501_614# 0.06415f
C1227 vbias a_3943_n300# 0
C1228 a_21863_1728# a_17951_1640# 0.00119f
C1229 a_17873_1728# a_18014_614# 0
C1230 a_17834_n300# a_16629_626# 0
C1231 vdd a_3309_1728# 0.0072f
C1232 a_14919_714# a_13437_4312# 0
C1233 a_16600_714# a_16629_626# 1.73715f
C1234 a_2415_1728# a_408_614# 0.08402f
C1235 a_7075_1728# a_5802_714# 0.00548f
C1236 a_5753_2028# vdd 0.03035f
C1237 q2n a_7893_3042# 0
C1238 a_14919_2028# q4p 0
C1239 a_8839_614# a_7153_1640# 0.00118f
C1240 a_17873_1728# a_17873_614# 0
C1241 a_9173_3042# a_7216_614# 0.08239f
C1242 a_n681_1728# a_408_614# 0
C1243 vdd a_23191_3042# 0
C1244 a_5722_n300# a_14491_614# 0.00123f
C1245 a_n3862_n388# a_11065_614# 0
C1246 a_17445_2028# a_18014_1728# 0.0035f
C1247 a_n3862_n388# a_1134_3042# 0.00849f
C1248 a_5831_626# a_5802_714# 1.73715f
C1249 q4n a_6647_3442# 0
C1250 a_17873_1728# vdd 0.01232f
C1251 a_5722_n300# q2p 0.59446f
C1252 a_16600_714# a_16239_n300# 0
C1253 a_2365_3042# a_1134_3042# 0.08263f
C1254 q2n a_4884_3342# 0.01006f
C1255 a_7216_614# a_8917_526# 0.00514f
C1256 a_25539_n300# vbias 0
C1257 vbias a_14491_614# 0
C1258 a_7036_n300# a_n3862_n388# 3.40787f
C1259 a_7216_614# a_7893_3042# 0.07294f
C1260 a_17834_n300# a_16759_n300# 0
C1261 a_11065_1728# a_7124_1728# 0
C1262 a_19637_1728# a_17922_1728# 0.08529f
C1263 a_7075_614# a_7036_n300# 0.06415f
C1264 a_4121_714# a_n3862_n388# 0.0018f
C1265 a_5722_n300# a_6647_714# 0.00184f
C1266 a_16600_714# a_16759_n300# 0.01148f
C1267 vdd a_25717_3442# 0.00339f
C1268 vbias a_228_n300# 0
C1269 a_16600_714# a_21863_1728# 0
C1270 a_21824_n300# a_19715_526# 2.06042f
C1271 vbias a_6647_714# 0
C1272 q4p a_18014_1728# 0.04333f
C1273 a_5831_626# a_6647_3442# 0.02168f
C1274 a_19535_1728# a_19535_614# 0
C1275 q2n a_n1115_3042# 0
C1276 a_5722_n300# a_9683_3042# 0.00195f
C1277 a_n5001_4543# a_2415_1728# 0
C1278 a_5961_n300# a_5802_714# 0.01148f
C1279 a_21863_614# a_21863_1728# 0
C1280 a_24235_4312# a_17951_1640# 0.49307f
C1281 a_16629_626# a_18014_1728# 0.13234f
C1282 a_5722_n300# a_14919_3442# 0.05202f
C1283 a_17834_n300# a_n3862_n388# 3.40787f
C1284 clkp a_n4259_n400# 0.0059f
C1285 a_16600_714# a_n3862_n388# 0.65746f
C1286 a_n5001_4543# a_n681_1728# 0
C1287 a_23627_614# a_n3862_n388# 0.00143f
C1288 q4n a_7124_1728# 0.02564f
C1289 a_5753_3442# a_4884_3342# 0.00312f
C1290 a_7153_1640# a_5802_714# 0.17936f
C1291 a_n1881_526# a_5831_626# 0.01433f
C1292 q4p a_26611_2028# 0
C1293 vdd a_n4151_714# 0.02753f
C1294 q4p a_12727_614# 0.00121f
C1295 a_n3261_1640# a_n4151_714# 0
C1296 a_7124_1728# a_7075_1728# 0.07559f
C1297 a_8403_3042# a_7216_1728# 0.03817f
C1298 a_n3582_614# q2p 0.3509f
C1299 a_17922_1728# a_17445_2028# 0.00198f
C1300 a_21863_614# a_n3862_n388# 0
C1301 a_11065_614# a_8917_526# 0.00851f
C1302 vbias a_17873_614# 0
C1303 a_5722_n300# vdd 0.54175f
C1304 a_2031_614# a_408_614# 0.00869f
C1305 a_25539_n300# a_16520_n300# 0.00257f
C1306 a_n3762_n300# a_n3723_614# 0.06415f
C1307 a_5831_626# a_7124_1728# 0
C1308 a_21863_1728# a_18014_1728# 0.00654f
C1309 a_7036_n300# a_8917_526# 1.28443f
C1310 a_267_614# vbias 0
C1311 a_19535_1728# a_18014_614# 0.00972f
C1312 a_21824_n300# a_22730_3042# 3.27181f
C1313 a_n3198_1728# a_n3398_4640# 0.00304f
C1314 a_16520_n300# q2p 0
C1315 vbias vdd 0.17188f
C1316 a_n3261_1640# vbias 0
C1317 a_5722_n300# a_14957_n400# 0.00444f
C1318 a_25289_1728# a_25289_614# 0
C1319 a_25717_714# a_25289_614# 0.01407f
C1320 a_n3862_n388# a_5015_2028# 0.00455f
C1321 a_n3862_n388# a_8737_614# 0.00168f
C1322 q4p a_13163_3042# 0.00312f
C1323 a_11932_3042# a_12727_614# 0.00676f
C1324 a_5753_714# a_5802_714# 0.08301f
C1325 a_11065_1728# a_11026_n300# 0
C1326 a_n5001_4543# a_408_614# 0.00109f
C1327 a_n4259_n400# a_n4043_n300# 0.02069f
C1328 vbias a_14957_n400# 0
C1329 q8n q8p 5.26997f
C1330 a_14491_1728# a_14491_614# 0
C1331 a_7216_614# a_8839_614# 0.00676f
C1332 a_16551_3442# a_15813_3442# 0.00678f
C1333 a_23525_614# q8p 0.00121f
C1334 a_17922_1728# a_16629_626# 0
C1335 a_5722_n300# a_13673_3042# 0.00553f
C1336 a_20481_3042# q8n 0
C1337 vbias a_n3339_1728# 0.00135f
C1338 clkp a_n4621_n400# 0.00981f
C1339 a_16600_714# a_8917_526# 0.04862f
C1340 a_n5001_4543# a_n5182_4640# 0.04623f
C1341 a_n297_614# a_n3862_n388# 0
C1342 vdd a_n4151_2028# 0.03627f
C1343 a_n1881_526# a_n4996_714# 0.52016f
C1344 a_n3261_1640# a_n4151_2028# 0
C1345 a_n1881_526# a_1545_1728# 0
C1346 a_11932_3042# a_13163_3042# 0.08263f
C1347 a_25539_n300# a_19715_526# 0.01835f
C1348 a_14491_614# a_13437_4312# 0.00186f
C1349 vdd a_21912_1728# 0.04128f
C1350 a_15813_2028# a_5722_n300# 0.00448f
C1351 q2p a_13437_4312# 0.70483f
C1352 a_7124_1728# a_7153_1640# 5.64552f
C1353 clkn a_3309_1728# 0
C1354 a_5441_n300# a_5961_n300# 0.01143f
C1355 a_16520_n300# a_18014_614# 0.09608f
C1356 vdd a_n3582_614# 0.00596f
C1357 a_n3290_1728# a_n2395_3042# 0
C1358 a_7153_1640# a_8737_1728# 0.01139f
C1359 a_17951_1640# a_25717_2028# 0
C1360 q4n a_11026_n300# 0.0571f
C1361 a_n3290_1728# a_n1881_526# 1.22853f
C1362 a_n3261_1640# a_n3582_614# 1.42163f
C1363 a_5722_n300# a_16975_n400# 0
C1364 a_14919_2028# a_8917_526# 0.07306f
C1365 a_5015_714# a_5802_714# 0.00187f
C1366 a_n3862_n388# a_12727_614# 0.00143f
C1367 q4p a_26611_3442# 0.01318f
C1368 a_15813_714# vdd 0.02911f
C1369 a_16520_n300# a_17873_614# 0.00159f
C1370 vdd a_n2445_1728# 0
C1371 a_228_n300# a_4521_n400# 0
C1372 a_n3261_1640# a_n2445_1728# 0.01608f
C1373 a_n1881_526# a_5753_714# 0.00187f
C1374 q2n a_5802_714# 0.01941f
C1375 a_17922_1728# a_21863_1728# 0
C1376 vbias a_16975_n400# 0.02852f
C1377 q4p a_7216_1728# 1.28324f
C1378 a_n1115_3042# a_n1625_3042# 0.01667f
C1379 a_2415_1728# q2p 0.01608f
C1380 a_16520_n300# vdd 0.54175f
C1381 q8n a_23191_3042# 0.00663f
C1382 a_228_n300# a_2415_1728# 0
C1383 a_16551_3442# a_16551_2028# 0
C1384 a_16055_n300# a_5722_n300# 0.02016f
C1385 q8n a_23627_1728# 0.03627f
C1386 a_n3862_n388# a_6755_n300# 0.01088f
C1387 a_n681_1728# q2p 0.00279f
C1388 a_n3339_1728# a_n3582_614# 0.0033f
C1389 a_7036_n300# a_10501_1728# 0
C1390 a_6539_n400# a_5802_714# 0.14869f
C1391 a_24235_4312# a_26611_2028# 0.01095f
C1392 a_19637_614# a_17951_1640# 0.00118f
C1393 a_16055_n300# vbias 0
C1394 a_7216_614# a_5802_714# 1.51373f
C1395 a_n2445_1728# a_n3339_1728# 0.00926f
C1396 a_14919_3442# a_13437_4312# 0.02168f
C1397 a_19971_3042# a_17951_1640# 0.0338f
C1398 a_17922_1728# a_n3862_n388# 0.00781f
C1399 a_16055_n300# a_15535_n300# 0.01143f
C1400 q2n a_6647_3442# 0
C1401 q8n a_25717_3442# 0
C1402 a_14491_1728# vdd 0.0106f
C1403 a_7036_n300# a_8839_614# 0.07182f
C1404 a_18014_614# a_19715_526# 0.00514f
C1405 a_11932_3042# a_7216_1728# 0.3509f
C1406 a_n3198_1728# a_n2061_614# 0
C1407 q2n a_1595_3042# 0.00703f
C1408 q4p a_15813_3442# 0
C1409 a_n3862_n388# a_4121_2028# 0.00369f
C1410 a_17445_714# a_18014_614# 0.00279f
C1411 a_n1881_526# a_5015_714# 0.08247f
C1412 a_5082_4640# a_n3862_n388# 0.04947f
C1413 a_15813_2028# a_15813_714# 0
C1414 q2n a_n2395_3042# 0.00187f
C1415 q2n a_n1881_526# 0.04256f
C1416 a_n3762_n300# a_n4996_714# 1.70894f
C1417 a_n4621_n400# a_n4259_n400# 0.02443f
C1418 vdd a_19715_526# 4.34967f
C1419 vbias a_n4814_3408# 0.01758f
C1420 vdd a_13437_4312# 1.7702f
C1421 clkp a_n3862_n388# 0.01123f
C1422 a_1595_3042# a_1085_3042# 0.01667f
C1423 a_16629_626# a_15813_3442# 0
C1424 a_17834_n300# a_19637_614# 0.07182f
C1425 a_17445_714# vdd 0.02753f
C1426 a_16600_714# a_19637_614# 0.0066f
C1427 a_16551_2028# a_17445_2028# 0.00926f
C1428 a_8917_526# a_12727_614# 0.00637f
C1429 q2p a_408_614# 2.93625f
C1430 a_11114_1728# vdd 0.04128f
C1431 q4p a_24471_3042# 0
C1432 a_5802_714# a_6647_2028# 0.07323f
C1433 a_21299_1728# q8p 0.00773f
C1434 a_n3290_1728# a_n3762_n300# 3.29923f
C1435 a_11883_3042# vdd 0
C1436 a_n3261_1640# a_n1959_614# 0.00122f
C1437 a_1929_614# a_n1881_526# 0.00637f
C1438 a_14957_n400# a_13437_4312# 0.00696f
C1439 a_16551_3442# a_16629_626# 0.02163f
C1440 a_5753_2028# a_5831_626# 0.01095f
C1441 a_16520_n300# a_16975_n400# 0.01446f
C1442 a_228_n300# a_408_614# 3.29949f
C1443 a_n3862_n388# a_26117_n400# 0.017f
C1444 a_5753_3442# a_6647_3442# 0.00556f
C1445 vbias a_n2905_3042# 0
C1446 vdd a_2415_1728# 0
C1447 a_14741_n300# a_11026_n300# 0.02042f
C1448 clkn a_5722_n300# 0.00744f
C1449 a_n3261_1640# a_2415_1728# 0
C1450 a_19971_3042# a_19201_3042# 0.01081f
C1451 a_17337_n400# a_16629_626# 0.00696f
C1452 a_14919_714# a_14491_614# 0.01407f
C1453 a_8839_614# a_8839_1728# 0
C1454 a_21299_614# q8p 0
C1455 clkn vbias 0.01933f
C1456 a_11065_614# a_5802_714# 0.01358f
C1457 a_n3261_1640# a_n681_1728# 0.03436f
C1458 a_5722_n300# a_11065_1728# 0.0013f
C1459 a_13673_3042# a_13437_4312# 0.0081f
C1460 a_16055_n300# a_16520_n300# 0.00338f
C1461 a_6647_3442# a_6647_2028# 0
C1462 a_2031_614# q2p 0.00124f
C1463 a_7036_n300# a_5802_714# 1.70894f
C1464 a_11114_1728# a_13673_3042# 0
C1465 a_17553_n300# vbias 0
C1466 a_7216_614# a_7124_1728# 0.34219f
C1467 a_18014_614# a_18691_3042# 0.07294f
C1468 a_228_n300# a_2031_614# 0.07182f
C1469 a_n3862_n388# a_n4043_n300# 0.01088f
C1470 a_12393_3042# a_13163_3042# 0.01081f
C1471 a_7216_614# a_8737_1728# 0.00972f
C1472 a_n3862_n388# a_6177_n400# 0.02032f
C1473 a_16551_2028# a_16629_626# 0.01095f
C1474 a_24235_4312# a_26117_n400# 0.01158f
C1475 a_24235_4312# a_26611_3442# 0.02163f
C1476 a_15813_2028# a_13437_4312# 0.01095f
C1477 a_26611_2028# a_25717_2028# 0.00926f
C1478 vdd a_22730_3042# 0.00134f
C1479 a_8737_614# a_8839_614# 0.08889f
C1480 vbias a_n3723_614# 0.00145f
C1481 a_n5001_4543# q2p 0.57073f
C1482 a_25539_n300# a_21824_n300# 0.02042f
C1483 vdd a_18691_3042# 0.0031f
C1484 a_16629_626# a_17445_2028# 0
C1485 a_19971_3042# a_18014_1728# 0.00736f
C1486 a_12829_1728# q4p 0.01139f
C1487 a_n2905_3042# a_n3582_614# 0.07294f
C1488 q2n a_n3762_n300# 0
C1489 q4n a_5722_n300# 0.30544f
C1490 a_1595_3042# a_1134_3042# 0.08239f
C1491 a_267_614# a_408_614# 0.02418f
C1492 a_n1881_526# a_651_1728# 0.00116f
C1493 vdd a_408_614# 0.01395f
C1494 a_n3261_1640# a_408_614# 0.02562f
C1495 a_9173_3042# a_7216_1728# 0.00736f
C1496 q4n a_12727_1728# 0.01402f
C1497 a_n4259_n400# a_n3862_n388# 0.0226f
C1498 a_n1881_526# a_1134_3042# 1.42994f
C1499 a_7124_1728# a_6647_2028# 0.00198f
C1500 q8n a_21912_1728# 5.71011f
C1501 a_5722_n300# a_7075_1728# 0.0035f
C1502 a_n3862_n388# a_17337_n400# 0.0226f
C1503 a_5802_714# a_8839_1728# 0.0014f
C1504 a_23525_614# a_21912_1728# 0.0269f
C1505 q4p a_16629_626# 0.08584f
C1506 a_n3198_1728# a_n1115_3042# 0.00344f
C1507 a_4121_714# a_n1881_526# 0.08177f
C1508 a_7216_1728# a_8917_526# 0.08674f
C1509 a_25755_n400# a_26117_n400# 0.02443f
C1510 a_14919_714# vdd 0.02753f
C1511 a_7893_3042# a_7216_1728# 0.03618f
C1512 a_5722_n300# a_5831_626# 1.86748f
C1513 vdd a_n5182_4640# 1.25445f
C1514 a_5753_2028# a_5753_714# 0
C1515 a_11932_3042# a_12829_1728# 0.00972f
C1516 a_12393_3042# a_7216_1728# 0
C1517 a_11065_614# a_7124_1728# 0
C1518 a_n2395_3042# a_n1625_3042# 0.01081f
C1519 a_11932_3042# q4p 1.54982f
C1520 vbias a_5831_626# 0.02602f
C1521 a_16520_n300# q8n 0.30496f
C1522 a_17553_n300# a_16520_n300# 0.00257f
C1523 a_n3582_614# a_n3723_614# 0.02418f
C1524 a_n3862_n388# a_3693_614# 0.00183f
C1525 q8n a_23961_3042# 0.03746f
C1526 a_n1575_1728# a_n1881_526# 0
C1527 a_24471_3042# a_24235_4312# 0.0081f
C1528 a_7036_n300# a_7124_1728# 3.31365f
C1529 a_5802_714# a_5015_2028# 0
C1530 a_8737_614# a_5802_714# 0.0066f
C1531 a_7036_n300# a_8737_1728# 0
C1532 q4p a_10501_614# 0
C1533 a_9173_3042# a_8403_3042# 0.01081f
C1534 a_n5001_4543# vdd 11.6353f
C1535 a_17922_1728# a_19637_614# 0.0269f
C1536 a_n3261_1640# a_n5001_4543# 0.31209f
C1537 a_19971_3042# a_17922_1728# 0
C1538 a_16629_626# a_16759_n300# 0.00765f
C1539 a_5961_n300# a_5722_n300# 0.04153f
C1540 a_8403_3042# a_7893_3042# 0.01667f
C1541 a_228_n300# a_3943_n300# 0.02042f
C1542 clkn vss 2.81212f
C1543 q8n vss 7.49004f
C1544 q8p vss 6.52772f
C1545 q4n vss 9.6035f
C1546 q4p vss 12.3789f
C1547 clkp vss 2.97796f
C1548 q2n vss 9.09597f
C1549 q2p vss 11.1416f
C1550 vbias vss 22.6831f
C1551 vdd vss 64.5471f
C1552 a_26853_n300# vss 0.77366f ; **FLOATING
C1553 a_26333_n300# vss 0.65211f ; **FLOATING
C1554 a_26117_n400# vss 0.91682f ; **FLOATING
C1555 a_25755_n400# vss 0.83062f ; **FLOATING
C1556 a_25539_n300# vss 0.69107f ; **FLOATING
C1557 a_17553_n300# vss 0.69107f ; **FLOATING
C1558 a_17337_n400# vss 0.83062f ; **FLOATING
C1559 a_16975_n400# vss 0.90907f ; **FLOATING
C1560 a_16759_n300# vss 0.65211f ; **FLOATING
C1561 a_16239_n300# vss 0.68586f ; **FLOATING
C1562 a_26611_714# vss 0.7169f ; **FLOATING
C1563 a_25717_714# vss 0.71433f ; **FLOATING
C1564 a_26611_2028# vss 0.71591f ; **FLOATING
C1565 a_25717_2028# vss 0.70984f ; **FLOATING
C1566 a_25289_614# vss 0.56018f ; **FLOATING
C1567 a_23627_614# vss 0.4477f ; **FLOATING
C1568 a_23525_614# vss 0.4477f ; **FLOATING
C1569 a_21824_n300# vss 3.60428f
C1570 a_21863_614# vss 0.56805f ; **FLOATING
C1571 a_21299_614# vss 0.56805f ; **FLOATING
C1572 a_19637_614# vss 0.4477f ; **FLOATING
C1573 a_19715_526# vss 7.03751f
C1574 a_19535_614# vss 0.4477f ; **FLOATING
C1575 a_17834_n300# vss 3.60428f
C1576 a_17873_614# vss 0.59246f ; **FLOATING
C1577 a_16055_n300# vss 0.68586f ; **FLOATING
C1578 a_15535_n300# vss 0.65211f ; **FLOATING
C1579 a_15319_n400# vss 0.90907f ; **FLOATING
C1580 a_14957_n400# vss 0.83062f ; **FLOATING
C1581 a_14741_n300# vss 0.69107f ; **FLOATING
C1582 a_6755_n300# vss 0.69107f ; **FLOATING
C1583 a_6539_n400# vss 0.83062f ; **FLOATING
C1584 a_6177_n400# vss 0.9084f ; **FLOATING
C1585 a_5961_n300# vss 0.65211f ; **FLOATING
C1586 a_5441_n300# vss 0.76212f ; **FLOATING
C1587 a_25289_1728# vss 0.70347f ; **FLOATING
C1588 a_23627_1728# vss 0.55654f ; **FLOATING
C1589 a_23525_1728# vss 0.55661f ; **FLOATING
C1590 a_21912_1728# vss 1.10045f
C1591 a_21863_1728# vss 0.70579f ; **FLOATING
C1592 a_21299_1728# vss 0.70579f ; **FLOATING
C1593 a_19637_1728# vss 0.55654f ; **FLOATING
C1594 a_19535_1728# vss 0.55661f ; **FLOATING
C1595 a_17922_1728# vss 1.1021f
C1596 a_17873_1728# vss 0.73496f ; **FLOATING
C1597 a_17445_714# vss 0.74159f ; **FLOATING
C1598 a_16551_714# vss 0.69424f ; **FLOATING
C1599 a_26611_3442# vss 0.43982f ; **FLOATING
C1600 a_25717_3442# vss 0.42178f ; **FLOATING
C1601 a_24471_3042# vss 0.67666f ; **FLOATING
C1602 a_23961_3042# vss 0.66456f ; **FLOATING
C1603 a_23191_3042# vss 0.66368f ; **FLOATING
C1604 a_22730_3042# vss 1.41541f
C1605 a_22681_3042# vss 0.68701f ; **FLOATING
C1606 a_20481_3042# vss 0.68701f ; **FLOATING
C1607 a_19971_3042# vss 0.66368f ; **FLOATING
C1608 a_19201_3042# vss 0.665f ; **FLOATING
C1609 a_18014_614# vss 1.41703f
C1610 a_18691_3042# vss 0.68567f ; **FLOATING
C1611 a_17445_2028# vss 0.73868f ; **FLOATING
C1612 a_16600_714# vss 7.0545f
C1613 a_16551_2028# vss 0.69325f ; **FLOATING
C1614 a_15813_714# vss 0.69424f ; **FLOATING
C1615 a_14919_714# vss 0.71433f ; **FLOATING
C1616 a_15813_2028# vss 0.69325f ; **FLOATING
C1617 a_14919_2028# vss 0.70984f ; **FLOATING
C1618 a_14491_614# vss 0.56018f ; **FLOATING
C1619 a_12829_614# vss 0.4477f ; **FLOATING
C1620 a_12727_614# vss 0.4477f ; **FLOATING
C1621 a_11026_n300# vss 3.60428f
C1622 a_11065_614# vss 0.56805f ; **FLOATING
C1623 a_10501_614# vss 0.56805f ; **FLOATING
C1624 a_8839_614# vss 0.4477f ; **FLOATING
C1625 a_8917_526# vss 6.90908f
C1626 a_8737_614# vss 0.4477f ; **FLOATING
C1627 a_7036_n300# vss 3.60428f
C1628 a_7075_614# vss 0.59246f ; **FLOATING
C1629 a_4521_n400# vss 0.88596f ; **FLOATING
C1630 a_4159_n400# vss 0.82972f ; **FLOATING
C1631 a_3943_n300# vss 0.69052f ; **FLOATING
C1632 a_n4043_n300# vss 0.69039f ; **FLOATING
C1633 a_n4259_n400# vss 0.82953f ; **FLOATING
C1634 a_n4621_n400# vss 0.89323f ; **FLOATING
C1635 a_14491_1728# vss 0.70347f ; **FLOATING
C1636 a_12829_1728# vss 0.55654f ; **FLOATING
C1637 a_12727_1728# vss 0.55661f ; **FLOATING
C1638 a_11114_1728# vss 1.10045f
C1639 a_11065_1728# vss 0.70579f ; **FLOATING
C1640 a_10501_1728# vss 0.70579f ; **FLOATING
C1641 a_8839_1728# vss 0.55654f ; **FLOATING
C1642 a_8737_1728# vss 0.55661f ; **FLOATING
C1643 a_7124_1728# vss 1.1021f
C1644 a_7075_1728# vss 0.73496f ; **FLOATING
C1645 a_6647_714# vss 0.74159f ; **FLOATING
C1646 a_5753_714# vss 0.69424f ; **FLOATING
C1647 a_17445_3442# vss 0.42178f ; **FLOATING
C1648 a_16520_n300# vss 4.9955f
C1649 a_16551_3442# vss 0.42622f ; **FLOATING
C1650 a_15813_3442# vss 0.42622f ; **FLOATING
C1651 a_14919_3442# vss 0.42178f ; **FLOATING
C1652 a_13673_3042# vss 0.67666f ; **FLOATING
C1653 a_13163_3042# vss 0.66456f ; **FLOATING
C1654 a_12393_3042# vss 0.66368f ; **FLOATING
C1655 a_11932_3042# vss 1.41541f
C1656 a_11883_3042# vss 0.68701f ; **FLOATING
C1657 a_9683_3042# vss 0.68701f ; **FLOATING
C1658 a_9173_3042# vss 0.66368f ; **FLOATING
C1659 a_8403_3042# vss 0.665f ; **FLOATING
C1660 a_7216_614# vss 1.41703f
C1661 a_7893_3042# vss 0.68567f ; **FLOATING
C1662 a_6647_2028# vss 0.73868f ; **FLOATING
C1663 a_5802_714# vss 7.05618f
C1664 a_5753_2028# vss 0.69325f ; **FLOATING
C1665 a_5015_714# vss 0.69424f ; **FLOATING
C1666 a_4121_714# vss 0.71417f ; **FLOATING
C1667 a_3693_614# vss 0.56172f ; **FLOATING
C1668 a_2031_614# vss 0.44925f ; **FLOATING
C1669 a_1929_614# vss 0.44925f ; **FLOATING
C1670 a_228_n300# vss 3.64665f
C1671 a_267_614# vss 0.56959f ; **FLOATING
C1672 a_n297_614# vss 0.56959f ; **FLOATING
C1673 a_n1959_614# vss 0.44925f ; **FLOATING
C1674 a_n2061_614# vss 0.44925f ; **FLOATING
C1675 a_n3762_n300# vss 3.64665f
C1676 a_n3723_614# vss 0.594f ; **FLOATING
C1677 a_5015_2028# vss 0.69728f ; **FLOATING
C1678 a_n1881_526# vss 7.12822f
C1679 a_4121_2028# vss 0.72163f ; **FLOATING
C1680 a_3309_1728# vss 0.68683f ; **FLOATING
C1681 a_2415_1728# vss 0.68032f ; **FLOATING
C1682 a_1545_1728# vss 0.68033f ; **FLOATING
C1683 a_408_614# vss 1.3798f
C1684 a_651_1728# vss 0.6914f ; **FLOATING
C1685 a_n681_1728# vss 0.6914f ; **FLOATING
C1686 a_n1575_1728# vss 0.68033f ; **FLOATING
C1687 a_n2445_1728# vss 0.68032f ; **FLOATING
C1688 a_n3290_1728# vss 1.38145f
C1689 a_n3339_1728# vss 0.70304f ; **FLOATING
C1690 a_n4151_714# vss 0.74255f ; **FLOATING
C1691 a_n5045_714# vss 0.7169f ; **FLOATING
C1692 a_6647_3442# vss 0.42178f ; **FLOATING
C1693 a_5722_n300# vss 4.79993f
C1694 a_5753_3442# vss 0.42759f ; **FLOATING
C1695 a_24235_4312# vss 5.72723f
C1696 a_17951_1640# vss 5.95819f
C1697 a_18014_1728# vss 6.0181f
C1698 a_16629_626# vss 5.36253f
C1699 a_13437_4312# vss 5.22672f
C1700 a_7153_1640# vss 5.95819f
C1701 a_7216_1728# vss 6.0181f
C1702 a_5831_626# vss 5.40164f
C1703 a_4884_3342# vss 0.88508f ; **FLOATING
C1704 a_3890_3342# vss 0.91111f ; **FLOATING
C1705 a_2875_3042# vss 0.67322f ; **FLOATING
C1706 a_2365_3042# vss 0.66608f ; **FLOATING
C1707 a_1595_3042# vss 0.6652f ; **FLOATING
C1708 a_1134_3042# vss 1.6459f
C1709 a_1085_3042# vss 0.68701f ; **FLOATING
C1710 a_n1115_3042# vss 0.68701f ; **FLOATING
C1711 a_n1625_3042# vss 0.6652f ; **FLOATING
C1712 a_n2395_3042# vss 0.66652f ; **FLOATING
C1713 a_n3582_614# vss 1.6475f
C1714 a_n2905_3042# vss 0.68558f ; **FLOATING
C1715 a_n4151_2028# vss 0.7377f ; **FLOATING
C1716 a_n4996_714# vss 7.42074f
C1717 a_n5045_2028# vss 0.71878f ; **FLOATING
C1718 a_5082_4640# vss 0.19978f ; **FLOATING
C1719 a_n3862_n388# vss 59.9008f
C1720 a_3298_4640# vss 0.18078f ; **FLOATING
C1721 a_n3261_1640# vss 5.44234f
C1722 a_n3198_1728# vss 5.54326f
C1723 a_n4452_3408# vss 0.65671f ; **FLOATING
C1724 a_n4814_3408# vss 0.78069f ; **FLOATING
C1725 a_n3398_4640# vss 0.18166f ; **FLOATING
C1726 a_n5182_4640# vss 0.19965f ; **FLOATING
C1727 a_n5001_4543# vss 3.9234f
.ends
