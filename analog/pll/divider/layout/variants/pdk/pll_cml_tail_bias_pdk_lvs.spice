* NGSPICE file created from pll_cml_tail_bias_pdk.ext - technology: sky130A

.subckt pll_cml_tail_bias_pdk vbias_sf vbias_logic vdd vss
X0 vdd a_n5001_4543# vbias_logic vdd sky130_fd_pr__pfet_01v8 ad=1.74 pd=12.58 as=0.87 ps=6.29 w=6 l=0.5
X1 vdd a_n5001_4543# a_n5001_4543# vdd sky130_fd_pr__pfet_01v8 ad=0.87 pd=6.29 as=0.87 ps=6.29 w=6 l=0.5
X2 vdd a_n5001_4543# vbias_logic vdd sky130_fd_pr__pfet_01v8 ad=0.87 pd=6.29 as=0.87 ps=6.29 w=6 l=0.5
X3 vbias_logic a_n5001_4543# vdd vdd sky130_fd_pr__pfet_01v8 ad=0.87 pd=6.29 as=0.87 ps=6.29 w=6 l=0.5
X4 vdd a_n5001_4543# a_n5001_4543# vdd sky130_fd_pr__pfet_01v8 ad=1.74 pd=12.58 as=0.87 ps=6.29 w=6 l=0.5
X5 vbias_logic a_n5001_4543# vdd vdd sky130_fd_pr__pfet_01v8 ad=0.87 pd=6.29 as=1.74 ps=12.58 w=6 l=0.5
X6 a_n5001_4543# a_n5001_4543# vdd vdd sky130_fd_pr__pfet_01v8 ad=0.87 pd=6.29 as=1.74 ps=12.58 w=6 l=0.5
X7 a_n5001_4543# vbias_sf vss vss sky130_fd_pr__nfet_01v8 ad=0.9686 pd=7.26 as=0.9686 ps=7.26 w=3.34 l=0.5
X8 vbias_logic vbias_logic vss vss sky130_fd_pr__nfet_01v8 ad=0.58 pd=4.29 as=0.58 ps=4.29 w=4 l=0.5
X9 a_n5001_4543# a_n5001_4543# vdd vdd sky130_fd_pr__pfet_01v8 ad=0.87 pd=6.29 as=0.87 ps=6.29 w=6 l=0.5
X10 vdd a_n5001_4543# vbias_logic vdd sky130_fd_pr__pfet_01v8 ad=0.87 pd=6.29 as=0.87 ps=6.29 w=6 l=0.5
X11 a_n5001_4543# a_n5001_4543# vdd vdd sky130_fd_pr__pfet_01v8 ad=0.87 pd=6.29 as=0.87 ps=6.29 w=6 l=0.5
X12 a_n5001_4543# a_n5001_4543# vdd vdd sky130_fd_pr__pfet_01v8 ad=0.87 pd=6.29 as=0.87 ps=6.29 w=6 l=0.5
X13 vdd a_n5001_4543# vbias_logic vdd sky130_fd_pr__pfet_01v8 ad=0.87 pd=6.29 as=0.87 ps=6.29 w=6 l=0.5
X14 vss vbias_logic vbias_logic vss sky130_fd_pr__nfet_01v8 ad=0.58 pd=4.29 as=0.58 ps=4.29 w=4 l=0.5
X15 vdd a_n5001_4543# a_n5001_4543# vdd sky130_fd_pr__pfet_01v8 ad=0.87 pd=6.29 as=0.87 ps=6.29 w=6 l=0.5
X16 vbias_logic a_n5001_4543# vdd vdd sky130_fd_pr__pfet_01v8 ad=0.87 pd=6.29 as=0.87 ps=6.29 w=6 l=0.5
X17 vdd a_n5001_4543# a_n5001_4543# vdd sky130_fd_pr__pfet_01v8 ad=0.87 pd=6.29 as=0.87 ps=6.29 w=6 l=0.5
X18 vbias_logic a_n5001_4543# vdd vdd sky130_fd_pr__pfet_01v8 ad=0.87 pd=6.29 as=0.87 ps=6.29 w=6 l=0.5
X19 vbias_logic vbias_logic vss vss sky130_fd_pr__nfet_01v8 ad=1.16 pd=8.58 as=0.58 ps=4.29 w=4 l=0.5
X20 a_n5001_4543# a_n5001_4543# vdd vdd sky130_fd_pr__pfet_01v8 ad=0.87 pd=6.29 as=0.87 ps=6.29 w=6 l=0.5
X21 vdd a_n5001_4543# a_n5001_4543# vdd sky130_fd_pr__pfet_01v8 ad=0.87 pd=6.29 as=0.87 ps=6.29 w=6 l=0.5
X22 vbias_logic a_n5001_4543# vdd vdd sky130_fd_pr__pfet_01v8 ad=0.87 pd=6.29 as=0.87 ps=6.29 w=6 l=0.5
X23 vdd a_n5001_4543# vbias_logic vdd sky130_fd_pr__pfet_01v8 ad=0.87 pd=6.29 as=0.87 ps=6.29 w=6 l=0.5
X24 vss vbias_logic vbias_logic vss sky130_fd_pr__nfet_01v8 ad=0.58 pd=4.29 as=0.58 ps=4.29 w=4 l=0.5
X25 vbias_logic vbias_logic vss vss sky130_fd_pr__nfet_01v8 ad=0.58 pd=4.29 as=1.16 ps=8.58 w=4 l=0.5
.ends
