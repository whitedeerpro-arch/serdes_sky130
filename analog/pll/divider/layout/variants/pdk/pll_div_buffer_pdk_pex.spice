* NGSPICE file created from pll_div_buffer_pdk.ext - technology: sky130A

.subckt pll_div_buffer_pdk inp inn outp outn vbias vdd vss
X0 a_n5076_n300# inn outp vss sky130_fd_pr__nfet_01v8_lvt ad=0.495 pd=3.33 as=0.495 ps=3.33 w=3 l=0.15
X1 outn inp a_n5076_n300# vss sky130_fd_pr__nfet_01v8_lvt ad=0.495 pd=3.33 as=0.93 ps=6.62 w=3 l=0.15
X2 outp inn a_n5076_n300# vss sky130_fd_pr__nfet_01v8_lvt ad=0.495 pd=3.33 as=0.93 ps=6.62 w=3 l=0.15
X3 vdd outn vss sky130_fd_pr__res_high_po_2p85 l=4.14
X4 a_n5076_n300# inp outn vss sky130_fd_pr__nfet_01v8_lvt ad=0.495 pd=3.33 as=0.495 ps=3.33 w=3 l=0.15
X5 vdd outp vss sky130_fd_pr__res_high_po_2p85 l=4.14
X6 a_n5076_n300# vbias vss vss sky130_fd_pr__nfet_01v8 ad=0.435 pd=3.29 as=0.87 ps=6.58 w=3 l=0.5
X7 outp inn a_n5076_n300# vss sky130_fd_pr__nfet_01v8_lvt ad=0.495 pd=3.33 as=0.495 ps=3.33 w=3 l=0.15
X8 a_n5076_n300# inn outp vss sky130_fd_pr__nfet_01v8_lvt ad=0.495 pd=3.33 as=0.495 ps=3.33 w=3 l=0.15
X9 outn inp a_n5076_n300# vss sky130_fd_pr__nfet_01v8_lvt ad=0.495 pd=3.33 as=0.495 ps=3.33 w=3 l=0.15
X10 a_n5076_n300# inn outp vss sky130_fd_pr__nfet_01v8_lvt ad=0.93 pd=6.62 as=0.495 ps=3.33 w=3 l=0.15
X11 a_n5076_n300# inp outn vss sky130_fd_pr__nfet_01v8_lvt ad=0.495 pd=3.33 as=0.495 ps=3.33 w=3 l=0.15
X12 vss vbias a_n5076_n300# vss sky130_fd_pr__nfet_01v8 ad=0.87 pd=6.58 as=0.435 ps=3.29 w=3 l=0.5
X13 a_n5076_n300# inp outn vss sky130_fd_pr__nfet_01v8_lvt ad=0.495 pd=3.33 as=0.495 ps=3.33 w=3 l=0.15
X14 outn inp a_n5076_n300# vss sky130_fd_pr__nfet_01v8_lvt ad=0.495 pd=3.33 as=0.495 ps=3.33 w=3 l=0.15
X15 a_n5076_n300# inn outp vss sky130_fd_pr__nfet_01v8_lvt ad=0.495 pd=3.33 as=0.495 ps=3.33 w=3 l=0.15
X16 a_n5076_n300# inp outn vss sky130_fd_pr__nfet_01v8_lvt ad=0.93 pd=6.62 as=0.495 ps=3.33 w=3 l=0.15
X17 outp inn a_n5076_n300# vss sky130_fd_pr__nfet_01v8_lvt ad=0.495 pd=3.33 as=0.495 ps=3.33 w=3 l=0.15
X18 outp inn a_n5076_n300# vss sky130_fd_pr__nfet_01v8_lvt ad=0.495 pd=3.33 as=0.495 ps=3.33 w=3 l=0.15
X19 outn inp a_n5076_n300# vss sky130_fd_pr__nfet_01v8_lvt ad=0.495 pd=3.33 as=0.495 ps=3.33 w=3 l=0.15
X20 a_n5076_n300# vbias vss vss sky130_fd_pr__nfet_01v8 ad=0.435 pd=3.29 as=0.87 ps=6.58 w=3 l=0.5
X21 vss vbias a_n5076_n300# vss sky130_fd_pr__nfet_01v8 ad=0.87 pd=6.58 as=0.435 ps=3.29 w=3 l=0.5
C0 outp vdd 0.035f
C1 a_5257_n300# a_4737_n300# 0.01143f
C2 outn vdd 0.035f
C3 a_n5357_n300# a_n5076_n300# 0.02016f
C4 vbias a_n5357_n300# 0.00817f
C5 inn a_n5045_3442# 0.00514f
C6 outp a_n5045_3442# 0.01699f
C7 a_4737_n300# a_n5076_n300# 0.04243f
C8 a_4737_n300# vbias 0.00794f
C9 inp a_5015_3442# 0.00514f
C10 a_n4151_3442# a_n5045_3442# 0.00556f
C11 inn outp 0.4749f
C12 a_5015_3442# a_n5076_n300# 0.04902f
C13 outn a_5015_3442# 0.01699f
C14 a_5015_3442# a_4121_3442# 0.00556f
C15 a_n4837_n300# a_n5076_n300# 0.04243f
C16 a_n5045_3442# a_n5076_n300# 0.04902f
C17 vbias a_n4837_n300# 0.00794f
C18 outp a_n4151_3442# 0.0194f
C19 a_5257_n300# a_n5076_n300# 0.02016f
C20 inn a_n5076_n300# 0.56801f
C21 a_5257_n300# vbias 0.00817f
C22 outp a_n5076_n300# 1.33276f
C23 a_n4151_3442# a_n5076_n300# 0.05242f
C24 inp a_n5076_n300# 0.56801f
C25 inp outn 0.4749f
C26 a_n4837_n300# a_n5357_n300# 0.01143f
C27 outn a_n5076_n300# 1.33276f
C28 a_n5076_n300# a_4121_3442# 0.05242f
C29 outn a_4121_3442# 0.0194f
C30 vbias a_n5076_n300# 0.50953f
C31 vbias vss 7.71364f
C32 inp vss 1.48781f
C33 inn vss 1.48781f
C34 outn vss 2.14237f
C35 outp vss 2.14237f
C36 vdd vss 7.9928f
C37 a_5257_n300# vss 0.76587f ; **FLOATING
C38 a_4737_n300# vss 0.71547f ; **FLOATING
C39 a_n4837_n300# vss 0.71547f ; **FLOATING
C40 a_n5357_n300# vss 0.76587f ; **FLOATING
C41 a_5015_3442# vss 0.44078f ; **FLOATING
C42 a_4121_3442# vss 0.42955f ; **FLOATING
C43 a_n4151_3442# vss 0.42955f ; **FLOATING
C44 a_n5076_n300# vss 8.24271f
C45 a_n5045_3442# vss 0.44078f ; **FLOATING
.ends
