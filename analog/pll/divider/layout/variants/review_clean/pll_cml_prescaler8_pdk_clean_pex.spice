* NGSPICE file created from pll_cml_prescaler8_pdk_clean.ext - technology: sky130A

.subckt pll_cml_prescaler8_pdk_clean clkp clkn q2p q2n q4p q4n q8p q8n vbias vdd vss
X0 a_21824_n300# a_n3862_n388# vss vss sky130_fd_pr__nfet_01v8 ad=0.435 pd=3.29 as=0.435 ps=3.29 w=3 l=0.5
X1 vdd clkp a_n4996_714# vss sky130_fd_pr__nfet_01v8_lvt ad=0.825 pd=5.33 as=1.55 ps=10.62 w=5 l=0.15
X2 vss a_n3862_n388# a_21824_n300# vss sky130_fd_pr__nfet_01v8 ad=0.435 pd=3.29 as=0.435 ps=3.29 w=3 l=0.5
X3 a_21824_n300# a_n3862_n388# vss vss sky130_fd_pr__nfet_01v8 ad=0.435 pd=3.29 as=0.435 ps=3.29 w=3 l=0.5
X4 a_n3198_1728# a_n3261_1640# a_n3290_1728# vss sky130_fd_pr__nfet_01v8_lvt ad=0.825 pd=5.33 as=0.825 ps=5.33 w=5 l=0.15
X5 vss a_n3862_n388# a_17834_n300# vss sky130_fd_pr__nfet_01v8 ad=0.435 pd=3.29 as=0.435 ps=3.29 w=3 l=0.5
X6 a_n3762_n300# a_n3862_n388# vss vss sky130_fd_pr__nfet_01v8 ad=0.435 pd=3.29 as=0.435 ps=3.29 w=3 l=0.5
X7 a_11026_n300# a_8917_526# a_11932_3042# vss sky130_fd_pr__nfet_01v8_lvt ad=0.66 pd=4.33 as=0.66 ps=4.33 w=4 l=0.15
X8 a_17834_n300# a_19715_526# a_17922_1728# vss sky130_fd_pr__nfet_01v8_lvt ad=0.66 pd=4.33 as=0.66 ps=4.33 w=4 l=0.15
X9 a_21912_1728# q8n q8p vss sky130_fd_pr__nfet_01v8_lvt ad=0.825 pd=5.33 as=0.825 ps=5.33 w=5 l=0.15
X10 vdd a_5831_626# a_5802_714# vss sky130_fd_pr__nfet_01v8_lvt ad=0.825 pd=5.33 as=1.55 ps=10.62 w=5 l=0.15
X11 q4p q4n a_11114_1728# vss sky130_fd_pr__nfet_01v8_lvt ad=0.825 pd=5.33 as=0.825 ps=5.33 w=5 l=0.15
X12 vss a_n3862_n388# a_228_n300# vss sky130_fd_pr__nfet_01v8 ad=0.435 pd=3.29 as=0.435 ps=3.29 w=3 l=0.5
X13 vss vbias a_8917_526# vss sky130_fd_pr__nfet_01v8 ad=1.16 pd=8.58 as=1.16 ps=8.58 w=4 l=0.5
X14 a_17922_1728# a_18014_1728# a_17951_1640# vss sky130_fd_pr__nfet_01v8_lvt ad=0.825 pd=5.33 as=0.825 ps=5.33 w=5 l=0.15
X15 a_7124_1728# a_7216_1728# a_7153_1640# vss sky130_fd_pr__nfet_01v8_lvt ad=0.825 pd=5.33 as=0.825 ps=5.33 w=5 l=0.15
X16 a_17922_1728# a_19715_526# a_17834_n300# vss sky130_fd_pr__nfet_01v8_lvt ad=0.66 pd=4.33 as=1.24 ps=8.62 w=4 l=0.15
X17 a_7124_1728# a_7216_1728# a_7153_1640# vss sky130_fd_pr__nfet_01v8_lvt ad=0.825 pd=5.33 as=0.825 ps=5.33 w=5 l=0.15
X18 a_17922_1728# a_18014_1728# a_17951_1640# vss sky130_fd_pr__nfet_01v8_lvt ad=0.825 pd=5.33 as=0.825 ps=5.33 w=5 l=0.15
X19 a_n4996_714# clkp vdd vss sky130_fd_pr__nfet_01v8_lvt ad=1.55 pd=10.62 as=0.825 ps=5.33 w=5 l=0.15
X20 a_n3290_1728# a_n3198_1728# a_n3261_1640# vss sky130_fd_pr__nfet_01v8_lvt ad=0.825 pd=5.33 as=0.825 ps=5.33 w=5 l=0.15
X21 a_5831_626# q2n a_5722_n300# vss sky130_fd_pr__nfet_01v8_lvt ad=0.495 pd=3.33 as=0.495 ps=3.33 w=3 l=0.15
X22 a_18014_614# q8n a_18014_1728# vss sky130_fd_pr__nfet_01v8_lvt ad=0.825 pd=5.33 as=0.825 ps=5.33 w=5 l=0.15
X23 a_5802_714# a_5831_626# vdd vss sky130_fd_pr__nfet_01v8_lvt ad=1.55 pd=10.62 as=0.825 ps=5.33 w=5 l=0.15
X24 a_11026_n300# a_n3862_n388# vss vss sky130_fd_pr__nfet_01v8 ad=0.435 pd=3.29 as=0.435 ps=3.29 w=3 l=0.5
X25 a_18014_614# q8p a_17951_1640# vss sky130_fd_pr__nfet_01v8_lvt ad=0.825 pd=5.33 as=0.825 ps=5.33 w=5 l=0.15
X26 q2p q2n a_408_614# vss sky130_fd_pr__nfet_01v8_lvt ad=0.825 pd=5.33 as=0.825 ps=5.33 w=5 l=0.15
X27 a_n4996_714# clkp vdd vss sky130_fd_pr__nfet_01v8_lvt ad=0.825 pd=5.33 as=0.825 ps=5.33 w=5 l=0.15
X28 a_228_n300# a_n3862_n388# vss vss sky130_fd_pr__nfet_01v8 ad=0.435 pd=3.29 as=0.435 ps=3.29 w=3 l=0.5
X29 a_5722_n300# vbias vss vss sky130_fd_pr__nfet_01v8 ad=0.435 pd=3.29 as=0.87 ps=6.58 w=3 l=0.5
X30 vdd clkp a_n4996_714# vss sky130_fd_pr__nfet_01v8_lvt ad=0.825 pd=5.33 as=0.825 ps=5.33 w=5 l=0.15
X31 q4p q4n a_11114_1728# vss sky130_fd_pr__nfet_01v8_lvt ad=0.825 pd=5.33 as=1.55 ps=10.62 w=5 l=0.15
X32 a_24235_4312# q4p a_16520_n300# vss sky130_fd_pr__nfet_01v8_lvt ad=0.495 pd=3.33 as=0.495 ps=3.33 w=3 l=0.15
X33 vss a_n3862_n388# a_n3762_n300# vss sky130_fd_pr__nfet_01v8 ad=0.435 pd=3.29 as=0.435 ps=3.29 w=3 l=0.5
X34 a_21824_n300# a_n3862_n388# vss vss sky130_fd_pr__nfet_01v8 ad=0.435 pd=3.29 as=0.435 ps=3.29 w=3 l=0.5
X35 a_n1881_526# clkn vdd vss sky130_fd_pr__nfet_01v8_lvt ad=0.825 pd=5.33 as=0.825 ps=5.33 w=5 l=0.15
X36 vdd clkp a_n4996_714# vss sky130_fd_pr__nfet_01v8_lvt ad=0.825 pd=5.33 as=0.825 ps=5.33 w=5 l=0.15
X37 vdd clkp a_n4996_714# vss sky130_fd_pr__nfet_01v8_lvt ad=0.825 pd=5.33 as=1.55 ps=10.62 w=5 l=0.15
X38 a_n4996_714# clkp vdd vss sky130_fd_pr__nfet_01v8_lvt ad=0.825 pd=5.33 as=0.825 ps=5.33 w=5 l=0.15
X39 vdd a_n5001_4543# a_n3862_n388# vdd sky130_fd_pr__pfet_01v8 ad=1.74 pd=12.58 as=0.87 ps=6.29 w=6 l=0.5
X40 q2n a_n3261_1640# a_1134_3042# vss sky130_fd_pr__nfet_01v8_lvt ad=0.825 pd=5.33 as=0.825 ps=5.33 w=5 l=0.15
X41 a_1134_3042# a_n3198_1728# q2p vss sky130_fd_pr__nfet_01v8_lvt ad=1.55 pd=10.62 as=0.825 ps=5.33 w=5 l=0.15
X42 vdd a_16629_626# a_16600_714# vss sky130_fd_pr__nfet_01v8_lvt ad=0.825 pd=5.33 as=0.825 ps=5.33 w=5 l=0.15
X43 vdd a_24235_4312# a_19715_526# vss sky130_fd_pr__nfet_01v8_lvt ad=0.825 pd=5.33 as=1.55 ps=10.62 w=5 l=0.15
X44 vss vbias a_16520_n300# vss sky130_fd_pr__nfet_01v8 ad=0.87 pd=6.58 as=0.435 ps=3.29 w=3 l=0.5
X45 vss a_n3862_n388# a_7036_n300# vss sky130_fd_pr__nfet_01v8 ad=0.435 pd=3.29 as=0.435 ps=3.29 w=3 l=0.5
X46 vdd clkn a_n1881_526# vss sky130_fd_pr__nfet_01v8_lvt ad=0.825 pd=5.33 as=1.55 ps=10.62 w=5 l=0.15
X47 a_7036_n300# a_n3862_n388# vss vss sky130_fd_pr__nfet_01v8 ad=0.435 pd=3.29 as=0.435 ps=3.29 w=3 l=0.5
X48 q8n q8p a_21912_1728# vss sky130_fd_pr__nfet_01v8_lvt ad=0.825 pd=5.33 as=1.55 ps=10.62 w=5 l=0.15
X49 vdd clkp a_n4996_714# vss sky130_fd_pr__nfet_01v8_lvt ad=0.825 pd=5.33 as=0.825 ps=5.33 w=5 l=0.15
X50 a_n1881_526# clkn vdd vss sky130_fd_pr__nfet_01v8_lvt ad=0.825 pd=5.33 as=0.825 ps=5.33 w=5 l=0.15
X51 a_17834_n300# a_n3862_n388# vss vss sky130_fd_pr__nfet_01v8 ad=0.435 pd=3.29 as=0.435 ps=3.29 w=3 l=0.5
X52 a_n4996_714# clkp vdd vss sky130_fd_pr__nfet_01v8_lvt ad=0.825 pd=5.33 as=0.825 ps=5.33 w=5 l=0.15
X53 a_7124_1728# a_7153_1640# a_7216_1728# vss sky130_fd_pr__nfet_01v8_lvt ad=0.825 pd=5.33 as=0.825 ps=5.33 w=5 l=0.15
X54 a_n3582_614# q2p a_n3261_1640# vss sky130_fd_pr__nfet_01v8_lvt ad=1.55 pd=10.62 as=0.825 ps=5.33 w=5 l=0.15
X55 q2n q2p a_408_614# vss sky130_fd_pr__nfet_01v8_lvt ad=0.825 pd=5.33 as=0.825 ps=5.33 w=5 l=0.15
X56 q4n q4p a_11114_1728# vss sky130_fd_pr__nfet_01v8_lvt ad=0.825 pd=5.33 as=0.825 ps=5.33 w=5 l=0.15
X57 vdd a_13437_4312# a_8917_526# vss sky130_fd_pr__nfet_01v8_lvt ad=0.825 pd=5.33 as=0.825 ps=5.33 w=5 l=0.15
X58 vdd clkn a_n1881_526# vss sky130_fd_pr__nfet_01v8_lvt ad=0.825 pd=5.33 as=0.825 ps=5.33 w=5 l=0.15
X59 a_n1881_526# clkn vdd vss sky130_fd_pr__nfet_01v8_lvt ad=0.825 pd=5.33 as=0.825 ps=5.33 w=5 l=0.15
X60 a_21824_n300# a_n3862_n388# vss vss sky130_fd_pr__nfet_01v8 ad=0.435 pd=3.29 as=0.435 ps=3.29 w=3 l=0.5
X61 vss a_n3862_n388# a_228_n300# vss sky130_fd_pr__nfet_01v8 ad=0.435 pd=3.29 as=0.435 ps=3.29 w=3 l=0.5
X62 q4p a_7216_1728# a_11932_3042# vss sky130_fd_pr__nfet_01v8_lvt ad=0.825 pd=5.33 as=0.825 ps=5.33 w=5 l=0.15
X63 a_228_n300# a_n3862_n388# vss vss sky130_fd_pr__nfet_01v8 ad=0.435 pd=3.29 as=0.435 ps=3.29 w=3 l=0.5
X64 a_5831_626# q2n a_5722_n300# vss sky130_fd_pr__nfet_01v8_lvt ad=0.495 pd=3.33 as=0.93 ps=6.62 w=3 l=0.15
X65 a_n3762_n300# a_n3862_n388# vss vss sky130_fd_pr__nfet_01v8 ad=0.435 pd=3.29 as=0.435 ps=3.29 w=3 l=0.5
X66 q8p q8n a_21912_1728# vss sky130_fd_pr__nfet_01v8_lvt ad=0.825 pd=5.33 as=0.825 ps=5.33 w=5 l=0.15
X67 a_17922_1728# a_17951_1640# a_18014_1728# vss sky130_fd_pr__nfet_01v8_lvt ad=0.825 pd=5.33 as=0.825 ps=5.33 w=5 l=0.15
X68 a_n1881_526# clkn vdd vss sky130_fd_pr__nfet_01v8_lvt ad=0.825 pd=5.33 as=0.825 ps=5.33 w=5 l=0.15
X69 vdd clkn a_n1881_526# vss sky130_fd_pr__nfet_01v8_lvt ad=0.825 pd=5.33 as=0.825 ps=5.33 w=5 l=0.15
X70 a_17834_n300# a_n3862_n388# vss vss sky130_fd_pr__nfet_01v8 ad=0.435 pd=3.29 as=0.435 ps=3.29 w=3 l=0.5
X71 a_n1881_526# clkn vdd vss sky130_fd_pr__nfet_01v8_lvt ad=1.55 pd=10.62 as=0.825 ps=5.33 w=5 l=0.15
X72 vss a_n3862_n388# a_17834_n300# vss sky130_fd_pr__nfet_01v8 ad=0.435 pd=3.29 as=0.435 ps=3.29 w=3 l=0.5
X73 a_17922_1728# a_19715_526# a_17834_n300# vss sky130_fd_pr__nfet_01v8_lvt ad=0.66 pd=4.33 as=0.66 ps=4.33 w=4 l=0.15
X74 a_17834_n300# a_19715_526# a_17922_1728# vss sky130_fd_pr__nfet_01v8_lvt ad=0.66 pd=4.33 as=0.66 ps=4.33 w=4 l=0.15
X75 vdd clkn a_n1881_526# vss sky130_fd_pr__nfet_01v8_lvt ad=0.825 pd=5.33 as=0.825 ps=5.33 w=5 l=0.15
X76 a_17834_n300# a_19715_526# a_17922_1728# vss sky130_fd_pr__nfet_01v8_lvt ad=0.66 pd=4.33 as=0.66 ps=4.33 w=4 l=0.15
X77 a_17834_n300# a_19715_526# a_17922_1728# vss sky130_fd_pr__nfet_01v8_lvt ad=0.66 pd=4.33 as=0.66 ps=4.33 w=4 l=0.15
X78 a_17922_1728# a_19715_526# a_17834_n300# vss sky130_fd_pr__nfet_01v8_lvt ad=0.66 pd=4.33 as=0.66 ps=4.33 w=4 l=0.15
X79 a_5722_n300# q2n a_5831_626# vss sky130_fd_pr__nfet_01v8_lvt ad=0.93 pd=6.62 as=0.495 ps=3.33 w=3 l=0.15
X80 a_17922_1728# a_19715_526# a_17834_n300# vss sky130_fd_pr__nfet_01v8_lvt ad=0.66 pd=4.33 as=0.66 ps=4.33 w=4 l=0.15
X81 vss a_n3862_n388# a_7036_n300# vss sky130_fd_pr__nfet_01v8 ad=0.435 pd=3.29 as=0.435 ps=3.29 w=3 l=0.5
X82 a_21912_1728# q8n q8p vss sky130_fd_pr__nfet_01v8_lvt ad=0.825 pd=5.33 as=0.825 ps=5.33 w=5 l=0.15
X83 a_11026_n300# a_n3862_n388# vss vss sky130_fd_pr__nfet_01v8 ad=0.435 pd=3.29 as=0.435 ps=3.29 w=3 l=0.5
X84 a_11026_n300# a_n3862_n388# vss vss sky130_fd_pr__nfet_01v8 ad=0.435 pd=3.29 as=0.435 ps=3.29 w=3 l=0.5
X85 a_408_614# q2n q2p vss sky130_fd_pr__nfet_01v8_lvt ad=1.55 pd=10.62 as=0.825 ps=5.33 w=5 l=0.15
X86 vdd a_16629_626# a_16600_714# vss sky130_fd_pr__nfet_01v8_lvt ad=0.825 pd=5.33 as=0.825 ps=5.33 w=5 l=0.15
X87 a_7153_1640# q4p a_7216_614# vss sky130_fd_pr__nfet_01v8_lvt ad=0.825 pd=5.33 as=0.825 ps=5.33 w=5 l=0.15
X88 a_n3290_1728# a_n1881_526# a_n3762_n300# vss sky130_fd_pr__nfet_01v8_lvt ad=0.66 pd=4.33 as=0.66 ps=4.33 w=4 l=0.15
X89 a_7216_614# q4n a_7216_1728# vss sky130_fd_pr__nfet_01v8_lvt ad=1.55 pd=10.62 as=0.825 ps=5.33 w=5 l=0.15
X90 a_11114_1728# q4n q4p vss sky130_fd_pr__nfet_01v8_lvt ad=0.825 pd=5.33 as=0.825 ps=5.33 w=5 l=0.15
X91 a_17834_n300# a_19715_526# a_17922_1728# vss sky130_fd_pr__nfet_01v8_lvt ad=0.66 pd=4.33 as=0.66 ps=4.33 w=4 l=0.15
X92 a_17922_1728# a_19715_526# a_17834_n300# vss sky130_fd_pr__nfet_01v8_lvt ad=0.66 pd=4.33 as=0.66 ps=4.33 w=4 l=0.15
X93 a_17834_n300# a_19715_526# a_17922_1728# vss sky130_fd_pr__nfet_01v8_lvt ad=0.66 pd=4.33 as=0.66 ps=4.33 w=4 l=0.15
X94 a_7036_n300# a_5802_714# a_7216_614# vss sky130_fd_pr__nfet_01v8_lvt ad=0.66 pd=4.33 as=0.66 ps=4.33 w=4 l=0.15
X95 a_21824_n300# a_n3862_n388# vss vss sky130_fd_pr__nfet_01v8 ad=0.435 pd=3.29 as=0.435 ps=3.29 w=3 l=0.5
X96 a_n3762_n300# a_n1881_526# a_n3290_1728# vss sky130_fd_pr__nfet_01v8_lvt ad=1.24 pd=8.62 as=0.66 ps=4.33 w=4 l=0.15
X97 a_n3862_n388# a_n5001_4543# vdd vdd sky130_fd_pr__pfet_01v8 ad=0.87 pd=6.29 as=0.87 ps=6.29 w=6 l=0.5
X98 a_22730_3042# a_19715_526# a_21824_n300# vss sky130_fd_pr__nfet_01v8_lvt ad=0.66 pd=4.33 as=0.66 ps=4.33 w=4 l=0.15
X99 a_17922_1728# a_19715_526# a_17834_n300# vss sky130_fd_pr__nfet_01v8_lvt ad=0.66 pd=4.33 as=0.66 ps=4.33 w=4 l=0.15
X100 vdd a_n5001_4543# a_n3862_n388# vdd sky130_fd_pr__pfet_01v8 ad=0.87 pd=6.29 as=0.87 ps=6.29 w=6 l=0.5
X101 vdd clkp a_n4996_714# vss sky130_fd_pr__nfet_01v8_lvt ad=0.825 pd=5.33 as=0.825 ps=5.33 w=5 l=0.15
X102 a_16629_626# q4n a_16520_n300# vss sky130_fd_pr__nfet_01v8_lvt ad=0.495 pd=3.33 as=0.495 ps=3.33 w=3 l=0.15
X103 a_24235_4312# q4p a_16520_n300# vss sky130_fd_pr__nfet_01v8_lvt ad=0.495 pd=3.33 as=0.93 ps=6.62 w=3 l=0.15
X104 vdd a_n5001_4543# a_n5001_4543# vdd sky130_fd_pr__pfet_01v8 ad=0.87 pd=6.29 as=0.87 ps=6.29 w=6 l=0.5
X105 a_21912_1728# q8p q8n vss sky130_fd_pr__nfet_01v8_lvt ad=1.55 pd=10.62 as=0.825 ps=5.33 w=5 l=0.15
X106 q4p q4n a_11114_1728# vss sky130_fd_pr__nfet_01v8_lvt ad=0.825 pd=5.33 as=0.825 ps=5.33 w=5 l=0.15
X107 a_7216_614# a_5802_714# a_7036_n300# vss sky130_fd_pr__nfet_01v8_lvt ad=0.66 pd=4.33 as=0.66 ps=4.33 w=4 l=0.15
X108 a_7036_n300# a_5802_714# a_7216_614# vss sky130_fd_pr__nfet_01v8_lvt ad=0.66 pd=4.33 as=0.66 ps=4.33 w=4 l=0.15
X109 a_17834_n300# a_n3862_n388# vss vss sky130_fd_pr__nfet_01v8 ad=0.435 pd=3.29 as=0.435 ps=3.29 w=3 l=0.5
X110 a_21824_n300# a_19715_526# a_22730_3042# vss sky130_fd_pr__nfet_01v8_lvt ad=0.66 pd=4.33 as=0.66 ps=4.33 w=4 l=0.15
X111 a_7036_n300# a_n3862_n388# vss vss sky130_fd_pr__nfet_01v8 ad=0.435 pd=3.29 as=0.435 ps=3.29 w=3 l=0.5
X112 vss a_n3862_n388# a_7036_n300# vss sky130_fd_pr__nfet_01v8 ad=0.435 pd=3.29 as=0.435 ps=3.29 w=3 l=0.5
X113 a_13437_4312# q2p a_5722_n300# vss sky130_fd_pr__nfet_01v8_lvt ad=0.495 pd=3.33 as=0.495 ps=3.33 w=3 l=0.15
X114 a_7216_1728# a_7153_1640# a_7124_1728# vss sky130_fd_pr__nfet_01v8_lvt ad=0.825 pd=5.33 as=0.825 ps=5.33 w=5 l=0.15
X115 vss a_n3862_n388# a_n3762_n300# vss sky130_fd_pr__nfet_01v8 ad=0.435 pd=3.29 as=0.435 ps=3.29 w=3 l=0.5
X116 a_n3261_1640# q2p a_n3582_614# vss sky130_fd_pr__nfet_01v8_lvt ad=0.825 pd=5.33 as=1.55 ps=10.62 w=5 l=0.15
X117 a_16600_714# a_16629_626# vdd vss sky130_fd_pr__nfet_01v8_lvt ad=0.825 pd=5.33 as=0.825 ps=5.33 w=5 l=0.15
X118 vdd a_16629_626# a_16600_714# vss sky130_fd_pr__nfet_01v8_lvt ad=0.825 pd=5.33 as=1.55 ps=10.62 w=5 l=0.15
X119 a_7216_614# a_5802_714# a_7036_n300# vss sky130_fd_pr__nfet_01v8_lvt ad=0.66 pd=4.33 as=0.66 ps=4.33 w=4 l=0.15
X120 a_11114_1728# q4p q4n vss sky130_fd_pr__nfet_01v8_lvt ad=0.825 pd=5.33 as=0.825 ps=5.33 w=5 l=0.15
X121 a_8917_526# a_13437_4312# vdd vss sky130_fd_pr__nfet_01v8_lvt ad=0.825 pd=5.33 as=0.825 ps=5.33 w=5 l=0.15
X122 a_7036_n300# a_5802_714# a_7216_614# vss sky130_fd_pr__nfet_01v8_lvt ad=0.66 pd=4.33 as=0.66 ps=4.33 w=4 l=0.15
X123 a_22730_3042# a_19715_526# a_21824_n300# vss sky130_fd_pr__nfet_01v8_lvt ad=0.66 pd=4.33 as=0.66 ps=4.33 w=4 l=0.15
X124 a_n3261_1640# a_n3198_1728# a_n3290_1728# vss sky130_fd_pr__nfet_01v8_lvt ad=0.825 pd=5.33 as=0.825 ps=5.33 w=5 l=0.15
X125 a_21824_n300# a_19715_526# a_22730_3042# vss sky130_fd_pr__nfet_01v8_lvt ad=0.66 pd=4.33 as=0.66 ps=4.33 w=4 l=0.15
X126 a_18014_614# a_16600_714# a_17834_n300# vss sky130_fd_pr__nfet_01v8_lvt ad=0.66 pd=4.33 as=1.24 ps=8.62 w=4 l=0.15
X127 vss a_n3862_n388# a_228_n300# vss sky130_fd_pr__nfet_01v8 ad=0.435 pd=3.29 as=0.435 ps=3.29 w=3 l=0.5
X128 vdd a_16629_626# a_16600_714# vss sky130_fd_pr__nfet_01v8_lvt ad=0.825 pd=5.33 as=0.825 ps=5.33 w=5 l=0.15
X129 a_7216_614# a_5802_714# a_7036_n300# vss sky130_fd_pr__nfet_01v8_lvt ad=0.66 pd=4.33 as=0.66 ps=4.33 w=4 l=0.15
X130 a_n3762_n300# a_n3862_n388# vss vss sky130_fd_pr__nfet_01v8 ad=0.435 pd=3.29 as=0.435 ps=3.29 w=3 l=0.5
X131 a_7036_n300# a_5802_714# a_7216_614# vss sky130_fd_pr__nfet_01v8_lvt ad=1.24 pd=8.62 as=0.66 ps=4.33 w=4 l=0.15
X132 a_17834_n300# a_n3862_n388# vss vss sky130_fd_pr__nfet_01v8 ad=0.435 pd=3.29 as=0.435 ps=3.29 w=3 l=0.5
X133 vss a_n3862_n388# a_17834_n300# vss sky130_fd_pr__nfet_01v8 ad=0.435 pd=3.29 as=0.435 ps=3.29 w=3 l=0.5
X134 a_7124_1728# a_7153_1640# a_7216_1728# vss sky130_fd_pr__nfet_01v8_lvt ad=0.825 pd=5.33 as=0.825 ps=5.33 w=5 l=0.15
X135 a_7036_n300# a_n3862_n388# vss vss sky130_fd_pr__nfet_01v8 ad=0.435 pd=3.29 as=0.435 ps=3.29 w=3 l=0.5
X136 a_17922_1728# a_17951_1640# a_18014_1728# vss sky130_fd_pr__nfet_01v8_lvt ad=0.825 pd=5.33 as=0.825 ps=5.33 w=5 l=0.15
X137 a_16600_714# a_16629_626# vdd vss sky130_fd_pr__nfet_01v8_lvt ad=0.825 pd=5.33 as=0.825 ps=5.33 w=5 l=0.15
X138 a_n3198_1728# q2n a_n3582_614# vss sky130_fd_pr__nfet_01v8_lvt ad=0.825 pd=5.33 as=1.55 ps=10.62 w=5 l=0.15
X139 a_16629_626# q4n a_16520_n300# vss sky130_fd_pr__nfet_01v8_lvt ad=0.495 pd=3.33 as=0.495 ps=3.33 w=3 l=0.15
X140 a_11026_n300# a_n3862_n388# vss vss sky130_fd_pr__nfet_01v8 ad=0.435 pd=3.29 as=0.435 ps=3.29 w=3 l=0.5
X141 vss a_n3862_n388# a_11026_n300# vss sky130_fd_pr__nfet_01v8 ad=0.435 pd=3.29 as=0.435 ps=3.29 w=3 l=0.5
X142 a_21912_1728# q8p q8n vss sky130_fd_pr__nfet_01v8_lvt ad=0.825 pd=5.33 as=0.825 ps=5.33 w=5 l=0.15
X143 a_7124_1728# a_8917_526# a_7036_n300# vss sky130_fd_pr__nfet_01v8_lvt ad=0.66 pd=4.33 as=0.66 ps=4.33 w=4 l=0.15
X144 a_7036_n300# a_8917_526# a_7124_1728# vss sky130_fd_pr__nfet_01v8_lvt ad=0.66 pd=4.33 as=0.66 ps=4.33 w=4 l=0.15
X145 q4p q4n a_11114_1728# vss sky130_fd_pr__nfet_01v8_lvt ad=0.825 pd=5.33 as=0.825 ps=5.33 w=5 l=0.15
X146 a_17922_1728# a_18014_1728# a_17951_1640# vss sky130_fd_pr__nfet_01v8_lvt ad=1.55 pd=10.62 as=0.825 ps=5.33 w=5 l=0.15
X147 a_n4996_714# vbias vss vss sky130_fd_pr__nfet_01v8 ad=1.16 pd=8.58 as=1.16 ps=8.58 w=4 l=0.5
X148 vss a_n3862_n388# a_21824_n300# vss sky130_fd_pr__nfet_01v8 ad=0.87 pd=6.58 as=0.435 ps=3.29 w=3 l=0.5
X149 a_7036_n300# a_8917_526# a_7124_1728# vss sky130_fd_pr__nfet_01v8_lvt ad=0.66 pd=4.33 as=0.66 ps=4.33 w=4 l=0.15
X150 a_21824_n300# a_n3862_n388# vss vss sky130_fd_pr__nfet_01v8 ad=0.435 pd=3.29 as=0.435 ps=3.29 w=3 l=0.5
X151 a_7036_n300# a_8917_526# a_7124_1728# vss sky130_fd_pr__nfet_01v8_lvt ad=0.66 pd=4.33 as=0.66 ps=4.33 w=4 l=0.15
X152 a_7124_1728# a_8917_526# a_7036_n300# vss sky130_fd_pr__nfet_01v8_lvt ad=0.66 pd=4.33 as=0.66 ps=4.33 w=4 l=0.15
X153 a_7124_1728# a_8917_526# a_7036_n300# vss sky130_fd_pr__nfet_01v8_lvt ad=0.66 pd=4.33 as=0.66 ps=4.33 w=4 l=0.15
X154 a_n3862_n388# a_n5001_4543# vdd vdd sky130_fd_pr__pfet_01v8 ad=0.87 pd=6.29 as=1.74 ps=12.58 w=6 l=0.5
X155 a_n4996_714# clkp vdd vss sky130_fd_pr__nfet_01v8_lvt ad=0.825 pd=5.33 as=0.825 ps=5.33 w=5 l=0.15
X156 a_n3290_1728# a_n3261_1640# a_n3198_1728# vss sky130_fd_pr__nfet_01v8_lvt ad=0.825 pd=5.33 as=0.825 ps=5.33 w=5 l=0.15
X157 vss a_n3862_n388# a_21824_n300# vss sky130_fd_pr__nfet_01v8 ad=0.435 pd=3.29 as=0.435 ps=3.29 w=3 l=0.5
X158 a_228_n300# a_n3862_n388# vss vss sky130_fd_pr__nfet_01v8 ad=0.435 pd=3.29 as=0.435 ps=3.29 w=3 l=0.5
X159 vdd a_n5001_4543# a_n5001_4543# vdd sky130_fd_pr__pfet_01v8 ad=1.74 pd=12.58 as=0.87 ps=6.29 w=6 l=0.5
X160 a_17834_n300# a_n3862_n388# vss vss sky130_fd_pr__nfet_01v8 ad=0.435 pd=3.29 as=0.435 ps=3.29 w=3 l=0.5
X161 q8p q8n a_21912_1728# vss sky130_fd_pr__nfet_01v8_lvt ad=0.825 pd=5.33 as=0.825 ps=5.33 w=5 l=0.15
X162 vdd a_16629_626# vss sky130_fd_pr__res_high_po_2p85 l=4.14
X163 a_11114_1728# q4n q4p vss sky130_fd_pr__nfet_01v8_lvt ad=0.825 pd=5.33 as=0.825 ps=5.33 w=5 l=0.15
X164 vss a_n3862_n388# a_n3762_n300# vss sky130_fd_pr__nfet_01v8 ad=0.435 pd=3.29 as=0.435 ps=3.29 w=3 l=0.5
X165 a_7036_n300# a_8917_526# a_7124_1728# vss sky130_fd_pr__nfet_01v8_lvt ad=0.66 pd=4.33 as=0.66 ps=4.33 w=4 l=0.15
X166 a_7124_1728# a_8917_526# a_7036_n300# vss sky130_fd_pr__nfet_01v8_lvt ad=0.66 pd=4.33 as=0.66 ps=4.33 w=4 l=0.15
X167 a_7036_n300# a_8917_526# a_7124_1728# vss sky130_fd_pr__nfet_01v8_lvt ad=0.66 pd=4.33 as=0.66 ps=4.33 w=4 l=0.15
X168 a_17951_1640# a_18014_1728# a_17922_1728# vss sky130_fd_pr__nfet_01v8_lvt ad=0.825 pd=5.33 as=0.825 ps=5.33 w=5 l=0.15
X169 a_228_n300# a_n3862_n388# vss vss sky130_fd_pr__nfet_01v8 ad=0.435 pd=3.29 as=0.435 ps=3.29 w=3 l=0.5
X170 a_5722_n300# q2p a_13437_4312# vss sky130_fd_pr__nfet_01v8_lvt ad=0.495 pd=3.33 as=0.495 ps=3.33 w=3 l=0.15
X171 a_7153_1640# a_7216_1728# a_7124_1728# vss sky130_fd_pr__nfet_01v8_lvt ad=0.825 pd=5.33 as=0.825 ps=5.33 w=5 l=0.15
X172 a_17951_1640# a_18014_1728# a_17922_1728# vss sky130_fd_pr__nfet_01v8_lvt ad=0.825 pd=5.33 as=1.55 ps=10.62 w=5 l=0.15
X173 vdd q8n vss sky130_fd_pr__res_high_po_2p85 l=4.14
X174 a_11026_n300# a_8917_526# a_11932_3042# vss sky130_fd_pr__nfet_01v8_lvt ad=0.66 pd=4.33 as=0.66 ps=4.33 w=4 l=0.15
X175 a_7124_1728# a_8917_526# a_7036_n300# vss sky130_fd_pr__nfet_01v8_lvt ad=0.66 pd=4.33 as=0.66 ps=4.33 w=4 l=0.15
X176 a_n3261_1640# a_n3198_1728# a_n3290_1728# vss sky130_fd_pr__nfet_01v8_lvt ad=0.825 pd=5.33 as=0.825 ps=5.33 w=5 l=0.15
X177 a_7153_1640# a_7216_1728# a_7124_1728# vss sky130_fd_pr__nfet_01v8_lvt ad=0.825 pd=5.33 as=0.825 ps=5.33 w=5 l=0.15
X178 vdd a_7216_1728# vss sky130_fd_pr__res_high_po_2p85 l=4.14
X179 a_18014_1728# q8n a_18014_614# vss sky130_fd_pr__nfet_01v8_lvt ad=0.825 pd=5.33 as=1.55 ps=10.62 w=5 l=0.15
X180 a_228_n300# a_n3862_n388# vss vss sky130_fd_pr__nfet_01v8 ad=0.435 pd=3.29 as=0.435 ps=3.29 w=3 l=0.5
X181 a_7216_1728# a_7153_1640# a_7124_1728# vss sky130_fd_pr__nfet_01v8_lvt ad=0.825 pd=5.33 as=0.825 ps=5.33 w=5 l=0.15
X182 vss a_n3862_n388# a_228_n300# vss sky130_fd_pr__nfet_01v8 ad=0.435 pd=3.29 as=0.435 ps=3.29 w=3 l=0.5
X183 vss a_n3862_n388# a_n3762_n300# vss sky130_fd_pr__nfet_01v8 ad=0.435 pd=3.29 as=0.435 ps=3.29 w=3 l=0.5
X184 vdd a_24235_4312# a_19715_526# vss sky130_fd_pr__nfet_01v8_lvt ad=0.825 pd=5.33 as=0.825 ps=5.33 w=5 l=0.15
X185 q8n q8p a_21912_1728# vss sky130_fd_pr__nfet_01v8_lvt ad=0.825 pd=5.33 as=0.825 ps=5.33 w=5 l=0.15
X186 a_18014_1728# a_17951_1640# a_17922_1728# vss sky130_fd_pr__nfet_01v8_lvt ad=0.825 pd=5.33 as=0.825 ps=5.33 w=5 l=0.15
X187 vdd clkn a_n1881_526# vss sky130_fd_pr__nfet_01v8_lvt ad=0.825 pd=5.33 as=0.825 ps=5.33 w=5 l=0.15
X188 vss a_n3862_n388# a_17834_n300# vss sky130_fd_pr__nfet_01v8 ad=0.87 pd=6.58 as=0.435 ps=3.29 w=3 l=0.5
X189 q2p a_n3198_1728# a_1134_3042# vss sky130_fd_pr__nfet_01v8_lvt ad=0.825 pd=5.33 as=0.825 ps=5.33 w=5 l=0.15
X190 vdd q8p vss sky130_fd_pr__res_high_po_2p85 l=4.14
X191 a_17834_n300# a_n3862_n388# vss vss sky130_fd_pr__nfet_01v8 ad=0.435 pd=3.29 as=0.435 ps=3.29 w=3 l=0.5
X192 a_7036_n300# a_n3862_n388# vss vss sky130_fd_pr__nfet_01v8 ad=0.435 pd=3.29 as=0.435 ps=3.29 w=3 l=0.5
X193 a_17922_1728# a_17951_1640# a_18014_1728# vss sky130_fd_pr__nfet_01v8_lvt ad=0.825 pd=5.33 as=0.825 ps=5.33 w=5 l=0.15
X194 vdd q2p vss sky130_fd_pr__res_high_po_2p85 l=4.14
X195 a_408_614# q2p q2n vss sky130_fd_pr__nfet_01v8_lvt ad=0.825 pd=5.33 as=0.825 ps=5.33 w=5 l=0.15
X196 a_7216_1728# a_7153_1640# a_7124_1728# vss sky130_fd_pr__nfet_01v8_lvt ad=0.825 pd=5.33 as=1.55 ps=10.62 w=5 l=0.15
X197 a_8917_526# a_13437_4312# vdd vss sky130_fd_pr__nfet_01v8_lvt ad=0.825 pd=5.33 as=0.825 ps=5.33 w=5 l=0.15
X198 a_11114_1728# q4p q4n vss sky130_fd_pr__nfet_01v8_lvt ad=0.825 pd=5.33 as=0.825 ps=5.33 w=5 l=0.15
X199 vss a_n3862_n388# a_21824_n300# vss sky130_fd_pr__nfet_01v8 ad=0.435 pd=3.29 as=0.435 ps=3.29 w=3 l=0.5
X200 a_21912_1728# q8n q8p vss sky130_fd_pr__nfet_01v8_lvt ad=0.825 pd=5.33 as=0.825 ps=5.33 w=5 l=0.15
X201 a_228_n300# a_n3862_n388# vss vss sky130_fd_pr__nfet_01v8 ad=0.435 pd=3.29 as=0.435 ps=3.29 w=3 l=0.5
X202 a_21824_n300# a_16600_714# a_21912_1728# vss sky130_fd_pr__nfet_01v8_lvt ad=0.66 pd=4.33 as=0.66 ps=4.33 w=4 l=0.15
X203 a_17834_n300# a_n3862_n388# vss vss sky130_fd_pr__nfet_01v8 ad=0.435 pd=3.29 as=0.435 ps=3.29 w=3 l=0.5
X204 vss a_n3862_n388# a_n3762_n300# vss sky130_fd_pr__nfet_01v8 ad=0.435 pd=3.29 as=0.435 ps=3.29 w=3 l=0.5
X205 a_n4996_714# clkp vdd vss sky130_fd_pr__nfet_01v8_lvt ad=1.55 pd=10.62 as=0.825 ps=5.33 w=5 l=0.15
X206 a_11114_1728# q4p q4n vss sky130_fd_pr__nfet_01v8_lvt ad=0.825 pd=5.33 as=0.825 ps=5.33 w=5 l=0.15
X207 vdd a_17951_1640# vss sky130_fd_pr__res_high_po_2p85 l=4.14
X208 a_21824_n300# a_16600_714# a_21912_1728# vss sky130_fd_pr__nfet_01v8_lvt ad=0.66 pd=4.33 as=0.66 ps=4.33 w=4 l=0.15
X209 a_17951_1640# a_18014_1728# a_17922_1728# vss sky130_fd_pr__nfet_01v8_lvt ad=0.825 pd=5.33 as=0.825 ps=5.33 w=5 l=0.15
X210 a_7153_1640# a_7216_1728# a_7124_1728# vss sky130_fd_pr__nfet_01v8_lvt ad=0.825 pd=5.33 as=0.825 ps=5.33 w=5 l=0.15
X211 vss vbias a_16520_n300# vss sky130_fd_pr__nfet_01v8 ad=0.87 pd=6.58 as=0.435 ps=3.29 w=3 l=0.5
X212 q8p q8n a_21912_1728# vss sky130_fd_pr__nfet_01v8_lvt ad=0.825 pd=5.33 as=0.825 ps=5.33 w=5 l=0.15
X213 q8p a_18014_1728# a_22730_3042# vss sky130_fd_pr__nfet_01v8_lvt ad=0.825 pd=5.33 as=1.55 ps=10.62 w=5 l=0.15
X214 q2p q2n a_408_614# vss sky130_fd_pr__nfet_01v8_lvt ad=0.825 pd=5.33 as=0.825 ps=5.33 w=5 l=0.15
X215 a_21912_1728# a_16600_714# a_21824_n300# vss sky130_fd_pr__nfet_01v8_lvt ad=0.66 pd=4.33 as=0.66 ps=4.33 w=4 l=0.15
X216 a_21824_n300# a_16600_714# a_21912_1728# vss sky130_fd_pr__nfet_01v8_lvt ad=1.24 pd=8.62 as=0.66 ps=4.33 w=4 l=0.15
X217 vss a_n3862_n388# a_11026_n300# vss sky130_fd_pr__nfet_01v8 ad=0.435 pd=3.29 as=0.435 ps=3.29 w=3 l=0.5
X218 a_16600_714# a_16629_626# vdd vss sky130_fd_pr__nfet_01v8_lvt ad=0.825 pd=5.33 as=0.825 ps=5.33 w=5 l=0.15
X219 a_7216_1728# q4n a_7216_614# vss sky130_fd_pr__nfet_01v8_lvt ad=0.825 pd=5.33 as=0.825 ps=5.33 w=5 l=0.15
X220 q4p q4n a_11114_1728# vss sky130_fd_pr__nfet_01v8_lvt ad=0.825 pd=5.33 as=0.825 ps=5.33 w=5 l=0.15
X221 a_228_n300# a_n3862_n388# vss vss sky130_fd_pr__nfet_01v8 ad=0.435 pd=3.29 as=0.435 ps=3.29 w=3 l=0.5
X222 a_24235_4312# q4p a_16520_n300# vss sky130_fd_pr__nfet_01v8_lvt ad=0.495 pd=3.33 as=0.495 ps=3.33 w=3 l=0.15
X223 a_11932_3042# a_7153_1640# q4n vss sky130_fd_pr__nfet_01v8_lvt ad=0.825 pd=5.33 as=0.825 ps=5.33 w=5 l=0.15
X224 vss a_n3862_n388# a_n3762_n300# vss sky130_fd_pr__nfet_01v8 ad=0.435 pd=3.29 as=0.435 ps=3.29 w=3 l=0.5
X225 a_19715_526# a_24235_4312# vdd vss sky130_fd_pr__nfet_01v8_lvt ad=1.55 pd=10.62 as=0.825 ps=5.33 w=5 l=0.15
X226 a_21912_1728# q8p q8n vss sky130_fd_pr__nfet_01v8_lvt ad=0.825 pd=5.33 as=0.825 ps=5.33 w=5 l=0.15
X227 a_n1881_526# clkn vdd vss sky130_fd_pr__nfet_01v8_lvt ad=0.825 pd=5.33 as=0.825 ps=5.33 w=5 l=0.15
X228 a_21912_1728# a_16600_714# a_21824_n300# vss sky130_fd_pr__nfet_01v8_lvt ad=0.66 pd=4.33 as=0.66 ps=4.33 w=4 l=0.15
X229 a_408_614# q2p q2n vss sky130_fd_pr__nfet_01v8_lvt ad=0.825 pd=5.33 as=0.825 ps=5.33 w=5 l=0.15
X230 vdd q4n vss sky130_fd_pr__res_high_po_2p85 l=4.14
X231 a_7036_n300# a_5802_714# a_7216_614# vss sky130_fd_pr__nfet_01v8_lvt ad=0.66 pd=4.33 as=0.66 ps=4.33 w=4 l=0.15
X232 a_5802_714# a_5831_626# vdd vss sky130_fd_pr__nfet_01v8_lvt ad=0.825 pd=5.33 as=0.825 ps=5.33 w=5 l=0.15
X233 vdd a_5831_626# a_5802_714# vss sky130_fd_pr__nfet_01v8_lvt ad=0.825 pd=5.33 as=0.825 ps=5.33 w=5 l=0.15
X234 a_7216_614# a_5802_714# a_7036_n300# vss sky130_fd_pr__nfet_01v8_lvt ad=0.66 pd=4.33 as=0.66 ps=4.33 w=4 l=0.15
X235 a_7036_n300# a_n3862_n388# vss vss sky130_fd_pr__nfet_01v8 ad=0.435 pd=3.29 as=0.435 ps=3.29 w=3 l=0.5
X236 vss a_n3862_n388# a_17834_n300# vss sky130_fd_pr__nfet_01v8 ad=0.435 pd=3.29 as=0.435 ps=3.29 w=3 l=0.5
X237 vss a_n3862_n388# a_11026_n300# vss sky130_fd_pr__nfet_01v8 ad=0.435 pd=3.29 as=0.435 ps=3.29 w=3 l=0.5
X238 a_5722_n300# q2p a_13437_4312# vss sky130_fd_pr__nfet_01v8_lvt ad=0.495 pd=3.33 as=0.495 ps=3.33 w=3 l=0.15
X239 a_7124_1728# a_7153_1640# a_7216_1728# vss sky130_fd_pr__nfet_01v8_lvt ad=0.825 pd=5.33 as=0.825 ps=5.33 w=5 l=0.15
X240 a_n3582_614# q2p a_n3261_1640# vss sky130_fd_pr__nfet_01v8_lvt ad=0.825 pd=5.33 as=0.825 ps=5.33 w=5 l=0.15
X241 vdd a_5831_626# a_5802_714# vss sky130_fd_pr__nfet_01v8_lvt ad=0.825 pd=5.33 as=0.825 ps=5.33 w=5 l=0.15
X242 a_n3762_n300# a_n3862_n388# vss vss sky130_fd_pr__nfet_01v8 ad=0.435 pd=3.29 as=0.435 ps=3.29 w=3 l=0.5
X243 vdd a_13437_4312# a_8917_526# vss sky130_fd_pr__nfet_01v8_lvt ad=0.825 pd=5.33 as=0.825 ps=5.33 w=5 l=0.15
X244 a_7036_n300# a_5802_714# a_7216_614# vss sky130_fd_pr__nfet_01v8_lvt ad=0.66 pd=4.33 as=0.66 ps=4.33 w=4 l=0.15
X245 a_7216_614# a_5802_714# a_7036_n300# vss sky130_fd_pr__nfet_01v8_lvt ad=0.66 pd=4.33 as=1.24 ps=8.62 w=4 l=0.15
X246 a_5802_714# a_5831_626# vdd vss sky130_fd_pr__nfet_01v8_lvt ad=0.825 pd=5.33 as=0.825 ps=5.33 w=5 l=0.15
X247 q4n q4p a_11114_1728# vss sky130_fd_pr__nfet_01v8_lvt ad=0.825 pd=5.33 as=0.825 ps=5.33 w=5 l=0.15
X248 a_22730_3042# a_19715_526# a_21824_n300# vss sky130_fd_pr__nfet_01v8_lvt ad=0.66 pd=4.33 as=0.66 ps=4.33 w=4 l=0.15
X249 a_7216_614# a_5802_714# a_7036_n300# vss sky130_fd_pr__nfet_01v8_lvt ad=0.66 pd=4.33 as=0.66 ps=4.33 w=4 l=0.15
X250 a_21824_n300# a_19715_526# a_22730_3042# vss sky130_fd_pr__nfet_01v8_lvt ad=0.66 pd=4.33 as=0.66 ps=4.33 w=4 l=0.15
X251 a_n3290_1728# a_n3198_1728# a_n3261_1640# vss sky130_fd_pr__nfet_01v8_lvt ad=0.825 pd=5.33 as=0.825 ps=5.33 w=5 l=0.15
X252 a_11026_n300# a_5802_714# a_11114_1728# vss sky130_fd_pr__nfet_01v8_lvt ad=0.66 pd=4.33 as=0.66 ps=4.33 w=4 l=0.15
X253 vss a_n3862_n388# a_21824_n300# vss sky130_fd_pr__nfet_01v8 ad=0.435 pd=3.29 as=0.435 ps=3.29 w=3 l=0.5
X254 q8p q8n a_21912_1728# vss sky130_fd_pr__nfet_01v8_lvt ad=0.825 pd=5.33 as=0.825 ps=5.33 w=5 l=0.15
X255 vdd a_5831_626# a_5802_714# vss sky130_fd_pr__nfet_01v8_lvt ad=0.825 pd=5.33 as=0.825 ps=5.33 w=5 l=0.15
X256 a_21824_n300# a_19715_526# a_22730_3042# vss sky130_fd_pr__nfet_01v8_lvt ad=0.66 pd=4.33 as=0.66 ps=4.33 w=4 l=0.15
X257 a_7216_614# a_5802_714# a_7036_n300# vss sky130_fd_pr__nfet_01v8_lvt ad=0.66 pd=4.33 as=0.66 ps=4.33 w=4 l=0.15
X258 a_228_n300# a_n3862_n388# vss vss sky130_fd_pr__nfet_01v8 ad=0.435 pd=3.29 as=0.435 ps=3.29 w=3 l=0.5
X259 a_5802_714# a_5831_626# vdd vss sky130_fd_pr__nfet_01v8_lvt ad=1.55 pd=10.62 as=0.825 ps=5.33 w=5 l=0.15
X260 a_n3762_n300# a_n3862_n388# vss vss sky130_fd_pr__nfet_01v8 ad=0.435 pd=3.29 as=0.435 ps=3.29 w=3 l=0.5
X261 a_22730_3042# a_19715_526# a_21824_n300# vss sky130_fd_pr__nfet_01v8_lvt ad=0.66 pd=4.33 as=0.66 ps=4.33 w=4 l=0.15
X262 a_7216_614# a_5802_714# a_7036_n300# vss sky130_fd_pr__nfet_01v8_lvt ad=0.66 pd=4.33 as=0.66 ps=4.33 w=4 l=0.15
X263 a_7036_n300# a_5802_714# a_7216_614# vss sky130_fd_pr__nfet_01v8_lvt ad=0.66 pd=4.33 as=0.66 ps=4.33 w=4 l=0.15
X264 vdd q4p vss sky130_fd_pr__res_high_po_2p85 l=4.14
X265 vss a_n3862_n388# a_n3762_n300# vss sky130_fd_pr__nfet_01v8 ad=0.435 pd=3.29 as=0.435 ps=3.29 w=3 l=0.5
X266 a_21824_n300# a_19715_526# a_22730_3042# vss sky130_fd_pr__nfet_01v8_lvt ad=0.66 pd=4.33 as=0.66 ps=4.33 w=4 l=0.15
X267 a_n5001_4543# a_n5001_4543# vdd vdd sky130_fd_pr__pfet_01v8 ad=0.87 pd=6.29 as=1.74 ps=12.58 w=6 l=0.5
X268 a_7216_1728# a_7153_1640# a_7124_1728# vss sky130_fd_pr__nfet_01v8_lvt ad=0.825 pd=5.33 as=0.825 ps=5.33 w=5 l=0.15
X269 vss a_n3862_n388# a_17834_n300# vss sky130_fd_pr__nfet_01v8 ad=0.435 pd=3.29 as=0.435 ps=3.29 w=3 l=0.5
X270 a_11026_n300# a_5802_714# a_11114_1728# vss sky130_fd_pr__nfet_01v8_lvt ad=0.66 pd=4.33 as=0.66 ps=4.33 w=4 l=0.15
X271 a_18014_1728# a_17951_1640# a_17922_1728# vss sky130_fd_pr__nfet_01v8_lvt ad=0.825 pd=5.33 as=0.825 ps=5.33 w=5 l=0.15
X272 a_11114_1728# a_5802_714# a_11026_n300# vss sky130_fd_pr__nfet_01v8_lvt ad=0.66 pd=4.33 as=0.66 ps=4.33 w=4 l=0.15
X273 a_n3582_614# q2n a_n3198_1728# vss sky130_fd_pr__nfet_01v8_lvt ad=0.825 pd=5.33 as=0.825 ps=5.33 w=5 l=0.15
X274 a_21824_n300# a_19715_526# a_22730_3042# vss sky130_fd_pr__nfet_01v8_lvt ad=0.66 pd=4.33 as=0.66 ps=4.33 w=4 l=0.15
X275 a_22730_3042# a_19715_526# a_21824_n300# vss sky130_fd_pr__nfet_01v8_lvt ad=0.66 pd=4.33 as=0.66 ps=4.33 w=4 l=0.15
X276 a_7036_n300# a_5802_714# a_7216_614# vss sky130_fd_pr__nfet_01v8_lvt ad=0.66 pd=4.33 as=0.66 ps=4.33 w=4 l=0.15
X277 a_17922_1728# a_18014_1728# a_17951_1640# vss sky130_fd_pr__nfet_01v8_lvt ad=0.825 pd=5.33 as=0.825 ps=5.33 w=5 l=0.15
X278 a_n5001_4543# vbias vss vss sky130_fd_pr__nfet_01v8 ad=0.9686 pd=7.26 as=0.9686 ps=7.26 w=3.34 l=0.5
X279 a_7124_1728# a_7216_1728# a_7153_1640# vss sky130_fd_pr__nfet_01v8_lvt ad=0.825 pd=5.33 as=0.825 ps=5.33 w=5 l=0.15
X280 a_21912_1728# q8n q8p vss sky130_fd_pr__nfet_01v8_lvt ad=1.55 pd=10.62 as=0.825 ps=5.33 w=5 l=0.15
X281 a_11026_n300# a_5802_714# a_11114_1728# vss sky130_fd_pr__nfet_01v8_lvt ad=0.66 pd=4.33 as=0.66 ps=4.33 w=4 l=0.15
X282 a_11114_1728# a_5802_714# a_11026_n300# vss sky130_fd_pr__nfet_01v8_lvt ad=0.66 pd=4.33 as=0.66 ps=4.33 w=4 l=0.15
X283 a_16520_n300# q4n a_16629_626# vss sky130_fd_pr__nfet_01v8_lvt ad=0.495 pd=3.33 as=0.495 ps=3.33 w=3 l=0.15
X284 a_n3862_n388# a_n3862_n388# vss vss sky130_fd_pr__nfet_01v8 ad=0.58 pd=4.29 as=0.58 ps=4.29 w=4 l=0.5
X285 q8n q8p a_21912_1728# vss sky130_fd_pr__nfet_01v8_lvt ad=0.825 pd=5.33 as=0.825 ps=5.33 w=5 l=0.15
X286 vdd a_5831_626# vss sky130_fd_pr__res_high_po_2p85 l=4.14
X287 vss a_n3862_n388# a_11026_n300# vss sky130_fd_pr__nfet_01v8 ad=0.435 pd=3.29 as=0.435 ps=3.29 w=3 l=0.5
X288 a_n3290_1728# a_n3261_1640# a_n3198_1728# vss sky130_fd_pr__nfet_01v8_lvt ad=0.825 pd=5.33 as=0.825 ps=5.33 w=5 l=0.15
X289 a_11114_1728# q4n q4p vss sky130_fd_pr__nfet_01v8_lvt ad=0.825 pd=5.33 as=0.825 ps=5.33 w=5 l=0.15
X290 a_16520_n300# q4p a_24235_4312# vss sky130_fd_pr__nfet_01v8_lvt ad=0.93 pd=6.62 as=0.495 ps=3.33 w=3 l=0.15
X291 a_228_n300# a_n1881_526# a_1134_3042# vss sky130_fd_pr__nfet_01v8_lvt ad=0.66 pd=4.33 as=0.66 ps=4.33 w=4 l=0.15
X292 a_11114_1728# a_5802_714# a_11026_n300# vss sky130_fd_pr__nfet_01v8_lvt ad=0.66 pd=4.33 as=0.66 ps=4.33 w=4 l=0.15
X293 a_5802_714# a_5831_626# vdd vss sky130_fd_pr__nfet_01v8_lvt ad=0.825 pd=5.33 as=0.825 ps=5.33 w=5 l=0.15
X294 vss a_n3862_n388# a_n3762_n300# vss sky130_fd_pr__nfet_01v8 ad=0.435 pd=3.29 as=0.435 ps=3.29 w=3 l=0.5
X295 a_11026_n300# a_5802_714# a_11114_1728# vss sky130_fd_pr__nfet_01v8_lvt ad=1.24 pd=8.62 as=0.66 ps=4.33 w=4 l=0.15
X296 q2n q2p a_408_614# vss sky130_fd_pr__nfet_01v8_lvt ad=0.825 pd=5.33 as=0.825 ps=5.33 w=5 l=0.15
X297 q4n q4p a_11114_1728# vss sky130_fd_pr__nfet_01v8_lvt ad=0.825 pd=5.33 as=0.825 ps=5.33 w=5 l=0.15
X298 a_1134_3042# a_n1881_526# a_228_n300# vss sky130_fd_pr__nfet_01v8_lvt ad=0.66 pd=4.33 as=0.66 ps=4.33 w=4 l=0.15
X299 a_228_n300# a_n1881_526# a_1134_3042# vss sky130_fd_pr__nfet_01v8_lvt ad=1.24 pd=8.62 as=0.66 ps=4.33 w=4 l=0.15
X300 q4n q4p a_11114_1728# vss sky130_fd_pr__nfet_01v8_lvt ad=0.825 pd=5.33 as=1.55 ps=10.62 w=5 l=0.15
X301 a_7124_1728# a_8917_526# a_7036_n300# vss sky130_fd_pr__nfet_01v8_lvt ad=0.66 pd=4.33 as=1.24 ps=8.62 w=4 l=0.15
X302 vdd a_n5001_4543# a_n3862_n388# vdd sky130_fd_pr__pfet_01v8 ad=0.87 pd=6.29 as=0.87 ps=6.29 w=6 l=0.5
X303 a_n5001_4543# a_n5001_4543# vdd vdd sky130_fd_pr__pfet_01v8 ad=0.87 pd=6.29 as=0.87 ps=6.29 w=6 l=0.5
X304 q4p a_7216_1728# a_11932_3042# vss sky130_fd_pr__nfet_01v8_lvt ad=0.825 pd=5.33 as=1.55 ps=10.62 w=5 l=0.15
X305 q4p q4n a_11114_1728# vss sky130_fd_pr__nfet_01v8_lvt ad=0.825 pd=5.33 as=0.825 ps=5.33 w=5 l=0.15
X306 vss vbias a_5722_n300# vss sky130_fd_pr__nfet_01v8 ad=0.87 pd=6.58 as=0.435 ps=3.29 w=3 l=0.5
X307 q8n a_17951_1640# a_22730_3042# vss sky130_fd_pr__nfet_01v8_lvt ad=0.825 pd=5.33 as=1.55 ps=10.62 w=5 l=0.15
X308 a_228_n300# a_n1881_526# a_1134_3042# vss sky130_fd_pr__nfet_01v8_lvt ad=0.66 pd=4.33 as=0.66 ps=4.33 w=4 l=0.15
X309 a_1134_3042# a_n1881_526# a_228_n300# vss sky130_fd_pr__nfet_01v8_lvt ad=0.66 pd=4.33 as=0.66 ps=4.33 w=4 l=0.15
X310 a_7036_n300# a_n3862_n388# vss vss sky130_fd_pr__nfet_01v8 ad=0.435 pd=3.29 as=0.435 ps=3.29 w=3 l=0.5
X311 vss a_n3862_n388# a_7036_n300# vss sky130_fd_pr__nfet_01v8 ad=0.435 pd=3.29 as=0.435 ps=3.29 w=3 l=0.5
X312 vss a_n3862_n388# a_11026_n300# vss sky130_fd_pr__nfet_01v8 ad=0.435 pd=3.29 as=0.435 ps=3.29 w=3 l=0.5
X313 a_13437_4312# q2p a_5722_n300# vss sky130_fd_pr__nfet_01v8_lvt ad=0.495 pd=3.33 as=0.495 ps=3.33 w=3 l=0.15
X314 a_7216_1728# a_7153_1640# a_7124_1728# vss sky130_fd_pr__nfet_01v8_lvt ad=0.825 pd=5.33 as=0.825 ps=5.33 w=5 l=0.15
X315 vss a_n3862_n388# a_228_n300# vss sky130_fd_pr__nfet_01v8 ad=0.435 pd=3.29 as=0.435 ps=3.29 w=3 l=0.5
X316 a_11026_n300# a_8917_526# a_11932_3042# vss sky130_fd_pr__nfet_01v8_lvt ad=0.66 pd=4.33 as=0.66 ps=4.33 w=4 l=0.15
X317 a_11932_3042# a_8917_526# a_11026_n300# vss sky130_fd_pr__nfet_01v8_lvt ad=0.66 pd=4.33 as=0.66 ps=4.33 w=4 l=0.15
X318 q2p q2n a_408_614# vss sky130_fd_pr__nfet_01v8_lvt ad=0.825 pd=5.33 as=1.55 ps=10.62 w=5 l=0.15
X319 vss a_n3862_n388# a_n3762_n300# vss sky130_fd_pr__nfet_01v8 ad=0.87 pd=6.58 as=0.435 ps=3.29 w=3 l=0.5
X320 a_8917_526# a_13437_4312# vdd vss sky130_fd_pr__nfet_01v8_lvt ad=1.55 pd=10.62 as=0.825 ps=5.33 w=5 l=0.15
X321 a_11114_1728# q4p q4n vss sky130_fd_pr__nfet_01v8_lvt ad=0.825 pd=5.33 as=0.825 ps=5.33 w=5 l=0.15
X322 vss vbias a_n1881_526# vss sky130_fd_pr__nfet_01v8 ad=1.16 pd=8.58 as=1.16 ps=8.58 w=4 l=0.5
X323 vdd a_18014_1728# vss sky130_fd_pr__res_high_po_2p85 l=4.14
X324 a_n3261_1640# a_n3198_1728# a_n3290_1728# vss sky130_fd_pr__nfet_01v8_lvt ad=0.825 pd=5.33 as=1.55 ps=10.62 w=5 l=0.15
X325 a_7124_1728# a_7216_1728# a_7153_1640# vss sky130_fd_pr__nfet_01v8_lvt ad=0.825 pd=5.33 as=0.825 ps=5.33 w=5 l=0.15
X326 a_11026_n300# a_8917_526# a_11932_3042# vss sky130_fd_pr__nfet_01v8_lvt ad=0.66 pd=4.33 as=0.66 ps=4.33 w=4 l=0.15
X327 a_11932_3042# a_8917_526# a_11026_n300# vss sky130_fd_pr__nfet_01v8_lvt ad=0.66 pd=4.33 as=0.66 ps=4.33 w=4 l=0.15
X328 a_11026_n300# a_8917_526# a_11932_3042# vss sky130_fd_pr__nfet_01v8_lvt ad=0.66 pd=4.33 as=0.66 ps=4.33 w=4 l=0.15
X329 a_11932_3042# a_8917_526# a_11026_n300# vss sky130_fd_pr__nfet_01v8_lvt ad=0.66 pd=4.33 as=0.66 ps=4.33 w=4 l=0.15
X330 a_n5001_4543# a_n5001_4543# vdd vdd sky130_fd_pr__pfet_01v8 ad=0.87 pd=6.29 as=0.87 ps=6.29 w=6 l=0.5
X331 a_7124_1728# a_7153_1640# a_7216_1728# vss sky130_fd_pr__nfet_01v8_lvt ad=0.825 pd=5.33 as=0.825 ps=5.33 w=5 l=0.15
X332 a_19715_526# a_24235_4312# vdd vss sky130_fd_pr__nfet_01v8_lvt ad=0.825 pd=5.33 as=0.825 ps=5.33 w=5 l=0.15
X333 a_21912_1728# q8p q8n vss sky130_fd_pr__nfet_01v8_lvt ad=0.825 pd=5.33 as=0.825 ps=5.33 w=5 l=0.15
X334 a_17922_1728# a_17951_1640# a_18014_1728# vss sky130_fd_pr__nfet_01v8_lvt ad=0.825 pd=5.33 as=0.825 ps=5.33 w=5 l=0.15
X335 a_11932_3042# a_8917_526# a_11026_n300# vss sky130_fd_pr__nfet_01v8_lvt ad=0.66 pd=4.33 as=0.66 ps=4.33 w=4 l=0.15
X336 a_11026_n300# a_8917_526# a_11932_3042# vss sky130_fd_pr__nfet_01v8_lvt ad=0.66 pd=4.33 as=0.66 ps=4.33 w=4 l=0.15
X337 a_n1881_526# clkn vdd vss sky130_fd_pr__nfet_01v8_lvt ad=0.825 pd=5.33 as=0.825 ps=5.33 w=5 l=0.15
X338 a_11026_n300# a_8917_526# a_11932_3042# vss sky130_fd_pr__nfet_01v8_lvt ad=0.66 pd=4.33 as=0.66 ps=4.33 w=4 l=0.15
X339 a_21912_1728# q8p q8n vss sky130_fd_pr__nfet_01v8_lvt ad=0.825 pd=5.33 as=0.825 ps=5.33 w=5 l=0.15
X340 a_11932_3042# a_8917_526# a_11026_n300# vss sky130_fd_pr__nfet_01v8_lvt ad=0.66 pd=4.33 as=0.66 ps=4.33 w=4 l=0.15
X341 a_11026_n300# a_n3862_n388# vss vss sky130_fd_pr__nfet_01v8 ad=0.435 pd=3.29 as=0.435 ps=3.29 w=3 l=0.5
X342 q4p q4n a_11114_1728# vss sky130_fd_pr__nfet_01v8_lvt ad=0.825 pd=5.33 as=0.825 ps=5.33 w=5 l=0.15
X343 vss a_n3862_n388# a_11026_n300# vss sky130_fd_pr__nfet_01v8 ad=0.435 pd=3.29 as=0.435 ps=3.29 w=3 l=0.5
X344 a_5722_n300# q2n a_5831_626# vss sky130_fd_pr__nfet_01v8_lvt ad=0.495 pd=3.33 as=0.495 ps=3.33 w=3 l=0.15
X345 a_18014_1728# a_17951_1640# a_17922_1728# vss sky130_fd_pr__nfet_01v8_lvt ad=0.825 pd=5.33 as=0.825 ps=5.33 w=5 l=0.15
X346 vdd a_5831_626# a_5802_714# vss sky130_fd_pr__nfet_01v8_lvt ad=0.825 pd=5.33 as=0.825 ps=5.33 w=5 l=0.15
X347 vss vbias a_5722_n300# vss sky130_fd_pr__nfet_01v8 ad=0.87 pd=6.58 as=0.435 ps=3.29 w=3 l=0.5
X348 a_17951_1640# q8p a_18014_614# vss sky130_fd_pr__nfet_01v8_lvt ad=0.825 pd=5.33 as=1.55 ps=10.62 w=5 l=0.15
X349 a_408_614# q2n q2p vss sky130_fd_pr__nfet_01v8_lvt ad=0.825 pd=5.33 as=0.825 ps=5.33 w=5 l=0.15
X350 a_11114_1728# q4p q4n vss sky130_fd_pr__nfet_01v8_lvt ad=1.55 pd=10.62 as=0.825 ps=5.33 w=5 l=0.15
X351 a_21824_n300# a_n3862_n388# vss vss sky130_fd_pr__nfet_01v8 ad=0.435 pd=3.29 as=0.435 ps=3.29 w=3 l=0.5
X352 a_n3290_1728# a_n3261_1640# a_n3198_1728# vss sky130_fd_pr__nfet_01v8_lvt ad=0.825 pd=5.33 as=0.825 ps=5.33 w=5 l=0.15
X353 vdd a_24235_4312# a_19715_526# vss sky130_fd_pr__nfet_01v8_lvt ad=0.825 pd=5.33 as=0.825 ps=5.33 w=5 l=0.15
X354 a_21824_n300# a_n3862_n388# vss vss sky130_fd_pr__nfet_01v8 ad=0.435 pd=3.29 as=0.87 ps=6.58 w=3 l=0.5
X355 q8p q8n a_21912_1728# vss sky130_fd_pr__nfet_01v8_lvt ad=0.825 pd=5.33 as=0.825 ps=5.33 w=5 l=0.15
X356 a_11114_1728# q4n q4p vss sky130_fd_pr__nfet_01v8_lvt ad=1.55 pd=10.62 as=0.825 ps=5.33 w=5 l=0.15
X357 a_21824_n300# a_16600_714# a_21912_1728# vss sky130_fd_pr__nfet_01v8_lvt ad=0.66 pd=4.33 as=0.66 ps=4.33 w=4 l=0.15
X358 a_22730_3042# a_17951_1640# q8n vss sky130_fd_pr__nfet_01v8_lvt ad=1.55 pd=10.62 as=0.825 ps=5.33 w=5 l=0.15
X359 a_1134_3042# a_n3261_1640# q2n vss sky130_fd_pr__nfet_01v8_lvt ad=0.825 pd=5.33 as=0.825 ps=5.33 w=5 l=0.15
X360 a_5722_n300# q2p a_13437_4312# vss sky130_fd_pr__nfet_01v8_lvt ad=0.93 pd=6.62 as=0.495 ps=3.33 w=3 l=0.15
X361 a_228_n300# a_n3862_n388# vss vss sky130_fd_pr__nfet_01v8 ad=0.435 pd=3.29 as=0.87 ps=6.58 w=3 l=0.5
X362 a_16600_714# a_16629_626# vdd vss sky130_fd_pr__nfet_01v8_lvt ad=0.825 pd=5.33 as=0.825 ps=5.33 w=5 l=0.15
X363 vdd a_24235_4312# a_19715_526# vss sky130_fd_pr__nfet_01v8_lvt ad=0.825 pd=5.33 as=0.825 ps=5.33 w=5 l=0.15
X364 a_19715_526# a_24235_4312# vdd vss sky130_fd_pr__nfet_01v8_lvt ad=1.55 pd=10.62 as=0.825 ps=5.33 w=5 l=0.15
X365 a_21824_n300# a_16600_714# a_21912_1728# vss sky130_fd_pr__nfet_01v8_lvt ad=0.66 pd=4.33 as=0.66 ps=4.33 w=4 l=0.15
X366 q4n q4p a_11114_1728# vss sky130_fd_pr__nfet_01v8_lvt ad=0.825 pd=5.33 as=0.825 ps=5.33 w=5 l=0.15
X367 a_21912_1728# a_16600_714# a_21824_n300# vss sky130_fd_pr__nfet_01v8_lvt ad=0.66 pd=4.33 as=0.66 ps=4.33 w=4 l=0.15
X368 a_17922_1728# a_18014_1728# a_17951_1640# vss sky130_fd_pr__nfet_01v8_lvt ad=0.825 pd=5.33 as=0.825 ps=5.33 w=5 l=0.15
X369 a_7124_1728# a_7216_1728# a_7153_1640# vss sky130_fd_pr__nfet_01v8_lvt ad=0.825 pd=5.33 as=0.825 ps=5.33 w=5 l=0.15
X370 a_19715_526# a_24235_4312# vdd vss sky130_fd_pr__nfet_01v8_lvt ad=0.825 pd=5.33 as=0.825 ps=5.33 w=5 l=0.15
X371 vdd a_24235_4312# a_19715_526# vss sky130_fd_pr__nfet_01v8_lvt ad=0.825 pd=5.33 as=0.825 ps=5.33 w=5 l=0.15
X372 a_21912_1728# a_16600_714# a_21824_n300# vss sky130_fd_pr__nfet_01v8_lvt ad=0.66 pd=4.33 as=0.66 ps=4.33 w=4 l=0.15
X373 a_21912_1728# a_16600_714# a_21824_n300# vss sky130_fd_pr__nfet_01v8_lvt ad=0.66 pd=4.33 as=0.66 ps=4.33 w=4 l=0.15
X374 vss vbias a_19715_526# vss sky130_fd_pr__nfet_01v8 ad=1.16 pd=8.58 as=1.16 ps=8.58 w=4 l=0.5
X375 a_21824_n300# a_16600_714# a_21912_1728# vss sky130_fd_pr__nfet_01v8_lvt ad=0.66 pd=4.33 as=0.66 ps=4.33 w=4 l=0.15
X376 a_21824_n300# a_n3862_n388# vss vss sky130_fd_pr__nfet_01v8 ad=0.435 pd=3.29 as=0.435 ps=3.29 w=3 l=0.5
X377 a_16520_n300# q4p a_24235_4312# vss sky130_fd_pr__nfet_01v8_lvt ad=0.495 pd=3.33 as=0.495 ps=3.33 w=3 l=0.15
X378 q4n a_7153_1640# a_11932_3042# vss sky130_fd_pr__nfet_01v8_lvt ad=0.825 pd=5.33 as=1.55 ps=10.62 w=5 l=0.15
X379 vss a_n3862_n388# a_228_n300# vss sky130_fd_pr__nfet_01v8 ad=0.435 pd=3.29 as=0.435 ps=3.29 w=3 l=0.5
X380 vdd a_24235_4312# a_19715_526# vss sky130_fd_pr__nfet_01v8_lvt ad=0.825 pd=5.33 as=0.825 ps=5.33 w=5 l=0.15
X381 a_11932_3042# a_7216_1728# q4p vss sky130_fd_pr__nfet_01v8_lvt ad=0.825 pd=5.33 as=0.825 ps=5.33 w=5 l=0.15
X382 q8n q8p a_21912_1728# vss sky130_fd_pr__nfet_01v8_lvt ad=0.825 pd=5.33 as=0.825 ps=5.33 w=5 l=0.15
X383 a_17922_1728# a_18014_1728# a_17951_1640# vss sky130_fd_pr__nfet_01v8_lvt ad=0.825 pd=5.33 as=0.825 ps=5.33 w=5 l=0.15
X384 a_n3762_n300# a_n3862_n388# vss vss sky130_fd_pr__nfet_01v8 ad=0.435 pd=3.29 as=0.435 ps=3.29 w=3 l=0.5
X385 vss a_n3862_n388# a_17834_n300# vss sky130_fd_pr__nfet_01v8 ad=0.435 pd=3.29 as=0.435 ps=3.29 w=3 l=0.5
X386 a_18014_1728# a_17951_1640# a_17922_1728# vss sky130_fd_pr__nfet_01v8_lvt ad=0.825 pd=5.33 as=0.825 ps=5.33 w=5 l=0.15
X387 vdd clkn a_n1881_526# vss sky130_fd_pr__nfet_01v8_lvt ad=0.825 pd=5.33 as=0.825 ps=5.33 w=5 l=0.15
X388 a_7216_614# q4n a_7216_1728# vss sky130_fd_pr__nfet_01v8_lvt ad=0.825 pd=5.33 as=0.825 ps=5.33 w=5 l=0.15
X389 a_19715_526# a_24235_4312# vdd vss sky130_fd_pr__nfet_01v8_lvt ad=0.825 pd=5.33 as=0.825 ps=5.33 w=5 l=0.15
X390 a_21912_1728# a_16600_714# a_21824_n300# vss sky130_fd_pr__nfet_01v8_lvt ad=0.66 pd=4.33 as=0.66 ps=4.33 w=4 l=0.15
X391 q2n q2p a_408_614# vss sky130_fd_pr__nfet_01v8_lvt ad=0.825 pd=5.33 as=1.55 ps=10.62 w=5 l=0.15
X392 a_21824_n300# a_16600_714# a_21912_1728# vss sky130_fd_pr__nfet_01v8_lvt ad=0.66 pd=4.33 as=0.66 ps=4.33 w=4 l=0.15
X393 a_21912_1728# a_16600_714# a_21824_n300# vss sky130_fd_pr__nfet_01v8_lvt ad=0.66 pd=4.33 as=0.66 ps=4.33 w=4 l=0.15
X394 vdd a_n3198_1728# vss sky130_fd_pr__res_high_po_2p85 l=4.14
X395 a_7124_1728# a_7216_1728# a_7153_1640# vss sky130_fd_pr__nfet_01v8_lvt ad=1.55 pd=10.62 as=0.825 ps=5.33 w=5 l=0.15
X396 a_21824_n300# a_16600_714# a_21912_1728# vss sky130_fd_pr__nfet_01v8_lvt ad=0.66 pd=4.33 as=0.66 ps=4.33 w=4 l=0.15
X397 a_17834_n300# a_n3862_n388# vss vss sky130_fd_pr__nfet_01v8 ad=0.435 pd=3.29 as=0.435 ps=3.29 w=3 l=0.5
X398 q8p q8n a_21912_1728# vss sky130_fd_pr__nfet_01v8_lvt ad=0.825 pd=5.33 as=1.55 ps=10.62 w=5 l=0.15
X399 vss a_n3862_n388# a_11026_n300# vss sky130_fd_pr__nfet_01v8 ad=0.87 pd=6.58 as=0.435 ps=3.29 w=3 l=0.5
X400 a_5831_626# q2n a_5722_n300# vss sky130_fd_pr__nfet_01v8_lvt ad=0.495 pd=3.33 as=0.495 ps=3.33 w=3 l=0.15
X401 vss a_n3862_n388# a_7036_n300# vss sky130_fd_pr__nfet_01v8 ad=0.435 pd=3.29 as=0.435 ps=3.29 w=3 l=0.5
X402 a_17922_1728# a_17951_1640# a_18014_1728# vss sky130_fd_pr__nfet_01v8_lvt ad=1.55 pd=10.62 as=0.825 ps=5.33 w=5 l=0.15
X403 vss a_n3862_n388# a_n3762_n300# vss sky130_fd_pr__nfet_01v8 ad=0.435 pd=3.29 as=0.435 ps=3.29 w=3 l=0.5
X404 a_7216_1728# a_7153_1640# a_7124_1728# vss sky130_fd_pr__nfet_01v8_lvt ad=0.825 pd=5.33 as=0.825 ps=5.33 w=5 l=0.15
X405 a_18014_614# q8p a_17951_1640# vss sky130_fd_pr__nfet_01v8_lvt ad=1.55 pd=10.62 as=0.825 ps=5.33 w=5 l=0.15
X406 a_7216_614# q4p a_7153_1640# vss sky130_fd_pr__nfet_01v8_lvt ad=0.825 pd=5.33 as=0.825 ps=5.33 w=5 l=0.15
X407 a_11114_1728# q4p q4n vss sky130_fd_pr__nfet_01v8_lvt ad=0.825 pd=5.33 as=0.825 ps=5.33 w=5 l=0.15
X408 a_8917_526# a_13437_4312# vdd vss sky130_fd_pr__nfet_01v8_lvt ad=0.825 pd=5.33 as=0.825 ps=5.33 w=5 l=0.15
X409 a_5802_714# a_5831_626# vdd vss sky130_fd_pr__nfet_01v8_lvt ad=0.825 pd=5.33 as=0.825 ps=5.33 w=5 l=0.15
X410 a_n3261_1640# a_n3198_1728# a_n3290_1728# vss sky130_fd_pr__nfet_01v8_lvt ad=0.825 pd=5.33 as=0.825 ps=5.33 w=5 l=0.15
X411 vdd a_13437_4312# a_8917_526# vss sky130_fd_pr__nfet_01v8_lvt ad=0.825 pd=5.33 as=1.55 ps=10.62 w=5 l=0.15
X412 a_21912_1728# q8n q8p vss sky130_fd_pr__nfet_01v8_lvt ad=0.825 pd=5.33 as=0.825 ps=5.33 w=5 l=0.15
X413 vdd a_n5001_4543# a_n3862_n388# vdd sky130_fd_pr__pfet_01v8 ad=0.87 pd=6.29 as=0.87 ps=6.29 w=6 l=0.5
X414 a_21824_n300# a_n3862_n388# vss vss sky130_fd_pr__nfet_01v8 ad=0.435 pd=3.29 as=0.435 ps=3.29 w=3 l=0.5
X415 a_n5001_4543# a_n5001_4543# vdd vdd sky130_fd_pr__pfet_01v8 ad=0.87 pd=6.29 as=0.87 ps=6.29 w=6 l=0.5
X416 vdd a_5831_626# a_5802_714# vss sky130_fd_pr__nfet_01v8_lvt ad=0.825 pd=5.33 as=1.55 ps=10.62 w=5 l=0.15
X417 vss a_n3862_n388# a_228_n300# vss sky130_fd_pr__nfet_01v8 ad=0.435 pd=3.29 as=0.435 ps=3.29 w=3 l=0.5
X418 a_22730_3042# a_19715_526# a_21824_n300# vss sky130_fd_pr__nfet_01v8_lvt ad=0.66 pd=4.33 as=0.66 ps=4.33 w=4 l=0.15
X419 a_17922_1728# a_19715_526# a_17834_n300# vss sky130_fd_pr__nfet_01v8_lvt ad=0.66 pd=4.33 as=0.66 ps=4.33 w=4 l=0.15
X420 a_n4996_714# clkp vdd vss sky130_fd_pr__nfet_01v8_lvt ad=0.825 pd=5.33 as=0.825 ps=5.33 w=5 l=0.15
X421 a_16520_n300# q4n a_16629_626# vss sky130_fd_pr__nfet_01v8_lvt ad=0.495 pd=3.33 as=0.495 ps=3.33 w=3 l=0.15
X422 a_n3762_n300# a_n3862_n388# vss vss sky130_fd_pr__nfet_01v8 ad=0.435 pd=3.29 as=0.435 ps=3.29 w=3 l=0.5
X423 q8n q8p a_21912_1728# vss sky130_fd_pr__nfet_01v8_lvt ad=0.825 pd=5.33 as=0.825 ps=5.33 w=5 l=0.15
X424 a_8917_526# a_13437_4312# vdd vss sky130_fd_pr__nfet_01v8_lvt ad=0.825 pd=5.33 as=0.825 ps=5.33 w=5 l=0.15
X425 vdd a_13437_4312# a_8917_526# vss sky130_fd_pr__nfet_01v8_lvt ad=0.825 pd=5.33 as=0.825 ps=5.33 w=5 l=0.15
X426 a_11026_n300# a_5802_714# a_11114_1728# vss sky130_fd_pr__nfet_01v8_lvt ad=0.66 pd=4.33 as=0.66 ps=4.33 w=4 l=0.15
X427 a_11114_1728# a_5802_714# a_11026_n300# vss sky130_fd_pr__nfet_01v8_lvt ad=0.66 pd=4.33 as=0.66 ps=4.33 w=4 l=0.15
X428 a_11114_1728# q4n q4p vss sky130_fd_pr__nfet_01v8_lvt ad=0.825 pd=5.33 as=0.825 ps=5.33 w=5 l=0.15
X429 q8n q8p a_21912_1728# vss sky130_fd_pr__nfet_01v8_lvt ad=0.825 pd=5.33 as=0.825 ps=5.33 w=5 l=0.15
X430 vss a_n3862_n388# a_7036_n300# vss sky130_fd_pr__nfet_01v8 ad=0.435 pd=3.29 as=0.435 ps=3.29 w=3 l=0.5
X431 a_21824_n300# a_19715_526# a_22730_3042# vss sky130_fd_pr__nfet_01v8_lvt ad=0.66 pd=4.33 as=0.66 ps=4.33 w=4 l=0.15
X432 a_17951_1640# a_18014_1728# a_17922_1728# vss sky130_fd_pr__nfet_01v8_lvt ad=0.825 pd=5.33 as=0.825 ps=5.33 w=5 l=0.15
X433 q8p a_18014_1728# a_22730_3042# vss sky130_fd_pr__nfet_01v8_lvt ad=0.825 pd=5.33 as=0.825 ps=5.33 w=5 l=0.15
X434 a_8917_526# a_13437_4312# vdd vss sky130_fd_pr__nfet_01v8_lvt ad=0.825 pd=5.33 as=0.825 ps=5.33 w=5 l=0.15
X435 a_7153_1640# a_7216_1728# a_7124_1728# vss sky130_fd_pr__nfet_01v8_lvt ad=0.825 pd=5.33 as=0.825 ps=5.33 w=5 l=0.15
X436 q8p q8n a_21912_1728# vss sky130_fd_pr__nfet_01v8_lvt ad=0.825 pd=5.33 as=0.825 ps=5.33 w=5 l=0.15
X437 vdd a_13437_4312# a_8917_526# vss sky130_fd_pr__nfet_01v8_lvt ad=0.825 pd=5.33 as=0.825 ps=5.33 w=5 l=0.15
X438 a_11114_1728# a_5802_714# a_11026_n300# vss sky130_fd_pr__nfet_01v8_lvt ad=0.66 pd=4.33 as=1.24 ps=8.62 w=4 l=0.15
X439 a_n3198_1728# q2n a_n3582_614# vss sky130_fd_pr__nfet_01v8_lvt ad=0.825 pd=5.33 as=0.825 ps=5.33 w=5 l=0.15
X440 a_8917_526# a_13437_4312# vdd vss sky130_fd_pr__nfet_01v8_lvt ad=1.55 pd=10.62 as=0.825 ps=5.33 w=5 l=0.15
X441 a_11114_1728# a_5802_714# a_11026_n300# vss sky130_fd_pr__nfet_01v8_lvt ad=0.66 pd=4.33 as=0.66 ps=4.33 w=4 l=0.15
X442 a_11026_n300# a_5802_714# a_11114_1728# vss sky130_fd_pr__nfet_01v8_lvt ad=0.66 pd=4.33 as=0.66 ps=4.33 w=4 l=0.15
X443 vss a_n3862_n388# a_n3862_n388# vss sky130_fd_pr__nfet_01v8 ad=0.58 pd=4.29 as=0.58 ps=4.29 w=4 l=0.5
X444 a_22730_3042# a_19715_526# a_21824_n300# vss sky130_fd_pr__nfet_01v8_lvt ad=0.66 pd=4.33 as=1.24 ps=8.62 w=4 l=0.15
X445 a_n3198_1728# a_n3261_1640# a_n3290_1728# vss sky130_fd_pr__nfet_01v8_lvt ad=0.825 pd=5.33 as=0.825 ps=5.33 w=5 l=0.15
X446 a_n3762_n300# a_n4996_714# a_n3582_614# vss sky130_fd_pr__nfet_01v8_lvt ad=0.66 pd=4.33 as=0.66 ps=4.33 w=4 l=0.15
X447 a_17834_n300# a_19715_526# a_17922_1728# vss sky130_fd_pr__nfet_01v8_lvt ad=1.24 pd=8.62 as=0.66 ps=4.33 w=4 l=0.15
X448 a_11026_n300# a_n3862_n388# vss vss sky130_fd_pr__nfet_01v8 ad=0.435 pd=3.29 as=0.87 ps=6.58 w=3 l=0.5
X449 a_24235_4312# q4p a_16520_n300# vss sky130_fd_pr__nfet_01v8_lvt ad=0.495 pd=3.33 as=0.495 ps=3.33 w=3 l=0.15
X450 a_11932_3042# a_7153_1640# q4n vss sky130_fd_pr__nfet_01v8_lvt ad=1.55 pd=10.62 as=0.825 ps=5.33 w=5 l=0.15
X451 a_21912_1728# q8p q8n vss sky130_fd_pr__nfet_01v8_lvt ad=0.825 pd=5.33 as=0.825 ps=5.33 w=5 l=0.15
X452 vdd a_13437_4312# a_8917_526# vss sky130_fd_pr__nfet_01v8_lvt ad=0.825 pd=5.33 as=0.825 ps=5.33 w=5 l=0.15
X453 a_8917_526# a_13437_4312# vdd vss sky130_fd_pr__nfet_01v8_lvt ad=0.825 pd=5.33 as=0.825 ps=5.33 w=5 l=0.15
X454 a_11114_1728# a_5802_714# a_11026_n300# vss sky130_fd_pr__nfet_01v8_lvt ad=0.66 pd=4.33 as=0.66 ps=4.33 w=4 l=0.15
X455 vss a_n3862_n388# a_228_n300# vss sky130_fd_pr__nfet_01v8 ad=0.435 pd=3.29 as=0.435 ps=3.29 w=3 l=0.5
X456 vdd a_5831_626# a_5802_714# vss sky130_fd_pr__nfet_01v8_lvt ad=0.825 pd=5.33 as=0.825 ps=5.33 w=5 l=0.15
X457 a_11026_n300# a_5802_714# a_11114_1728# vss sky130_fd_pr__nfet_01v8_lvt ad=0.66 pd=4.33 as=0.66 ps=4.33 w=4 l=0.15
X458 a_n1881_526# clkn vdd vss sky130_fd_pr__nfet_01v8_lvt ad=1.55 pd=10.62 as=0.825 ps=5.33 w=5 l=0.15
X459 a_11114_1728# a_5802_714# a_11026_n300# vss sky130_fd_pr__nfet_01v8_lvt ad=0.66 pd=4.33 as=0.66 ps=4.33 w=4 l=0.15
X460 a_408_614# q2p q2n vss sky130_fd_pr__nfet_01v8_lvt ad=0.825 pd=5.33 as=0.825 ps=5.33 w=5 l=0.15
X461 vss a_n3862_n388# a_7036_n300# vss sky130_fd_pr__nfet_01v8 ad=0.87 pd=6.58 as=0.435 ps=3.29 w=3 l=0.5
X462 a_n3582_614# a_n4996_714# a_n3762_n300# vss sky130_fd_pr__nfet_01v8_lvt ad=0.66 pd=4.33 as=0.66 ps=4.33 w=4 l=0.15
X463 a_n3762_n300# a_n4996_714# a_n3582_614# vss sky130_fd_pr__nfet_01v8_lvt ad=0.66 pd=4.33 as=0.66 ps=4.33 w=4 l=0.15
X464 a_n3582_614# a_n4996_714# a_n3762_n300# vss sky130_fd_pr__nfet_01v8_lvt ad=0.66 pd=4.33 as=1.24 ps=8.62 w=4 l=0.15
X465 a_11026_n300# a_5802_714# a_11114_1728# vss sky130_fd_pr__nfet_01v8_lvt ad=0.66 pd=4.33 as=0.66 ps=4.33 w=4 l=0.15
X466 a_n3762_n300# a_n4996_714# a_n3582_614# vss sky130_fd_pr__nfet_01v8_lvt ad=0.66 pd=4.33 as=0.66 ps=4.33 w=4 l=0.15
X467 a_n3582_614# a_n4996_714# a_n3762_n300# vss sky130_fd_pr__nfet_01v8_lvt ad=0.66 pd=4.33 as=0.66 ps=4.33 w=4 l=0.15
X468 a_11026_n300# a_n3862_n388# vss vss sky130_fd_pr__nfet_01v8 ad=0.435 pd=3.29 as=0.435 ps=3.29 w=3 l=0.5
X469 vss a_n3862_n388# a_17834_n300# vss sky130_fd_pr__nfet_01v8 ad=0.435 pd=3.29 as=0.435 ps=3.29 w=3 l=0.5
X470 vss a_n3862_n388# a_7036_n300# vss sky130_fd_pr__nfet_01v8 ad=0.435 pd=3.29 as=0.435 ps=3.29 w=3 l=0.5
X471 a_5722_n300# q2p a_13437_4312# vss sky130_fd_pr__nfet_01v8_lvt ad=0.495 pd=3.33 as=0.495 ps=3.33 w=3 l=0.15
X472 a_7124_1728# a_7153_1640# a_7216_1728# vss sky130_fd_pr__nfet_01v8_lvt ad=0.825 pd=5.33 as=0.825 ps=5.33 w=5 l=0.15
X473 a_11026_n300# a_n3862_n388# vss vss sky130_fd_pr__nfet_01v8 ad=0.435 pd=3.29 as=0.435 ps=3.29 w=3 l=0.5
X474 q4n q4p a_11114_1728# vss sky130_fd_pr__nfet_01v8_lvt ad=0.825 pd=5.33 as=0.825 ps=5.33 w=5 l=0.15
X475 vdd a_13437_4312# a_8917_526# vss sky130_fd_pr__nfet_01v8_lvt ad=0.825 pd=5.33 as=0.825 ps=5.33 w=5 l=0.15
X476 a_1134_3042# a_n1881_526# a_228_n300# vss sky130_fd_pr__nfet_01v8_lvt ad=0.66 pd=4.33 as=0.66 ps=4.33 w=4 l=0.15
X477 a_n3582_614# a_n4996_714# a_n3762_n300# vss sky130_fd_pr__nfet_01v8_lvt ad=0.66 pd=4.33 as=0.66 ps=4.33 w=4 l=0.15
X478 a_17951_1640# a_18014_1728# a_17922_1728# vss sky130_fd_pr__nfet_01v8_lvt ad=0.825 pd=5.33 as=0.825 ps=5.33 w=5 l=0.15
X479 a_n3290_1728# a_n3198_1728# a_n3261_1640# vss sky130_fd_pr__nfet_01v8_lvt ad=0.825 pd=5.33 as=0.825 ps=5.33 w=5 l=0.15
X480 a_17834_n300# a_16600_714# a_18014_614# vss sky130_fd_pr__nfet_01v8_lvt ad=0.66 pd=4.33 as=0.66 ps=4.33 w=4 l=0.15
X481 a_7153_1640# a_7216_1728# a_7124_1728# vss sky130_fd_pr__nfet_01v8_lvt ad=0.825 pd=5.33 as=1.55 ps=10.62 w=5 l=0.15
X482 q8p q8n a_21912_1728# vss sky130_fd_pr__nfet_01v8_lvt ad=0.825 pd=5.33 as=0.825 ps=5.33 w=5 l=0.15
X483 vss a_n3862_n388# a_21824_n300# vss sky130_fd_pr__nfet_01v8 ad=0.435 pd=3.29 as=0.435 ps=3.29 w=3 l=0.5
X484 a_228_n300# a_n1881_526# a_1134_3042# vss sky130_fd_pr__nfet_01v8_lvt ad=0.66 pd=4.33 as=0.66 ps=4.33 w=4 l=0.15
X485 a_21824_n300# a_n3862_n388# vss vss sky130_fd_pr__nfet_01v8 ad=0.435 pd=3.29 as=0.435 ps=3.29 w=3 l=0.5
X486 a_11932_3042# a_8917_526# a_11026_n300# vss sky130_fd_pr__nfet_01v8_lvt ad=0.66 pd=4.33 as=1.24 ps=8.62 w=4 l=0.15
X487 vss a_n3862_n388# a_228_n300# vss sky130_fd_pr__nfet_01v8 ad=0.435 pd=3.29 as=0.435 ps=3.29 w=3 l=0.5
X488 a_7036_n300# a_8917_526# a_7124_1728# vss sky130_fd_pr__nfet_01v8_lvt ad=1.24 pd=8.62 as=0.66 ps=4.33 w=4 l=0.15
X489 vss a_n3862_n388# a_n3762_n300# vss sky130_fd_pr__nfet_01v8 ad=0.435 pd=3.29 as=0.435 ps=3.29 w=3 l=0.5
X490 a_n3862_n388# a_n5001_4543# vdd vdd sky130_fd_pr__pfet_01v8 ad=0.87 pd=6.29 as=0.87 ps=6.29 w=6 l=0.5
X491 vdd clkp a_n4996_714# vss sky130_fd_pr__nfet_01v8_lvt ad=0.825 pd=5.33 as=0.825 ps=5.33 w=5 l=0.15
X492 a_7216_1728# a_7153_1640# a_7124_1728# vss sky130_fd_pr__nfet_01v8_lvt ad=0.825 pd=5.33 as=0.825 ps=5.33 w=5 l=0.15
X493 a_n3762_n300# a_n3862_n388# vss vss sky130_fd_pr__nfet_01v8 ad=0.435 pd=3.29 as=0.435 ps=3.29 w=3 l=0.5
X494 a_17834_n300# a_16600_714# a_18014_614# vss sky130_fd_pr__nfet_01v8_lvt ad=0.66 pd=4.33 as=0.66 ps=4.33 w=4 l=0.15
X495 a_n3198_1728# a_n3261_1640# a_n3290_1728# vss sky130_fd_pr__nfet_01v8_lvt ad=0.825 pd=5.33 as=0.825 ps=5.33 w=5 l=0.15
X496 vss a_n3862_n388# a_17834_n300# vss sky130_fd_pr__nfet_01v8 ad=0.435 pd=3.29 as=0.435 ps=3.29 w=3 l=0.5
X497 vdd a_n5001_4543# a_n5001_4543# vdd sky130_fd_pr__pfet_01v8 ad=0.87 pd=6.29 as=0.87 ps=6.29 w=6 l=0.5
X498 a_17834_n300# a_n3862_n388# vss vss sky130_fd_pr__nfet_01v8 ad=0.435 pd=3.29 as=0.87 ps=6.58 w=3 l=0.5
X499 a_21912_1728# q8n q8p vss sky130_fd_pr__nfet_01v8_lvt ad=0.825 pd=5.33 as=0.825 ps=5.33 w=5 l=0.15
X500 a_18014_1728# a_17951_1640# a_17922_1728# vss sky130_fd_pr__nfet_01v8_lvt ad=0.825 pd=5.33 as=0.825 ps=5.33 w=5 l=0.15
X501 vss a_n3862_n388# a_7036_n300# vss sky130_fd_pr__nfet_01v8 ad=0.435 pd=3.29 as=0.435 ps=3.29 w=3 l=0.5
X502 a_7124_1728# a_8917_526# a_7036_n300# vss sky130_fd_pr__nfet_01v8_lvt ad=0.66 pd=4.33 as=0.66 ps=4.33 w=4 l=0.15
X503 a_17922_1728# a_18014_1728# a_17951_1640# vss sky130_fd_pr__nfet_01v8_lvt ad=0.825 pd=5.33 as=0.825 ps=5.33 w=5 l=0.15
X504 a_17834_n300# a_16600_714# a_18014_614# vss sky130_fd_pr__nfet_01v8_lvt ad=1.24 pd=8.62 as=0.66 ps=4.33 w=4 l=0.15
X505 a_18014_614# a_16600_714# a_17834_n300# vss sky130_fd_pr__nfet_01v8_lvt ad=0.66 pd=4.33 as=0.66 ps=4.33 w=4 l=0.15
X506 a_7124_1728# a_7216_1728# a_7153_1640# vss sky130_fd_pr__nfet_01v8_lvt ad=0.825 pd=5.33 as=0.825 ps=5.33 w=5 l=0.15
X507 a_7036_n300# a_8917_526# a_7124_1728# vss sky130_fd_pr__nfet_01v8_lvt ad=0.66 pd=4.33 as=0.66 ps=4.33 w=4 l=0.15
X508 a_n3290_1728# a_n3198_1728# a_n3261_1640# vss sky130_fd_pr__nfet_01v8_lvt ad=1.55 pd=10.62 as=0.825 ps=5.33 w=5 l=0.15
X509 a_11114_1728# q4n q4p vss sky130_fd_pr__nfet_01v8_lvt ad=0.825 pd=5.33 as=0.825 ps=5.33 w=5 l=0.15
X510 a_18014_614# a_16600_714# a_17834_n300# vss sky130_fd_pr__nfet_01v8_lvt ad=0.66 pd=4.33 as=0.66 ps=4.33 w=4 l=0.15
X511 a_11026_n300# a_n3862_n388# vss vss sky130_fd_pr__nfet_01v8 ad=0.435 pd=3.29 as=0.435 ps=3.29 w=3 l=0.5
X512 a_5831_626# q2n a_5722_n300# vss sky130_fd_pr__nfet_01v8_lvt ad=0.495 pd=3.33 as=0.495 ps=3.33 w=3 l=0.15
X513 a_408_614# a_n4996_714# a_228_n300# vss sky130_fd_pr__nfet_01v8_lvt ad=0.66 pd=4.33 as=0.66 ps=4.33 w=4 l=0.15
X514 a_5802_714# a_5831_626# vdd vss sky130_fd_pr__nfet_01v8_lvt ad=0.825 pd=5.33 as=0.825 ps=5.33 w=5 l=0.15
X515 vss a_n3862_n388# a_228_n300# vss sky130_fd_pr__nfet_01v8 ad=0.435 pd=3.29 as=0.435 ps=3.29 w=3 l=0.5
X516 a_n3762_n300# a_n3862_n388# vss vss sky130_fd_pr__nfet_01v8 ad=0.435 pd=3.29 as=0.435 ps=3.29 w=3 l=0.5
X517 a_7036_n300# a_n3862_n388# vss vss sky130_fd_pr__nfet_01v8 ad=0.435 pd=3.29 as=0.435 ps=3.29 w=3 l=0.5
X518 q4n q4p a_11114_1728# vss sky130_fd_pr__nfet_01v8_lvt ad=0.825 pd=5.33 as=0.825 ps=5.33 w=5 l=0.15
X519 a_17834_n300# a_n3862_n388# vss vss sky130_fd_pr__nfet_01v8 ad=0.435 pd=3.29 as=0.435 ps=3.29 w=3 l=0.5
X520 a_228_n300# a_n4996_714# a_408_614# vss sky130_fd_pr__nfet_01v8_lvt ad=0.66 pd=4.33 as=0.66 ps=4.33 w=4 l=0.15
X521 a_16600_714# vbias vss vss sky130_fd_pr__nfet_01v8 ad=1.16 pd=8.58 as=1.16 ps=8.58 w=4 l=0.5
X522 vss a_n3862_n388# a_21824_n300# vss sky130_fd_pr__nfet_01v8 ad=0.435 pd=3.29 as=0.435 ps=3.29 w=3 l=0.5
X523 a_408_614# a_n4996_714# a_228_n300# vss sky130_fd_pr__nfet_01v8_lvt ad=0.66 pd=4.33 as=0.66 ps=4.33 w=4 l=0.15
X524 q8n a_17951_1640# a_22730_3042# vss sky130_fd_pr__nfet_01v8_lvt ad=0.825 pd=5.33 as=0.825 ps=5.33 w=5 l=0.15
X525 a_22730_3042# a_18014_1728# q8p vss sky130_fd_pr__nfet_01v8_lvt ad=1.55 pd=10.62 as=0.825 ps=5.33 w=5 l=0.15
X526 q2n a_n3261_1640# a_1134_3042# vss sky130_fd_pr__nfet_01v8_lvt ad=0.825 pd=5.33 as=1.55 ps=10.62 w=5 l=0.15
X527 a_408_614# a_n4996_714# a_228_n300# vss sky130_fd_pr__nfet_01v8_lvt ad=0.66 pd=4.33 as=1.24 ps=8.62 w=4 l=0.15
X528 a_228_n300# a_n4996_714# a_408_614# vss sky130_fd_pr__nfet_01v8_lvt ad=0.66 pd=4.33 as=0.66 ps=4.33 w=4 l=0.15
X529 a_7036_n300# a_n3862_n388# vss vss sky130_fd_pr__nfet_01v8 ad=0.435 pd=3.29 as=0.435 ps=3.29 w=3 l=0.5
X530 a_1134_3042# a_n3198_1728# q2p vss sky130_fd_pr__nfet_01v8_lvt ad=0.825 pd=5.33 as=0.825 ps=5.33 w=5 l=0.15
X531 a_408_614# a_n4996_714# a_228_n300# vss sky130_fd_pr__nfet_01v8_lvt ad=0.66 pd=4.33 as=0.66 ps=4.33 w=4 l=0.15
X532 a_13437_4312# q2p a_5722_n300# vss sky130_fd_pr__nfet_01v8_lvt ad=0.495 pd=3.33 as=0.495 ps=3.33 w=3 l=0.15
X533 a_7216_1728# a_7153_1640# a_7124_1728# vss sky130_fd_pr__nfet_01v8_lvt ad=0.825 pd=5.33 as=0.825 ps=5.33 w=5 l=0.15
X534 vss a_n3862_n388# a_7036_n300# vss sky130_fd_pr__nfet_01v8 ad=0.435 pd=3.29 as=0.435 ps=3.29 w=3 l=0.5
X535 vdd a_16629_626# a_16600_714# vss sky130_fd_pr__nfet_01v8_lvt ad=0.825 pd=5.33 as=0.825 ps=5.33 w=5 l=0.15
X536 q2p q2n a_408_614# vss sky130_fd_pr__nfet_01v8_lvt ad=0.825 pd=5.33 as=0.825 ps=5.33 w=5 l=0.15
X537 a_11114_1728# q4p q4n vss sky130_fd_pr__nfet_01v8_lvt ad=0.825 pd=5.33 as=0.825 ps=5.33 w=5 l=0.15
X538 a_18014_1728# a_17951_1640# a_17922_1728# vss sky130_fd_pr__nfet_01v8_lvt ad=0.825 pd=5.33 as=1.55 ps=10.62 w=5 l=0.15
X539 vdd a_7153_1640# vss sky130_fd_pr__res_high_po_2p85 l=4.14
X540 a_228_n300# a_n4996_714# a_408_614# vss sky130_fd_pr__nfet_01v8_lvt ad=0.66 pd=4.33 as=0.66 ps=4.33 w=4 l=0.15
X541 vdd a_13437_4312# a_8917_526# vss sky130_fd_pr__nfet_01v8_lvt ad=0.825 pd=5.33 as=1.55 ps=10.62 w=5 l=0.15
X542 vss a_n3862_n388# a_21824_n300# vss sky130_fd_pr__nfet_01v8 ad=0.435 pd=3.29 as=0.435 ps=3.29 w=3 l=0.5
X543 vss a_n3862_n388# a_21824_n300# vss sky130_fd_pr__nfet_01v8 ad=0.435 pd=3.29 as=0.435 ps=3.29 w=3 l=0.5
X544 vss a_n3862_n388# a_228_n300# vss sky130_fd_pr__nfet_01v8 ad=0.87 pd=6.58 as=0.435 ps=3.29 w=3 l=0.5
X545 a_7124_1728# a_7153_1640# a_7216_1728# vss sky130_fd_pr__nfet_01v8_lvt ad=1.55 pd=10.62 as=0.825 ps=5.33 w=5 l=0.15
X546 a_n3762_n300# a_n3862_n388# vss vss sky130_fd_pr__nfet_01v8 ad=0.435 pd=3.29 as=0.87 ps=6.58 w=3 l=0.5
X547 a_19715_526# a_24235_4312# vdd vss sky130_fd_pr__nfet_01v8_lvt ad=0.825 pd=5.33 as=0.825 ps=5.33 w=5 l=0.15
X548 a_21912_1728# q8p q8n vss sky130_fd_pr__nfet_01v8_lvt ad=0.825 pd=5.33 as=0.825 ps=5.33 w=5 l=0.15
X549 a_17922_1728# a_17951_1640# a_18014_1728# vss sky130_fd_pr__nfet_01v8_lvt ad=0.825 pd=5.33 as=0.825 ps=5.33 w=5 l=0.15
X550 a_7216_1728# q4n a_7216_614# vss sky130_fd_pr__nfet_01v8_lvt ad=0.825 pd=5.33 as=1.55 ps=10.62 w=5 l=0.15
X551 a_17834_n300# a_n3862_n388# vss vss sky130_fd_pr__nfet_01v8 ad=0.435 pd=3.29 as=0.435 ps=3.29 w=3 l=0.5
X552 a_5802_714# a_5831_626# vdd vss sky130_fd_pr__nfet_01v8_lvt ad=0.825 pd=5.33 as=0.825 ps=5.33 w=5 l=0.15
X553 a_19715_526# a_24235_4312# vdd vss sky130_fd_pr__nfet_01v8_lvt ad=0.825 pd=5.33 as=0.825 ps=5.33 w=5 l=0.15
X554 a_21912_1728# a_16600_714# a_21824_n300# vss sky130_fd_pr__nfet_01v8_lvt ad=0.66 pd=4.33 as=1.24 ps=8.62 w=4 l=0.15
X555 a_17951_1640# a_18014_1728# a_17922_1728# vss sky130_fd_pr__nfet_01v8_lvt ad=0.825 pd=5.33 as=0.825 ps=5.33 w=5 l=0.15
X556 a_7153_1640# a_7216_1728# a_7124_1728# vss sky130_fd_pr__nfet_01v8_lvt ad=0.825 pd=5.33 as=0.825 ps=5.33 w=5 l=0.15
X557 a_7153_1640# a_7216_1728# a_7124_1728# vss sky130_fd_pr__nfet_01v8_lvt ad=0.825 pd=5.33 as=0.825 ps=5.33 w=5 l=0.15
X558 a_17951_1640# a_18014_1728# a_17922_1728# vss sky130_fd_pr__nfet_01v8_lvt ad=0.825 pd=5.33 as=0.825 ps=5.33 w=5 l=0.15
X559 vdd a_24235_4312# a_19715_526# vss sky130_fd_pr__nfet_01v8_lvt ad=0.825 pd=5.33 as=1.55 ps=10.62 w=5 l=0.15
X560 a_n3290_1728# a_n1881_526# a_n3762_n300# vss sky130_fd_pr__nfet_01v8_lvt ad=0.66 pd=4.33 as=0.66 ps=4.33 w=4 l=0.15
X561 vss a_n3862_n388# a_17834_n300# vss sky130_fd_pr__nfet_01v8 ad=0.435 pd=3.29 as=0.435 ps=3.29 w=3 l=0.5
X562 a_5722_n300# q2n a_5831_626# vss sky130_fd_pr__nfet_01v8_lvt ad=0.495 pd=3.33 as=0.495 ps=3.33 w=3 l=0.15
X563 vss a_n3862_n388# a_11026_n300# vss sky130_fd_pr__nfet_01v8 ad=0.435 pd=3.29 as=0.435 ps=3.29 w=3 l=0.5
X564 a_11026_n300# a_n3862_n388# vss vss sky130_fd_pr__nfet_01v8 ad=0.435 pd=3.29 as=0.435 ps=3.29 w=3 l=0.5
X565 a_21912_1728# q8n q8p vss sky130_fd_pr__nfet_01v8_lvt ad=0.825 pd=5.33 as=0.825 ps=5.33 w=5 l=0.15
X566 a_18014_1728# a_17951_1640# a_17922_1728# vss sky130_fd_pr__nfet_01v8_lvt ad=0.825 pd=5.33 as=0.825 ps=5.33 w=5 l=0.15
X567 a_18014_1728# q8n a_18014_614# vss sky130_fd_pr__nfet_01v8_lvt ad=0.825 pd=5.33 as=0.825 ps=5.33 w=5 l=0.15
X568 a_17951_1640# q8p a_18014_614# vss sky130_fd_pr__nfet_01v8_lvt ad=0.825 pd=5.33 as=0.825 ps=5.33 w=5 l=0.15
X569 a_408_614# q2n q2p vss sky130_fd_pr__nfet_01v8_lvt ad=0.825 pd=5.33 as=0.825 ps=5.33 w=5 l=0.15
X570 a_7153_1640# q4p a_7216_614# vss sky130_fd_pr__nfet_01v8_lvt ad=0.825 pd=5.33 as=1.55 ps=10.62 w=5 l=0.15
X571 vdd a_16629_626# a_16600_714# vss sky130_fd_pr__nfet_01v8_lvt ad=0.825 pd=5.33 as=1.55 ps=10.62 w=5 l=0.15
X572 vdd a_24235_4312# vss sky130_fd_pr__res_high_po_2p85 l=4.14
X573 a_n3762_n300# a_n1881_526# a_n3290_1728# vss sky130_fd_pr__nfet_01v8_lvt ad=0.66 pd=4.33 as=0.66 ps=4.33 w=4 l=0.15
X574 a_11114_1728# q4n q4p vss sky130_fd_pr__nfet_01v8_lvt ad=0.825 pd=5.33 as=0.825 ps=5.33 w=5 l=0.15
X575 a_n3762_n300# a_n1881_526# a_n3290_1728# vss sky130_fd_pr__nfet_01v8_lvt ad=0.66 pd=4.33 as=0.66 ps=4.33 w=4 l=0.15
X576 a_n3290_1728# a_n1881_526# a_n3762_n300# vss sky130_fd_pr__nfet_01v8_lvt ad=0.66 pd=4.33 as=0.66 ps=4.33 w=4 l=0.15
X577 vss a_n3862_n388# a_21824_n300# vss sky130_fd_pr__nfet_01v8 ad=0.435 pd=3.29 as=0.435 ps=3.29 w=3 l=0.5
X578 a_n3290_1728# a_n1881_526# a_n3762_n300# vss sky130_fd_pr__nfet_01v8_lvt ad=0.66 pd=4.33 as=0.66 ps=4.33 w=4 l=0.15
X579 a_228_n300# a_n4996_714# a_408_614# vss sky130_fd_pr__nfet_01v8_lvt ad=0.66 pd=4.33 as=0.66 ps=4.33 w=4 l=0.15
X580 a_n3862_n388# a_n5001_4543# vdd vdd sky130_fd_pr__pfet_01v8 ad=0.87 pd=6.29 as=0.87 ps=6.29 w=6 l=0.5
X581 a_n3762_n300# a_n1881_526# a_n3290_1728# vss sky130_fd_pr__nfet_01v8_lvt ad=0.66 pd=4.33 as=0.66 ps=4.33 w=4 l=0.15
X582 a_n3290_1728# a_n1881_526# a_n3762_n300# vss sky130_fd_pr__nfet_01v8_lvt ad=0.66 pd=4.33 as=0.66 ps=4.33 w=4 l=0.15
X583 vdd a_n5001_4543# a_n5001_4543# vdd sky130_fd_pr__pfet_01v8 ad=0.87 pd=6.29 as=0.87 ps=6.29 w=6 l=0.5
X584 vdd clkp a_n4996_714# vss sky130_fd_pr__nfet_01v8_lvt ad=0.825 pd=5.33 as=0.825 ps=5.33 w=5 l=0.15
X585 a_1134_3042# a_n3261_1640# q2n vss sky130_fd_pr__nfet_01v8_lvt ad=1.55 pd=10.62 as=0.825 ps=5.33 w=5 l=0.15
X586 a_16629_626# q4n a_16520_n300# vss sky130_fd_pr__nfet_01v8_lvt ad=0.495 pd=3.33 as=0.495 ps=3.33 w=3 l=0.15
X587 a_19715_526# a_24235_4312# vdd vss sky130_fd_pr__nfet_01v8_lvt ad=0.825 pd=5.33 as=0.825 ps=5.33 w=5 l=0.15
X588 a_16600_714# a_16629_626# vdd vss sky130_fd_pr__nfet_01v8_lvt ad=1.55 pd=10.62 as=0.825 ps=5.33 w=5 l=0.15
X589 vss a_n3862_n388# a_17834_n300# vss sky130_fd_pr__nfet_01v8 ad=0.435 pd=3.29 as=0.435 ps=3.29 w=3 l=0.5
X590 a_21912_1728# q8p q8n vss sky130_fd_pr__nfet_01v8_lvt ad=0.825 pd=5.33 as=0.825 ps=5.33 w=5 l=0.15
X591 a_228_n300# a_n4996_714# a_408_614# vss sky130_fd_pr__nfet_01v8_lvt ad=0.66 pd=4.33 as=0.66 ps=4.33 w=4 l=0.15
X592 a_11026_n300# a_n3862_n388# vss vss sky130_fd_pr__nfet_01v8 ad=0.435 pd=3.29 as=0.435 ps=3.29 w=3 l=0.5
X593 a_408_614# q2p q2n vss sky130_fd_pr__nfet_01v8_lvt ad=1.55 pd=10.62 as=0.825 ps=5.33 w=5 l=0.15
X594 a_n3762_n300# a_n1881_526# a_n3290_1728# vss sky130_fd_pr__nfet_01v8_lvt ad=0.66 pd=4.33 as=0.66 ps=4.33 w=4 l=0.15
X595 a_408_614# a_n4996_714# a_228_n300# vss sky130_fd_pr__nfet_01v8_lvt ad=0.66 pd=4.33 as=0.66 ps=4.33 w=4 l=0.15
X596 a_16520_n300# vbias vss vss sky130_fd_pr__nfet_01v8 ad=0.435 pd=3.29 as=0.87 ps=6.58 w=3 l=0.5
X597 a_n3290_1728# a_n1881_526# a_n3762_n300# vss sky130_fd_pr__nfet_01v8_lvt ad=0.66 pd=4.33 as=1.24 ps=8.62 w=4 l=0.15
X598 a_7036_n300# a_n3862_n388# vss vss sky130_fd_pr__nfet_01v8 ad=0.435 pd=3.29 as=0.435 ps=3.29 w=3 l=0.5
X599 a_17922_1728# a_18014_1728# a_17951_1640# vss sky130_fd_pr__nfet_01v8_lvt ad=0.825 pd=5.33 as=0.825 ps=5.33 w=5 l=0.15
X600 a_7124_1728# a_7216_1728# a_7153_1640# vss sky130_fd_pr__nfet_01v8_lvt ad=0.825 pd=5.33 as=0.825 ps=5.33 w=5 l=0.15
X601 a_22730_3042# a_18014_1728# q8p vss sky130_fd_pr__nfet_01v8_lvt ad=0.825 pd=5.33 as=0.825 ps=5.33 w=5 l=0.15
X602 a_n3582_614# q2n a_n3198_1728# vss sky130_fd_pr__nfet_01v8_lvt ad=1.55 pd=10.62 as=0.825 ps=5.33 w=5 l=0.15
X603 a_13437_4312# q2p a_5722_n300# vss sky130_fd_pr__nfet_01v8_lvt ad=0.495 pd=3.33 as=0.93 ps=6.62 w=3 l=0.15
X604 a_n3261_1640# q2p a_n3582_614# vss sky130_fd_pr__nfet_01v8_lvt ad=0.825 pd=5.33 as=0.825 ps=5.33 w=5 l=0.15
X605 a_408_614# a_n4996_714# a_228_n300# vss sky130_fd_pr__nfet_01v8_lvt ad=0.66 pd=4.33 as=0.66 ps=4.33 w=4 l=0.15
X606 a_16520_n300# vbias vss vss sky130_fd_pr__nfet_01v8 ad=0.435 pd=3.29 as=0.87 ps=6.58 w=3 l=0.5
X607 vss a_n3862_n388# a_11026_n300# vss sky130_fd_pr__nfet_01v8 ad=0.435 pd=3.29 as=0.435 ps=3.29 w=3 l=0.5
X608 a_228_n300# a_n4996_714# a_408_614# vss sky130_fd_pr__nfet_01v8_lvt ad=0.66 pd=4.33 as=0.66 ps=4.33 w=4 l=0.15
X609 a_408_614# a_n4996_714# a_228_n300# vss sky130_fd_pr__nfet_01v8_lvt ad=0.66 pd=4.33 as=0.66 ps=4.33 w=4 l=0.15
X610 vss a_n3862_n388# a_21824_n300# vss sky130_fd_pr__nfet_01v8 ad=0.435 pd=3.29 as=0.435 ps=3.29 w=3 l=0.5
X611 a_n3762_n300# a_n4996_714# a_n3582_614# vss sky130_fd_pr__nfet_01v8_lvt ad=1.24 pd=8.62 as=0.66 ps=4.33 w=4 l=0.15
X612 a_16520_n300# q4p a_24235_4312# vss sky130_fd_pr__nfet_01v8_lvt ad=0.495 pd=3.33 as=0.495 ps=3.33 w=3 l=0.15
X613 a_228_n300# a_n3862_n388# vss vss sky130_fd_pr__nfet_01v8 ad=0.435 pd=3.29 as=0.435 ps=3.29 w=3 l=0.5
X614 a_n3862_n388# a_n3862_n388# vss vss sky130_fd_pr__nfet_01v8 ad=1.16 pd=8.58 as=0.58 ps=4.29 w=4 l=0.5
X615 a_n3762_n300# a_n1881_526# a_n3290_1728# vss sky130_fd_pr__nfet_01v8_lvt ad=0.66 pd=4.33 as=0.66 ps=4.33 w=4 l=0.15
X616 q4n a_7153_1640# a_11932_3042# vss sky130_fd_pr__nfet_01v8_lvt ad=0.825 pd=5.33 as=0.825 ps=5.33 w=5 l=0.15
X617 vss a_n3862_n388# a_n3762_n300# vss sky130_fd_pr__nfet_01v8 ad=0.435 pd=3.29 as=0.435 ps=3.29 w=3 l=0.5
X618 q8n q8p a_21912_1728# vss sky130_fd_pr__nfet_01v8_lvt ad=0.825 pd=5.33 as=0.825 ps=5.33 w=5 l=0.15
X619 a_5722_n300# q2n a_5831_626# vss sky130_fd_pr__nfet_01v8_lvt ad=0.495 pd=3.33 as=0.495 ps=3.33 w=3 l=0.15
X620 a_11932_3042# a_7216_1728# q4p vss sky130_fd_pr__nfet_01v8_lvt ad=1.55 pd=10.62 as=0.825 ps=5.33 w=5 l=0.15
X621 a_18014_1728# a_17951_1640# a_17922_1728# vss sky130_fd_pr__nfet_01v8_lvt ad=0.825 pd=5.33 as=0.825 ps=5.33 w=5 l=0.15
X622 vss a_n3862_n388# a_17834_n300# vss sky130_fd_pr__nfet_01v8 ad=0.435 pd=3.29 as=0.435 ps=3.29 w=3 l=0.5
X623 vdd clkn a_n1881_526# vss sky130_fd_pr__nfet_01v8_lvt ad=0.825 pd=5.33 as=0.825 ps=5.33 w=5 l=0.15
X624 a_408_614# a_n4996_714# a_228_n300# vss sky130_fd_pr__nfet_01v8_lvt ad=0.66 pd=4.33 as=0.66 ps=4.33 w=4 l=0.15
X625 a_n3762_n300# a_n3862_n388# vss vss sky130_fd_pr__nfet_01v8 ad=0.435 pd=3.29 as=0.435 ps=3.29 w=3 l=0.5
X626 a_17834_n300# a_n3862_n388# vss vss sky130_fd_pr__nfet_01v8 ad=0.435 pd=3.29 as=0.435 ps=3.29 w=3 l=0.5
X627 q2n q2p a_408_614# vss sky130_fd_pr__nfet_01v8_lvt ad=0.825 pd=5.33 as=0.825 ps=5.33 w=5 l=0.15
X628 a_228_n300# a_n4996_714# a_408_614# vss sky130_fd_pr__nfet_01v8_lvt ad=0.66 pd=4.33 as=0.66 ps=4.33 w=4 l=0.15
X629 a_n3762_n300# a_n4996_714# a_n3582_614# vss sky130_fd_pr__nfet_01v8_lvt ad=0.66 pd=4.33 as=0.66 ps=4.33 w=4 l=0.15
X630 a_n3290_1728# a_n1881_526# a_n3762_n300# vss sky130_fd_pr__nfet_01v8_lvt ad=0.66 pd=4.33 as=0.66 ps=4.33 w=4 l=0.15
X631 a_n3582_614# a_n4996_714# a_n3762_n300# vss sky130_fd_pr__nfet_01v8_lvt ad=0.66 pd=4.33 as=0.66 ps=4.33 w=4 l=0.15
X632 a_n3762_n300# a_n1881_526# a_n3290_1728# vss sky130_fd_pr__nfet_01v8_lvt ad=0.66 pd=4.33 as=0.66 ps=4.33 w=4 l=0.15
X633 a_7124_1728# a_7153_1640# a_7216_1728# vss sky130_fd_pr__nfet_01v8_lvt ad=0.825 pd=5.33 as=0.825 ps=5.33 w=5 l=0.15
X634 a_17834_n300# a_19715_526# a_17922_1728# vss sky130_fd_pr__nfet_01v8_lvt ad=0.66 pd=4.33 as=0.66 ps=4.33 w=4 l=0.15
X635 a_17922_1728# a_17951_1640# a_18014_1728# vss sky130_fd_pr__nfet_01v8_lvt ad=0.825 pd=5.33 as=0.825 ps=5.33 w=5 l=0.15
X636 a_228_n300# a_n4996_714# a_408_614# vss sky130_fd_pr__nfet_01v8_lvt ad=1.24 pd=8.62 as=0.66 ps=4.33 w=4 l=0.15
X637 vdd q2n vss sky130_fd_pr__res_high_po_2p85 l=4.14
X638 a_n3582_614# a_n4996_714# a_n3762_n300# vss sky130_fd_pr__nfet_01v8_lvt ad=0.66 pd=4.33 as=0.66 ps=4.33 w=4 l=0.15
X639 a_n3762_n300# a_n1881_526# a_n3290_1728# vss sky130_fd_pr__nfet_01v8_lvt ad=0.66 pd=4.33 as=0.66 ps=4.33 w=4 l=0.15
X640 a_n3582_614# a_n4996_714# a_n3762_n300# vss sky130_fd_pr__nfet_01v8_lvt ad=0.66 pd=4.33 as=0.66 ps=4.33 w=4 l=0.15
X641 a_n3762_n300# a_n4996_714# a_n3582_614# vss sky130_fd_pr__nfet_01v8_lvt ad=0.66 pd=4.33 as=0.66 ps=4.33 w=4 l=0.15
X642 a_n3290_1728# a_n1881_526# a_n3762_n300# vss sky130_fd_pr__nfet_01v8_lvt ad=0.66 pd=4.33 as=0.66 ps=4.33 w=4 l=0.15
X643 vss a_n3862_n388# a_11026_n300# vss sky130_fd_pr__nfet_01v8 ad=0.435 pd=3.29 as=0.435 ps=3.29 w=3 l=0.5
X644 vdd a_n3261_1640# vss sky130_fd_pr__res_high_po_2p85 l=4.14
X645 a_16629_626# q4n a_16520_n300# vss sky130_fd_pr__nfet_01v8_lvt ad=0.495 pd=3.33 as=0.93 ps=6.62 w=3 l=0.15
X646 vss a_n3862_n388# a_228_n300# vss sky130_fd_pr__nfet_01v8 ad=0.435 pd=3.29 as=0.435 ps=3.29 w=3 l=0.5
X647 a_11026_n300# a_n3862_n388# vss vss sky130_fd_pr__nfet_01v8 ad=0.435 pd=3.29 as=0.435 ps=3.29 w=3 l=0.5
X648 a_7036_n300# a_n3862_n388# vss vss sky130_fd_pr__nfet_01v8 ad=0.435 pd=3.29 as=0.87 ps=6.58 w=3 l=0.5
X649 a_7216_614# q4p a_7153_1640# vss sky130_fd_pr__nfet_01v8_lvt ad=1.55 pd=10.62 as=0.825 ps=5.33 w=5 l=0.15
X650 vss a_n3862_n388# a_11026_n300# vss sky130_fd_pr__nfet_01v8 ad=0.435 pd=3.29 as=0.435 ps=3.29 w=3 l=0.5
X651 a_16600_714# a_16629_626# vdd vss sky130_fd_pr__nfet_01v8_lvt ad=0.825 pd=5.33 as=0.825 ps=5.33 w=5 l=0.15
X652 a_1134_3042# a_n1881_526# a_228_n300# vss sky130_fd_pr__nfet_01v8_lvt ad=0.66 pd=4.33 as=1.24 ps=8.62 w=4 l=0.15
X653 q4p q4n a_11114_1728# vss sky130_fd_pr__nfet_01v8_lvt ad=0.825 pd=5.33 as=0.825 ps=5.33 w=5 l=0.15
X654 a_22730_3042# a_19715_526# a_21824_n300# vss sky130_fd_pr__nfet_01v8_lvt ad=0.66 pd=4.33 as=0.66 ps=4.33 w=4 l=0.15
X655 a_n3582_614# a_n4996_714# a_n3762_n300# vss sky130_fd_pr__nfet_01v8_lvt ad=0.66 pd=4.33 as=0.66 ps=4.33 w=4 l=0.15
X656 a_228_n300# a_n1881_526# a_1134_3042# vss sky130_fd_pr__nfet_01v8_lvt ad=0.66 pd=4.33 as=0.66 ps=4.33 w=4 l=0.15
X657 a_n3762_n300# a_n4996_714# a_n3582_614# vss sky130_fd_pr__nfet_01v8_lvt ad=0.66 pd=4.33 as=0.66 ps=4.33 w=4 l=0.15
X658 a_17834_n300# a_16600_714# a_18014_614# vss sky130_fd_pr__nfet_01v8_lvt ad=0.66 pd=4.33 as=0.66 ps=4.33 w=4 l=0.15
X659 a_21912_1728# q8n q8p vss sky130_fd_pr__nfet_01v8_lvt ad=0.825 pd=5.33 as=0.825 ps=5.33 w=5 l=0.15
X660 vdd a_n5001_4543# a_n3862_n388# vdd sky130_fd_pr__pfet_01v8 ad=0.87 pd=6.29 as=0.87 ps=6.29 w=6 l=0.5
X661 a_21824_n300# a_n3862_n388# vss vss sky130_fd_pr__nfet_01v8 ad=0.435 pd=3.29 as=0.435 ps=3.29 w=3 l=0.5
X662 a_n3862_n388# a_n5001_4543# vdd vdd sky130_fd_pr__pfet_01v8 ad=0.87 pd=6.29 as=0.87 ps=6.29 w=6 l=0.5
X663 a_1134_3042# a_n1881_526# a_228_n300# vss sky130_fd_pr__nfet_01v8_lvt ad=0.66 pd=4.33 as=0.66 ps=4.33 w=4 l=0.15
X664 a_228_n300# a_n1881_526# a_1134_3042# vss sky130_fd_pr__nfet_01v8_lvt ad=0.66 pd=4.33 as=0.66 ps=4.33 w=4 l=0.15
X665 vss a_n3862_n388# a_21824_n300# vss sky130_fd_pr__nfet_01v8 ad=0.435 pd=3.29 as=0.435 ps=3.29 w=3 l=0.5
X666 a_n5001_4543# a_n5001_4543# vdd vdd sky130_fd_pr__pfet_01v8 ad=0.87 pd=6.29 as=0.87 ps=6.29 w=6 l=0.5
X667 a_n4996_714# clkp vdd vss sky130_fd_pr__nfet_01v8_lvt ad=0.825 pd=5.33 as=0.825 ps=5.33 w=5 l=0.15
X668 a_n3762_n300# a_n4996_714# a_n3582_614# vss sky130_fd_pr__nfet_01v8_lvt ad=0.66 pd=4.33 as=0.66 ps=4.33 w=4 l=0.15
X669 a_1134_3042# a_n1881_526# a_228_n300# vss sky130_fd_pr__nfet_01v8_lvt ad=0.66 pd=4.33 as=0.66 ps=4.33 w=4 l=0.15
X670 vdd a_n5001_4543# a_n5001_4543# vdd sky130_fd_pr__pfet_01v8 ad=0.87 pd=6.29 as=0.87 ps=6.29 w=6 l=0.5
X671 a_n3290_1728# a_n3261_1640# a_n3198_1728# vss sky130_fd_pr__nfet_01v8_lvt ad=1.55 pd=10.62 as=0.825 ps=5.33 w=5 l=0.15
X672 a_16520_n300# q4n a_16629_626# vss sky130_fd_pr__nfet_01v8_lvt ad=0.93 pd=6.62 as=0.495 ps=3.33 w=3 l=0.15
X673 a_18014_614# a_16600_714# a_17834_n300# vss sky130_fd_pr__nfet_01v8_lvt ad=0.66 pd=4.33 as=0.66 ps=4.33 w=4 l=0.15
X674 a_17834_n300# a_16600_714# a_18014_614# vss sky130_fd_pr__nfet_01v8_lvt ad=0.66 pd=4.33 as=0.66 ps=4.33 w=4 l=0.15
X675 a_16600_714# a_16629_626# vdd vss sky130_fd_pr__nfet_01v8_lvt ad=0.825 pd=5.33 as=0.825 ps=5.33 w=5 l=0.15
X676 a_16520_n300# q4p a_24235_4312# vss sky130_fd_pr__nfet_01v8_lvt ad=0.495 pd=3.33 as=0.495 ps=3.33 w=3 l=0.15
X677 a_11114_1728# q4n q4p vss sky130_fd_pr__nfet_01v8_lvt ad=0.825 pd=5.33 as=0.825 ps=5.33 w=5 l=0.15
X678 a_21824_n300# a_19715_526# a_22730_3042# vss sky130_fd_pr__nfet_01v8_lvt ad=1.24 pd=8.62 as=0.66 ps=4.33 w=4 l=0.15
X679 a_228_n300# a_n1881_526# a_1134_3042# vss sky130_fd_pr__nfet_01v8_lvt ad=0.66 pd=4.33 as=0.66 ps=4.33 w=4 l=0.15
X680 a_18014_614# q8n a_18014_1728# vss sky130_fd_pr__nfet_01v8_lvt ad=1.55 pd=10.62 as=0.825 ps=5.33 w=5 l=0.15
X681 a_1134_3042# a_n1881_526# a_228_n300# vss sky130_fd_pr__nfet_01v8_lvt ad=0.66 pd=4.33 as=0.66 ps=4.33 w=4 l=0.15
X682 a_7036_n300# a_n3862_n388# vss vss sky130_fd_pr__nfet_01v8 ad=0.435 pd=3.29 as=0.435 ps=3.29 w=3 l=0.5
X683 a_17951_1640# a_18014_1728# a_17922_1728# vss sky130_fd_pr__nfet_01v8_lvt ad=0.825 pd=5.33 as=0.825 ps=5.33 w=5 l=0.15
X684 a_228_n300# a_n1881_526# a_1134_3042# vss sky130_fd_pr__nfet_01v8_lvt ad=0.66 pd=4.33 as=0.66 ps=4.33 w=4 l=0.15
X685 a_n3762_n300# a_n3862_n388# vss vss sky130_fd_pr__nfet_01v8 ad=0.435 pd=3.29 as=0.435 ps=3.29 w=3 l=0.5
X686 a_228_n300# a_n3862_n388# vss vss sky130_fd_pr__nfet_01v8 ad=0.435 pd=3.29 as=0.435 ps=3.29 w=3 l=0.5
X687 a_18014_614# a_16600_714# a_17834_n300# vss sky130_fd_pr__nfet_01v8_lvt ad=0.66 pd=4.33 as=0.66 ps=4.33 w=4 l=0.15
X688 a_7153_1640# a_7216_1728# a_7124_1728# vss sky130_fd_pr__nfet_01v8_lvt ad=0.825 pd=5.33 as=0.825 ps=5.33 w=5 l=0.15
X689 a_17834_n300# a_16600_714# a_18014_614# vss sky130_fd_pr__nfet_01v8_lvt ad=0.66 pd=4.33 as=0.66 ps=4.33 w=4 l=0.15
X690 a_16600_714# a_16629_626# vdd vss sky130_fd_pr__nfet_01v8_lvt ad=1.55 pd=10.62 as=0.825 ps=5.33 w=5 l=0.15
X691 vdd a_16629_626# a_16600_714# vss sky130_fd_pr__nfet_01v8_lvt ad=0.825 pd=5.33 as=0.825 ps=5.33 w=5 l=0.15
X692 vdd a_13437_4312# vss sky130_fd_pr__res_high_po_2p85 l=4.14
X693 a_18014_614# a_16600_714# a_17834_n300# vss sky130_fd_pr__nfet_01v8_lvt ad=0.66 pd=4.33 as=0.66 ps=4.33 w=4 l=0.15
X694 a_5802_714# vbias vss vss sky130_fd_pr__nfet_01v8 ad=1.16 pd=8.58 as=1.16 ps=8.58 w=4 l=0.5
X695 a_n3198_1728# a_n3261_1640# a_n3290_1728# vss sky130_fd_pr__nfet_01v8_lvt ad=0.825 pd=5.33 as=1.55 ps=10.62 w=5 l=0.15
X696 a_1134_3042# a_n1881_526# a_228_n300# vss sky130_fd_pr__nfet_01v8_lvt ad=0.66 pd=4.33 as=0.66 ps=4.33 w=4 l=0.15
X697 vss a_n3862_n388# a_n3862_n388# vss sky130_fd_pr__nfet_01v8 ad=0.58 pd=4.29 as=0.58 ps=4.29 w=4 l=0.5
X698 a_18014_614# a_16600_714# a_17834_n300# vss sky130_fd_pr__nfet_01v8_lvt ad=0.66 pd=4.33 as=0.66 ps=4.33 w=4 l=0.15
X699 a_17834_n300# a_16600_714# a_18014_614# vss sky130_fd_pr__nfet_01v8_lvt ad=0.66 pd=4.33 as=0.66 ps=4.33 w=4 l=0.15
X700 vdd a_16629_626# a_16600_714# vss sky130_fd_pr__nfet_01v8_lvt ad=0.825 pd=5.33 as=0.825 ps=5.33 w=5 l=0.15
X701 vdd a_5831_626# a_5802_714# vss sky130_fd_pr__nfet_01v8_lvt ad=0.825 pd=5.33 as=0.825 ps=5.33 w=5 l=0.15
X702 a_18014_614# a_16600_714# a_17834_n300# vss sky130_fd_pr__nfet_01v8_lvt ad=0.66 pd=4.33 as=0.66 ps=4.33 w=4 l=0.15
X703 a_7124_1728# a_8917_526# a_7036_n300# vss sky130_fd_pr__nfet_01v8_lvt ad=0.66 pd=4.33 as=0.66 ps=4.33 w=4 l=0.15
X704 a_228_n300# a_n3862_n388# vss vss sky130_fd_pr__nfet_01v8 ad=0.435 pd=3.29 as=0.435 ps=3.29 w=3 l=0.5
X705 a_11114_1728# q4p q4n vss sky130_fd_pr__nfet_01v8_lvt ad=0.825 pd=5.33 as=0.825 ps=5.33 w=5 l=0.15
X706 vss a_n3862_n388# a_7036_n300# vss sky130_fd_pr__nfet_01v8 ad=0.435 pd=3.29 as=0.435 ps=3.29 w=3 l=0.5
X707 vdd a_24235_4312# a_19715_526# vss sky130_fd_pr__nfet_01v8_lvt ad=0.825 pd=5.33 as=0.825 ps=5.33 w=5 l=0.15
X708 a_17834_n300# a_16600_714# a_18014_614# vss sky130_fd_pr__nfet_01v8_lvt ad=0.66 pd=4.33 as=0.66 ps=4.33 w=4 l=0.15
X709 vdd clkn a_n1881_526# vss sky130_fd_pr__nfet_01v8_lvt ad=0.825 pd=5.33 as=1.55 ps=10.62 w=5 l=0.15
X710 a_7036_n300# a_8917_526# a_7124_1728# vss sky130_fd_pr__nfet_01v8_lvt ad=0.66 pd=4.33 as=0.66 ps=4.33 w=4 l=0.15
X711 a_22730_3042# a_17951_1640# q8n vss sky130_fd_pr__nfet_01v8_lvt ad=0.825 pd=5.33 as=0.825 ps=5.33 w=5 l=0.15
X712 a_5722_n300# vbias vss vss sky130_fd_pr__nfet_01v8 ad=0.435 pd=3.29 as=0.87 ps=6.58 w=3 l=0.5
X713 vss a_n3862_n388# a_11026_n300# vss sky130_fd_pr__nfet_01v8 ad=0.435 pd=3.29 as=0.435 ps=3.29 w=3 l=0.5
X714 q2p a_n3198_1728# a_1134_3042# vss sky130_fd_pr__nfet_01v8_lvt ad=0.825 pd=5.33 as=1.55 ps=10.62 w=5 l=0.15
X715 a_16520_n300# q4n a_16629_626# vss sky130_fd_pr__nfet_01v8_lvt ad=0.495 pd=3.33 as=0.495 ps=3.33 w=3 l=0.15
X716 a_7124_1728# a_7153_1640# a_7216_1728# vss sky130_fd_pr__nfet_01v8_lvt ad=0.825 pd=5.33 as=0.825 ps=5.33 w=5 l=0.15
X717 vss a_n3862_n388# a_7036_n300# vss sky130_fd_pr__nfet_01v8 ad=0.435 pd=3.29 as=0.435 ps=3.29 w=3 l=0.5
X718 q8n q8p a_21912_1728# vss sky130_fd_pr__nfet_01v8_lvt ad=0.825 pd=5.33 as=0.825 ps=5.33 w=5 l=0.15
X719 a_11026_n300# a_8917_526# a_11932_3042# vss sky130_fd_pr__nfet_01v8_lvt ad=1.24 pd=8.62 as=0.66 ps=4.33 w=4 l=0.15
X720 a_11932_3042# a_8917_526# a_11026_n300# vss sky130_fd_pr__nfet_01v8_lvt ad=0.66 pd=4.33 as=0.66 ps=4.33 w=4 l=0.15
X721 a_408_614# q2n q2p vss sky130_fd_pr__nfet_01v8_lvt ad=0.825 pd=5.33 as=0.825 ps=5.33 w=5 l=0.15
X722 a_7036_n300# a_n3862_n388# vss vss sky130_fd_pr__nfet_01v8 ad=0.435 pd=3.29 as=0.435 ps=3.29 w=3 l=0.5
X723 a_n3862_n388# a_n3862_n388# vss vss sky130_fd_pr__nfet_01v8 ad=0.58 pd=4.29 as=1.16 ps=8.58 w=4 l=0.5
X724 q4n q4p a_11114_1728# vss sky130_fd_pr__nfet_01v8_lvt ad=0.825 pd=5.33 as=0.825 ps=5.33 w=5 l=0.15
X725 a_17922_1728# a_17951_1640# a_18014_1728# vss sky130_fd_pr__nfet_01v8_lvt ad=0.825 pd=5.33 as=0.825 ps=5.33 w=5 l=0.15
X726 a_17922_1728# a_19715_526# a_17834_n300# vss sky130_fd_pr__nfet_01v8_lvt ad=0.66 pd=4.33 as=0.66 ps=4.33 w=4 l=0.15
X727 a_11932_3042# a_8917_526# a_11026_n300# vss sky130_fd_pr__nfet_01v8_lvt ad=0.66 pd=4.33 as=0.66 ps=4.33 w=4 l=0.15
C0 a_n3862_n388# clkn 0.16287f
C1 a_n1881_526# q2n 0.04258f
C2 a_11114_1728# a_7153_1640# 0.02888f
C3 a_17951_1640# a_16629_626# 0
C4 q2n clkn 0
C5 a_5831_626# a_7124_1728# 0
C6 a_1134_3042# a_n3261_1640# 0.38418f
C7 a_13437_4312# a_16629_626# 0.26528f
C8 a_11932_3042# a_5802_714# 0.00514f
C9 a_408_614# a_n3198_1728# 0.03242f
C10 a_24235_4312# a_21824_n300# 0.00138f
C11 a_n1881_526# a_n5001_4543# 0
C12 a_n5001_4543# clkn 0
C13 a_18014_1728# a_16600_714# 0.08889f
C14 a_16600_714# a_8917_526# 0.04862f
C15 q8p a_16520_n300# 0.30621f
C16 a_17951_1640# q4p 0.03419f
C17 vdd a_11932_3042# 0.00134f
C18 q2p a_228_n300# 0.05539f
C19 a_n1881_526# a_n3582_614# 0.00514f
C20 a_7216_614# a_8917_526# 0.00514f
C21 a_16600_714# vbias 0.18354f
C22 a_n1881_526# a_n3261_1640# 0.01453f
C23 q4p a_13437_4312# 0.06834f
C24 a_n3261_1640# clkn 0
C25 a_n3862_n388# a_13437_4312# 0.00721f
C26 a_22730_3042# a_17951_1640# 0.38418f
C27 a_7216_614# a_7153_1640# 1.54856f
C28 a_11026_n300# q4p 0.07495f
C29 q4n a_13437_4312# 0.1513f
C30 q8n a_17951_1640# 0.82663f
C31 a_17922_1728# a_17951_1640# 5.64552f
C32 a_7124_1728# q4p 0.04786f
C33 a_19715_526# a_21824_n300# 2.06042f
C34 a_n3862_n388# a_11026_n300# 3.3988f
C35 a_11026_n300# q4n 0.0571f
C36 a_17834_n300# a_21824_n300# 0.02002f
C37 a_n3862_n388# a_7124_1728# 0.00784f
C38 q8p vdd 0.2242f
C39 a_7124_1728# q4n 0.02564f
C40 a_5722_n300# a_7216_1728# 0.32358f
C41 a_n3290_1728# a_n4996_714# 0.33443f
C42 a_19715_526# a_18014_614# 0.00514f
C43 q8p a_21912_1728# 5.64587f
C44 a_17834_n300# a_18014_614# 3.27155f
C45 vdd a_16520_n300# 0.54175f
C46 a_n1881_526# vbias 0.17783f
C47 vbias clkn 0.01949f
C48 a_21912_1728# a_16520_n300# 0.04617f
C49 a_1134_3042# q2p 1.42291f
C50 vdd a_5802_714# 4.39617f
C51 a_11932_3042# q4p 1.54984f
C52 a_5831_626# a_5802_714# 1.73726f
C53 a_n3198_1728# a_228_n300# 0
C54 a_n3862_n388# a_11932_3042# 0.00407f
C55 a_19715_526# a_24235_4312# 1.72028f
C56 a_11932_3042# q4n 1.63815f
C57 a_18014_1728# a_17951_1640# 4.3546f
C58 a_16520_n300# a_16629_626# 1.86781f
C59 a_7036_n300# a_7216_1728# 0.057f
C60 vdd a_21912_1728# 0.04128f
C61 a_5831_626# vdd 1.7766f
C62 a_8917_526# a_13437_4312# 1.72028f
C63 a_n1881_526# q2p 0.0987f
C64 q2p clkn 0
C65 q8p q4p 0.20021f
C66 a_11026_n300# a_8917_526# 2.06042f
C67 a_13437_4312# vbias 0.02558f
C68 a_13437_4312# a_7153_1640# 0.49307f
C69 a_7124_1728# a_8917_526# 1.23071f
C70 a_16520_n300# q4p 0.59446f
C71 a_11026_n300# vbias 0
C72 vdd a_16629_626# 1.77401f
C73 a_19715_526# a_17834_n300# 1.28443f
C74 a_n3862_n388# a_16520_n300# 0.04269f
C75 q8p a_22730_3042# 1.54984f
C76 a_7124_1728# a_7153_1640# 5.64552f
C77 a_1134_3042# a_n3198_1728# 0.3509f
C78 q8p q8n 5.27003f
C79 a_16520_n300# q4n 0.59446f
C80 q8p a_17922_1728# 0.04786f
C81 q4p a_5802_714# 0.01503f
C82 a_22730_3042# a_16520_n300# 0.09607f
C83 a_n3862_n388# a_5802_714# 0.66534f
C84 q8n a_16520_n300# 0.30496f
C85 q2n a_5802_714# 0.01941f
C86 q4n a_5802_714# 0.08782f
C87 vdd a_n3762_n300# 0
C88 a_17922_1728# a_16520_n300# 0.04617f
C89 a_n3290_1728# a_408_614# 0.00331f
C90 a_13437_4312# q2p 0.70483f
C91 vdd q4p 0.97516f
C92 a_8917_526# a_11932_3042# 1.42884f
C93 a_n3862_n388# vdd 3.33217f
C94 a_n1881_526# a_n3198_1728# 0.04911f
C95 vdd q2n 1.8247f
C96 vdd q4n 1.74922f
C97 a_n3862_n388# a_21912_1728# 0.00422f
C98 a_5722_n300# a_11114_1728# 0.04617f
C99 a_n4996_714# a_408_614# 1.23756f
C100 a_11932_3042# a_7153_1640# 0.38418f
C101 a_5831_626# a_n3862_n388# 0.1624f
C102 a_5831_626# q2n 0.62014f
C103 a_22730_3042# vdd 0.00134f
C104 a_5831_626# q4n 0.43024f
C105 q8n vdd 1.70811f
C106 a_17922_1728# vdd 0.04128f
C107 a_22730_3042# a_21912_1728# 0.34219f
C108 q8n a_21912_1728# 5.71011f
C109 q8p a_18014_1728# 1.28324f
C110 a_17922_1728# a_21912_1728# 0.00472f
C111 q4p a_16629_626# 0.08584f
C112 vdd a_n5001_4543# 11.6986f
C113 a_n3862_n388# a_16629_626# 0.00916f
C114 a_18014_1728# a_16520_n300# 0.32358f
C115 a_5831_626# a_n5001_4543# 0
C116 q4n a_16629_626# 0.62014f
C117 a_8917_526# a_16520_n300# 0.00559f
C118 a_n3582_614# vdd 0.00596f
C119 vdd a_n3261_1640# 0.42392f
C120 q8n a_16629_626# 0.43024f
C121 a_11932_3042# q2p 0
C122 a_16520_n300# vbias 0.51371f
C123 a_5722_n300# a_16600_714# 0.00559f
C124 a_17922_1728# a_16629_626# 0
C125 a_7036_n300# a_11114_1728# 0
C126 a_8917_526# a_5802_714# 0.52016f
C127 a_n3862_n388# a_n3762_n300# 3.40821f
C128 q2n a_n3762_n300# 0
C129 a_5722_n300# a_7216_614# 0.09608f
C130 a_5802_714# vbias 0.18234f
C131 a_5802_714# a_7153_1640# 0.17962f
C132 a_n3290_1728# a_228_n300# 0
C133 q4n q4p 5.40736f
C134 a_18014_1728# vdd 0.1184f
C135 a_n3862_n388# q2n 0.44611f
C136 vdd a_8917_526# 4.3527f
C137 a_21824_n300# a_16600_714# 1.29365f
C138 a_18014_1728# a_21912_1728# 0.04462f
C139 a_22730_3042# q4p 0
C140 q4n q2n 0
C141 q8n q4p 0.98802f
C142 a_22730_3042# a_n3862_n388# 0.00407f
C143 vdd vbias 0.17188f
C144 vdd a_7153_1640# 0.41322f
C145 a_18014_614# a_16600_714# 1.51373f
C146 a_n4996_714# a_228_n300# 1.29365f
C147 a_17922_1728# a_n3862_n388# 0.00784f
C148 a_n1881_526# a_5722_n300# 0.00479f
C149 q8n q4n 0
C150 a_5722_n300# clkn 0.00744f
C151 a_5831_626# vbias 0.02424f
C152 a_5831_626# a_7153_1640# 0
C153 a_16520_n300# q2p 0
C154 a_n3582_614# a_n3762_n300# 3.27162f
C155 q8n a_22730_3042# 1.63815f
C156 a_n3862_n388# a_n5001_4543# 2.77696f
C157 a_n3261_1640# a_n3762_n300# 0.05419f
C158 vdd clkp 1.56424f
C159 a_7216_614# a_7036_n300# 3.27155f
C160 q2n a_n5001_4543# 0.47716f
C161 a_18014_1728# a_16629_626# 0.13258f
C162 q8n a_17922_1728# 0.02564f
C163 a_8917_526# a_16629_626# 0.00956f
C164 a_n3582_614# a_n3862_n388# 0.00768f
C165 a_n3862_n388# a_n3261_1640# 0.00739f
C166 vbias a_16629_626# 0.02424f
C167 a_n3582_614# q2n 0.37498f
C168 q2n a_n3261_1640# 0.82133f
C169 vdd q2p 1.25357f
C170 a_18014_1728# q4p 0.04333f
C171 a_5831_626# q2p 0.08584f
C172 a_1134_3042# a_n4996_714# 0.00514f
C173 vbias a_n3762_n300# 0.00988f
C174 a_8917_526# q4p 0.15618f
C175 a_n3582_614# a_n5001_4543# 0.03528f
C176 a_5722_n300# a_13437_4312# 1.86877f
C177 a_n3261_1640# a_n5001_4543# 0.31209f
C178 a_18014_1728# q4n 0.00134f
C179 a_n3862_n388# a_8917_526# 0.7373f
C180 a_8917_526# q4n 0.06643f
C181 a_11114_1728# a_7216_1728# 0.04462f
C182 q4p a_7153_1640# 1.58747f
C183 a_5722_n300# a_11026_n300# 0.01116f
C184 a_n1881_526# a_n3290_1728# 1.2286f
C185 a_18014_1728# a_22730_3042# 0.3509f
C186 clkp a_n3762_n300# 0.0011f
C187 a_n3862_n388# vbias 9.21507f
C188 q8n a_18014_1728# 0.8005f
C189 a_19715_526# a_16600_714# 0.52016f
C190 a_5722_n300# a_7124_1728# 0.04617f
C191 a_17922_1728# a_18014_1728# 5.709f
C192 q2n vbias 0
C193 a_n3582_614# a_n3261_1640# 1.42163f
C194 q4n a_7153_1640# 0.82663f
C195 q2p a_16629_626# 0.01371f
C196 a_17834_n300# a_16600_714# 1.70894f
C197 a_18014_614# a_17951_1640# 1.54856f
C198 a_n1881_526# a_n4996_714# 0.52016f
C199 a_n3862_n388# clkp 0.01123f
C200 clkp q2n 0
C201 vbias a_n5001_4543# 0.12991f
C202 q2p a_n3762_n300# 0
C203 a_408_614# a_228_n300# 3.29949f
C204 vdd a_n3198_1728# 0.10971f
C205 q4p q2p 0.24995f
C206 a_11026_n300# a_7036_n300# 0.02002f
C207 a_5722_n300# a_11932_3042# 0.09607f
C208 a_n3582_614# vbias 0.00386f
C209 clkp a_n5001_4543# 0.00163f
C210 a_n3862_n388# q2p 0.34061f
C211 vbias a_n3261_1640# 0
C212 a_7036_n300# a_7124_1728# 3.31365f
C213 a_7216_614# a_7216_1728# 1.64151f
C214 q2n q2p 3.69468f
C215 q4n q2p 1.16596f
C216 a_24235_4312# a_17951_1640# 0.49307f
C217 a_n3582_614# clkp 0.0024f
C218 clkp a_n3261_1640# 0
C219 q2p a_n5001_4543# 0.57073f
C220 a_8917_526# vbias 0.18619f
C221 a_8917_526# a_7153_1640# 0.01411f
C222 a_1134_3042# a_408_614# 0.27937f
C223 a_19715_526# a_17951_1640# 0.01411f
C224 a_5722_n300# a_16520_n300# 0.08428f
C225 a_n3198_1728# a_n3762_n300# 0.03252f
C226 a_n3582_614# q2p 0.3509f
C227 q2p a_n3261_1640# 1.56448f
C228 a_17834_n300# a_17951_1640# 0.07375f
C229 q8p a_21824_n300# 0.07495f
C230 clkp vbias 0.16407f
C231 a_5722_n300# a_5802_714# 0.53676f
C232 q2n a_n3198_1728# 0.78181f
C233 a_21824_n300# a_16520_n300# 0.01116f
C234 q8p a_18014_614# 0.3509f
C235 a_n1881_526# a_408_614# 0.24199f
C236 a_8917_526# q2p 0.01941f
C237 a_408_614# clkn 0
C238 a_5722_n300# vdd 0.54175f
C239 a_18014_614# a_16520_n300# 0.09608f
C240 q2p a_7153_1640# 0.03419f
C241 a_5722_n300# a_5831_626# 1.86781f
C242 a_n3198_1728# a_n5001_4543# 0.31335f
C243 a_7036_n300# a_5802_714# 1.70894f
C244 a_7124_1728# a_7216_1728# 5.709f
C245 a_n3582_614# a_n3198_1728# 1.45456f
C246 q8p a_24235_4312# 0.06834f
C247 a_n3198_1728# a_n3261_1640# 2.64348f
C248 a_21824_n300# a_21912_1728# 3.31391f
C249 a_5722_n300# a_16629_626# 0.01006f
C250 vdd a_18014_614# 0.00134f
C251 a_24235_4312# a_16520_n300# 1.86877f
C252 a_1134_3042# a_228_n300# 3.27189f
C253 a_5831_626# a_7036_n300# 0.0011f
C254 a_n3290_1728# vdd 0.01395f
C255 q8p a_19715_526# 0.15618f
C256 a_11932_3042# a_7216_1728# 0.3509f
C257 a_5722_n300# q4p 0.30621f
C258 a_18014_614# a_16629_626# 0.01036f
C259 a_5722_n300# a_n3862_n388# 0.12569f
C260 a_24235_4312# vdd 1.76935f
C261 a_19715_526# a_16520_n300# 0.53142f
C262 a_5722_n300# q2n 0.59446f
C263 a_5722_n300# q4n 0.30544f
C264 a_n1881_526# a_228_n300# 2.06042f
C265 a_17834_n300# a_16520_n300# 0.01116f
C266 clkn a_228_n300# 0.00138f
C267 a_24235_4312# a_21912_1728# 0
C268 a_n4996_714# vdd 4.39356f
C269 clkp a_n3198_1728# 0
C270 a_n3862_n388# a_21824_n300# 3.3988f
C271 a_19715_526# vdd 4.34974f
C272 a_n3862_n388# a_18014_614# 0.00768f
C273 a_22730_3042# a_21824_n300# 3.27181f
C274 q2p a_n3198_1728# 1.245f
C275 q8n a_21824_n300# 0.0571f
C276 a_18014_614# q4n 0
C277 a_n3862_n388# a_7036_n300# 3.40821f
C278 a_17922_1728# a_21824_n300# 0
C279 a_19715_526# a_21912_1728# 0.26469f
C280 a_n3290_1728# a_n3762_n300# 3.29923f
C281 a_17834_n300# a_21912_1728# 0
C282 a_7216_1728# a_5802_714# 0.08889f
C283 q8n a_18014_614# 0.37498f
C284 a_n1881_526# a_1134_3042# 1.42994f
C285 a_17922_1728# a_18014_614# 0.34219f
C286 a_1134_3042# clkn 0.00254f
C287 a_11114_1728# a_13437_4312# 0
C288 a_n3290_1728# a_n3862_n388# 0.00777f
C289 a_n4996_714# a_n3762_n300# 1.70894f
C290 a_n3290_1728# q2n 0.02554f
C291 a_24235_4312# q4p 0.70483f
C292 a_11026_n300# a_11114_1728# 3.31391f
C293 vdd a_7216_1728# 0.1184f
C294 a_24235_4312# a_n3862_n388# 0.00721f
C295 a_17834_n300# a_16629_626# 0.0011f
C296 a_7124_1728# a_11114_1728# 0.00472f
C297 a_5722_n300# a_8917_526# 0.53142f
C298 a_5831_626# a_7216_1728# 0.13258f
C299 a_n4996_714# a_n3862_n388# 0.65925f
C300 a_5722_n300# vbias 0.51465f
C301 a_22730_3042# a_24235_4312# 0.0105f
C302 a_n4996_714# q2n 0.05028f
C303 a_5722_n300# a_7153_1640# 0.29528f
C304 q8n a_24235_4312# 0.1376f
C305 a_n3290_1728# a_n5001_4543# 0.00109f
C306 a_17951_1640# a_16600_714# 0.17962f
C307 a_n1881_526# clkn 1.70462f
C308 a_19715_526# q4p 0.01941f
C309 a_16600_714# a_13437_4312# 0.00956f
C310 a_n3290_1728# a_n3582_614# 0.27937f
C311 a_n3290_1728# a_n3261_1640# 2.9359f
C312 a_18014_1728# a_18014_614# 1.64151f
C313 a_19715_526# a_n3862_n388# 0.7373f
C314 a_21824_n300# vbias 0
C315 a_n4996_714# a_n5001_4543# 0
C316 a_408_614# vdd 0.01395f
C317 a_n3862_n388# a_17834_n300# 3.40821f
C318 a_11114_1728# a_11932_3042# 0.34219f
C319 a_7036_n300# a_8917_526# 1.28443f
C320 a_19715_526# a_22730_3042# 1.42884f
C321 q8n a_19715_526# 0.06643f
C322 a_19715_526# a_17922_1728# 1.23071f
C323 a_n4996_714# a_n3582_614# 1.51483f
C324 a_7216_614# a_7124_1728# 0.34219f
C325 a_n4996_714# a_n3261_1640# 0.11279f
C326 a_7036_n300# vbias 0
C327 a_5722_n300# q2p 0.59446f
C328 a_7036_n300# a_7153_1640# 0.07375f
C329 a_17922_1728# a_17834_n300# 3.31365f
C330 q4p a_7216_1728# 1.28324f
C331 q2n a_7216_1728# 0.00134f
C332 q4n a_7216_1728# 0.8005f
C333 a_n3290_1728# vbias 0.00115f
C334 a_24235_4312# vbias 0.02558f
C335 a_n3290_1728# clkp 0
C336 a_408_614# a_n3762_n300# 0
C337 a_n4996_714# vbias 0.52654f
C338 a_11114_1728# a_5802_714# 1.23968f
C339 a_19715_526# a_18014_1728# 0.08674f
C340 a_n3862_n388# a_408_614# 0.0053f
C341 a_18014_1728# a_17834_n300# 0.057f
C342 a_n4996_714# clkp 1.7216f
C343 a_408_614# q2n 2.94395f
C344 q8p a_16600_714# 0.01503f
C345 a_n3290_1728# q2p 0.03251f
C346 vdd a_228_n300# 0
C347 a_19715_526# vbias 0.18499f
C348 vdd a_11114_1728# 0.04128f
C349 a_17834_n300# vbias 0
C350 a_16600_714# a_16520_n300# 0.53676f
C351 a_11026_n300# a_13437_4312# 0.00138f
C352 a_408_614# a_n5001_4543# 0.00109f
C353 a_n4996_714# q2p 0.01536f
C354 a_8917_526# a_7216_1728# 0.08674f
C355 a_11026_n300# a_7124_1728# 0
C356 a_7216_614# a_5802_714# 1.51373f
C357 a_408_614# a_n3261_1640# 0.02563f
C358 a_7216_1728# a_7153_1640# 4.3546f
C359 vdd a_16600_714# 4.39617f
C360 a_1134_3042# vdd 0.00596f
C361 a_21912_1728# a_16600_714# 1.23968f
C362 vdd a_7216_614# 0.00134f
C363 a_n3762_n300# a_228_n300# 0.02002f
C364 a_11932_3042# a_13437_4312# 0.0105f
C365 a_n3290_1728# a_n3198_1728# 2.94284f
C366 a_5831_626# a_7216_614# 0.01036f
C367 a_n1881_526# a_5802_714# 0.04862f
C368 a_5802_714# clkn 0.00898f
C369 a_11114_1728# q4p 5.64587f
C370 a_11026_n300# a_11932_3042# 3.27181f
C371 a_n3862_n388# a_228_n300# 3.40799f
C372 a_n3862_n388# a_11114_1728# 0.00422f
C373 q2n a_228_n300# 0.03262f
C374 a_11114_1728# q4n 5.71011f
C375 a_16600_714# a_16629_626# 1.73726f
C376 a_n4996_714# a_n3198_1728# 0.05606f
C377 a_7216_1728# q2p 0.04333f
C378 q8p a_17951_1640# 1.58747f
C379 a_n1881_526# vdd 4.35305f
C380 vdd clkn 1.56419f
C381 a_17951_1640# a_16520_n300# 0.29528f
C382 a_n1881_526# a_5831_626# 0.01433f
C383 a_5831_626# clkn 0.07343f
C384 a_16520_n300# a_13437_4312# 0.01006f
C385 a_n3862_n388# a_16600_714# 0.65785f
C386 a_n3261_1640# a_228_n300# 0
C387 a_7216_614# q4p 0.3509f
C388 a_408_614# q2p 2.93625f
C389 a_16600_714# q4n 0.01941f
C390 a_1134_3042# a_n3862_n388# 0.00852f
C391 a_1134_3042# q2n 1.45119f
C392 a_n3862_n388# a_7216_614# 0.00768f
C393 a_11026_n300# a_5802_714# 1.29365f
C394 vdd a_17951_1640# 0.41322f
C395 a_7216_614# q2n 0
C396 a_22730_3042# a_16600_714# 0.00514f
C397 a_5722_n300# a_7036_n300# 0.01116f
C398 a_7216_614# q4n 0.37498f
C399 q8n a_16600_714# 0.08782f
C400 a_7124_1728# a_5802_714# 0.36474f
C401 a_21912_1728# a_17951_1640# 0.02888f
C402 a_17922_1728# a_16600_714# 0.36474f
C403 vdd a_13437_4312# 1.7702f
C404 a_n1881_526# a_n3762_n300# 1.28443f
C405 a_11114_1728# a_8917_526# 0.26469f
C406 a_1134_3042# a_n5001_4543# 0.03466f
C407 vdd a_7124_1728# 0.04128f
C408 vbias a_228_n300# 0
C409 a_n1881_526# a_n3862_n388# 1.09823f
C410 clkn vss 2.86085f
C411 q8n vss 7.57373f
C412 q8p vss 6.61644f
C413 q4n vss 9.69613f
C414 q4p vss 12.4766f
C415 clkp vss 3.0176f
C416 q2n vss 9.20825f
C417 q2p vss 11.2369f
C418 vbias vss 22.8598f
C419 vdd vss 65.49f
C420 a_21824_n300# vss 3.69252f
C421 a_19715_526# vss 7.27552f
C422 a_17834_n300# vss 3.69252f
C423 a_21912_1728# vss 1.19985f
C424 a_17922_1728# vss 1.2015f
C425 a_22730_3042# vss 1.52092f
C426 a_18014_614# vss 1.52256f
C427 a_16600_714# vss 7.29851f
C428 a_11026_n300# vss 3.69252f
C429 a_8917_526# vss 7.14976f
C430 a_7036_n300# vss 3.69252f
C431 a_11114_1728# vss 1.19985f
C432 a_7124_1728# vss 1.2015f
C433 a_16520_n300# vss 5.21691f
C434 a_11932_3042# vss 1.52092f
C435 a_7216_614# vss 1.52256f
C436 a_5802_714# vss 7.29987f
C437 a_228_n300# vss 3.7344f
C438 a_n3762_n300# vss 3.7344f
C439 a_n1881_526# vss 7.35835f
C440 a_408_614# vss 1.47908f
C441 a_n3290_1728# vss 1.48073f
C442 a_5722_n300# vss 5.02484f
C443 a_24235_4312# vss 5.8079f
C444 a_17951_1640# vss 6.0493f
C445 a_18014_1728# vss 6.10292f
C446 a_16629_626# vss 5.45652f
C447 a_13437_4312# vss 5.30755f
C448 a_7153_1640# vss 6.0493f
C449 a_7216_1728# vss 6.10292f
C450 a_5831_626# vss 5.5007f
C451 a_1134_3042# vss 1.75466f
C452 a_n3582_614# vss 1.75628f
C453 a_n4996_714# vss 7.65188f
C454 a_n3862_n388# vss 60.4367f
C455 a_n3261_1640# vss 5.53341f
C456 a_n3198_1728# vss 5.62782f
C457 a_n5001_4543# vss 4.02681f
.ends
