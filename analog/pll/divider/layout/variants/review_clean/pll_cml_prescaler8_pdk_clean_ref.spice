.subckt pll_cml_tail_bias_pdk vbias_sf vbias_logic vdd vss
Xsink pdiode vbias_sf vss vss sky130_fd_pr__nfet_01v8 w=3.333333333 l=0.5
Xpd pdiode pdiode vdd vdd sky130_fd_pr__pfet_01v8 w=60 l=0.5
Xpm vbias_logic pdiode vdd vdd sky130_fd_pr__pfet_01v8 w=60 l=0.5
Xref vbias_logic vbias_logic vss vss sky130_fd_pr__nfet_01v8 w=20 l=0.5
.ends pll_cml_tail_bias_pdk

.subckt pll_cml_latch_h40_pdk dp dn qp qn clk_track clk_hold vbias vdd vss
Xrp vdd qp vss sky130_fd_pr__res_high_po_2p85 l=4.14
Xrn vdd qn vss sky130_fd_pr__res_high_po_2p85 l=4.14
Xdp qn dp track vss sky130_fd_pr__nfet_01v8_lvt w=20 l=0.15
Xdn qp dn track vss sky130_fd_pr__nfet_01v8_lvt w=20 l=0.15
Xhp qn qp hold vss sky130_fd_pr__nfet_01v8_lvt w=40 l=0.15
Xhn qp qn hold vss sky130_fd_pr__nfet_01v8_lvt w=40 l=0.15
Xct track clk_track tail vss sky130_fd_pr__nfet_01v8_lvt w=64 l=0.15
Xch hold clk_hold tail vss sky130_fd_pr__nfet_01v8_lvt w=64 l=0.15
Xtail tail vbias vss vss sky130_fd_pr__nfet_01v8 w=72 l=0.5
.ends pll_cml_latch_h40_pdk

.subckt pll_cml_div2_biased_h40_pdk clkp clkn qp qn mp mn vbias vbias_logic vdd vss
Xfp vdd clkp ckp vss sky130_fd_pr__nfet_01v8_lvt w=80 l=0.15
Xfn vdd clkn ckn vss sky130_fd_pr__nfet_01v8_lvt w=80 l=0.15
Xsp ckp vbias vss vss sky130_fd_pr__nfet_01v8 w=4 l=0.5
Xsn ckn vbias vss vss sky130_fd_pr__nfet_01v8 w=4 l=0.5
Xmaster qn qp mp mn ckp ckn vbias_logic vdd vss pll_cml_latch_h40_pdk
Xslave mp mn qp qn ckn ckp vbias_logic vdd vss pll_cml_latch_h40_pdk
.ends pll_cml_div2_biased_h40_pdk

.subckt pll_cml_latch_h80_pdk dp dn qp qn clk_track clk_hold vbias vdd vss
Xrp vdd qp vss sky130_fd_pr__res_high_po_2p85 l=4.14
Xrn vdd qn vss sky130_fd_pr__res_high_po_2p85 l=4.14
Xdp qn dp track vss sky130_fd_pr__nfet_01v8_lvt w=20 l=0.15
Xdn qp dn track vss sky130_fd_pr__nfet_01v8_lvt w=20 l=0.15
Xhp qn qp hold vss sky130_fd_pr__nfet_01v8_lvt w=80 l=0.15
Xhn qp qn hold vss sky130_fd_pr__nfet_01v8_lvt w=80 l=0.15
Xct track clk_track tail vss sky130_fd_pr__nfet_01v8_lvt w=64 l=0.15
Xch hold clk_hold tail vss sky130_fd_pr__nfet_01v8_lvt w=64 l=0.15
Xtail tail vbias vss vss sky130_fd_pr__nfet_01v8 w=72 l=0.5
.ends pll_cml_latch_h80_pdk

.subckt pll_cml_div2_biased_h80_pdk clkp clkn qp qn mp mn vbias vbias_logic vdd vss
Xfp vdd clkp ckp vss sky130_fd_pr__nfet_01v8_lvt w=80 l=0.15
Xfn vdd clkn ckn vss sky130_fd_pr__nfet_01v8_lvt w=80 l=0.15
Xsp ckp vbias vss vss sky130_fd_pr__nfet_01v8 w=4 l=0.5
Xsn ckn vbias vss vss sky130_fd_pr__nfet_01v8 w=4 l=0.5
Xmaster qn qp mp mn ckp ckn vbias_logic vdd vss pll_cml_latch_h80_pdk
Xslave mp mn qp qn ckn ckp vbias_logic vdd vss pll_cml_latch_h80_pdk
.ends pll_cml_div2_biased_h80_pdk

.subckt pll_div_buffer_pdk inp inn outp outn vbias vdd vss
Xp outn inp tail vss sky130_fd_pr__nfet_01v8_lvt w=24 l=0.15
Xn outp inn tail vss sky130_fd_pr__nfet_01v8_lvt w=24 l=0.15
Xt tail vbias vss vss sky130_fd_pr__nfet_01v8 w=12 l=0.5
Xr0 vdd outn vss sky130_fd_pr__res_high_po_2p85 l=4.14
Xr1 vdd outp vss sky130_fd_pr__res_high_po_2p85 l=4.14
.ends pll_div_buffer_pdk

.subckt pll_cml_prescaler8_pdk_clean clkp clkn q2p q2n q4p q4n q8p q8n vbias vdd vss
Xbias vbias vbias_logic vdd vss pll_cml_tail_bias_pdk
X2 clkp clkn q2p q2n m2p m2n vbias vbias_logic vdd vss pll_cml_div2_biased_h40_pdk
Xb24 q2p q2n b24p b24n vbias vdd vss pll_div_buffer_pdk
X4 b24p b24n q4p q4n m4p m4n vbias vbias_logic vdd vss pll_cml_div2_biased_h80_pdk
Xb48 q4p q4n b48p b48n vbias vdd vss pll_div_buffer_pdk
X8 b48p b48n q8p q8n m8p m8n vbias vbias_logic vdd vss pll_cml_div2_biased_h80_pdk
.ends pll_cml_prescaler8_pdk_clean
