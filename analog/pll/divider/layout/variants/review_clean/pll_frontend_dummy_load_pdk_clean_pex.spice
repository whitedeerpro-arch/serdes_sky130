* NGSPICE file created from pll_frontend_dummy_load_pdk_clean.ext - technology: sky130A

.subckt pll_frontend_dummy_load_pdk_clean clkp clkn vbias vdd vss
X0 a_n1679_1828# clkp vdd vss sky130_fd_pr__nfet_01v8_lvt ad=0.825 pd=5.33 as=0.825 ps=5.33 w=5 l=0.15
X1 a_85_1828# clkn vdd vss sky130_fd_pr__nfet_01v8_lvt ad=0.825 pd=5.33 as=0.825 ps=5.33 w=5 l=0.15
X2 a_85_1828# clkn vdd vss sky130_fd_pr__nfet_01v8_lvt ad=0.825 pd=5.33 as=0.825 ps=5.33 w=5 l=0.15
X3 a_n1679_1828# clkp vdd vss sky130_fd_pr__nfet_01v8_lvt ad=0.825 pd=5.33 as=0.825 ps=5.33 w=5 l=0.15
X4 vss vbias a_85_1828# vss sky130_fd_pr__nfet_01v8 ad=1.16 pd=8.58 as=1.16 ps=8.58 w=4 l=0.5
X5 vdd clkp a_n1679_1828# vss sky130_fd_pr__nfet_01v8_lvt ad=0.825 pd=5.33 as=0.825 ps=5.33 w=5 l=0.15
X6 vdd clkn a_85_1828# vss sky130_fd_pr__nfet_01v8_lvt ad=0.825 pd=5.33 as=0.825 ps=5.33 w=5 l=0.15
X7 a_85_1828# clkn vdd vss sky130_fd_pr__nfet_01v8_lvt ad=0.825 pd=5.33 as=0.825 ps=5.33 w=5 l=0.15
X8 a_n1679_1828# clkp vdd vss sky130_fd_pr__nfet_01v8_lvt ad=1.55 pd=10.62 as=0.825 ps=5.33 w=5 l=0.15
X9 vdd clkn a_85_1828# vss sky130_fd_pr__nfet_01v8_lvt ad=0.825 pd=5.33 as=0.825 ps=5.33 w=5 l=0.15
X10 vdd clkn a_85_1828# vss sky130_fd_pr__nfet_01v8_lvt ad=0.825 pd=5.33 as=0.825 ps=5.33 w=5 l=0.15
X11 vdd clkp a_n1679_1828# vss sky130_fd_pr__nfet_01v8_lvt ad=0.825 pd=5.33 as=0.825 ps=5.33 w=5 l=0.15
X12 a_85_1828# clkn vdd vss sky130_fd_pr__nfet_01v8_lvt ad=1.55 pd=10.62 as=0.825 ps=5.33 w=5 l=0.15
X13 a_n1679_1828# clkp vdd vss sky130_fd_pr__nfet_01v8_lvt ad=0.825 pd=5.33 as=0.825 ps=5.33 w=5 l=0.15
X14 a_85_1828# clkn vdd vss sky130_fd_pr__nfet_01v8_lvt ad=0.825 pd=5.33 as=0.825 ps=5.33 w=5 l=0.15
X15 a_n1679_1828# clkp vdd vss sky130_fd_pr__nfet_01v8_lvt ad=0.825 pd=5.33 as=0.825 ps=5.33 w=5 l=0.15
X16 vdd clkn a_85_1828# vss sky130_fd_pr__nfet_01v8_lvt ad=0.825 pd=5.33 as=0.825 ps=5.33 w=5 l=0.15
X17 vdd clkp a_n1679_1828# vss sky130_fd_pr__nfet_01v8_lvt ad=0.825 pd=5.33 as=1.55 ps=10.62 w=5 l=0.15
X18 a_85_1828# clkn vdd vss sky130_fd_pr__nfet_01v8_lvt ad=0.825 pd=5.33 as=0.825 ps=5.33 w=5 l=0.15
X19 vss a_85_1828# vss vss sky130_fd_pr__nfet_01v8_lvt ad=0.66 pd=4.33 as=46.88 ps=311.44 w=4 l=0.15
X20 vss a_85_1828# vss vss sky130_fd_pr__nfet_01v8_lvt ad=0.66 pd=4.33 as=0 ps=0 w=4 l=0.15
X21 vdd clkp a_n1679_1828# vss sky130_fd_pr__nfet_01v8_lvt ad=0.825 pd=5.33 as=0.825 ps=5.33 w=5 l=0.15
X22 a_n1679_1828# clkp vdd vss sky130_fd_pr__nfet_01v8_lvt ad=0.825 pd=5.33 as=0.825 ps=5.33 w=5 l=0.15
X23 vss a_85_1828# vss vss sky130_fd_pr__nfet_01v8_lvt ad=0.66 pd=4.33 as=0 ps=0 w=4 l=0.15
X24 vss a_85_1828# vss vss sky130_fd_pr__nfet_01v8_lvt ad=0.66 pd=4.33 as=0 ps=0 w=4 l=0.15
X25 vdd clkp a_n1679_1828# vss sky130_fd_pr__nfet_01v8_lvt ad=0.825 pd=5.33 as=0.825 ps=5.33 w=5 l=0.15
X26 a_85_1828# clkn vdd vss sky130_fd_pr__nfet_01v8_lvt ad=0.825 pd=5.33 as=0.825 ps=5.33 w=5 l=0.15
X27 vss a_85_1828# vss vss sky130_fd_pr__nfet_01v8_lvt ad=1.24 pd=8.62 as=0 ps=0 w=4 l=0.15
X28 vss a_85_1828# vss vss sky130_fd_pr__nfet_01v8_lvt ad=0.66 pd=4.33 as=0 ps=0 w=4 l=0.15
X29 vss a_85_1828# vss vss sky130_fd_pr__nfet_01v8_lvt ad=0.66 pd=4.33 as=0 ps=0 w=4 l=0.15
X30 vss a_85_1828# vss vss sky130_fd_pr__nfet_01v8_lvt ad=0.66 pd=4.33 as=0 ps=0 w=4 l=0.15
X31 vss a_85_1828# vss vss sky130_fd_pr__nfet_01v8_lvt ad=0.66 pd=4.33 as=0 ps=0 w=4 l=0.15
X32 vss a_85_1828# vss vss sky130_fd_pr__nfet_01v8_lvt ad=0.66 pd=4.33 as=0 ps=0 w=4 l=0.15
X33 a_n1679_1828# clkp vdd vss sky130_fd_pr__nfet_01v8_lvt ad=0.825 pd=5.33 as=0.825 ps=5.33 w=5 l=0.15
X34 vdd clkn a_85_1828# vss sky130_fd_pr__nfet_01v8_lvt ad=0.825 pd=5.33 as=0.825 ps=5.33 w=5 l=0.15
X35 vss a_85_1828# vss vss sky130_fd_pr__nfet_01v8_lvt ad=0.66 pd=4.33 as=0 ps=0 w=4 l=0.15
X36 vss a_85_1828# vss vss sky130_fd_pr__nfet_01v8_lvt ad=0.66 pd=4.33 as=0 ps=0 w=4 l=0.15
X37 vss a_85_1828# vss vss sky130_fd_pr__nfet_01v8_lvt ad=0.66 pd=4.33 as=0 ps=0 w=4 l=0.15
X38 a_85_1828# clkn vdd vss sky130_fd_pr__nfet_01v8_lvt ad=0.825 pd=5.33 as=0.825 ps=5.33 w=5 l=0.15
X39 vss a_n1679_1828# vss vss sky130_fd_pr__nfet_01v8_lvt ad=0.66 pd=4.33 as=0 ps=0 w=4 l=0.15
X40 vss a_n1679_1828# vss vss sky130_fd_pr__nfet_01v8_lvt ad=0.66 pd=4.33 as=0 ps=0 w=4 l=0.15
X41 vss a_n1679_1828# vss vss sky130_fd_pr__nfet_01v8_lvt ad=0.66 pd=4.33 as=0 ps=0 w=4 l=0.15
X42 vss a_n1679_1828# vss vss sky130_fd_pr__nfet_01v8_lvt ad=0.66 pd=4.33 as=0 ps=0 w=4 l=0.15
X43 vss a_n1679_1828# vss vss sky130_fd_pr__nfet_01v8_lvt ad=1.24 pd=8.62 as=0 ps=0 w=4 l=0.15
X44 vss a_n1679_1828# vss vss sky130_fd_pr__nfet_01v8_lvt ad=0.66 pd=4.33 as=0 ps=0 w=4 l=0.15
X45 vss a_n1679_1828# vss vss sky130_fd_pr__nfet_01v8_lvt ad=0.66 pd=4.33 as=0 ps=0 w=4 l=0.15
X46 vss a_n1679_1828# vss vss sky130_fd_pr__nfet_01v8_lvt ad=0.66 pd=4.33 as=0 ps=0 w=4 l=0.15
X47 vss a_n1679_1828# vss vss sky130_fd_pr__nfet_01v8_lvt ad=0.66 pd=4.33 as=0 ps=0 w=4 l=0.15
X48 vss a_85_1828# vss vss sky130_fd_pr__nfet_01v8_lvt ad=0.66 pd=4.33 as=0 ps=0 w=4 l=0.15
X49 vss a_85_1828# vss vss sky130_fd_pr__nfet_01v8_lvt ad=0.66 pd=4.33 as=0 ps=0 w=4 l=0.15
X50 a_n1679_1828# vbias vss vss sky130_fd_pr__nfet_01v8 ad=1.16 pd=8.58 as=1.16 ps=8.58 w=4 l=0.5
X51 vss a_n1679_1828# vss vss sky130_fd_pr__nfet_01v8_lvt ad=0.66 pd=4.33 as=0 ps=0 w=4 l=0.15
X52 vss a_n1679_1828# vss vss sky130_fd_pr__nfet_01v8_lvt ad=0.66 pd=4.33 as=0 ps=0 w=4 l=0.15
X53 vss a_n1679_1828# vss vss sky130_fd_pr__nfet_01v8_lvt ad=0.66 pd=4.33 as=0 ps=0 w=4 l=0.15
X54 vss a_n1679_1828# vss vss sky130_fd_pr__nfet_01v8_lvt ad=0.66 pd=4.33 as=0 ps=0 w=4 l=0.15
X55 vss a_n1679_1828# vss vss sky130_fd_pr__nfet_01v8_lvt ad=0.66 pd=4.33 as=0 ps=0 w=4 l=0.15
X56 vss a_n1679_1828# vss vss sky130_fd_pr__nfet_01v8_lvt ad=0.66 pd=4.33 as=0 ps=0 w=4 l=0.15
X57 vss a_85_1828# vss vss sky130_fd_pr__nfet_01v8_lvt ad=0.66 pd=4.33 as=0 ps=0 w=4 l=0.15
X58 vdd clkp a_n1679_1828# vss sky130_fd_pr__nfet_01v8_lvt ad=0.825 pd=5.33 as=0.825 ps=5.33 w=5 l=0.15
X59 vdd clkn a_85_1828# vss sky130_fd_pr__nfet_01v8_lvt ad=0.825 pd=5.33 as=0.825 ps=5.33 w=5 l=0.15
X60 vdd clkn a_85_1828# vss sky130_fd_pr__nfet_01v8_lvt ad=0.825 pd=5.33 as=0.825 ps=5.33 w=5 l=0.15
X61 vss a_n1679_1828# vss vss sky130_fd_pr__nfet_01v8_lvt ad=0.66 pd=4.33 as=0 ps=0 w=4 l=0.15
X62 a_n1679_1828# clkp vdd vss sky130_fd_pr__nfet_01v8_lvt ad=0.825 pd=5.33 as=0.825 ps=5.33 w=5 l=0.15
X63 vdd clkp a_n1679_1828# vss sky130_fd_pr__nfet_01v8_lvt ad=0.825 pd=5.33 as=0.825 ps=5.33 w=5 l=0.15
X64 vdd clkn a_85_1828# vss sky130_fd_pr__nfet_01v8_lvt ad=0.825 pd=5.33 as=1.55 ps=10.62 w=5 l=0.15
X65 vdd clkp a_n1679_1828# vss sky130_fd_pr__nfet_01v8_lvt ad=0.825 pd=5.33 as=0.825 ps=5.33 w=5 l=0.15
C0 vbias a_n1679_1828# 0.22307f
C1 vbias a_85_1828# 0.19866f
C2 vdd a_n1679_1828# 4.04922f
C3 clkn a_n1679_1828# 0.00349f
C4 a_85_1828# a_n1679_1828# 0.15915f
C5 clkp a_n1679_1828# 1.46475f
C6 clkn vdd 1.51307f
C7 vdd a_85_1828# 4.04922f
C8 clkn a_85_1828# 1.46475f
C9 vdd clkp 1.51307f
C10 clkn clkp 0.00755f
C11 clkp a_85_1828# 0.00349f
C12 vbias vss 1.86944f
C13 clkn vss 2.35932f
C14 vdd vss 2.97885f
C15 clkp vss 2.35932f
C16 a_85_1828# vss 7.0209f
C17 a_n1679_1828# vss 6.98579f
.ends
