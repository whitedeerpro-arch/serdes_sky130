.subckt pll_frontend_dummy_load_pdk_clean clkp clkn vbias vdd vss
Xfp vdd clkp ckp vss sky130_fd_pr__nfet_01v8_lvt w=80 l=0.15
Xfn vdd clkn ckn vss sky130_fd_pr__nfet_01v8_lvt w=80 l=0.15
Xsp ckp vbias vss vss sky130_fd_pr__nfet_01v8 w=4 l=0.5
Xsn ckn vbias vss vss sky130_fd_pr__nfet_01v8 w=4 l=0.5
Xcp vss ckp vss vss sky130_fd_pr__nfet_01v8_lvt w=64 l=0.15
Xcn vss ckn vss vss sky130_fd_pr__nfet_01v8_lvt w=64 l=0.15
.ends pll_frontend_dummy_load_pdk_clean
