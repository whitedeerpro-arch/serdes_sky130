* NGSPICE file created from pll_saff_reclock_prescaler8_2g_pdk.ext - technology: sky130A

.subckt pll_saff_reclock_prescaler8_2g_pdk clkp clkn q2p q2n q4p q4n q8p q8n vdd vss
X0 vdd a_2192_n1472# a_3108_872# vdd sky130_fd_pr__pfet_01v8 ad=0.434 pd=3.42 as=0.231 ps=1.73 w=1.4 l=0.15
X1 a_3108_872# a_3108_n1152# a_2810_872# vss sky130_fd_pr__nfet_01v8_lvt ad=0.231 pd=1.73 as=0.434 ps=3.42 w=1.4 l=0.15
X2 a_3108_872# a_2192_n1472# a_3108_n1152# vdd sky130_fd_pr__pfet_01v8 ad=0.319 pd=2.78 as=0.319 ps=2.78 w=1.1 l=0.15
X3 q4n q4p vdd vdd sky130_fd_pr__pfet_01v8 ad=0.3625 pd=3.08 as=0.3625 ps=3.08 w=1.25 l=0.15
X4 a_3108_872# a_2192_n1472# vdd vdd sky130_fd_pr__pfet_01v8 ad=0.231 pd=1.73 as=0.434 ps=3.42 w=1.4 l=0.15
X5 a_10422_872# a_10422_n1152# a_10124_872# vss sky130_fd_pr__nfet_01v8_lvt ad=0.18975 pd=1.48 as=0.3565 ps=2.92 w=1.15 l=0.15
X6 a_9170_n1222# a_8240_n1092# vdd vdd sky130_fd_pr__pfet_01v8 ad=0.5075 pd=4.08 as=0.5075 ps=4.08 w=1.75 l=0.15
X7 a_6498_n1152# a_6498_208# vdd vdd sky130_fd_pr__pfet_01v8 ad=0.1885 pd=1.88 as=0.1885 ps=1.88 w=0.65 l=0.15
X8 vss a_6220_308# a_6498_n1152# vss sky130_fd_pr__nfet_01v8_lvt ad=0.403 pd=3.22 as=0.2145 ps=1.63 w=1.3 l=0.15
X9 a_3022_n580# a_3022_486# vss vss sky130_fd_pr__nfet_01v8 ad=0.1595 pd=1.68 as=0.1595 ps=1.68 w=0.55 l=0.15
X10 a_14521_n1092# a_14521_872# vdd vdd sky130_fd_pr__pfet_01v8 ad=0.406 pd=3.38 as=0.406 ps=3.38 w=1.4 l=0.15
X11 a_10124_872# a_10422_n1152# a_10422_872# vss sky130_fd_pr__nfet_01v8_lvt ad=0.3565 pd=2.92 as=0.18975 ps=1.48 w=1.15 l=0.15
X12 vss a_360_228# a_2192_n1472# vss sky130_fd_pr__nfet_01v8 ad=0.4185 pd=3.32 as=0.22275 ps=1.68 w=1.35 l=0.15
X13 a_6220_308# a_5290_872# vdd vdd sky130_fd_pr__pfet_01v8 ad=0.5075 pd=4.08 as=0.5075 ps=4.08 w=1.75 l=0.15
X14 a_13066_n1152# a_8154_n580# a_12974_n1152# vdd sky130_fd_pr__pfet_01v8 ad=0.231 pd=1.73 as=0.434 ps=3.42 w=1.4 l=0.15
X15 vss a_11630_208# q4n vss sky130_fd_pr__nfet_01v8 ad=0.403 pd=3.22 as=0.2145 ps=1.63 w=1.3 l=0.15
X16 a_8240_n1092# a_8240_872# vdd vdd sky130_fd_pr__pfet_01v8 ad=0.406 pd=3.38 as=0.406 ps=3.38 w=1.4 l=0.15
X17 a_10124_872# a_2192_n1472# vdd vdd sky130_fd_pr__pfet_01v8 ad=0.377 pd=3.18 as=0.377 ps=3.18 w=1.3 l=0.15
X18 a_11630_n1152# a_10422_n1152# vdd vdd sky130_fd_pr__pfet_01v8 ad=0.231 pd=1.73 as=0.434 ps=3.42 w=1.4 l=0.15
X19 a_8240_872# a_3022_486# a_8240_n1092# vdd sky130_fd_pr__pfet_01v8 ad=0.261 pd=2.38 as=0.261 ps=2.38 w=0.9 l=0.15
X20 a_13066_n1152# a_8154_486# a_12974_872# vdd sky130_fd_pr__pfet_01v8 ad=0.231 pd=1.73 as=0.434 ps=3.42 w=1.4 l=0.15
X21 a_14223_n1092# a_14521_872# a_14521_n1092# vss sky130_fd_pr__nfet_01v8_lvt ad=0.372 pd=3.02 as=0.198 ps=1.53 w=1.2 l=0.15
X22 a_7942_n1092# a_8154_n580# a_7894_n468# vss sky130_fd_pr__nfet_01v8_lvt ad=0.231 pd=1.73 as=0.434 ps=3.42 w=1.4 l=0.15
X23 a_10076_n468# a_8154_486# a_10124_n1132# vss sky130_fd_pr__nfet_01v8_lvt ad=0.434 pd=3.42 as=0.231 ps=1.73 w=1.4 l=0.15
X24 a_17911_n1152# a_17911_208# vdd vdd sky130_fd_pr__pfet_01v8 ad=0.1885 pd=1.88 as=0.1885 ps=1.88 w=0.65 l=0.15
X25 vdd a_10422_n1152# a_11630_n1152# vdd sky130_fd_pr__pfet_01v8 ad=0.434 pd=3.42 as=0.231 ps=1.73 w=1.4 l=0.15
X26 vss a_3022_486# a_7894_n468# vss sky130_fd_pr__nfet_01v8_lvt ad=0.341 pd=2.82 as=0.1815 ps=1.43 w=1.1 l=0.15
X27 a_16703_872# a_16703_n1152# a_16405_872# vss sky130_fd_pr__nfet_01v8_lvt ad=0.18975 pd=1.48 as=0.3565 ps=2.92 w=1.15 l=0.15
X28 a_360_228# clkp vdd vdd sky130_fd_pr__pfet_01v8 ad=0.495 pd=3.33 as=0.93 ps=6.62 w=3 l=0.15
X29 a_7894_n468# a_3022_486# vss vss sky130_fd_pr__nfet_01v8_lvt ad=0.1815 pd=1.43 as=0.341 ps=2.82 w=1.1 l=0.15
X30 a_5290_n1152# a_2192_n1472# a_5290_872# vdd sky130_fd_pr__pfet_01v8 ad=0.29 pd=2.58 as=0.29 ps=2.58 w=1 l=0.15
X31 a_16405_872# a_16703_n1152# a_16703_872# vss sky130_fd_pr__nfet_01v8_lvt ad=0.3565 pd=2.92 as=0.18975 ps=1.48 w=1.15 l=0.15
X32 vss a_17911_208# q8n vss sky130_fd_pr__nfet_01v8 ad=0.465 pd=3.62 as=0.2475 ps=1.83 w=1.5 l=0.15
X33 vdd clkp a_360_228# vdd sky130_fd_pr__pfet_01v8 ad=0.93 pd=6.62 as=0.495 ps=3.33 w=3 l=0.15
X34 q2p q2n vss vss sky130_fd_pr__nfet_01v8 ad=0.174 pd=1.78 as=0.174 ps=1.78 w=0.6 l=0.15
X35 a_14521_872# a_3022_486# a_14521_n1092# vdd sky130_fd_pr__pfet_01v8 ad=0.261 pd=2.38 as=0.261 ps=2.38 w=0.9 l=0.15
X36 a_2192_n1472# a_360_228# vdd vdd sky130_fd_pr__pfet_01v8 ad=0.495 pd=3.33 as=0.93 ps=6.62 w=3 l=0.15
X37 a_5290_872# a_5290_n1152# vdd vdd sky130_fd_pr__pfet_01v8 ad=0.435 pd=3.58 as=0.435 ps=3.58 w=1.5 l=0.15
X38 a_16703_872# a_2192_n1472# vdd vdd sky130_fd_pr__pfet_01v8 ad=0.231 pd=1.73 as=0.434 ps=3.42 w=1.4 l=0.15
X39 a_16405_872# a_12974_872# a_16357_n468# vss sky130_fd_pr__nfet_01v8_lvt ad=0.231 pd=1.73 as=0.434 ps=3.42 w=1.4 l=0.15
X40 vdd a_3022_486# a_14521_n1092# vdd sky130_fd_pr__pfet_01v8 ad=0.341 pd=2.82 as=0.1815 ps=1.43 w=1.1 l=0.15
X41 vdd a_360_228# a_2192_n1472# vdd sky130_fd_pr__pfet_01v8 ad=0.93 pd=6.62 as=0.495 ps=3.33 w=3 l=0.15
X42 a_8240_n1092# a_3022_486# vdd vdd sky130_fd_pr__pfet_01v8 ad=0.1815 pd=1.43 as=0.341 ps=2.82 w=1.1 l=0.15
X43 a_360_228# a_360_n1472# vdd vdd sky130_fd_pr__pfet_01v8 ad=0.29 pd=2.58 as=0.29 ps=2.58 w=1 l=0.15
X44 a_2192_n1472# a_360_228# vdd vdd sky130_fd_pr__pfet_01v8 ad=0.495 pd=3.33 as=0.495 ps=3.33 w=3 l=0.15
X45 vss a_3022_486# a_14175_n468# vss sky130_fd_pr__nfet_01v8_lvt ad=0.341 pd=2.82 as=0.1815 ps=1.43 w=1.1 l=0.15
X46 a_12974_n1152# a_8154_n580# a_13066_n1152# vdd sky130_fd_pr__pfet_01v8 ad=0.434 pd=3.42 as=0.231 ps=1.73 w=1.4 l=0.15
X47 vdd a_6498_n1152# q2p vdd sky130_fd_pr__pfet_01v8 ad=0.837 pd=6.02 as=0.4455 ps=3.03 w=2.7 l=0.15
X48 a_14175_n468# a_3022_486# vss vss sky130_fd_pr__nfet_01v8_lvt ad=0.1815 pd=1.43 as=0.341 ps=2.82 w=1.1 l=0.15
X49 q8n a_17911_208# vdd vdd sky130_fd_pr__pfet_01v8 ad=0.5115 pd=3.43 as=0.961 ps=6.82 w=3.1 l=0.15
X50 a_16357_n468# a_12974_n1152# a_16405_n1132# vss sky130_fd_pr__nfet_01v8_lvt ad=0.434 pd=3.42 as=0.231 ps=1.73 w=1.4 l=0.15
X51 vdd a_360_228# a_2192_n1472# vdd sky130_fd_pr__pfet_01v8 ad=0.495 pd=3.33 as=0.495 ps=3.33 w=3 l=0.15
X52 q2p a_6498_n1152# vdd vdd sky130_fd_pr__pfet_01v8 ad=0.4455 pd=3.03 as=0.837 ps=6.02 w=2.7 l=0.15
X53 vdd a_2192_n1472# a_16703_872# vdd sky130_fd_pr__pfet_01v8 ad=0.434 pd=3.42 as=0.231 ps=1.73 w=1.4 l=0.15
X54 a_16357_n468# a_12974_872# a_16405_872# vss sky130_fd_pr__nfet_01v8_lvt ad=0.434 pd=3.42 as=0.231 ps=1.73 w=1.4 l=0.15
X55 q8n q8p vdd vdd sky130_fd_pr__pfet_01v8 ad=0.3915 pd=3.28 as=0.3915 ps=3.28 w=1.35 l=0.15
X56 vss a_964_n1472# vss vss sky130_fd_pr__nfet_01v8 ad=0.145 pd=1.29 as=36.54 ps=304.98001 w=1 l=0.5
X57 q2n q2p vss vss sky130_fd_pr__nfet_01v8 ad=0.174 pd=1.78 as=0.174 ps=1.78 w=0.6 l=0.15
X58 q4p q4n vss vss sky130_fd_pr__nfet_01v8 ad=0.174 pd=1.78 as=0.174 ps=1.78 w=0.6 l=0.15
X59 a_2810_n1132# a_3022_n580# a_2762_n468# vss sky130_fd_pr__nfet_01v8_lvt ad=0.2805 pd=2.03 as=0.527 ps=4.02 w=1.7 l=0.15
X60 a_12974_872# a_8154_486# a_13066_n1152# vdd sky130_fd_pr__pfet_01v8 ad=0.434 pd=3.42 as=0.231 ps=1.73 w=1.4 l=0.15
X61 a_10422_872# a_10422_n1152# vdd vdd sky130_fd_pr__pfet_01v8 ad=0.435 pd=3.58 as=0.435 ps=3.58 w=1.5 l=0.15
X62 a_5290_n1152# a_5290_872# a_4992_n1132# vss sky130_fd_pr__nfet_01v8_lvt ad=0.18975 pd=1.48 as=0.3565 ps=2.92 w=1.15 l=0.15
X63 a_7942_n1092# a_8240_872# a_8240_n1092# vss sky130_fd_pr__nfet_01v8_lvt ad=0.372 pd=3.02 as=0.198 ps=1.53 w=1.2 l=0.15
X64 a_6220_n1222# a_5290_n1152# vss vss sky130_fd_pr__nfet_01v8 ad=0.232 pd=2.18 as=0.232 ps=2.18 w=0.8 l=0.15
X65 a_7894_n468# a_3022_486# vss vss sky130_fd_pr__nfet_01v8_lvt ad=0.1815 pd=1.43 as=0.341 ps=2.82 w=1.1 l=0.15
X66 a_360_n1472# clkn vdd vdd sky130_fd_pr__pfet_01v8 ad=0.495 pd=3.33 as=0.93 ps=6.62 w=3 l=0.15
X67 vss a_3022_486# a_14175_n468# vss sky130_fd_pr__nfet_01v8_lvt ad=0.341 pd=2.82 as=0.1815 ps=1.43 w=1.1 l=0.15
X68 a_12974_872# a_8154_n580# a_13066_872# vdd sky130_fd_pr__pfet_01v8 ad=0.434 pd=3.42 as=0.231 ps=1.73 w=1.4 l=0.15
X69 a_17911_n1152# a_17911_208# vss vss sky130_fd_pr__nfet_01v8 ad=0.1595 pd=1.68 as=0.1595 ps=1.68 w=0.55 l=0.15
X70 a_14223_n1092# a_13066_n1152# a_14175_n468# vss sky130_fd_pr__nfet_01v8_lvt ad=0.231 pd=1.73 as=0.434 ps=3.42 w=1.4 l=0.15
X71 a_13066_872# a_8154_n580# a_12974_872# vdd sky130_fd_pr__pfet_01v8 ad=0.231 pd=1.73 as=0.434 ps=3.42 w=1.4 l=0.15
X72 a_12974_n1152# a_8154_486# a_13066_872# vdd sky130_fd_pr__pfet_01v8 ad=0.434 pd=3.42 as=0.231 ps=1.73 w=1.4 l=0.15
X73 a_13066_872# a_8154_486# a_12974_n1152# vdd sky130_fd_pr__pfet_01v8 ad=0.231 pd=1.73 as=0.434 ps=3.42 w=1.4 l=0.15
X74 a_6498_n1152# a_6220_308# vss vss sky130_fd_pr__nfet_01v8_lvt ad=0.2145 pd=1.63 as=0.403 ps=3.22 w=1.3 l=0.15
X75 a_360_n1472# a_360_228# vdd vdd sky130_fd_pr__pfet_01v8 ad=0.29 pd=2.58 as=0.29 ps=2.58 w=1 l=0.15
X76 vss a_9170_308# a_8154_486# vss sky130_fd_pr__nfet_01v8_lvt ad=0.434 pd=3.42 as=0.231 ps=1.73 w=1.4 l=0.15
X77 a_2192_n1472# a_360_228# vss vss sky130_fd_pr__nfet_01v8 ad=0.22275 pd=1.68 as=0.22275 ps=1.68 w=1.35 l=0.15
X78 a_4992_872# a_2192_n1472# vdd vdd sky130_fd_pr__pfet_01v8 ad=0.377 pd=3.18 as=0.377 ps=3.18 w=1.3 l=0.15
X79 vdd a_17911_208# q8n vdd sky130_fd_pr__pfet_01v8 ad=0.961 pd=6.82 as=0.5115 ps=3.43 w=3.1 l=0.15
X80 a_16703_872# a_16703_n1152# vdd vdd sky130_fd_pr__pfet_01v8 ad=0.435 pd=3.58 as=0.435 ps=3.58 w=1.5 l=0.15
X81 a_11352_308# a_10422_872# vss vss sky130_fd_pr__nfet_01v8 ad=0.232 pd=2.18 as=0.232 ps=2.18 w=0.8 l=0.15
X82 q4n a_11630_208# vss vss sky130_fd_pr__nfet_01v8 ad=0.2145 pd=1.63 as=0.403 ps=3.22 w=1.3 l=0.15
X83 a_17911_n1152# a_17633_308# vss vss sky130_fd_pr__nfet_01v8_lvt ad=0.2145 pd=1.63 as=0.403 ps=3.22 w=1.3 l=0.15
X84 vdd a_2192_n1472# a_5290_n1152# vdd sky130_fd_pr__pfet_01v8 ad=0.434 pd=3.42 as=0.231 ps=1.73 w=1.4 l=0.15
X85 a_4038_n1222# a_3108_n1152# vss vss sky130_fd_pr__nfet_01v8 ad=0.232 pd=2.18 as=0.232 ps=2.18 w=0.8 l=0.15
X86 a_13066_n1152# a_8154_n580# a_12974_872# vss sky130_fd_pr__nfet_01v8 ad=0.377 pd=3.18 as=0.377 ps=3.18 w=1.3 l=0.15
X87 a_10422_n1152# a_10422_872# vdd vdd sky130_fd_pr__pfet_01v8 ad=0.435 pd=3.58 as=0.435 ps=3.58 w=1.5 l=0.15
X88 a_14521_n1092# a_14521_872# a_14223_n1092# vss sky130_fd_pr__nfet_01v8_lvt ad=0.198 pd=1.53 as=0.372 ps=3.02 w=1.2 l=0.15
X89 vdd a_360_228# a_2192_n1472# vdd sky130_fd_pr__pfet_01v8 ad=0.495 pd=3.33 as=0.495 ps=3.33 w=3 l=0.15
X90 a_2810_n1132# a_3108_872# a_3108_n1152# vss sky130_fd_pr__nfet_01v8_lvt ad=0.434 pd=3.42 as=0.231 ps=1.73 w=1.4 l=0.15
X91 a_15451_n1222# a_14521_n1092# vss vss sky130_fd_pr__nfet_01v8 ad=0.232 pd=2.18 as=0.232 ps=2.18 w=0.8 l=0.15
X92 a_8240_872# a_3022_486# vdd vdd sky130_fd_pr__pfet_01v8 ad=0.1815 pd=1.43 as=0.341 ps=2.82 w=1.1 l=0.15
X93 a_7942_872# a_8154_486# a_7894_n468# vss sky130_fd_pr__nfet_01v8_lvt ad=0.231 pd=1.73 as=0.434 ps=3.42 w=1.4 l=0.15
X94 a_2762_n468# a_2192_n1472# vss vss sky130_fd_pr__nfet_01v8_lvt ad=0.22275 pd=1.68 as=0.4185 ps=3.32 w=1.35 l=0.15
X95 a_16703_n1152# a_16703_872# a_16405_n1132# vss sky130_fd_pr__nfet_01v8_lvt ad=0.18975 pd=1.48 as=0.3565 ps=2.92 w=1.15 l=0.15
X96 a_6498_n1152# a_5290_n1152# vdd vdd sky130_fd_pr__pfet_01v8 ad=0.231 pd=1.73 as=0.434 ps=3.42 w=1.4 l=0.15
X97 a_4992_n1132# a_2192_n1472# vdd vdd sky130_fd_pr__pfet_01v8 ad=0.377 pd=3.18 as=0.377 ps=3.18 w=1.3 l=0.15
X98 vdd a_5290_872# a_6498_208# vdd sky130_fd_pr__pfet_01v8 ad=0.434 pd=3.42 as=0.231 ps=1.73 w=1.4 l=0.15
X99 a_8154_486# a_8154_n580# vss vss sky130_fd_pr__nfet_01v8 ad=0.2175 pd=2.08 as=0.2175 ps=2.08 w=0.75 l=0.15
X100 vdd a_3022_486# a_8240_872# vdd sky130_fd_pr__pfet_01v8 ad=0.341 pd=2.82 as=0.1815 ps=1.43 w=1.1 l=0.15
X101 a_7894_n468# a_8154_486# a_7942_872# vss sky130_fd_pr__nfet_01v8_lvt ad=0.434 pd=3.42 as=0.231 ps=1.73 w=1.4 l=0.15
X102 a_6498_208# a_5290_872# vdd vdd sky130_fd_pr__pfet_01v8 ad=0.231 pd=1.73 as=0.434 ps=3.42 w=1.4 l=0.15
X103 q8n a_17911_208# vss vss sky130_fd_pr__nfet_01v8 ad=0.2475 pd=1.83 as=0.465 ps=3.62 w=1.5 l=0.15
X104 q2n q2p vdd vdd sky130_fd_pr__pfet_01v8 ad=0.3625 pd=3.08 as=0.3625 ps=3.08 w=1.25 l=0.15
X105 a_11352_308# a_10422_872# vdd vdd sky130_fd_pr__pfet_01v8 ad=0.5075 pd=4.08 as=0.5075 ps=4.08 w=1.75 l=0.15
X106 a_3022_486# a_3022_n580# vdd vdd sky130_fd_pr__pfet_01v8 ad=0.1885 pd=1.88 as=0.1885 ps=1.88 w=0.65 l=0.15
X107 a_3022_486# a_3108_n1152# vdd vdd sky130_fd_pr__pfet_01v8 ad=0.3135 pd=2.23 as=0.589 ps=4.42 w=1.9 l=0.15
X108 a_3108_872# a_3108_n1152# vdd vdd sky130_fd_pr__pfet_01v8 ad=0.464 pd=3.78 as=0.464 ps=3.78 w=1.6 l=0.15
X109 a_14521_872# a_3022_486# vdd vdd sky130_fd_pr__pfet_01v8 ad=0.1815 pd=1.43 as=0.341 ps=2.82 w=1.1 l=0.15
X110 a_14223_872# a_13066_872# a_14175_n468# vss sky130_fd_pr__nfet_01v8_lvt ad=0.231 pd=1.73 as=0.434 ps=3.42 w=1.4 l=0.15
X111 a_16703_n1152# a_2192_n1472# vdd vdd sky130_fd_pr__pfet_01v8 ad=0.231 pd=1.73 as=0.434 ps=3.42 w=1.4 l=0.15
X112 a_3108_n1152# a_3108_872# vdd vdd sky130_fd_pr__pfet_01v8 ad=0.464 pd=3.78 as=0.464 ps=3.78 w=1.6 l=0.15
X113 vss a_15451_308# a_12974_n1152# vss sky130_fd_pr__nfet_01v8_lvt ad=0.434 pd=3.42 as=0.231 ps=1.73 w=1.4 l=0.15
X114 vdd a_10422_872# a_11630_208# vdd sky130_fd_pr__pfet_01v8 ad=0.434 pd=3.42 as=0.231 ps=1.73 w=1.4 l=0.15
X115 vdd a_3022_486# a_14521_872# vdd sky130_fd_pr__pfet_01v8 ad=0.341 pd=2.82 as=0.1815 ps=1.43 w=1.1 l=0.15
X116 a_14175_n468# a_13066_872# a_14223_872# vss sky130_fd_pr__nfet_01v8_lvt ad=0.434 pd=3.42 as=0.231 ps=1.73 w=1.4 l=0.15
X117 vdd a_360_n1472# a_964_n1472# vdd sky130_fd_pr__pfet_01v8 ad=0.93 pd=6.62 as=0.495 ps=3.33 w=3 l=0.15
X118 vss a_4038_n1222# a_3022_n580# vss sky130_fd_pr__nfet_01v8_lvt ad=0.527 pd=4.02 as=0.2805 ps=2.03 w=1.7 l=0.15
X119 vss a_6498_n1152# q2p vss sky130_fd_pr__nfet_01v8 ad=0.403 pd=3.22 as=0.2145 ps=1.63 w=1.3 l=0.15
X120 a_4944_n468# a_3022_486# a_4992_n1132# vss sky130_fd_pr__nfet_01v8_lvt ad=0.434 pd=3.42 as=0.231 ps=1.73 w=1.4 l=0.15
X121 a_14521_n1092# a_3022_486# a_14521_872# vdd sky130_fd_pr__pfet_01v8 ad=0.261 pd=2.38 as=0.261 ps=2.38 w=0.9 l=0.15
X122 a_16405_872# a_2192_n1472# vdd vdd sky130_fd_pr__pfet_01v8 ad=0.377 pd=3.18 as=0.377 ps=3.18 w=1.3 l=0.15
X123 vss a_964_n1472# vss vss sky130_fd_pr__nfet_01v8 ad=0.145 pd=1.29 as=0 ps=0 w=1 l=0.5
X124 a_2192_n1472# a_360_228# vdd vdd sky130_fd_pr__pfet_01v8 ad=0.495 pd=3.33 as=0.495 ps=3.33 w=3 l=0.15
X125 a_3022_n580# a_4038_n1222# vss vss sky130_fd_pr__nfet_01v8_lvt ad=0.2805 pd=2.03 as=0.527 ps=4.02 w=1.7 l=0.15
X126 q2p a_6498_n1152# vss vss sky130_fd_pr__nfet_01v8 ad=0.2145 pd=1.63 as=0.403 ps=3.22 w=1.3 l=0.15
X127 a_8240_n1092# a_8240_872# a_7942_n1092# vss sky130_fd_pr__nfet_01v8_lvt ad=0.198 pd=1.53 as=0.372 ps=3.02 w=1.2 l=0.15
X128 a_14175_n468# a_3022_486# vss vss sky130_fd_pr__nfet_01v8_lvt ad=0.1815 pd=1.43 as=0.341 ps=2.82 w=1.1 l=0.15
X129 a_6498_208# a_6498_n1152# vdd vdd sky130_fd_pr__pfet_01v8 ad=0.1885 pd=1.88 as=0.1885 ps=1.88 w=0.65 l=0.15
X130 a_360_n1472# clkn vss vss sky130_fd_pr__nfet_01v8 ad=0.198 pd=1.53 as=0.372 ps=3.02 w=1.2 l=0.15
X131 a_9170_n1222# a_8240_n1092# vss vss sky130_fd_pr__nfet_01v8 ad=0.232 pd=2.18 as=0.232 ps=2.18 w=0.8 l=0.15
X132 a_10124_n1132# a_10422_872# a_10422_n1152# vss sky130_fd_pr__nfet_01v8_lvt ad=0.3565 pd=2.92 as=0.18975 ps=1.48 w=1.15 l=0.15
X133 a_11630_n1152# a_11630_208# vdd vdd sky130_fd_pr__pfet_01v8 ad=0.1885 pd=1.88 as=0.1885 ps=1.88 w=0.65 l=0.15
X134 vdd a_5290_n1152# a_6498_n1152# vdd sky130_fd_pr__pfet_01v8 ad=0.434 pd=3.42 as=0.231 ps=1.73 w=1.4 l=0.15
X135 a_8240_872# a_8240_n1092# vdd vdd sky130_fd_pr__pfet_01v8 ad=0.406 pd=3.38 as=0.406 ps=3.38 w=1.4 l=0.15
X136 a_11630_208# a_11630_n1152# vdd vdd sky130_fd_pr__pfet_01v8 ad=0.1885 pd=1.88 as=0.1885 ps=1.88 w=0.65 l=0.15
X137 a_3022_486# a_3022_n580# vss vss sky130_fd_pr__nfet_01v8 ad=0.2465 pd=2.28 as=0.2465 ps=2.28 w=0.85 l=0.15
X138 a_16703_n1152# a_2192_n1472# a_16703_872# vdd sky130_fd_pr__pfet_01v8 ad=0.29 pd=2.58 as=0.29 ps=2.58 w=1 l=0.15
X139 q2p q2n vdd vdd sky130_fd_pr__pfet_01v8 ad=0.3625 pd=3.08 as=0.3625 ps=3.08 w=1.25 l=0.15
X140 vdd a_3108_n1152# a_3022_486# vdd sky130_fd_pr__pfet_01v8 ad=0.589 pd=4.42 as=0.3135 ps=2.23 w=1.9 l=0.15
X141 a_964_n1472# a_360_n1472# vdd vdd sky130_fd_pr__pfet_01v8 ad=0.495 pd=3.33 as=0.93 ps=6.62 w=3 l=0.15
X142 a_14223_n1092# a_3022_486# vdd vdd sky130_fd_pr__pfet_01v8 ad=0.319 pd=2.78 as=0.319 ps=2.78 w=1.1 l=0.15
X143 vdd a_11630_n1152# q4p vdd sky130_fd_pr__pfet_01v8 ad=0.837 pd=6.02 as=0.4455 ps=3.03 w=2.7 l=0.15
X144 a_8154_486# a_9170_308# vss vss sky130_fd_pr__nfet_01v8_lvt ad=0.231 pd=1.73 as=0.434 ps=3.42 w=1.4 l=0.15
X145 a_2810_872# a_2192_n1472# vdd vdd sky130_fd_pr__pfet_01v8 ad=0.377 pd=3.18 as=0.377 ps=3.18 w=1.3 l=0.15
X146 vss a_6220_n1222# a_6498_208# vss sky130_fd_pr__nfet_01v8_lvt ad=0.403 pd=3.22 as=0.2145 ps=1.63 w=1.3 l=0.15
X147 vss a_360_228# a_2192_n1472# vss sky130_fd_pr__nfet_01v8 ad=0.22275 pd=1.68 as=0.22275 ps=1.68 w=1.35 l=0.15
X148 q4p a_11630_n1152# vdd vdd sky130_fd_pr__pfet_01v8 ad=0.4455 pd=3.03 as=0.837 ps=6.02 w=2.7 l=0.15
X149 a_4038_308# a_3108_872# vss vss sky130_fd_pr__nfet_01v8 ad=0.232 pd=2.18 as=0.232 ps=2.18 w=0.8 l=0.15
X150 vss a_964_n1472# vss vss sky130_fd_pr__nfet_01v8 ad=0.29 pd=2.58 as=0 ps=0 w=1 l=0.5
X151 q4p q4n vdd vdd sky130_fd_pr__pfet_01v8 ad=0.3625 pd=3.08 as=0.3625 ps=3.08 w=1.25 l=0.15
X152 a_6498_208# a_6220_n1222# vss vss sky130_fd_pr__nfet_01v8_lvt ad=0.2145 pd=1.63 as=0.403 ps=3.22 w=1.3 l=0.15
X153 a_12974_n1152# a_14521_n1092# vdd vdd sky130_fd_pr__pfet_01v8 ad=0.2475 pd=1.83 as=0.465 ps=3.62 w=1.5 l=0.15
X154 vss a_17911_n1152# q8p vss sky130_fd_pr__nfet_01v8 ad=0.465 pd=3.62 as=0.2475 ps=1.83 w=1.5 l=0.15
X155 vdd a_3022_486# a_8240_n1092# vdd sky130_fd_pr__pfet_01v8 ad=0.341 pd=2.82 as=0.1815 ps=1.43 w=1.1 l=0.15
X156 a_3108_n1152# a_2192_n1472# vdd vdd sky130_fd_pr__pfet_01v8 ad=0.231 pd=1.73 as=0.434 ps=3.42 w=1.4 l=0.15
X157 vdd a_360_228# a_2192_n1472# vdd sky130_fd_pr__pfet_01v8 ad=0.93 pd=6.62 as=0.495 ps=3.33 w=3 l=0.15
X158 a_17911_208# a_17911_n1152# vdd vdd sky130_fd_pr__pfet_01v8 ad=0.1885 pd=1.88 as=0.1885 ps=1.88 w=0.65 l=0.15
X159 q8p a_17911_n1152# vss vss sky130_fd_pr__nfet_01v8 ad=0.2475 pd=1.83 as=0.465 ps=3.62 w=1.5 l=0.15
X160 a_17911_n1152# a_16703_n1152# vdd vdd sky130_fd_pr__pfet_01v8 ad=0.231 pd=1.73 as=0.434 ps=3.42 w=1.4 l=0.15
X161 a_9170_308# a_8240_872# vss vss sky130_fd_pr__nfet_01v8 ad=0.232 pd=2.18 as=0.232 ps=2.18 w=0.8 l=0.15
X162 vss a_11352_n1222# a_11630_208# vss sky130_fd_pr__nfet_01v8_lvt ad=0.403 pd=3.22 as=0.2145 ps=1.63 w=1.3 l=0.15
X163 a_3108_n1152# a_3108_872# a_2810_n1132# vss sky130_fd_pr__nfet_01v8_lvt ad=0.231 pd=1.73 as=0.434 ps=3.42 w=1.4 l=0.15
X164 a_8240_n1092# a_3022_486# a_8240_872# vdd sky130_fd_pr__pfet_01v8 ad=0.261 pd=2.38 as=0.261 ps=2.38 w=0.9 l=0.15
X165 vdd a_3108_872# a_3022_n580# vdd sky130_fd_pr__pfet_01v8 ad=0.589 pd=4.42 as=0.3135 ps=2.23 w=1.9 l=0.15
X166 a_12974_n1152# a_12974_872# vss vss sky130_fd_pr__nfet_01v8 ad=0.2175 pd=2.08 as=0.2175 ps=2.08 w=0.75 l=0.15
X167 vss a_2192_n1472# a_4944_n468# vss sky130_fd_pr__nfet_01v8_lvt ad=0.341 pd=2.82 as=0.1815 ps=1.43 w=1.1 l=0.15
X168 vss a_2192_n1472# a_10076_n468# vss sky130_fd_pr__nfet_01v8_lvt ad=0.341 pd=2.82 as=0.1815 ps=1.43 w=1.1 l=0.15
X169 a_4038_308# a_3108_872# vdd vdd sky130_fd_pr__pfet_01v8 ad=0.5075 pd=4.08 as=0.5075 ps=4.08 w=1.75 l=0.15
X170 a_3022_n580# a_3108_872# vdd vdd sky130_fd_pr__pfet_01v8 ad=0.3135 pd=2.23 as=0.589 ps=4.42 w=1.9 l=0.15
X171 vdd clkn a_360_n1472# vdd sky130_fd_pr__pfet_01v8 ad=0.93 pd=6.62 as=0.495 ps=3.33 w=3 l=0.15
X172 a_10124_n1132# a_8154_486# a_10076_n468# vss sky130_fd_pr__nfet_01v8_lvt ad=0.231 pd=1.73 as=0.434 ps=3.42 w=1.4 l=0.15
X173 a_10422_872# a_2192_n1472# a_10422_n1152# vdd sky130_fd_pr__pfet_01v8 ad=0.29 pd=2.58 as=0.29 ps=2.58 w=1 l=0.15
X174 a_10422_n1152# a_2192_n1472# vdd vdd sky130_fd_pr__pfet_01v8 ad=0.231 pd=1.73 as=0.434 ps=3.42 w=1.4 l=0.15
X175 a_7942_872# a_8240_n1092# a_8240_872# vss sky130_fd_pr__nfet_01v8_lvt ad=0.372 pd=3.02 as=0.198 ps=1.53 w=1.2 l=0.15
X176 vdd a_14521_n1092# a_12974_n1152# vdd sky130_fd_pr__pfet_01v8 ad=0.465 pd=3.62 as=0.2475 ps=1.83 w=1.5 l=0.15
X177 a_9170_308# a_8240_872# vdd vdd sky130_fd_pr__pfet_01v8 ad=0.5075 pd=4.08 as=0.5075 ps=4.08 w=1.75 l=0.15
X178 a_8240_872# a_8240_n1092# a_7942_872# vss sky130_fd_pr__nfet_01v8_lvt ad=0.198 pd=1.53 as=0.372 ps=3.02 w=1.2 l=0.15
X179 vss a_2192_n1472# a_10076_n468# vss sky130_fd_pr__nfet_01v8_lvt ad=0.341 pd=2.82 as=0.1815 ps=1.43 w=1.1 l=0.15
X180 vss a_6498_208# q2n vss sky130_fd_pr__nfet_01v8 ad=0.403 pd=3.22 as=0.2145 ps=1.63 w=1.3 l=0.15
X181 a_12974_n1152# a_15451_308# vss vss sky130_fd_pr__nfet_01v8_lvt ad=0.231 pd=1.73 as=0.434 ps=3.42 w=1.4 l=0.15
X182 a_11630_208# a_10422_872# vdd vdd sky130_fd_pr__pfet_01v8 ad=0.231 pd=1.73 as=0.434 ps=3.42 w=1.4 l=0.15
X183 a_14223_872# a_3022_486# vdd vdd sky130_fd_pr__pfet_01v8 ad=0.319 pd=2.78 as=0.319 ps=2.78 w=1.1 l=0.15
X184 a_17633_308# a_16703_872# vss vss sky130_fd_pr__nfet_01v8 ad=0.232 pd=2.18 as=0.232 ps=2.18 w=0.8 l=0.15
X185 vss a_4038_308# a_3022_486# vss sky130_fd_pr__nfet_01v8_lvt ad=0.527 pd=4.02 as=0.2805 ps=2.03 w=1.7 l=0.15
X186 a_7894_n468# a_8154_n580# a_7942_n1092# vss sky130_fd_pr__nfet_01v8_lvt ad=0.434 pd=3.42 as=0.231 ps=1.73 w=1.4 l=0.15
X187 a_10076_n468# a_2192_n1472# vss vss sky130_fd_pr__nfet_01v8_lvt ad=0.1815 pd=1.43 as=0.341 ps=2.82 w=1.1 l=0.15
X188 vdd a_2192_n1472# a_3108_n1152# vdd sky130_fd_pr__pfet_01v8 ad=0.434 pd=3.42 as=0.231 ps=1.73 w=1.4 l=0.15
X189 vss a_2192_n1472# a_16357_n468# vss sky130_fd_pr__nfet_01v8_lvt ad=0.341 pd=2.82 as=0.1815 ps=1.43 w=1.1 l=0.15
X190 a_8154_486# a_8154_n580# vdd vdd sky130_fd_pr__pfet_01v8 ad=0.174 pd=1.78 as=0.174 ps=1.78 w=0.6 l=0.15
X191 a_5290_n1152# a_5290_872# vdd vdd sky130_fd_pr__pfet_01v8 ad=0.435 pd=3.58 as=0.435 ps=3.58 w=1.5 l=0.15
X192 a_3022_n580# a_3022_486# vdd vdd sky130_fd_pr__pfet_01v8 ad=0.2755 pd=2.48 as=0.2755 ps=2.48 w=0.95 l=0.15
X193 a_16405_n1132# a_12974_n1152# a_16357_n468# vss sky130_fd_pr__nfet_01v8_lvt ad=0.231 pd=1.73 as=0.434 ps=3.42 w=1.4 l=0.15
X194 a_16405_n1132# a_2192_n1472# vdd vdd sky130_fd_pr__pfet_01v8 ad=0.377 pd=3.18 as=0.377 ps=3.18 w=1.3 l=0.15
X195 a_11352_n1222# a_10422_n1152# vss vss sky130_fd_pr__nfet_01v8 ad=0.232 pd=2.18 as=0.232 ps=2.18 w=0.8 l=0.15
X196 a_17633_n1222# a_16703_n1152# vdd vdd sky130_fd_pr__pfet_01v8 ad=0.5075 pd=4.08 as=0.5075 ps=4.08 w=1.75 l=0.15
X197 a_10422_n1152# a_2192_n1472# a_10422_872# vdd sky130_fd_pr__pfet_01v8 ad=0.29 pd=2.58 as=0.29 ps=2.58 w=1 l=0.15
X198 a_2810_n1132# a_2192_n1472# vdd vdd sky130_fd_pr__pfet_01v8 ad=0.377 pd=3.18 as=0.377 ps=3.18 w=1.3 l=0.15
X199 a_17633_308# a_16703_872# vdd vdd sky130_fd_pr__pfet_01v8 ad=0.5075 pd=4.08 as=0.5075 ps=4.08 w=1.75 l=0.15
X200 a_17911_208# a_16703_872# vdd vdd sky130_fd_pr__pfet_01v8 ad=0.231 pd=1.73 as=0.434 ps=3.42 w=1.4 l=0.15
X201 vss a_11630_n1152# q4p vss sky130_fd_pr__nfet_01v8 ad=0.403 pd=3.22 as=0.2145 ps=1.63 w=1.3 l=0.15
X202 vss a_360_n1472# a_964_n1472# vss sky130_fd_pr__nfet_01v8 ad=0.4185 pd=3.32 as=0.22275 ps=1.68 w=1.35 l=0.15
X203 vss a_964_n1472# vss vss sky130_fd_pr__nfet_01v8 ad=0.145 pd=1.29 as=0 ps=0 w=1 l=0.5
X204 vdd a_16703_872# a_17911_208# vdd sky130_fd_pr__pfet_01v8 ad=0.434 pd=3.42 as=0.231 ps=1.73 w=1.4 l=0.15
X205 q4p a_11630_n1152# vss vss sky130_fd_pr__nfet_01v8 ad=0.2145 pd=1.63 as=0.403 ps=3.22 w=1.3 l=0.15
X206 a_8154_n580# a_8154_486# vdd vdd sky130_fd_pr__pfet_01v8 ad=0.2465 pd=2.28 as=0.2465 ps=2.28 w=0.85 l=0.15
X207 vdd a_2192_n1472# a_16703_n1152# vdd sky130_fd_pr__pfet_01v8 ad=0.434 pd=3.42 as=0.231 ps=1.73 w=1.4 l=0.15
X208 a_360_228# clkp vss vss sky130_fd_pr__nfet_01v8 ad=0.198 pd=1.53 as=0.372 ps=3.02 w=1.2 l=0.15
X209 vss a_11352_308# a_11630_n1152# vss sky130_fd_pr__nfet_01v8_lvt ad=0.403 pd=3.22 as=0.2145 ps=1.63 w=1.3 l=0.15
X210 a_17633_n1222# a_16703_n1152# vss vss sky130_fd_pr__nfet_01v8 ad=0.232 pd=2.18 as=0.232 ps=2.18 w=0.8 l=0.15
X211 a_4992_872# a_5290_n1152# a_5290_872# vss sky130_fd_pr__nfet_01v8_lvt ad=0.3565 pd=2.92 as=0.18975 ps=1.48 w=1.15 l=0.15
X212 a_4944_n468# a_2192_n1472# vss vss sky130_fd_pr__nfet_01v8_lvt ad=0.1815 pd=1.43 as=0.341 ps=2.82 w=1.1 l=0.15
X213 a_14521_872# a_14521_n1092# vdd vdd sky130_fd_pr__pfet_01v8 ad=0.406 pd=3.38 as=0.406 ps=3.38 w=1.4 l=0.15
X214 a_14175_n468# a_13066_n1152# a_14223_n1092# vss sky130_fd_pr__nfet_01v8_lvt ad=0.434 pd=3.42 as=0.231 ps=1.73 w=1.4 l=0.15
X215 vss clkp a_360_228# vss sky130_fd_pr__nfet_01v8 ad=0.372 pd=3.02 as=0.198 ps=1.53 w=1.2 l=0.15
X216 a_5290_872# a_5290_n1152# a_4992_872# vss sky130_fd_pr__nfet_01v8_lvt ad=0.18975 pd=1.48 as=0.3565 ps=2.92 w=1.15 l=0.15
X217 a_5290_872# a_2192_n1472# vdd vdd sky130_fd_pr__pfet_01v8 ad=0.231 pd=1.73 as=0.434 ps=3.42 w=1.4 l=0.15
X218 a_4992_872# a_3022_n580# a_4944_n468# vss sky130_fd_pr__nfet_01v8_lvt ad=0.231 pd=1.73 as=0.434 ps=3.42 w=1.4 l=0.15
X219 a_11630_208# a_11352_n1222# vss vss sky130_fd_pr__nfet_01v8_lvt ad=0.2145 pd=1.63 as=0.403 ps=3.22 w=1.3 l=0.15
X220 a_12974_872# a_12974_n1152# vdd vdd sky130_fd_pr__pfet_01v8 ad=0.2465 pd=2.28 as=0.2465 ps=2.28 w=0.85 l=0.15
X221 a_10076_n468# a_2192_n1472# vss vss sky130_fd_pr__nfet_01v8_lvt ad=0.1815 pd=1.43 as=0.341 ps=2.82 w=1.1 l=0.15
X222 a_360_n1472# a_360_228# vss vss sky130_fd_pr__nfet_01v8 ad=0.1305 pd=1.48 as=0.1305 ps=1.48 w=0.45 l=0.15
X223 a_14521_n1092# a_3022_486# vdd vdd sky130_fd_pr__pfet_01v8 ad=0.1815 pd=1.43 as=0.341 ps=2.82 w=1.1 l=0.15
X224 vdd a_2192_n1472# a_5290_872# vdd sky130_fd_pr__pfet_01v8 ad=0.434 pd=3.42 as=0.231 ps=1.73 w=1.4 l=0.15
X225 a_5290_872# a_2192_n1472# a_5290_n1152# vdd sky130_fd_pr__pfet_01v8 ad=0.29 pd=2.58 as=0.29 ps=2.58 w=1 l=0.15
X226 a_4944_n468# a_3022_n580# a_4992_872# vss sky130_fd_pr__nfet_01v8_lvt ad=0.434 pd=3.42 as=0.231 ps=1.73 w=1.4 l=0.15
X227 a_8154_n580# a_8154_486# vss vss sky130_fd_pr__nfet_01v8 ad=0.145 pd=1.58 as=0.145 ps=1.58 w=0.5 l=0.15
X228 vss a_17633_308# a_17911_n1152# vss sky130_fd_pr__nfet_01v8_lvt ad=0.403 pd=3.22 as=0.2145 ps=1.63 w=1.3 l=0.15
X229 a_4038_n1222# a_3108_n1152# vdd vdd sky130_fd_pr__pfet_01v8 ad=0.5075 pd=4.08 as=0.5075 ps=4.08 w=1.75 l=0.15
X230 a_10422_872# a_2192_n1472# vdd vdd sky130_fd_pr__pfet_01v8 ad=0.231 pd=1.73 as=0.434 ps=3.42 w=1.4 l=0.15
X231 vdd a_17911_n1152# q8p vdd sky130_fd_pr__pfet_01v8 ad=0.961 pd=6.82 as=0.5115 ps=3.43 w=3.1 l=0.15
X232 a_10124_872# a_8154_n580# a_10076_n468# vss sky130_fd_pr__nfet_01v8_lvt ad=0.231 pd=1.73 as=0.434 ps=3.42 w=1.4 l=0.15
X233 a_7942_872# a_3022_486# vdd vdd sky130_fd_pr__pfet_01v8 ad=0.319 pd=2.78 as=0.319 ps=2.78 w=1.1 l=0.15
X234 a_2762_n468# a_2192_n1472# vss vss sky130_fd_pr__nfet_01v8_lvt ad=0.22275 pd=1.68 as=0.4185 ps=3.32 w=1.35 l=0.15
X235 a_6498_208# a_6498_n1152# vss vss sky130_fd_pr__nfet_01v8 ad=0.1595 pd=1.68 as=0.1595 ps=1.68 w=0.55 l=0.15
X236 q8p a_17911_n1152# vdd vdd sky130_fd_pr__pfet_01v8 ad=0.5115 pd=3.43 as=0.961 ps=6.82 w=3.1 l=0.15
X237 a_11630_n1152# a_11630_208# vss vss sky130_fd_pr__nfet_01v8 ad=0.1595 pd=1.68 as=0.1595 ps=1.68 w=0.55 l=0.15
X238 a_4944_n468# a_2192_n1472# vss vss sky130_fd_pr__nfet_01v8_lvt ad=0.1815 pd=1.43 as=0.341 ps=2.82 w=1.1 l=0.15
X239 a_11630_208# a_11630_n1152# vss vss sky130_fd_pr__nfet_01v8 ad=0.1595 pd=1.68 as=0.1595 ps=1.68 w=0.55 l=0.15
X240 a_13066_872# a_8154_486# a_12974_872# vss sky130_fd_pr__nfet_01v8 ad=0.377 pd=3.18 as=0.377 ps=3.18 w=1.3 l=0.15
X241 q2n a_6498_208# vss vss sky130_fd_pr__nfet_01v8 ad=0.2145 pd=1.63 as=0.403 ps=3.22 w=1.3 l=0.15
X242 q8p q8n vdd vdd sky130_fd_pr__pfet_01v8 ad=0.3915 pd=3.28 as=0.3915 ps=3.28 w=1.35 l=0.15
X243 a_15451_308# a_14521_872# vss vss sky130_fd_pr__nfet_01v8 ad=0.232 pd=2.18 as=0.232 ps=2.18 w=0.8 l=0.15
X244 q8p q8n vss vss sky130_fd_pr__nfet_01v8 ad=0.1885 pd=1.88 as=0.1885 ps=1.88 w=0.65 l=0.15
X245 a_3022_486# a_4038_308# vss vss sky130_fd_pr__nfet_01v8_lvt ad=0.2805 pd=2.03 as=0.527 ps=4.02 w=1.7 l=0.15
X246 vdd a_2192_n1472# a_10422_872# vdd sky130_fd_pr__pfet_01v8 ad=0.434 pd=3.42 as=0.231 ps=1.73 w=1.4 l=0.15
X247 vss a_2192_n1472# a_2762_n468# vss sky130_fd_pr__nfet_01v8_lvt ad=0.4185 pd=3.32 as=0.22275 ps=1.68 w=1.35 l=0.15
X248 a_10076_n468# a_8154_n580# a_10124_872# vss sky130_fd_pr__nfet_01v8_lvt ad=0.434 pd=3.42 as=0.231 ps=1.73 w=1.4 l=0.15
X249 a_13066_872# a_8154_n580# a_12974_n1152# vss sky130_fd_pr__nfet_01v8 ad=0.377 pd=3.18 as=0.377 ps=3.18 w=1.3 l=0.15
X250 a_17911_208# a_17633_n1222# vss vss sky130_fd_pr__nfet_01v8_lvt ad=0.2145 pd=1.63 as=0.403 ps=3.22 w=1.3 l=0.15
X251 vss a_2192_n1472# a_2762_n468# vss sky130_fd_pr__nfet_01v8_lvt ad=0.4185 pd=3.32 as=0.22275 ps=1.68 w=1.35 l=0.15
X252 q4n a_11630_208# vdd vdd sky130_fd_pr__pfet_01v8 ad=0.4455 pd=3.03 as=0.837 ps=6.02 w=2.7 l=0.15
X253 a_16405_n1132# a_16703_872# a_16703_n1152# vss sky130_fd_pr__nfet_01v8_lvt ad=0.3565 pd=2.92 as=0.18975 ps=1.48 w=1.15 l=0.15
X254 q2n a_6498_208# vdd vdd sky130_fd_pr__pfet_01v8 ad=0.4455 pd=3.03 as=0.837 ps=6.02 w=2.7 l=0.15
X255 a_3108_n1152# a_2192_n1472# a_3108_872# vdd sky130_fd_pr__pfet_01v8 ad=0.319 pd=2.78 as=0.319 ps=2.78 w=1.1 l=0.15
X256 a_2762_n468# a_3022_486# a_2810_872# vss sky130_fd_pr__nfet_01v8_lvt ad=0.527 pd=4.02 as=0.2805 ps=2.03 w=1.7 l=0.15
X257 a_16357_n468# a_2192_n1472# vss vss sky130_fd_pr__nfet_01v8_lvt ad=0.1815 pd=1.43 as=0.341 ps=2.82 w=1.1 l=0.15
X258 a_12974_872# a_12974_n1152# vss vss sky130_fd_pr__nfet_01v8 ad=0.145 pd=1.58 as=0.145 ps=1.58 w=0.5 l=0.15
X259 vss a_2192_n1472# a_4944_n468# vss sky130_fd_pr__nfet_01v8_lvt ad=0.341 pd=2.82 as=0.1815 ps=1.43 w=1.1 l=0.15
X260 a_6498_n1152# a_6498_208# vss vss sky130_fd_pr__nfet_01v8 ad=0.1595 pd=1.68 as=0.1595 ps=1.68 w=0.55 l=0.15
X261 a_12974_n1152# a_12974_872# vdd vdd sky130_fd_pr__pfet_01v8 ad=0.174 pd=1.78 as=0.174 ps=1.78 w=0.6 l=0.15
X262 a_8154_486# a_8240_n1092# vdd vdd sky130_fd_pr__pfet_01v8 ad=0.2475 pd=1.83 as=0.465 ps=3.62 w=1.5 l=0.15
X263 a_2810_872# a_3022_486# a_2762_n468# vss sky130_fd_pr__nfet_01v8_lvt ad=0.2805 pd=2.03 as=0.527 ps=4.02 w=1.7 l=0.15
X264 vss a_17633_n1222# a_17911_208# vss sky130_fd_pr__nfet_01v8_lvt ad=0.403 pd=3.22 as=0.2145 ps=1.63 w=1.3 l=0.15
X265 a_4992_n1132# a_3022_486# a_4944_n468# vss sky130_fd_pr__nfet_01v8_lvt ad=0.231 pd=1.73 as=0.434 ps=3.42 w=1.4 l=0.15
X266 vdd a_16703_n1152# a_17911_n1152# vdd sky130_fd_pr__pfet_01v8 ad=0.434 pd=3.42 as=0.231 ps=1.73 w=1.4 l=0.15
X267 a_6220_n1222# a_5290_n1152# vdd vdd sky130_fd_pr__pfet_01v8 ad=0.5075 pd=4.08 as=0.5075 ps=4.08 w=1.75 l=0.15
X268 a_11352_n1222# a_10422_n1152# vdd vdd sky130_fd_pr__pfet_01v8 ad=0.5075 pd=4.08 as=0.5075 ps=4.08 w=1.75 l=0.15
X269 a_10124_n1132# a_2192_n1472# vdd vdd sky130_fd_pr__pfet_01v8 ad=0.377 pd=3.18 as=0.377 ps=3.18 w=1.3 l=0.15
X270 vdd a_8240_872# a_8154_n580# vdd sky130_fd_pr__pfet_01v8 ad=0.465 pd=3.62 as=0.2475 ps=1.83 w=1.5 l=0.15
X271 vss a_9170_n1222# a_8154_n580# vss sky130_fd_pr__nfet_01v8_lvt ad=0.434 pd=3.42 as=0.231 ps=1.73 w=1.4 l=0.15
X272 q4n q4p vss vss sky130_fd_pr__nfet_01v8 ad=0.174 pd=1.78 as=0.174 ps=1.78 w=0.6 l=0.15
X273 a_8154_n580# a_8240_872# vdd vdd sky130_fd_pr__pfet_01v8 ad=0.2475 pd=1.83 as=0.465 ps=3.62 w=1.5 l=0.15
X274 a_8154_n580# a_9170_n1222# vss vss sky130_fd_pr__nfet_01v8_lvt ad=0.231 pd=1.73 as=0.434 ps=3.42 w=1.4 l=0.15
X275 a_14223_872# a_14521_n1092# a_14521_872# vss sky130_fd_pr__nfet_01v8_lvt ad=0.372 pd=3.02 as=0.198 ps=1.53 w=1.2 l=0.15
X276 a_13066_n1152# a_8154_486# a_12974_n1152# vss sky130_fd_pr__nfet_01v8 ad=0.377 pd=3.18 as=0.377 ps=3.18 w=1.3 l=0.15
X277 a_15451_308# a_14521_872# vdd vdd sky130_fd_pr__pfet_01v8 ad=0.5075 pd=4.08 as=0.5075 ps=4.08 w=1.75 l=0.15
X278 a_17911_208# a_17911_n1152# vss vss sky130_fd_pr__nfet_01v8 ad=0.1595 pd=1.68 as=0.1595 ps=1.68 w=0.55 l=0.15
X279 a_10422_n1152# a_10422_872# a_10124_n1132# vss sky130_fd_pr__nfet_01v8_lvt ad=0.18975 pd=1.48 as=0.3565 ps=2.92 w=1.15 l=0.15
X280 a_14521_872# a_14521_n1092# a_14223_872# vss sky130_fd_pr__nfet_01v8_lvt ad=0.198 pd=1.53 as=0.372 ps=3.02 w=1.2 l=0.15
X281 a_5290_n1152# a_2192_n1472# vdd vdd sky130_fd_pr__pfet_01v8 ad=0.231 pd=1.73 as=0.434 ps=3.42 w=1.4 l=0.15
X282 a_2192_n1472# a_360_228# vss vss sky130_fd_pr__nfet_01v8 ad=0.22275 pd=1.68 as=0.4185 ps=3.32 w=1.35 l=0.15
X283 vss a_360_228# a_2192_n1472# vss sky130_fd_pr__nfet_01v8 ad=0.4185 pd=3.32 as=0.22275 ps=1.68 w=1.35 l=0.15
X284 a_16703_872# a_2192_n1472# a_16703_n1152# vdd sky130_fd_pr__pfet_01v8 ad=0.29 pd=2.58 as=0.29 ps=2.58 w=1 l=0.15
X285 a_360_228# a_360_n1472# vss vss sky130_fd_pr__nfet_01v8 ad=0.1305 pd=1.48 as=0.1305 ps=1.48 w=0.45 l=0.15
X286 vdd a_14521_872# a_12974_872# vdd sky130_fd_pr__pfet_01v8 ad=0.465 pd=3.62 as=0.2475 ps=1.83 w=1.5 l=0.15
X287 vss a_15451_n1222# a_12974_872# vss sky130_fd_pr__nfet_01v8_lvt ad=0.434 pd=3.42 as=0.231 ps=1.73 w=1.4 l=0.15
X288 a_2192_n1472# a_360_228# vss vss sky130_fd_pr__nfet_01v8 ad=0.22275 pd=1.68 as=0.22275 ps=1.68 w=1.35 l=0.15
X289 vss a_2192_n1472# a_16357_n468# vss sky130_fd_pr__nfet_01v8_lvt ad=0.341 pd=2.82 as=0.1815 ps=1.43 w=1.1 l=0.15
X290 vdd a_2192_n1472# a_10422_n1152# vdd sky130_fd_pr__pfet_01v8 ad=0.434 pd=3.42 as=0.231 ps=1.73 w=1.4 l=0.15
X291 a_7942_n1092# a_3022_486# vdd vdd sky130_fd_pr__pfet_01v8 ad=0.319 pd=2.78 as=0.319 ps=2.78 w=1.1 l=0.15
X292 vdd a_6498_208# q2n vdd sky130_fd_pr__pfet_01v8 ad=0.837 pd=6.02 as=0.4455 ps=3.03 w=2.7 l=0.15
X293 a_2192_n1472# a_360_228# vdd vdd sky130_fd_pr__pfet_01v8 ad=0.495 pd=3.33 as=0.93 ps=6.62 w=3 l=0.15
X294 vss a_360_228# a_2192_n1472# vss sky130_fd_pr__nfet_01v8 ad=0.22275 pd=1.68 as=0.22275 ps=1.68 w=1.35 l=0.15
X295 a_12974_872# a_14521_872# vdd vdd sky130_fd_pr__pfet_01v8 ad=0.2475 pd=1.83 as=0.465 ps=3.62 w=1.5 l=0.15
X296 a_12974_872# a_15451_n1222# vss vss sky130_fd_pr__nfet_01v8_lvt ad=0.231 pd=1.73 as=0.434 ps=3.42 w=1.4 l=0.15
X297 vss clkn a_360_n1472# vss sky130_fd_pr__nfet_01v8 ad=0.372 pd=3.02 as=0.198 ps=1.53 w=1.2 l=0.15
X298 a_964_n1472# a_360_n1472# vss vss sky130_fd_pr__nfet_01v8 ad=0.22275 pd=1.68 as=0.4185 ps=3.32 w=1.35 l=0.15
X299 vdd a_11630_208# q4n vdd sky130_fd_pr__pfet_01v8 ad=0.837 pd=6.02 as=0.4455 ps=3.03 w=2.7 l=0.15
X300 a_16357_n468# a_2192_n1472# vss vss sky130_fd_pr__nfet_01v8_lvt ad=0.1815 pd=1.43 as=0.341 ps=2.82 w=1.1 l=0.15
X301 a_2192_n1472# a_360_228# vss vss sky130_fd_pr__nfet_01v8 ad=0.22275 pd=1.68 as=0.4185 ps=3.32 w=1.35 l=0.15
X302 q8n q8p vss vss sky130_fd_pr__nfet_01v8 ad=0.1885 pd=1.88 as=0.1885 ps=1.88 w=0.65 l=0.15
X303 a_11630_n1152# a_11352_308# vss vss sky130_fd_pr__nfet_01v8_lvt ad=0.2145 pd=1.63 as=0.403 ps=3.22 w=1.3 l=0.15
X304 a_16703_n1152# a_16703_872# vdd vdd sky130_fd_pr__pfet_01v8 ad=0.435 pd=3.58 as=0.435 ps=3.58 w=1.5 l=0.15
X305 vdd a_8240_n1092# a_8154_486# vdd sky130_fd_pr__pfet_01v8 ad=0.465 pd=3.62 as=0.2475 ps=1.83 w=1.5 l=0.15
X306 a_6220_308# a_5290_872# vss vss sky130_fd_pr__nfet_01v8 ad=0.232 pd=2.18 as=0.232 ps=2.18 w=0.8 l=0.15
X307 a_2762_n468# a_3022_n580# a_2810_n1132# vss sky130_fd_pr__nfet_01v8_lvt ad=0.527 pd=4.02 as=0.2805 ps=2.03 w=1.7 l=0.15
X308 a_4992_n1132# a_5290_872# a_5290_n1152# vss sky130_fd_pr__nfet_01v8_lvt ad=0.3565 pd=2.92 as=0.18975 ps=1.48 w=1.15 l=0.15
X309 a_2810_872# a_3108_n1152# a_3108_872# vss sky130_fd_pr__nfet_01v8_lvt ad=0.434 pd=3.42 as=0.231 ps=1.73 w=1.4 l=0.15
X310 vss a_3022_486# a_7894_n468# vss sky130_fd_pr__nfet_01v8_lvt ad=0.341 pd=2.82 as=0.1815 ps=1.43 w=1.1 l=0.15
X311 a_15451_n1222# a_14521_n1092# vdd vdd sky130_fd_pr__pfet_01v8 ad=0.5075 pd=4.08 as=0.5075 ps=4.08 w=1.75 l=0.15
.ends
