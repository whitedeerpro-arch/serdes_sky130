* NGSPICE file created from pll_saff_reclock_prescaler8_2g_pdk.ext - technology: sky130A

.subckt pll_saff_reclock_prescaler8_2g_pdk clkp clkn q2p q2n q4p q4n q8p q8n vdd vss
X0 vdd a_2192_n1472# a_3108_872# vdd sky130_fd_pr__pfet_01v8 ad=0.434 pd=3.42 as=0.231 ps=1.73 w=1.4 l=0.15
X1 a_3108_872# a_3108_n1152# a_2810_872# vss sky130_fd_pr__nfet_01v8_lvt ad=0.231 pd=1.73 as=0.434 ps=3.42 w=1.4 l=0.15
X2 a_3108_872# a_2192_n1472# a_3108_n1152# vdd sky130_fd_pr__pfet_01v8 ad=0.319 pd=2.78 as=0.319 ps=2.78 w=1.1 l=0.15
X3 q4n q4p vdd vdd sky130_fd_pr__pfet_01v8 ad=0.3625 pd=3.08 as=0.3625 ps=3.08 w=1.25 l=0.15
X4 a_3108_872# a_2192_n1472# vdd vdd sky130_fd_pr__pfet_01v8 ad=0.231 pd=1.73 as=0.434 ps=3.42 w=1.4 l=0.15
X5 a_10422_872# a_10422_n1152# a_10124_872# vss sky130_fd_pr__nfet_01v8_lvt ad=0.18975 pd=1.48 as=0.3565 ps=2.92 w=1.15 l=0.15
X6 a_9170_n1222# a_8240_n1092# vdd vdd sky130_fd_pr__pfet_01v8 ad=0.5075 pd=4.08 as=0.5075 ps=4.08 w=1.75 l=0.15
X7 a_6498_n1152# a_6498_208# vdd vdd sky130_fd_pr__pfet_01v8 ad=0.1885 pd=1.88 as=0.1885 ps=1.88 w=0.65 l=0.15
X8 vss a_6220_308# a_6498_n1152# vss sky130_fd_pr__nfet_01v8_lvt ad=0.403 pd=3.22 as=0.2145 ps=1.63 w=1.3 l=0.15
X9 a_3022_n580# a_3022_486# vss vss sky130_fd_pr__nfet_01v8 ad=0.1595 pd=1.68 as=0.1595 ps=1.68 w=0.55 l=0.15
X10 a_14521_n1092# a_14521_872# vdd vdd sky130_fd_pr__pfet_01v8 ad=0.406 pd=3.38 as=0.406 ps=3.38 w=1.4 l=0.15
X11 a_10124_872# a_10422_n1152# a_10422_872# vss sky130_fd_pr__nfet_01v8_lvt ad=0.3565 pd=2.92 as=0.18975 ps=1.48 w=1.15 l=0.15
X12 vss a_360_228# a_2192_n1472# vss sky130_fd_pr__nfet_01v8 ad=0.4185 pd=3.32 as=0.22275 ps=1.68 w=1.35 l=0.15
X13 a_6220_308# a_5290_872# vdd vdd sky130_fd_pr__pfet_01v8 ad=0.5075 pd=4.08 as=0.5075 ps=4.08 w=1.75 l=0.15
X14 a_13066_n1152# a_8154_n580# a_12974_n1152# vdd sky130_fd_pr__pfet_01v8 ad=0.231 pd=1.73 as=0.434 ps=3.42 w=1.4 l=0.15
X15 vss a_11630_208# q4n vss sky130_fd_pr__nfet_01v8 ad=0.403 pd=3.22 as=0.2145 ps=1.63 w=1.3 l=0.15
X16 a_8240_n1092# a_8240_872# vdd vdd sky130_fd_pr__pfet_01v8 ad=0.406 pd=3.38 as=0.406 ps=3.38 w=1.4 l=0.15
X17 a_10124_872# a_2192_n1472# vdd vdd sky130_fd_pr__pfet_01v8 ad=0.377 pd=3.18 as=0.377 ps=3.18 w=1.3 l=0.15
X18 a_11630_n1152# a_10422_n1152# vdd vdd sky130_fd_pr__pfet_01v8 ad=0.231 pd=1.73 as=0.434 ps=3.42 w=1.4 l=0.15
X19 a_8240_872# a_3022_486# a_8240_n1092# vdd sky130_fd_pr__pfet_01v8 ad=0.261 pd=2.38 as=0.261 ps=2.38 w=0.9 l=0.15
X20 a_13066_n1152# a_8154_486# a_12974_872# vdd sky130_fd_pr__pfet_01v8 ad=0.231 pd=1.73 as=0.434 ps=3.42 w=1.4 l=0.15
X21 a_14223_n1092# a_14521_872# a_14521_n1092# vss sky130_fd_pr__nfet_01v8_lvt ad=0.372 pd=3.02 as=0.198 ps=1.53 w=1.2 l=0.15
X22 a_7942_n1092# a_8154_n580# a_7894_n468# vss sky130_fd_pr__nfet_01v8_lvt ad=0.231 pd=1.73 as=0.434 ps=3.42 w=1.4 l=0.15
X23 a_10076_n468# a_8154_486# a_10124_n1132# vss sky130_fd_pr__nfet_01v8_lvt ad=0.434 pd=3.42 as=0.231 ps=1.73 w=1.4 l=0.15
X24 a_17911_n1152# a_17911_208# vdd vdd sky130_fd_pr__pfet_01v8 ad=0.1885 pd=1.88 as=0.1885 ps=1.88 w=0.65 l=0.15
X25 vdd a_10422_n1152# a_11630_n1152# vdd sky130_fd_pr__pfet_01v8 ad=0.434 pd=3.42 as=0.231 ps=1.73 w=1.4 l=0.15
X26 vss a_3022_486# a_7894_n468# vss sky130_fd_pr__nfet_01v8_lvt ad=0.341 pd=2.82 as=0.1815 ps=1.43 w=1.1 l=0.15
X27 a_16703_872# a_16703_n1152# a_16405_872# vss sky130_fd_pr__nfet_01v8_lvt ad=0.18975 pd=1.48 as=0.3565 ps=2.92 w=1.15 l=0.15
X28 a_360_228# clkp vdd vdd sky130_fd_pr__pfet_01v8 ad=0.495 pd=3.33 as=0.93 ps=6.62 w=3 l=0.15
X29 a_7894_n468# a_3022_486# vss vss sky130_fd_pr__nfet_01v8_lvt ad=0.1815 pd=1.43 as=0.341 ps=2.82 w=1.1 l=0.15
X30 a_5290_n1152# a_2192_n1472# a_5290_872# vdd sky130_fd_pr__pfet_01v8 ad=0.29 pd=2.58 as=0.29 ps=2.58 w=1 l=0.15
X31 a_16405_872# a_16703_n1152# a_16703_872# vss sky130_fd_pr__nfet_01v8_lvt ad=0.3565 pd=2.92 as=0.18975 ps=1.48 w=1.15 l=0.15
X32 vss a_17911_208# q8n vss sky130_fd_pr__nfet_01v8 ad=0.465 pd=3.62 as=0.2475 ps=1.83 w=1.5 l=0.15
X33 vdd clkp a_360_228# vdd sky130_fd_pr__pfet_01v8 ad=0.93 pd=6.62 as=0.495 ps=3.33 w=3 l=0.15
X34 q2p q2n vss vss sky130_fd_pr__nfet_01v8 ad=0.174 pd=1.78 as=0.174 ps=1.78 w=0.6 l=0.15
X35 a_14521_872# a_3022_486# a_14521_n1092# vdd sky130_fd_pr__pfet_01v8 ad=0.261 pd=2.38 as=0.261 ps=2.38 w=0.9 l=0.15
X36 a_2192_n1472# a_360_228# vdd vdd sky130_fd_pr__pfet_01v8 ad=0.495 pd=3.33 as=0.93 ps=6.62 w=3 l=0.15
X37 a_5290_872# a_5290_n1152# vdd vdd sky130_fd_pr__pfet_01v8 ad=0.435 pd=3.58 as=0.435 ps=3.58 w=1.5 l=0.15
X38 a_16703_872# a_2192_n1472# vdd vdd sky130_fd_pr__pfet_01v8 ad=0.231 pd=1.73 as=0.434 ps=3.42 w=1.4 l=0.15
X39 a_16405_872# a_12974_872# a_16357_n468# vss sky130_fd_pr__nfet_01v8_lvt ad=0.231 pd=1.73 as=0.434 ps=3.42 w=1.4 l=0.15
X40 vdd a_3022_486# a_14521_n1092# vdd sky130_fd_pr__pfet_01v8 ad=0.341 pd=2.82 as=0.1815 ps=1.43 w=1.1 l=0.15
X41 vdd a_360_228# a_2192_n1472# vdd sky130_fd_pr__pfet_01v8 ad=0.93 pd=6.62 as=0.495 ps=3.33 w=3 l=0.15
X42 a_8240_n1092# a_3022_486# vdd vdd sky130_fd_pr__pfet_01v8 ad=0.1815 pd=1.43 as=0.341 ps=2.82 w=1.1 l=0.15
X43 a_360_228# a_360_n1472# vdd vdd sky130_fd_pr__pfet_01v8 ad=0.29 pd=2.58 as=0.29 ps=2.58 w=1 l=0.15
X44 a_2192_n1472# a_360_228# vdd vdd sky130_fd_pr__pfet_01v8 ad=0.495 pd=3.33 as=0.495 ps=3.33 w=3 l=0.15
X45 vss a_3022_486# a_14175_n468# vss sky130_fd_pr__nfet_01v8_lvt ad=0.341 pd=2.82 as=0.1815 ps=1.43 w=1.1 l=0.15
X46 a_12974_n1152# a_8154_n580# a_13066_n1152# vdd sky130_fd_pr__pfet_01v8 ad=0.434 pd=3.42 as=0.231 ps=1.73 w=1.4 l=0.15
X47 vdd a_6498_n1152# q2p vdd sky130_fd_pr__pfet_01v8 ad=0.837 pd=6.02 as=0.4455 ps=3.03 w=2.7 l=0.15
X48 a_14175_n468# a_3022_486# vss vss sky130_fd_pr__nfet_01v8_lvt ad=0.1815 pd=1.43 as=0.341 ps=2.82 w=1.1 l=0.15
X49 q8n a_17911_208# vdd vdd sky130_fd_pr__pfet_01v8 ad=0.5115 pd=3.43 as=0.961 ps=6.82 w=3.1 l=0.15
X50 a_16357_n468# a_12974_n1152# a_16405_n1132# vss sky130_fd_pr__nfet_01v8_lvt ad=0.434 pd=3.42 as=0.231 ps=1.73 w=1.4 l=0.15
X51 vdd a_360_228# a_2192_n1472# vdd sky130_fd_pr__pfet_01v8 ad=0.495 pd=3.33 as=0.495 ps=3.33 w=3 l=0.15
X52 q2p a_6498_n1152# vdd vdd sky130_fd_pr__pfet_01v8 ad=0.4455 pd=3.03 as=0.837 ps=6.02 w=2.7 l=0.15
X53 vdd a_2192_n1472# a_16703_872# vdd sky130_fd_pr__pfet_01v8 ad=0.434 pd=3.42 as=0.231 ps=1.73 w=1.4 l=0.15
X54 a_16357_n468# a_12974_872# a_16405_872# vss sky130_fd_pr__nfet_01v8_lvt ad=0.434 pd=3.42 as=0.231 ps=1.73 w=1.4 l=0.15
X55 q8n q8p vdd vdd sky130_fd_pr__pfet_01v8 ad=0.3915 pd=3.28 as=0.3915 ps=3.28 w=1.35 l=0.15
X56 vss a_964_n1472# vss vss sky130_fd_pr__nfet_01v8 ad=0.145 pd=1.29 as=36.54 ps=304.98001 w=1 l=0.5
X57 q2n q2p vss vss sky130_fd_pr__nfet_01v8 ad=0.174 pd=1.78 as=0.174 ps=1.78 w=0.6 l=0.15
X58 q4p q4n vss vss sky130_fd_pr__nfet_01v8 ad=0.174 pd=1.78 as=0.174 ps=1.78 w=0.6 l=0.15
X59 a_2810_n1132# a_3022_n580# a_2762_n468# vss sky130_fd_pr__nfet_01v8_lvt ad=0.2805 pd=2.03 as=0.527 ps=4.02 w=1.7 l=0.15
X60 a_12974_872# a_8154_486# a_13066_n1152# vdd sky130_fd_pr__pfet_01v8 ad=0.434 pd=3.42 as=0.231 ps=1.73 w=1.4 l=0.15
X61 a_10422_872# a_10422_n1152# vdd vdd sky130_fd_pr__pfet_01v8 ad=0.435 pd=3.58 as=0.435 ps=3.58 w=1.5 l=0.15
X62 a_5290_n1152# a_5290_872# a_4992_n1132# vss sky130_fd_pr__nfet_01v8_lvt ad=0.18975 pd=1.48 as=0.3565 ps=2.92 w=1.15 l=0.15
X63 a_7942_n1092# a_8240_872# a_8240_n1092# vss sky130_fd_pr__nfet_01v8_lvt ad=0.372 pd=3.02 as=0.198 ps=1.53 w=1.2 l=0.15
X64 a_6220_n1222# a_5290_n1152# vss vss sky130_fd_pr__nfet_01v8 ad=0.232 pd=2.18 as=0.232 ps=2.18 w=0.8 l=0.15
X65 a_7894_n468# a_3022_486# vss vss sky130_fd_pr__nfet_01v8_lvt ad=0.1815 pd=1.43 as=0.341 ps=2.82 w=1.1 l=0.15
X66 a_360_n1472# clkn vdd vdd sky130_fd_pr__pfet_01v8 ad=0.495 pd=3.33 as=0.93 ps=6.62 w=3 l=0.15
X67 vss a_3022_486# a_14175_n468# vss sky130_fd_pr__nfet_01v8_lvt ad=0.341 pd=2.82 as=0.1815 ps=1.43 w=1.1 l=0.15
X68 a_12974_872# a_8154_n580# a_13066_872# vdd sky130_fd_pr__pfet_01v8 ad=0.434 pd=3.42 as=0.231 ps=1.73 w=1.4 l=0.15
X69 a_17911_n1152# a_17911_208# vss vss sky130_fd_pr__nfet_01v8 ad=0.1595 pd=1.68 as=0.1595 ps=1.68 w=0.55 l=0.15
X70 a_14223_n1092# a_13066_n1152# a_14175_n468# vss sky130_fd_pr__nfet_01v8_lvt ad=0.231 pd=1.73 as=0.434 ps=3.42 w=1.4 l=0.15
X71 a_13066_872# a_8154_n580# a_12974_872# vdd sky130_fd_pr__pfet_01v8 ad=0.231 pd=1.73 as=0.434 ps=3.42 w=1.4 l=0.15
X72 a_12974_n1152# a_8154_486# a_13066_872# vdd sky130_fd_pr__pfet_01v8 ad=0.434 pd=3.42 as=0.231 ps=1.73 w=1.4 l=0.15
X73 a_13066_872# a_8154_486# a_12974_n1152# vdd sky130_fd_pr__pfet_01v8 ad=0.231 pd=1.73 as=0.434 ps=3.42 w=1.4 l=0.15
X74 a_6498_n1152# a_6220_308# vss vss sky130_fd_pr__nfet_01v8_lvt ad=0.2145 pd=1.63 as=0.403 ps=3.22 w=1.3 l=0.15
X75 a_360_n1472# a_360_228# vdd vdd sky130_fd_pr__pfet_01v8 ad=0.29 pd=2.58 as=0.29 ps=2.58 w=1 l=0.15
X76 vss a_9170_308# a_8154_486# vss sky130_fd_pr__nfet_01v8_lvt ad=0.434 pd=3.42 as=0.231 ps=1.73 w=1.4 l=0.15
X77 a_2192_n1472# a_360_228# vss vss sky130_fd_pr__nfet_01v8 ad=0.22275 pd=1.68 as=0.22275 ps=1.68 w=1.35 l=0.15
X78 a_4992_872# a_2192_n1472# vdd vdd sky130_fd_pr__pfet_01v8 ad=0.377 pd=3.18 as=0.377 ps=3.18 w=1.3 l=0.15
X79 vdd a_17911_208# q8n vdd sky130_fd_pr__pfet_01v8 ad=0.961 pd=6.82 as=0.5115 ps=3.43 w=3.1 l=0.15
X80 a_16703_872# a_16703_n1152# vdd vdd sky130_fd_pr__pfet_01v8 ad=0.435 pd=3.58 as=0.435 ps=3.58 w=1.5 l=0.15
X81 a_11352_308# a_10422_872# vss vss sky130_fd_pr__nfet_01v8 ad=0.232 pd=2.18 as=0.232 ps=2.18 w=0.8 l=0.15
X82 q4n a_11630_208# vss vss sky130_fd_pr__nfet_01v8 ad=0.2145 pd=1.63 as=0.403 ps=3.22 w=1.3 l=0.15
X83 a_17911_n1152# a_17633_308# vss vss sky130_fd_pr__nfet_01v8_lvt ad=0.2145 pd=1.63 as=0.403 ps=3.22 w=1.3 l=0.15
X84 vdd a_2192_n1472# a_5290_n1152# vdd sky130_fd_pr__pfet_01v8 ad=0.434 pd=3.42 as=0.231 ps=1.73 w=1.4 l=0.15
X85 a_4038_n1222# a_3108_n1152# vss vss sky130_fd_pr__nfet_01v8 ad=0.232 pd=2.18 as=0.232 ps=2.18 w=0.8 l=0.15
X86 a_13066_n1152# a_8154_n580# a_12974_872# vss sky130_fd_pr__nfet_01v8 ad=0.377 pd=3.18 as=0.377 ps=3.18 w=1.3 l=0.15
X87 a_10422_n1152# a_10422_872# vdd vdd sky130_fd_pr__pfet_01v8 ad=0.435 pd=3.58 as=0.435 ps=3.58 w=1.5 l=0.15
X88 a_14521_n1092# a_14521_872# a_14223_n1092# vss sky130_fd_pr__nfet_01v8_lvt ad=0.198 pd=1.53 as=0.372 ps=3.02 w=1.2 l=0.15
X89 vdd a_360_228# a_2192_n1472# vdd sky130_fd_pr__pfet_01v8 ad=0.495 pd=3.33 as=0.495 ps=3.33 w=3 l=0.15
X90 a_2810_n1132# a_3108_872# a_3108_n1152# vss sky130_fd_pr__nfet_01v8_lvt ad=0.434 pd=3.42 as=0.231 ps=1.73 w=1.4 l=0.15
X91 a_15451_n1222# a_14521_n1092# vss vss sky130_fd_pr__nfet_01v8 ad=0.232 pd=2.18 as=0.232 ps=2.18 w=0.8 l=0.15
X92 a_8240_872# a_3022_486# vdd vdd sky130_fd_pr__pfet_01v8 ad=0.1815 pd=1.43 as=0.341 ps=2.82 w=1.1 l=0.15
X93 a_7942_872# a_8154_486# a_7894_n468# vss sky130_fd_pr__nfet_01v8_lvt ad=0.231 pd=1.73 as=0.434 ps=3.42 w=1.4 l=0.15
X94 a_2762_n468# a_2192_n1472# vss vss sky130_fd_pr__nfet_01v8_lvt ad=0.22275 pd=1.68 as=0.4185 ps=3.32 w=1.35 l=0.15
X95 a_16703_n1152# a_16703_872# a_16405_n1132# vss sky130_fd_pr__nfet_01v8_lvt ad=0.18975 pd=1.48 as=0.3565 ps=2.92 w=1.15 l=0.15
X96 a_6498_n1152# a_5290_n1152# vdd vdd sky130_fd_pr__pfet_01v8 ad=0.231 pd=1.73 as=0.434 ps=3.42 w=1.4 l=0.15
X97 a_4992_n1132# a_2192_n1472# vdd vdd sky130_fd_pr__pfet_01v8 ad=0.377 pd=3.18 as=0.377 ps=3.18 w=1.3 l=0.15
X98 vdd a_5290_872# a_6498_208# vdd sky130_fd_pr__pfet_01v8 ad=0.434 pd=3.42 as=0.231 ps=1.73 w=1.4 l=0.15
X99 a_8154_486# a_8154_n580# vss vss sky130_fd_pr__nfet_01v8 ad=0.2175 pd=2.08 as=0.2175 ps=2.08 w=0.75 l=0.15
X100 vdd a_3022_486# a_8240_872# vdd sky130_fd_pr__pfet_01v8 ad=0.341 pd=2.82 as=0.1815 ps=1.43 w=1.1 l=0.15
X101 a_7894_n468# a_8154_486# a_7942_872# vss sky130_fd_pr__nfet_01v8_lvt ad=0.434 pd=3.42 as=0.231 ps=1.73 w=1.4 l=0.15
X102 a_6498_208# a_5290_872# vdd vdd sky130_fd_pr__pfet_01v8 ad=0.231 pd=1.73 as=0.434 ps=3.42 w=1.4 l=0.15
X103 q8n a_17911_208# vss vss sky130_fd_pr__nfet_01v8 ad=0.2475 pd=1.83 as=0.465 ps=3.62 w=1.5 l=0.15
X104 q2n q2p vdd vdd sky130_fd_pr__pfet_01v8 ad=0.3625 pd=3.08 as=0.3625 ps=3.08 w=1.25 l=0.15
X105 a_11352_308# a_10422_872# vdd vdd sky130_fd_pr__pfet_01v8 ad=0.5075 pd=4.08 as=0.5075 ps=4.08 w=1.75 l=0.15
X106 a_3022_486# a_3022_n580# vdd vdd sky130_fd_pr__pfet_01v8 ad=0.1885 pd=1.88 as=0.1885 ps=1.88 w=0.65 l=0.15
X107 a_3022_486# a_3108_n1152# vdd vdd sky130_fd_pr__pfet_01v8 ad=0.3135 pd=2.23 as=0.589 ps=4.42 w=1.9 l=0.15
X108 a_3108_872# a_3108_n1152# vdd vdd sky130_fd_pr__pfet_01v8 ad=0.464 pd=3.78 as=0.464 ps=3.78 w=1.6 l=0.15
X109 a_14521_872# a_3022_486# vdd vdd sky130_fd_pr__pfet_01v8 ad=0.1815 pd=1.43 as=0.341 ps=2.82 w=1.1 l=0.15
X110 a_14223_872# a_13066_872# a_14175_n468# vss sky130_fd_pr__nfet_01v8_lvt ad=0.231 pd=1.73 as=0.434 ps=3.42 w=1.4 l=0.15
X111 a_16703_n1152# a_2192_n1472# vdd vdd sky130_fd_pr__pfet_01v8 ad=0.231 pd=1.73 as=0.434 ps=3.42 w=1.4 l=0.15
X112 a_3108_n1152# a_3108_872# vdd vdd sky130_fd_pr__pfet_01v8 ad=0.464 pd=3.78 as=0.464 ps=3.78 w=1.6 l=0.15
X113 vss a_15451_308# a_12974_n1152# vss sky130_fd_pr__nfet_01v8_lvt ad=0.434 pd=3.42 as=0.231 ps=1.73 w=1.4 l=0.15
X114 vdd a_10422_872# a_11630_208# vdd sky130_fd_pr__pfet_01v8 ad=0.434 pd=3.42 as=0.231 ps=1.73 w=1.4 l=0.15
X115 vdd a_3022_486# a_14521_872# vdd sky130_fd_pr__pfet_01v8 ad=0.341 pd=2.82 as=0.1815 ps=1.43 w=1.1 l=0.15
X116 a_14175_n468# a_13066_872# a_14223_872# vss sky130_fd_pr__nfet_01v8_lvt ad=0.434 pd=3.42 as=0.231 ps=1.73 w=1.4 l=0.15
X117 vdd a_360_n1472# a_964_n1472# vdd sky130_fd_pr__pfet_01v8 ad=0.93 pd=6.62 as=0.495 ps=3.33 w=3 l=0.15
X118 vss a_4038_n1222# a_3022_n580# vss sky130_fd_pr__nfet_01v8_lvt ad=0.527 pd=4.02 as=0.2805 ps=2.03 w=1.7 l=0.15
X119 vss a_6498_n1152# q2p vss sky130_fd_pr__nfet_01v8 ad=0.403 pd=3.22 as=0.2145 ps=1.63 w=1.3 l=0.15
X120 a_4944_n468# a_3022_486# a_4992_n1132# vss sky130_fd_pr__nfet_01v8_lvt ad=0.434 pd=3.42 as=0.231 ps=1.73 w=1.4 l=0.15
X121 a_14521_n1092# a_3022_486# a_14521_872# vdd sky130_fd_pr__pfet_01v8 ad=0.261 pd=2.38 as=0.261 ps=2.38 w=0.9 l=0.15
X122 a_16405_872# a_2192_n1472# vdd vdd sky130_fd_pr__pfet_01v8 ad=0.377 pd=3.18 as=0.377 ps=3.18 w=1.3 l=0.15
X123 vss a_964_n1472# vss vss sky130_fd_pr__nfet_01v8 ad=0.145 pd=1.29 as=0 ps=0 w=1 l=0.5
X124 a_2192_n1472# a_360_228# vdd vdd sky130_fd_pr__pfet_01v8 ad=0.495 pd=3.33 as=0.495 ps=3.33 w=3 l=0.15
X125 a_3022_n580# a_4038_n1222# vss vss sky130_fd_pr__nfet_01v8_lvt ad=0.2805 pd=2.03 as=0.527 ps=4.02 w=1.7 l=0.15
X126 q2p a_6498_n1152# vss vss sky130_fd_pr__nfet_01v8 ad=0.2145 pd=1.63 as=0.403 ps=3.22 w=1.3 l=0.15
X127 a_8240_n1092# a_8240_872# a_7942_n1092# vss sky130_fd_pr__nfet_01v8_lvt ad=0.198 pd=1.53 as=0.372 ps=3.02 w=1.2 l=0.15
X128 a_14175_n468# a_3022_486# vss vss sky130_fd_pr__nfet_01v8_lvt ad=0.1815 pd=1.43 as=0.341 ps=2.82 w=1.1 l=0.15
X129 a_6498_208# a_6498_n1152# vdd vdd sky130_fd_pr__pfet_01v8 ad=0.1885 pd=1.88 as=0.1885 ps=1.88 w=0.65 l=0.15
X130 a_360_n1472# clkn vss vss sky130_fd_pr__nfet_01v8 ad=0.198 pd=1.53 as=0.372 ps=3.02 w=1.2 l=0.15
X131 a_9170_n1222# a_8240_n1092# vss vss sky130_fd_pr__nfet_01v8 ad=0.232 pd=2.18 as=0.232 ps=2.18 w=0.8 l=0.15
X132 a_10124_n1132# a_10422_872# a_10422_n1152# vss sky130_fd_pr__nfet_01v8_lvt ad=0.3565 pd=2.92 as=0.18975 ps=1.48 w=1.15 l=0.15
X133 a_11630_n1152# a_11630_208# vdd vdd sky130_fd_pr__pfet_01v8 ad=0.1885 pd=1.88 as=0.1885 ps=1.88 w=0.65 l=0.15
X134 vdd a_5290_n1152# a_6498_n1152# vdd sky130_fd_pr__pfet_01v8 ad=0.434 pd=3.42 as=0.231 ps=1.73 w=1.4 l=0.15
X135 a_8240_872# a_8240_n1092# vdd vdd sky130_fd_pr__pfet_01v8 ad=0.406 pd=3.38 as=0.406 ps=3.38 w=1.4 l=0.15
X136 a_11630_208# a_11630_n1152# vdd vdd sky130_fd_pr__pfet_01v8 ad=0.1885 pd=1.88 as=0.1885 ps=1.88 w=0.65 l=0.15
X137 a_3022_486# a_3022_n580# vss vss sky130_fd_pr__nfet_01v8 ad=0.2465 pd=2.28 as=0.2465 ps=2.28 w=0.85 l=0.15
X138 a_16703_n1152# a_2192_n1472# a_16703_872# vdd sky130_fd_pr__pfet_01v8 ad=0.29 pd=2.58 as=0.29 ps=2.58 w=1 l=0.15
X139 q2p q2n vdd vdd sky130_fd_pr__pfet_01v8 ad=0.3625 pd=3.08 as=0.3625 ps=3.08 w=1.25 l=0.15
X140 vdd a_3108_n1152# a_3022_486# vdd sky130_fd_pr__pfet_01v8 ad=0.589 pd=4.42 as=0.3135 ps=2.23 w=1.9 l=0.15
X141 a_964_n1472# a_360_n1472# vdd vdd sky130_fd_pr__pfet_01v8 ad=0.495 pd=3.33 as=0.93 ps=6.62 w=3 l=0.15
X142 a_14223_n1092# a_3022_486# vdd vdd sky130_fd_pr__pfet_01v8 ad=0.319 pd=2.78 as=0.319 ps=2.78 w=1.1 l=0.15
X143 vdd a_11630_n1152# q4p vdd sky130_fd_pr__pfet_01v8 ad=0.837 pd=6.02 as=0.4455 ps=3.03 w=2.7 l=0.15
X144 a_8154_486# a_9170_308# vss vss sky130_fd_pr__nfet_01v8_lvt ad=0.231 pd=1.73 as=0.434 ps=3.42 w=1.4 l=0.15
X145 a_2810_872# a_2192_n1472# vdd vdd sky130_fd_pr__pfet_01v8 ad=0.377 pd=3.18 as=0.377 ps=3.18 w=1.3 l=0.15
X146 vss a_6220_n1222# a_6498_208# vss sky130_fd_pr__nfet_01v8_lvt ad=0.403 pd=3.22 as=0.2145 ps=1.63 w=1.3 l=0.15
X147 vss a_360_228# a_2192_n1472# vss sky130_fd_pr__nfet_01v8 ad=0.22275 pd=1.68 as=0.22275 ps=1.68 w=1.35 l=0.15
X148 q4p a_11630_n1152# vdd vdd sky130_fd_pr__pfet_01v8 ad=0.4455 pd=3.03 as=0.837 ps=6.02 w=2.7 l=0.15
X149 a_4038_308# a_3108_872# vss vss sky130_fd_pr__nfet_01v8 ad=0.232 pd=2.18 as=0.232 ps=2.18 w=0.8 l=0.15
X150 vss a_964_n1472# vss vss sky130_fd_pr__nfet_01v8 ad=0.29 pd=2.58 as=0 ps=0 w=1 l=0.5
X151 q4p q4n vdd vdd sky130_fd_pr__pfet_01v8 ad=0.3625 pd=3.08 as=0.3625 ps=3.08 w=1.25 l=0.15
X152 a_6498_208# a_6220_n1222# vss vss sky130_fd_pr__nfet_01v8_lvt ad=0.2145 pd=1.63 as=0.403 ps=3.22 w=1.3 l=0.15
X153 a_12974_n1152# a_14521_n1092# vdd vdd sky130_fd_pr__pfet_01v8 ad=0.2475 pd=1.83 as=0.465 ps=3.62 w=1.5 l=0.15
X154 vss a_17911_n1152# q8p vss sky130_fd_pr__nfet_01v8 ad=0.465 pd=3.62 as=0.2475 ps=1.83 w=1.5 l=0.15
X155 vdd a_3022_486# a_8240_n1092# vdd sky130_fd_pr__pfet_01v8 ad=0.341 pd=2.82 as=0.1815 ps=1.43 w=1.1 l=0.15
X156 a_3108_n1152# a_2192_n1472# vdd vdd sky130_fd_pr__pfet_01v8 ad=0.231 pd=1.73 as=0.434 ps=3.42 w=1.4 l=0.15
X157 vdd a_360_228# a_2192_n1472# vdd sky130_fd_pr__pfet_01v8 ad=0.93 pd=6.62 as=0.495 ps=3.33 w=3 l=0.15
X158 a_17911_208# a_17911_n1152# vdd vdd sky130_fd_pr__pfet_01v8 ad=0.1885 pd=1.88 as=0.1885 ps=1.88 w=0.65 l=0.15
X159 q8p a_17911_n1152# vss vss sky130_fd_pr__nfet_01v8 ad=0.2475 pd=1.83 as=0.465 ps=3.62 w=1.5 l=0.15
X160 a_17911_n1152# a_16703_n1152# vdd vdd sky130_fd_pr__pfet_01v8 ad=0.231 pd=1.73 as=0.434 ps=3.42 w=1.4 l=0.15
X161 a_9170_308# a_8240_872# vss vss sky130_fd_pr__nfet_01v8 ad=0.232 pd=2.18 as=0.232 ps=2.18 w=0.8 l=0.15
X162 vss a_11352_n1222# a_11630_208# vss sky130_fd_pr__nfet_01v8_lvt ad=0.403 pd=3.22 as=0.2145 ps=1.63 w=1.3 l=0.15
X163 a_3108_n1152# a_3108_872# a_2810_n1132# vss sky130_fd_pr__nfet_01v8_lvt ad=0.231 pd=1.73 as=0.434 ps=3.42 w=1.4 l=0.15
X164 a_8240_n1092# a_3022_486# a_8240_872# vdd sky130_fd_pr__pfet_01v8 ad=0.261 pd=2.38 as=0.261 ps=2.38 w=0.9 l=0.15
X165 vdd a_3108_872# a_3022_n580# vdd sky130_fd_pr__pfet_01v8 ad=0.589 pd=4.42 as=0.3135 ps=2.23 w=1.9 l=0.15
X166 a_12974_n1152# a_12974_872# vss vss sky130_fd_pr__nfet_01v8 ad=0.2175 pd=2.08 as=0.2175 ps=2.08 w=0.75 l=0.15
X167 vss a_2192_n1472# a_4944_n468# vss sky130_fd_pr__nfet_01v8_lvt ad=0.341 pd=2.82 as=0.1815 ps=1.43 w=1.1 l=0.15
X168 vss a_2192_n1472# a_10076_n468# vss sky130_fd_pr__nfet_01v8_lvt ad=0.341 pd=2.82 as=0.1815 ps=1.43 w=1.1 l=0.15
X169 a_4038_308# a_3108_872# vdd vdd sky130_fd_pr__pfet_01v8 ad=0.5075 pd=4.08 as=0.5075 ps=4.08 w=1.75 l=0.15
X170 a_3022_n580# a_3108_872# vdd vdd sky130_fd_pr__pfet_01v8 ad=0.3135 pd=2.23 as=0.589 ps=4.42 w=1.9 l=0.15
X171 vdd clkn a_360_n1472# vdd sky130_fd_pr__pfet_01v8 ad=0.93 pd=6.62 as=0.495 ps=3.33 w=3 l=0.15
X172 a_10124_n1132# a_8154_486# a_10076_n468# vss sky130_fd_pr__nfet_01v8_lvt ad=0.231 pd=1.73 as=0.434 ps=3.42 w=1.4 l=0.15
X173 a_10422_872# a_2192_n1472# a_10422_n1152# vdd sky130_fd_pr__pfet_01v8 ad=0.29 pd=2.58 as=0.29 ps=2.58 w=1 l=0.15
X174 a_10422_n1152# a_2192_n1472# vdd vdd sky130_fd_pr__pfet_01v8 ad=0.231 pd=1.73 as=0.434 ps=3.42 w=1.4 l=0.15
X175 a_7942_872# a_8240_n1092# a_8240_872# vss sky130_fd_pr__nfet_01v8_lvt ad=0.372 pd=3.02 as=0.198 ps=1.53 w=1.2 l=0.15
X176 vdd a_14521_n1092# a_12974_n1152# vdd sky130_fd_pr__pfet_01v8 ad=0.465 pd=3.62 as=0.2475 ps=1.83 w=1.5 l=0.15
X177 a_9170_308# a_8240_872# vdd vdd sky130_fd_pr__pfet_01v8 ad=0.5075 pd=4.08 as=0.5075 ps=4.08 w=1.75 l=0.15
X178 a_8240_872# a_8240_n1092# a_7942_872# vss sky130_fd_pr__nfet_01v8_lvt ad=0.198 pd=1.53 as=0.372 ps=3.02 w=1.2 l=0.15
X179 vss a_2192_n1472# a_10076_n468# vss sky130_fd_pr__nfet_01v8_lvt ad=0.341 pd=2.82 as=0.1815 ps=1.43 w=1.1 l=0.15
X180 vss a_6498_208# q2n vss sky130_fd_pr__nfet_01v8 ad=0.403 pd=3.22 as=0.2145 ps=1.63 w=1.3 l=0.15
X181 a_12974_n1152# a_15451_308# vss vss sky130_fd_pr__nfet_01v8_lvt ad=0.231 pd=1.73 as=0.434 ps=3.42 w=1.4 l=0.15
X182 a_11630_208# a_10422_872# vdd vdd sky130_fd_pr__pfet_01v8 ad=0.231 pd=1.73 as=0.434 ps=3.42 w=1.4 l=0.15
X183 a_14223_872# a_3022_486# vdd vdd sky130_fd_pr__pfet_01v8 ad=0.319 pd=2.78 as=0.319 ps=2.78 w=1.1 l=0.15
X184 a_17633_308# a_16703_872# vss vss sky130_fd_pr__nfet_01v8 ad=0.232 pd=2.18 as=0.232 ps=2.18 w=0.8 l=0.15
X185 vss a_4038_308# a_3022_486# vss sky130_fd_pr__nfet_01v8_lvt ad=0.527 pd=4.02 as=0.2805 ps=2.03 w=1.7 l=0.15
X186 a_7894_n468# a_8154_n580# a_7942_n1092# vss sky130_fd_pr__nfet_01v8_lvt ad=0.434 pd=3.42 as=0.231 ps=1.73 w=1.4 l=0.15
X187 a_10076_n468# a_2192_n1472# vss vss sky130_fd_pr__nfet_01v8_lvt ad=0.1815 pd=1.43 as=0.341 ps=2.82 w=1.1 l=0.15
X188 vdd a_2192_n1472# a_3108_n1152# vdd sky130_fd_pr__pfet_01v8 ad=0.434 pd=3.42 as=0.231 ps=1.73 w=1.4 l=0.15
X189 vss a_2192_n1472# a_16357_n468# vss sky130_fd_pr__nfet_01v8_lvt ad=0.341 pd=2.82 as=0.1815 ps=1.43 w=1.1 l=0.15
X190 a_8154_486# a_8154_n580# vdd vdd sky130_fd_pr__pfet_01v8 ad=0.174 pd=1.78 as=0.174 ps=1.78 w=0.6 l=0.15
X191 a_5290_n1152# a_5290_872# vdd vdd sky130_fd_pr__pfet_01v8 ad=0.435 pd=3.58 as=0.435 ps=3.58 w=1.5 l=0.15
X192 a_3022_n580# a_3022_486# vdd vdd sky130_fd_pr__pfet_01v8 ad=0.2755 pd=2.48 as=0.2755 ps=2.48 w=0.95 l=0.15
X193 a_16405_n1132# a_12974_n1152# a_16357_n468# vss sky130_fd_pr__nfet_01v8_lvt ad=0.231 pd=1.73 as=0.434 ps=3.42 w=1.4 l=0.15
X194 a_16405_n1132# a_2192_n1472# vdd vdd sky130_fd_pr__pfet_01v8 ad=0.377 pd=3.18 as=0.377 ps=3.18 w=1.3 l=0.15
X195 a_11352_n1222# a_10422_n1152# vss vss sky130_fd_pr__nfet_01v8 ad=0.232 pd=2.18 as=0.232 ps=2.18 w=0.8 l=0.15
X196 a_17633_n1222# a_16703_n1152# vdd vdd sky130_fd_pr__pfet_01v8 ad=0.5075 pd=4.08 as=0.5075 ps=4.08 w=1.75 l=0.15
X197 a_10422_n1152# a_2192_n1472# a_10422_872# vdd sky130_fd_pr__pfet_01v8 ad=0.29 pd=2.58 as=0.29 ps=2.58 w=1 l=0.15
X198 a_2810_n1132# a_2192_n1472# vdd vdd sky130_fd_pr__pfet_01v8 ad=0.377 pd=3.18 as=0.377 ps=3.18 w=1.3 l=0.15
X199 a_17633_308# a_16703_872# vdd vdd sky130_fd_pr__pfet_01v8 ad=0.5075 pd=4.08 as=0.5075 ps=4.08 w=1.75 l=0.15
X200 a_17911_208# a_16703_872# vdd vdd sky130_fd_pr__pfet_01v8 ad=0.231 pd=1.73 as=0.434 ps=3.42 w=1.4 l=0.15
X201 vss a_11630_n1152# q4p vss sky130_fd_pr__nfet_01v8 ad=0.403 pd=3.22 as=0.2145 ps=1.63 w=1.3 l=0.15
X202 vss a_360_n1472# a_964_n1472# vss sky130_fd_pr__nfet_01v8 ad=0.4185 pd=3.32 as=0.22275 ps=1.68 w=1.35 l=0.15
X203 vss a_964_n1472# vss vss sky130_fd_pr__nfet_01v8 ad=0.145 pd=1.29 as=0 ps=0 w=1 l=0.5
X204 vdd a_16703_872# a_17911_208# vdd sky130_fd_pr__pfet_01v8 ad=0.434 pd=3.42 as=0.231 ps=1.73 w=1.4 l=0.15
X205 q4p a_11630_n1152# vss vss sky130_fd_pr__nfet_01v8 ad=0.2145 pd=1.63 as=0.403 ps=3.22 w=1.3 l=0.15
X206 a_8154_n580# a_8154_486# vdd vdd sky130_fd_pr__pfet_01v8 ad=0.2465 pd=2.28 as=0.2465 ps=2.28 w=0.85 l=0.15
X207 vdd a_2192_n1472# a_16703_n1152# vdd sky130_fd_pr__pfet_01v8 ad=0.434 pd=3.42 as=0.231 ps=1.73 w=1.4 l=0.15
X208 a_360_228# clkp vss vss sky130_fd_pr__nfet_01v8 ad=0.198 pd=1.53 as=0.372 ps=3.02 w=1.2 l=0.15
X209 vss a_11352_308# a_11630_n1152# vss sky130_fd_pr__nfet_01v8_lvt ad=0.403 pd=3.22 as=0.2145 ps=1.63 w=1.3 l=0.15
X210 a_17633_n1222# a_16703_n1152# vss vss sky130_fd_pr__nfet_01v8 ad=0.232 pd=2.18 as=0.232 ps=2.18 w=0.8 l=0.15
X211 a_4992_872# a_5290_n1152# a_5290_872# vss sky130_fd_pr__nfet_01v8_lvt ad=0.3565 pd=2.92 as=0.18975 ps=1.48 w=1.15 l=0.15
X212 a_4944_n468# a_2192_n1472# vss vss sky130_fd_pr__nfet_01v8_lvt ad=0.1815 pd=1.43 as=0.341 ps=2.82 w=1.1 l=0.15
X213 a_14521_872# a_14521_n1092# vdd vdd sky130_fd_pr__pfet_01v8 ad=0.406 pd=3.38 as=0.406 ps=3.38 w=1.4 l=0.15
X214 a_14175_n468# a_13066_n1152# a_14223_n1092# vss sky130_fd_pr__nfet_01v8_lvt ad=0.434 pd=3.42 as=0.231 ps=1.73 w=1.4 l=0.15
X215 vss clkp a_360_228# vss sky130_fd_pr__nfet_01v8 ad=0.372 pd=3.02 as=0.198 ps=1.53 w=1.2 l=0.15
X216 a_5290_872# a_5290_n1152# a_4992_872# vss sky130_fd_pr__nfet_01v8_lvt ad=0.18975 pd=1.48 as=0.3565 ps=2.92 w=1.15 l=0.15
X217 a_5290_872# a_2192_n1472# vdd vdd sky130_fd_pr__pfet_01v8 ad=0.231 pd=1.73 as=0.434 ps=3.42 w=1.4 l=0.15
X218 a_4992_872# a_3022_n580# a_4944_n468# vss sky130_fd_pr__nfet_01v8_lvt ad=0.231 pd=1.73 as=0.434 ps=3.42 w=1.4 l=0.15
X219 a_11630_208# a_11352_n1222# vss vss sky130_fd_pr__nfet_01v8_lvt ad=0.2145 pd=1.63 as=0.403 ps=3.22 w=1.3 l=0.15
X220 a_12974_872# a_12974_n1152# vdd vdd sky130_fd_pr__pfet_01v8 ad=0.2465 pd=2.28 as=0.2465 ps=2.28 w=0.85 l=0.15
X221 a_10076_n468# a_2192_n1472# vss vss sky130_fd_pr__nfet_01v8_lvt ad=0.1815 pd=1.43 as=0.341 ps=2.82 w=1.1 l=0.15
X222 a_360_n1472# a_360_228# vss vss sky130_fd_pr__nfet_01v8 ad=0.1305 pd=1.48 as=0.1305 ps=1.48 w=0.45 l=0.15
X223 a_14521_n1092# a_3022_486# vdd vdd sky130_fd_pr__pfet_01v8 ad=0.1815 pd=1.43 as=0.341 ps=2.82 w=1.1 l=0.15
X224 vdd a_2192_n1472# a_5290_872# vdd sky130_fd_pr__pfet_01v8 ad=0.434 pd=3.42 as=0.231 ps=1.73 w=1.4 l=0.15
X225 a_5290_872# a_2192_n1472# a_5290_n1152# vdd sky130_fd_pr__pfet_01v8 ad=0.29 pd=2.58 as=0.29 ps=2.58 w=1 l=0.15
X226 a_4944_n468# a_3022_n580# a_4992_872# vss sky130_fd_pr__nfet_01v8_lvt ad=0.434 pd=3.42 as=0.231 ps=1.73 w=1.4 l=0.15
X227 a_8154_n580# a_8154_486# vss vss sky130_fd_pr__nfet_01v8 ad=0.145 pd=1.58 as=0.145 ps=1.58 w=0.5 l=0.15
X228 vss a_17633_308# a_17911_n1152# vss sky130_fd_pr__nfet_01v8_lvt ad=0.403 pd=3.22 as=0.2145 ps=1.63 w=1.3 l=0.15
X229 a_4038_n1222# a_3108_n1152# vdd vdd sky130_fd_pr__pfet_01v8 ad=0.5075 pd=4.08 as=0.5075 ps=4.08 w=1.75 l=0.15
X230 a_10422_872# a_2192_n1472# vdd vdd sky130_fd_pr__pfet_01v8 ad=0.231 pd=1.73 as=0.434 ps=3.42 w=1.4 l=0.15
X231 vdd a_17911_n1152# q8p vdd sky130_fd_pr__pfet_01v8 ad=0.961 pd=6.82 as=0.5115 ps=3.43 w=3.1 l=0.15
X232 a_10124_872# a_8154_n580# a_10076_n468# vss sky130_fd_pr__nfet_01v8_lvt ad=0.231 pd=1.73 as=0.434 ps=3.42 w=1.4 l=0.15
X233 a_7942_872# a_3022_486# vdd vdd sky130_fd_pr__pfet_01v8 ad=0.319 pd=2.78 as=0.319 ps=2.78 w=1.1 l=0.15
X234 a_2762_n468# a_2192_n1472# vss vss sky130_fd_pr__nfet_01v8_lvt ad=0.22275 pd=1.68 as=0.4185 ps=3.32 w=1.35 l=0.15
X235 a_6498_208# a_6498_n1152# vss vss sky130_fd_pr__nfet_01v8 ad=0.1595 pd=1.68 as=0.1595 ps=1.68 w=0.55 l=0.15
X236 q8p a_17911_n1152# vdd vdd sky130_fd_pr__pfet_01v8 ad=0.5115 pd=3.43 as=0.961 ps=6.82 w=3.1 l=0.15
X237 a_11630_n1152# a_11630_208# vss vss sky130_fd_pr__nfet_01v8 ad=0.1595 pd=1.68 as=0.1595 ps=1.68 w=0.55 l=0.15
X238 a_4944_n468# a_2192_n1472# vss vss sky130_fd_pr__nfet_01v8_lvt ad=0.1815 pd=1.43 as=0.341 ps=2.82 w=1.1 l=0.15
X239 a_11630_208# a_11630_n1152# vss vss sky130_fd_pr__nfet_01v8 ad=0.1595 pd=1.68 as=0.1595 ps=1.68 w=0.55 l=0.15
X240 a_13066_872# a_8154_486# a_12974_872# vss sky130_fd_pr__nfet_01v8 ad=0.377 pd=3.18 as=0.377 ps=3.18 w=1.3 l=0.15
X241 q2n a_6498_208# vss vss sky130_fd_pr__nfet_01v8 ad=0.2145 pd=1.63 as=0.403 ps=3.22 w=1.3 l=0.15
X242 q8p q8n vdd vdd sky130_fd_pr__pfet_01v8 ad=0.3915 pd=3.28 as=0.3915 ps=3.28 w=1.35 l=0.15
X243 a_15451_308# a_14521_872# vss vss sky130_fd_pr__nfet_01v8 ad=0.232 pd=2.18 as=0.232 ps=2.18 w=0.8 l=0.15
X244 q8p q8n vss vss sky130_fd_pr__nfet_01v8 ad=0.1885 pd=1.88 as=0.1885 ps=1.88 w=0.65 l=0.15
X245 a_3022_486# a_4038_308# vss vss sky130_fd_pr__nfet_01v8_lvt ad=0.2805 pd=2.03 as=0.527 ps=4.02 w=1.7 l=0.15
X246 vdd a_2192_n1472# a_10422_872# vdd sky130_fd_pr__pfet_01v8 ad=0.434 pd=3.42 as=0.231 ps=1.73 w=1.4 l=0.15
X247 vss a_2192_n1472# a_2762_n468# vss sky130_fd_pr__nfet_01v8_lvt ad=0.4185 pd=3.32 as=0.22275 ps=1.68 w=1.35 l=0.15
X248 a_10076_n468# a_8154_n580# a_10124_872# vss sky130_fd_pr__nfet_01v8_lvt ad=0.434 pd=3.42 as=0.231 ps=1.73 w=1.4 l=0.15
X249 a_13066_872# a_8154_n580# a_12974_n1152# vss sky130_fd_pr__nfet_01v8 ad=0.377 pd=3.18 as=0.377 ps=3.18 w=1.3 l=0.15
X250 a_17911_208# a_17633_n1222# vss vss sky130_fd_pr__nfet_01v8_lvt ad=0.2145 pd=1.63 as=0.403 ps=3.22 w=1.3 l=0.15
X251 vss a_2192_n1472# a_2762_n468# vss sky130_fd_pr__nfet_01v8_lvt ad=0.4185 pd=3.32 as=0.22275 ps=1.68 w=1.35 l=0.15
X252 q4n a_11630_208# vdd vdd sky130_fd_pr__pfet_01v8 ad=0.4455 pd=3.03 as=0.837 ps=6.02 w=2.7 l=0.15
X253 a_16405_n1132# a_16703_872# a_16703_n1152# vss sky130_fd_pr__nfet_01v8_lvt ad=0.3565 pd=2.92 as=0.18975 ps=1.48 w=1.15 l=0.15
X254 q2n a_6498_208# vdd vdd sky130_fd_pr__pfet_01v8 ad=0.4455 pd=3.03 as=0.837 ps=6.02 w=2.7 l=0.15
X255 a_3108_n1152# a_2192_n1472# a_3108_872# vdd sky130_fd_pr__pfet_01v8 ad=0.319 pd=2.78 as=0.319 ps=2.78 w=1.1 l=0.15
X256 a_2762_n468# a_3022_486# a_2810_872# vss sky130_fd_pr__nfet_01v8_lvt ad=0.527 pd=4.02 as=0.2805 ps=2.03 w=1.7 l=0.15
X257 a_16357_n468# a_2192_n1472# vss vss sky130_fd_pr__nfet_01v8_lvt ad=0.1815 pd=1.43 as=0.341 ps=2.82 w=1.1 l=0.15
X258 a_12974_872# a_12974_n1152# vss vss sky130_fd_pr__nfet_01v8 ad=0.145 pd=1.58 as=0.145 ps=1.58 w=0.5 l=0.15
X259 vss a_2192_n1472# a_4944_n468# vss sky130_fd_pr__nfet_01v8_lvt ad=0.341 pd=2.82 as=0.1815 ps=1.43 w=1.1 l=0.15
X260 a_6498_n1152# a_6498_208# vss vss sky130_fd_pr__nfet_01v8 ad=0.1595 pd=1.68 as=0.1595 ps=1.68 w=0.55 l=0.15
X261 a_12974_n1152# a_12974_872# vdd vdd sky130_fd_pr__pfet_01v8 ad=0.174 pd=1.78 as=0.174 ps=1.78 w=0.6 l=0.15
X262 a_8154_486# a_8240_n1092# vdd vdd sky130_fd_pr__pfet_01v8 ad=0.2475 pd=1.83 as=0.465 ps=3.62 w=1.5 l=0.15
X263 a_2810_872# a_3022_486# a_2762_n468# vss sky130_fd_pr__nfet_01v8_lvt ad=0.2805 pd=2.03 as=0.527 ps=4.02 w=1.7 l=0.15
X264 vss a_17633_n1222# a_17911_208# vss sky130_fd_pr__nfet_01v8_lvt ad=0.403 pd=3.22 as=0.2145 ps=1.63 w=1.3 l=0.15
X265 a_4992_n1132# a_3022_486# a_4944_n468# vss sky130_fd_pr__nfet_01v8_lvt ad=0.231 pd=1.73 as=0.434 ps=3.42 w=1.4 l=0.15
X266 vdd a_16703_n1152# a_17911_n1152# vdd sky130_fd_pr__pfet_01v8 ad=0.434 pd=3.42 as=0.231 ps=1.73 w=1.4 l=0.15
X267 a_6220_n1222# a_5290_n1152# vdd vdd sky130_fd_pr__pfet_01v8 ad=0.5075 pd=4.08 as=0.5075 ps=4.08 w=1.75 l=0.15
X268 a_11352_n1222# a_10422_n1152# vdd vdd sky130_fd_pr__pfet_01v8 ad=0.5075 pd=4.08 as=0.5075 ps=4.08 w=1.75 l=0.15
X269 a_10124_n1132# a_2192_n1472# vdd vdd sky130_fd_pr__pfet_01v8 ad=0.377 pd=3.18 as=0.377 ps=3.18 w=1.3 l=0.15
X270 vdd a_8240_872# a_8154_n580# vdd sky130_fd_pr__pfet_01v8 ad=0.465 pd=3.62 as=0.2475 ps=1.83 w=1.5 l=0.15
X271 vss a_9170_n1222# a_8154_n580# vss sky130_fd_pr__nfet_01v8_lvt ad=0.434 pd=3.42 as=0.231 ps=1.73 w=1.4 l=0.15
X272 q4n q4p vss vss sky130_fd_pr__nfet_01v8 ad=0.174 pd=1.78 as=0.174 ps=1.78 w=0.6 l=0.15
X273 a_8154_n580# a_8240_872# vdd vdd sky130_fd_pr__pfet_01v8 ad=0.2475 pd=1.83 as=0.465 ps=3.62 w=1.5 l=0.15
X274 a_8154_n580# a_9170_n1222# vss vss sky130_fd_pr__nfet_01v8_lvt ad=0.231 pd=1.73 as=0.434 ps=3.42 w=1.4 l=0.15
X275 a_14223_872# a_14521_n1092# a_14521_872# vss sky130_fd_pr__nfet_01v8_lvt ad=0.372 pd=3.02 as=0.198 ps=1.53 w=1.2 l=0.15
X276 a_13066_n1152# a_8154_486# a_12974_n1152# vss sky130_fd_pr__nfet_01v8 ad=0.377 pd=3.18 as=0.377 ps=3.18 w=1.3 l=0.15
X277 a_15451_308# a_14521_872# vdd vdd sky130_fd_pr__pfet_01v8 ad=0.5075 pd=4.08 as=0.5075 ps=4.08 w=1.75 l=0.15
X278 a_17911_208# a_17911_n1152# vss vss sky130_fd_pr__nfet_01v8 ad=0.1595 pd=1.68 as=0.1595 ps=1.68 w=0.55 l=0.15
X279 a_10422_n1152# a_10422_872# a_10124_n1132# vss sky130_fd_pr__nfet_01v8_lvt ad=0.18975 pd=1.48 as=0.3565 ps=2.92 w=1.15 l=0.15
X280 a_14521_872# a_14521_n1092# a_14223_872# vss sky130_fd_pr__nfet_01v8_lvt ad=0.198 pd=1.53 as=0.372 ps=3.02 w=1.2 l=0.15
X281 a_5290_n1152# a_2192_n1472# vdd vdd sky130_fd_pr__pfet_01v8 ad=0.231 pd=1.73 as=0.434 ps=3.42 w=1.4 l=0.15
X282 a_2192_n1472# a_360_228# vss vss sky130_fd_pr__nfet_01v8 ad=0.22275 pd=1.68 as=0.4185 ps=3.32 w=1.35 l=0.15
X283 vss a_360_228# a_2192_n1472# vss sky130_fd_pr__nfet_01v8 ad=0.4185 pd=3.32 as=0.22275 ps=1.68 w=1.35 l=0.15
X284 a_16703_872# a_2192_n1472# a_16703_n1152# vdd sky130_fd_pr__pfet_01v8 ad=0.29 pd=2.58 as=0.29 ps=2.58 w=1 l=0.15
X285 a_360_228# a_360_n1472# vss vss sky130_fd_pr__nfet_01v8 ad=0.1305 pd=1.48 as=0.1305 ps=1.48 w=0.45 l=0.15
X286 vdd a_14521_872# a_12974_872# vdd sky130_fd_pr__pfet_01v8 ad=0.465 pd=3.62 as=0.2475 ps=1.83 w=1.5 l=0.15
X287 vss a_15451_n1222# a_12974_872# vss sky130_fd_pr__nfet_01v8_lvt ad=0.434 pd=3.42 as=0.231 ps=1.73 w=1.4 l=0.15
X288 a_2192_n1472# a_360_228# vss vss sky130_fd_pr__nfet_01v8 ad=0.22275 pd=1.68 as=0.22275 ps=1.68 w=1.35 l=0.15
X289 vss a_2192_n1472# a_16357_n468# vss sky130_fd_pr__nfet_01v8_lvt ad=0.341 pd=2.82 as=0.1815 ps=1.43 w=1.1 l=0.15
X290 vdd a_2192_n1472# a_10422_n1152# vdd sky130_fd_pr__pfet_01v8 ad=0.434 pd=3.42 as=0.231 ps=1.73 w=1.4 l=0.15
X291 a_7942_n1092# a_3022_486# vdd vdd sky130_fd_pr__pfet_01v8 ad=0.319 pd=2.78 as=0.319 ps=2.78 w=1.1 l=0.15
X292 vdd a_6498_208# q2n vdd sky130_fd_pr__pfet_01v8 ad=0.837 pd=6.02 as=0.4455 ps=3.03 w=2.7 l=0.15
X293 a_2192_n1472# a_360_228# vdd vdd sky130_fd_pr__pfet_01v8 ad=0.495 pd=3.33 as=0.93 ps=6.62 w=3 l=0.15
X294 vss a_360_228# a_2192_n1472# vss sky130_fd_pr__nfet_01v8 ad=0.22275 pd=1.68 as=0.22275 ps=1.68 w=1.35 l=0.15
X295 a_12974_872# a_14521_872# vdd vdd sky130_fd_pr__pfet_01v8 ad=0.2475 pd=1.83 as=0.465 ps=3.62 w=1.5 l=0.15
X296 a_12974_872# a_15451_n1222# vss vss sky130_fd_pr__nfet_01v8_lvt ad=0.231 pd=1.73 as=0.434 ps=3.42 w=1.4 l=0.15
X297 vss clkn a_360_n1472# vss sky130_fd_pr__nfet_01v8 ad=0.372 pd=3.02 as=0.198 ps=1.53 w=1.2 l=0.15
X298 a_964_n1472# a_360_n1472# vss vss sky130_fd_pr__nfet_01v8 ad=0.22275 pd=1.68 as=0.4185 ps=3.32 w=1.35 l=0.15
X299 vdd a_11630_208# q4n vdd sky130_fd_pr__pfet_01v8 ad=0.837 pd=6.02 as=0.4455 ps=3.03 w=2.7 l=0.15
X300 a_16357_n468# a_2192_n1472# vss vss sky130_fd_pr__nfet_01v8_lvt ad=0.1815 pd=1.43 as=0.341 ps=2.82 w=1.1 l=0.15
X301 a_2192_n1472# a_360_228# vss vss sky130_fd_pr__nfet_01v8 ad=0.22275 pd=1.68 as=0.4185 ps=3.32 w=1.35 l=0.15
X302 q8n q8p vss vss sky130_fd_pr__nfet_01v8 ad=0.1885 pd=1.88 as=0.1885 ps=1.88 w=0.65 l=0.15
X303 a_11630_n1152# a_11352_308# vss vss sky130_fd_pr__nfet_01v8_lvt ad=0.2145 pd=1.63 as=0.403 ps=3.22 w=1.3 l=0.15
X304 a_16703_n1152# a_16703_872# vdd vdd sky130_fd_pr__pfet_01v8 ad=0.435 pd=3.58 as=0.435 ps=3.58 w=1.5 l=0.15
X305 vdd a_8240_n1092# a_8154_486# vdd sky130_fd_pr__pfet_01v8 ad=0.465 pd=3.62 as=0.2475 ps=1.83 w=1.5 l=0.15
X306 a_6220_308# a_5290_872# vss vss sky130_fd_pr__nfet_01v8 ad=0.232 pd=2.18 as=0.232 ps=2.18 w=0.8 l=0.15
X307 a_2762_n468# a_3022_n580# a_2810_n1132# vss sky130_fd_pr__nfet_01v8_lvt ad=0.527 pd=4.02 as=0.2805 ps=2.03 w=1.7 l=0.15
X308 a_4992_n1132# a_5290_872# a_5290_n1152# vss sky130_fd_pr__nfet_01v8_lvt ad=0.3565 pd=2.92 as=0.18975 ps=1.48 w=1.15 l=0.15
X309 a_2810_872# a_3108_n1152# a_3108_872# vss sky130_fd_pr__nfet_01v8_lvt ad=0.434 pd=3.42 as=0.231 ps=1.73 w=1.4 l=0.15
X310 vss a_3022_486# a_7894_n468# vss sky130_fd_pr__nfet_01v8_lvt ad=0.341 pd=2.82 as=0.1815 ps=1.43 w=1.1 l=0.15
X311 a_15451_n1222# a_14521_n1092# vdd vdd sky130_fd_pr__pfet_01v8 ad=0.5075 pd=4.08 as=0.5075 ps=4.08 w=1.75 l=0.15
C0 a_10124_872# q4n 0
C1 a_5290_872# q2n 0.00582f
C2 a_6220_308# a_4992_872# 0
C3 a_5290_n1152# a_3108_872# 0
C4 a_9170_308# a_2192_n1472# 0.02779f
C5 a_6220_308# vdd 0.21019f
C6 a_4038_308# a_3108_n1152# 0.04149f
C7 a_3108_n1152# a_2810_872# 0.12109f
C8 a_10124_n1132# a_8154_486# 0.09693f
C9 a_14521_n1092# a_14223_872# 0.11671f
C10 vdd a_4992_n1132# 0.1584f
C11 a_11352_n1222# a_11630_n1152# 0.13522f
C12 a_10076_n468# a_11630_n1152# 0
C13 a_8240_872# a_8154_n580# 0.25163f
C14 a_14223_n1092# a_15451_n1222# 0
C15 a_7894_n468# a_9170_308# 0
C16 a_8154_486# a_5290_n1152# 0
C17 a_13066_n1152# a_3022_486# 0.3725f
C18 a_3022_486# a_14175_n468# 0.26649f
C19 a_2762_n468# a_3108_872# 0.00467f
C20 a_3022_486# a_3022_n580# 0.96923f
C21 q4p a_13066_872# 0.00784f
C22 a_11630_n1152# q4p 0.34376f
C23 a_5290_n1152# a_5290_872# 1.1542f
C24 a_14521_n1092# a_16405_872# 0
C25 a_16703_872# q8p 0.01228f
C26 a_3022_486# a_11630_208# 0.00612f
C27 a_9170_308# a_10422_n1152# 0
C28 a_8154_n580# q2n 0
C29 a_16703_872# a_16405_872# 0.14468f
C30 a_4038_n1222# a_4992_n1132# 0
C31 a_7942_n1092# a_8240_n1092# 0.15631f
C32 a_3022_n580# a_2810_n1132# 0.15351f
C33 a_8240_872# a_2192_n1472# 0.16186f
C34 a_5290_872# a_3108_872# 0
C35 a_3022_n580# a_6498_n1152# 0
C36 a_15451_n1222# a_2192_n1472# 0.02805f
C37 a_3022_486# a_14223_872# 0.12683f
C38 a_16357_n468# a_12974_872# 0.06508f
C39 a_3022_486# a_360_228# 0.00835f
C40 a_9170_308# a_7942_872# 0
C41 vdd a_964_n1472# 0.53596f
C42 a_10124_n1132# a_8154_n580# 0.00706f
C43 a_8240_872# a_7894_n468# 0.00457f
C44 q2n a_2192_n1472# 0.15718f
C45 a_4992_872# vdd 0.15827f
C46 a_2810_n1132# a_360_228# 0.00887f
C47 a_14521_n1092# a_15451_308# 0.04149f
C48 a_3022_486# a_16405_872# 0
C49 q8p a_17633_n1222# 0
C50 a_16703_872# a_15451_308# 0
C51 a_8240_872# a_10422_n1152# 0
C52 a_16405_872# a_17633_n1222# 0
C53 a_7894_n468# q2n 0
C54 a_10422_872# a_8240_n1092# 0
C55 a_13066_n1152# a_13066_872# 0.0045f
C56 a_13066_872# a_14175_n468# 0.05819f
C57 a_10124_872# a_10422_872# 0.14468f
C58 a_10124_n1132# a_2192_n1472# 0.1548f
C59 a_4038_n1222# a_4992_872# 0
C60 a_16405_n1132# a_15451_308# 0
C61 a_8240_872# a_7942_872# 0.14832f
C62 a_11630_n1152# a_11630_208# 0.74865f
C63 a_4038_n1222# vdd 0.22348f
C64 a_5290_n1152# a_2192_n1472# 0.5801f
C65 a_3022_486# a_15451_308# 0
C66 a_8154_486# a_14223_n1092# 0.00162f
C67 a_14223_872# a_13066_872# 0.09258f
C68 a_8154_486# a_8154_n580# 1.132f
C69 a_4944_n468# a_4038_308# 0
C70 a_6220_n1222# a_6220_308# 0.45158f
C71 a_4944_n468# a_2810_872# 0
C72 a_7942_n1092# a_9170_308# 0
C73 a_3108_872# a_2192_n1472# 0.54873f
C74 a_7942_872# q2n 0.00349f
C75 a_10124_n1132# a_10422_n1152# 0.16125f
C76 a_6220_n1222# a_4992_n1132# 0
C77 a_10076_n468# a_8240_n1092# 0
C78 a_11352_n1222# a_10124_872# 0
C79 a_6220_308# a_6498_208# 0.04572f
C80 a_12974_n1152# a_15451_n1222# 0.14362f
C81 a_2762_n468# a_2192_n1472# 0.29379f
C82 a_10076_n468# a_10124_872# 0.28305f
C83 a_12974_872# vdd 1.75012f
C84 a_14521_872# a_15451_n1222# 0.0552f
C85 a_8154_486# a_2192_n1472# 1.26939f
C86 a_6498_208# a_4992_n1132# 0
C87 q4p a_10124_872# 0
C88 a_6220_308# q2p 0.00166f
C89 a_5290_872# a_2192_n1472# 0.54417f
C90 a_10124_n1132# q4n 0
C91 a_9170_n1222# vdd 0.22299f
C92 a_3022_n580# a_3108_n1152# 0.13968f
C93 a_9170_308# a_10422_872# 0
C94 a_7894_n468# a_8154_486# 0.24031f
C95 a_8240_872# a_7942_n1092# 0.09975f
C96 a_11352_308# vdd 0.20845f
C97 a_16357_n468# a_14521_n1092# 0
C98 a_8154_n580# a_14223_n1092# 0.00266f
C99 a_16357_n468# a_16703_872# 0.00603f
C100 a_15451_308# a_13066_872# 0
C101 a_8154_486# a_10422_n1152# 0.06514f
C102 a_6220_n1222# a_4992_872# 0
C103 a_3108_n1152# a_360_228# 0
C104 a_7942_n1092# q2n 0.00717f
C105 a_16357_n468# a_16405_n1132# 0.28305f
C106 a_6220_n1222# vdd 0.22279f
C107 a_4992_872# a_6498_208# 0
C108 a_14223_n1092# a_2192_n1472# 0.02102f
C109 a_8154_486# a_7942_872# 0.1056f
C110 a_8154_n580# a_2192_n1472# 1.47093f
C111 q8n vdd 0.86555f
C112 a_10076_n468# a_9170_308# 0
C113 a_8240_872# a_10422_872# 0
C114 a_6498_208# vdd 0.95868f
C115 a_8154_486# q4n 0.08414f
C116 a_10124_n1132# a_7942_n1092# 0
C117 a_4992_872# q2p 0
C118 a_7894_n468# a_8154_n580# 0.15096f
C119 a_16357_n468# a_17633_n1222# 0
C120 a_10124_872# a_11630_208# 0
C121 a_3022_486# a_6220_308# 0
C122 a_12974_n1152# a_8154_486# 0.74577f
C123 vdd q2p 0.81295f
C124 a_12974_872# a_11352_308# 0
C125 a_3022_486# a_4992_n1132# 0.09658f
C126 a_10422_n1152# a_8154_n580# 0.0434f
C127 a_5290_n1152# a_4038_308# 0
C128 a_14521_872# a_8154_486# 0
C129 a_16703_n1152# a_15451_n1222# 0
C130 a_6220_308# a_6498_n1152# 0.13196f
C131 a_7894_n468# a_2192_n1472# 0.01324f
C132 a_2810_n1132# a_4992_n1132# 0
C133 a_4038_308# a_3108_872# 0.29692f
C134 a_4992_n1132# a_6498_n1152# 0
C135 a_3108_872# a_2810_872# 0.16273f
C136 a_10124_n1132# a_10422_872# 0.09853f
C137 a_8240_872# a_10076_n468# 0
C138 a_8154_n580# a_7942_872# 0.07223f
C139 a_14521_n1092# vdd 1.35036f
C140 a_7942_n1092# a_8154_486# 0.05627f
C141 q4n a_14223_n1092# 0
C142 a_10422_n1152# a_2192_n1472# 0.57994f
C143 a_2762_n468# a_4038_308# 0
C144 a_16703_872# vdd 1.45413f
C145 a_2762_n468# a_2810_872# 0.30692f
C146 a_8154_n580# q4n 0.00782f
C147 a_3022_n580# a_4944_n468# 0.06036f
C148 vdd a_16405_n1132# 0.16085f
C149 a_12974_n1152# a_14223_n1092# 0.00216f
C150 a_7942_872# a_2192_n1472# 0.01799f
C151 a_3022_486# a_964_n1472# 0
C152 a_12974_n1152# a_8154_n580# 0.79571f
C153 a_5290_872# a_4038_308# 0
C154 a_3022_486# a_4992_872# 0.00555f
C155 a_14521_872# a_14223_n1092# 0.09975f
C156 a_14521_872# a_8154_n580# 0
C157 q4n a_2192_n1472# 0.15487f
C158 a_10124_n1132# a_11352_n1222# 0
C159 a_3022_486# vdd 9.43186f
C160 a_10124_n1132# a_10076_n468# 0.28305f
C161 a_2810_n1132# a_964_n1472# 0.00105f
C162 a_7894_n468# a_7942_872# 0.28099f
C163 a_8154_486# a_10422_872# 0.03354f
C164 a_4992_872# a_6498_n1152# 0
C165 vdd a_17633_n1222# 0.23043f
C166 a_12974_n1152# a_2192_n1472# 1.34456f
C167 a_2810_n1132# vdd 0.16047f
C168 vdd a_6498_n1152# 0.96035f
C169 a_7942_n1092# a_8154_n580# 0.14436f
C170 a_14521_n1092# a_12974_872# 0.02813f
C171 a_14521_872# a_2192_n1472# 0.16191f
C172 a_6220_n1222# a_6498_208# 0.1293f
C173 a_3022_486# a_4038_n1222# 0.14435f
C174 a_16703_872# a_12974_872# 0.04252f
C175 a_10422_n1152# q4n 0.01055f
C176 a_13066_n1152# a_15451_n1222# 0
C177 a_14175_n468# a_15451_n1222# 0
C178 a_4038_n1222# a_2810_n1132# 0
C179 a_12974_872# a_16405_n1132# 0.00723f
C180 a_6220_n1222# q2p 0
C181 a_7942_n1092# a_2192_n1472# 0.01799f
C182 a_11352_n1222# a_8154_486# 0.0043f
C183 a_12974_n1152# a_10422_n1152# 0
C184 a_10076_n468# a_8154_486# 0.05971f
C185 a_14223_872# a_15451_n1222# 0
C186 a_4038_308# a_2192_n1472# 0.02872f
C187 a_6498_208# q2p 0.06452f
C188 a_2810_872# a_2192_n1472# 0.16137f
C189 a_3022_486# a_12974_872# 0.02135f
C190 vdd a_13066_872# 0.67903f
C191 a_3108_n1152# a_4992_n1132# 0
C192 a_8154_n580# a_10422_872# 0.05535f
C193 a_11630_n1152# vdd 0.95586f
C194 a_7894_n468# a_7942_n1092# 0.28099f
C195 q4p a_8154_486# 0.10256f
C196 a_12974_872# a_17633_n1222# 0
C197 a_3022_486# a_9170_n1222# 0
C198 a_16405_872# a_15451_n1222# 0
C199 a_12974_n1152# q4n 0.00895f
C200 a_10124_n1132# a_11630_208# 0
C201 a_3022_486# a_11352_308# 0
C202 a_360_n1472# a_2192_n1472# 0.00218f
C203 a_10422_872# a_2192_n1472# 0.54402f
C204 a_16703_872# q8n 0.00655f
C205 a_3022_n580# a_5290_n1152# 0.03893f
C206 a_11352_n1222# a_8154_n580# 0
C207 a_17633_308# a_2192_n1472# 0
C208 q8n a_16405_n1132# 0
C209 a_12974_n1152# a_14521_872# 0.03173f
C210 a_3022_n580# a_3108_872# 0.26632f
C211 a_10076_n468# a_8154_n580# 0.06057f
C212 a_6220_n1222# a_3022_486# 0.00375f
C213 a_4992_872# a_3108_n1152# 0
C214 a_16703_n1152# a_2192_n1472# 0.42834f
C215 a_15451_308# a_15451_n1222# 0.45208f
C216 a_17911_208# a_2192_n1472# 0
C217 q4p a_14223_n1092# 0
C218 a_3022_n580# a_2762_n468# 0.16178f
C219 a_13066_n1152# a_8154_486# 0.3979f
C220 q4p a_8154_n580# 0.05685f
C221 a_10422_n1152# a_10422_872# 1.1542f
C222 a_12974_872# a_13066_872# 0.59255f
C223 a_8154_486# a_14175_n468# 0
C224 a_11630_n1152# a_12974_872# 0.00376f
C225 vdd a_3108_n1152# 1.40653f
C226 a_3022_486# a_6498_208# 0.01949f
C227 a_3108_872# a_360_228# 0
C228 a_11352_n1222# a_2192_n1472# 0.02956f
C229 a_6220_n1222# a_6498_n1152# 0.13522f
C230 q8n a_17633_n1222# 0.00201f
C231 a_10076_n468# a_2192_n1472# 0.28367f
C232 a_8154_486# a_11630_208# 0.01512f
C233 a_17911_n1152# a_2192_n1472# 0
C234 a_3022_n580# a_5290_872# 0.03989f
C235 a_2762_n468# a_360_228# 0.00248f
C236 a_14521_n1092# a_16703_872# 0
C237 a_6498_208# a_6498_n1152# 0.74865f
C238 a_3022_486# q2p 0.12774f
C239 a_8154_486# a_14223_872# 0.00144f
C240 q4p a_2192_n1472# 0.15294f
C241 a_11630_n1152# a_11352_308# 0.13196f
C242 q4n a_10422_872# 0.00582f
C243 a_4038_n1222# a_3108_n1152# 0.16538f
C244 a_14521_n1092# a_16405_n1132# 0
C245 a_11352_n1222# a_10422_n1152# 0.16551f
C246 q2p a_6498_n1152# 0.3443f
C247 a_16703_872# a_16405_n1132# 0.09853f
C248 clkn a_360_n1472# 0.29341f
C249 a_6220_308# a_4944_n468# 0
C250 a_10076_n468# a_10422_n1152# 0.03106f
C251 a_13066_n1152# a_14223_n1092# 0.08943f
C252 a_3022_486# a_14521_n1092# 0.41696f
C253 vdd a_8240_n1092# 1.3495f
C254 a_4944_n468# a_4992_n1132# 0.28305f
C255 a_13066_n1152# a_8154_n580# 0.30048f
C256 a_14223_n1092# a_14175_n468# 0.28415f
C257 a_10124_872# vdd 0.15827f
C258 a_8154_n580# a_14175_n468# 0
C259 a_3022_486# a_16703_872# 0
C260 q4p a_10422_n1152# 0.00512f
C261 a_4038_308# a_2810_872# 0
C262 a_12974_n1152# a_17633_308# 0
C263 a_10076_n468# a_7942_872# 0
C264 a_11630_208# a_8154_n580# 0.00605f
C265 a_16703_872# a_17633_n1222# 0.0552f
C266 a_11352_n1222# q4n 0.00167f
C267 a_3022_486# a_16405_n1132# 0
C268 a_12974_n1152# a_16703_n1152# 0.05192f
C269 a_12974_n1152# a_17911_208# 0
C270 a_8154_n580# a_14223_872# 0.00273f
C271 a_13066_n1152# a_2192_n1472# 0.15128f
C272 a_14175_n468# a_2192_n1472# 0.01693f
C273 a_14521_872# a_16703_n1152# 0
C274 a_16405_n1132# a_17633_n1222# 0
C275 a_16357_n468# a_15451_n1222# 0
C276 a_3022_n580# a_2192_n1472# 1.05323f
C277 q4p q4n 0.63335f
C278 a_11352_n1222# a_12974_n1152# 0
C279 a_11630_208# a_2192_n1472# 0.06626f
C280 clkp clkn 0.00451f
C281 a_17911_n1152# a_12974_n1152# 0
C282 a_4992_872# a_4944_n468# 0.28305f
C283 a_3022_486# a_2810_n1132# 0.05761f
C284 a_12974_n1152# q4p 0.00352f
C285 a_14223_872# a_2192_n1472# 0.02102f
C286 a_3022_486# a_6498_n1152# 0.00719f
C287 a_360_228# a_2192_n1472# 2.0367f
C288 a_14521_n1092# a_13066_872# 0.0384f
C289 vdd a_4944_n468# 0.02688f
C290 a_6220_308# q2n 0
C291 q8p a_2192_n1472# 0.00129f
C292 a_10076_n468# a_7942_n1092# 0
C293 a_9170_308# vdd 0.20865f
C294 a_11630_208# a_10422_n1152# 0.01915f
C295 a_4992_n1132# q2n 0
C296 a_16405_872# a_2192_n1472# 0.1346f
C297 a_9170_n1222# a_8240_n1092# 0.16551f
C298 a_9170_n1222# a_10124_872# 0
C299 a_15451_308# a_14223_n1092# 0
C300 a_4038_n1222# a_4944_n468# 0
C301 a_11352_308# a_10124_872# 0
C302 a_13066_n1152# q4n 0.00772f
C303 q4n a_14175_n468# 0
C304 a_3022_486# a_13066_872# 0.16383f
C305 a_3022_486# a_11630_n1152# 0.00102f
C306 a_11630_208# q4n 0.41278f
C307 a_6220_308# a_5290_n1152# 0.04149f
C308 a_13066_n1152# a_12974_n1152# 0.53467f
C309 a_11352_n1222# a_10422_872# 0.0552f
C310 a_12974_n1152# a_14175_n468# 0.00216f
C311 a_5290_n1152# a_4992_n1132# 0.16125f
C312 a_17633_308# a_16703_n1152# 0.04149f
C313 a_15451_308# a_2192_n1472# 0.02625f
C314 a_17911_208# a_17633_308# 0.04534f
C315 a_10076_n468# a_10422_872# 0.00603f
C316 clkp a_360_n1472# 0.03319f
C317 a_8240_872# vdd 1.3809f
C318 a_13066_n1152# a_14521_872# 0.02802f
C319 vdd a_15451_n1222# 0.22324f
C320 a_14521_872# a_14175_n468# 0.0061f
C321 a_12974_n1152# a_11630_208# 0.00173f
C322 a_6498_208# a_8240_n1092# 0
C323 a_4992_872# q2n 0
C324 a_3108_872# a_4992_n1132# 0
C325 a_17911_208# a_16703_n1152# 0.01917f
C326 q4p a_10422_872# 0.01126f
C327 a_17911_n1152# a_17633_308# 0.13199f
C328 clkn a_360_228# 0.02661f
C329 a_12974_n1152# a_14223_872# 0
C330 vdd q2n 0.80755f
C331 a_14521_872# a_14223_872# 0.14832f
C332 q2p a_8240_n1092# 0
C333 a_17911_n1152# a_16703_n1152# 0.12944f
C334 a_17911_n1152# a_17911_208# 0.7496f
C335 a_9170_308# a_9170_n1222# 0.45208f
C336 a_6220_308# a_5290_872# 0.29705f
C337 a_10076_n468# a_11352_n1222# 0
C338 a_12974_n1152# a_16405_872# 0.00572f
C339 a_3022_n580# a_4038_308# 0.05134f
C340 a_5290_872# a_4992_n1132# 0.09853f
C341 a_3022_n580# a_2810_872# 0.07668f
C342 a_10124_n1132# vdd 0.1584f
C343 a_11630_n1152# a_13066_872# 0
C344 a_3022_486# a_3108_n1152# 0.22227f
C345 a_4992_872# a_5290_n1152# 0.11509f
C346 a_14521_872# a_16405_872# 0
C347 a_11352_n1222# q4p 0
C348 a_6220_n1222# a_4944_n468# 0
C349 a_5290_n1152# vdd 1.38863f
C350 a_16357_n468# a_14223_n1092# 0
C351 a_4992_872# a_3108_872# 0
C352 a_2810_n1132# a_3108_n1152# 0.17233f
C353 a_12974_872# a_15451_n1222# 0.13198f
C354 a_2810_872# a_360_228# 0.00887f
C355 a_6498_208# a_4944_n468# 0
C356 a_2762_n468# a_964_n1472# 0
C357 vdd a_3108_872# 1.43584f
C358 a_8240_872# a_9170_n1222# 0.0552f
C359 a_12974_n1152# a_15451_308# 0.13452f
C360 a_11630_208# a_10422_872# 0.12975f
C361 a_4038_n1222# a_5290_n1152# 0
C362 a_2762_n468# vdd 0.02576f
C363 a_14521_872# a_15451_308# 0.29705f
C364 a_16357_n468# a_2192_n1472# 0.26674f
C365 a_360_n1472# a_360_228# 0.64789f
C366 a_8154_486# vdd 2.48682f
C367 a_3022_486# a_8240_n1092# 0.40866f
C368 a_4992_872# a_5290_872# 0.14468f
C369 a_3022_486# a_10124_872# 0
C370 a_4038_n1222# a_3108_872# 0.0552f
C371 a_6220_308# a_2192_n1472# 0.02758f
C372 vdd a_5290_872# 1.42857f
C373 a_4038_n1222# a_2762_n468# 0
C374 a_4992_n1132# a_2192_n1472# 0.15455f
C375 a_8240_n1092# a_6498_n1152# 0
C376 a_11352_n1222# a_11630_208# 0.1293f
C377 a_10124_n1132# a_9170_n1222# 0
C378 a_7894_n468# a_6220_308# 0
C379 a_17633_308# q8p 0.00201f
C380 a_10076_n468# a_11630_208# 0
C381 a_13066_n1152# q4p 0
C382 a_8240_872# a_6498_208# 0
C383 a_10124_n1132# a_11352_308# 0
C384 q4p a_14175_n468# 0
C385 a_17633_308# a_16405_872# 0
C386 a_4038_n1222# a_5290_872# 0
C387 a_6220_n1222# q2n 0.00167f
C388 a_16703_n1152# q8p 0.00571f
C389 q4p a_11630_208# 0.06442f
C390 a_17911_208# q8p 0.06556f
C391 clkp a_360_228# 0.27432f
C392 a_16405_872# a_16703_n1152# 0.11509f
C393 a_8240_872# q2p 0.0013f
C394 a_17911_208# a_16405_872# 0
C395 a_6498_208# q2n 0.41333f
C396 vdd a_14223_n1092# 0.14953f
C397 vdd a_8154_n580# 3.13237f
C398 q4p a_14223_872# 0
C399 a_12974_872# a_8154_486# 0.81682f
C400 a_3022_486# a_4944_n468# 0.06014f
C401 a_17911_n1152# q8p 0.3644f
C402 a_11630_n1152# a_10124_872# 0
C403 a_964_n1472# a_2192_n1472# 0.00392f
C404 a_17911_n1152# a_16405_872# 0
C405 q2p q2n 0.63342f
C406 a_4992_872# a_2192_n1472# 0.15455f
C407 a_3022_486# a_9170_308# 0
C408 a_6220_n1222# a_5290_n1152# 0.16551f
C409 a_16357_n468# a_12974_n1152# 0.06423f
C410 a_9170_n1222# a_8154_486# 0.14265f
C411 a_2810_n1132# a_4944_n468# 0
C412 vdd a_2192_n1472# 11.9634f
C413 a_4944_n468# a_6498_n1152# 0
C414 a_14521_n1092# a_15451_n1222# 0.16551f
C415 a_11352_308# a_8154_486# 0
C416 a_16357_n468# a_14521_872# 0
C417 a_16703_n1152# a_15451_308# 0
C418 a_13066_n1152# a_14175_n468# 0.058f
C419 a_16703_872# a_15451_n1222# 0
C420 a_6498_208# a_5290_n1152# 0.01915f
C421 a_13066_n1152# a_11630_208# 0
C422 a_7894_n468# vdd 0.02564f
C423 a_16405_n1132# a_15451_n1222# 0
C424 a_4038_n1222# a_2192_n1472# 0.03051f
C425 a_5290_n1152# q2p 0.00512f
C426 a_13066_n1152# a_14223_872# 0
C427 a_12974_872# a_14223_n1092# 0.00144f
C428 vdd a_10422_n1152# 1.3868f
C429 a_12974_872# a_8154_n580# 0.57348f
C430 a_14223_872# a_14175_n468# 0.28415f
C431 a_8240_872# a_3022_486# 0.36948f
C432 a_3022_n580# a_360_228# 0.00714f
C433 a_3022_486# a_15451_n1222# 0
C434 a_6220_308# a_7942_n1092# 0
C435 a_6220_n1222# a_5290_872# 0.0552f
C436 a_6498_208# a_8154_486# 0
C437 a_9170_n1222# a_8154_n580# 0.13193f
C438 vdd a_7942_872# 0.14852f
C439 a_8240_872# a_6498_n1152# 0
C440 a_3022_486# q2n 0.06584f
C441 a_6498_208# a_5290_872# 0.12975f
C442 a_11352_308# a_8154_n580# 0.0039f
C443 a_12974_872# a_2192_n1472# 1.56311f
C444 vdd q4n 0.80031f
C445 a_4038_308# a_4992_n1132# 0
C446 a_8154_486# q2p 0
C447 clkn a_964_n1472# 0.00325f
C448 q2n a_6498_n1152# 0.06432f
C449 a_5290_872# q2p 0.01126f
C450 a_9170_n1222# a_2192_n1472# 0.02959f
C451 clkn vdd 0.70371f
C452 a_3022_486# a_10124_n1132# 0
C453 a_16405_872# a_14223_872# 0
C454 a_12974_n1152# vdd 1.66635f
C455 a_16357_n468# a_17633_308# 0
C456 a_11352_308# a_2192_n1472# 0.02778f
C457 a_14521_872# vdd 1.38389f
C458 a_13066_n1152# a_15451_308# 0
C459 a_14521_n1092# a_8154_486# 0
C460 a_15451_308# a_14175_n468# 0
C461 a_3022_486# a_5290_n1152# 0.06227f
C462 a_16405_872# q8p 0
C463 a_7894_n468# a_9170_n1222# 0
C464 a_10124_872# a_8240_n1092# 0
C465 a_16357_n468# a_16703_n1152# 0.03106f
C466 a_6498_208# a_8154_n580# 0
C467 a_16357_n468# a_17911_208# 0
C468 a_13066_872# a_15451_n1222# 0
C469 a_4944_n468# a_3108_n1152# 0
C470 a_3022_486# a_3108_872# 0.04875f
C471 a_9170_n1222# a_10422_n1152# 0
C472 a_6220_n1222# a_2192_n1472# 0.02936f
C473 a_5290_n1152# a_6498_n1152# 0.12943f
C474 a_7942_n1092# vdd 0.1474f
C475 a_4992_872# a_4038_308# 0
C476 a_4992_872# a_2810_872# 0
C477 a_15451_308# a_14223_872# 0
C478 a_16357_n468# a_17911_n1152# 0
C479 a_11352_308# a_10422_n1152# 0.04149f
C480 a_8154_n580# q2p 0.00543f
C481 q8n a_2192_n1472# 0.00171f
C482 a_3022_486# a_2762_n468# 0.25283f
C483 a_12974_872# q4n 0.00577f
C484 a_6498_208# a_2192_n1472# 0.06947f
C485 vdd a_4038_308# 0.20913f
C486 a_2810_n1132# a_3108_872# 0.1045f
C487 vdd a_2810_872# 0.16103f
C488 a_6220_n1222# a_7894_n468# 0
C489 a_3022_486# a_8154_486# 1.5553f
C490 a_9170_n1222# a_7942_872# 0
C491 a_16405_872# a_15451_308# 0
C492 a_2810_n1132# a_2762_n468# 0.30692f
C493 a_360_n1472# a_964_n1472# 0.26313f
C494 a_12974_n1152# a_12974_872# 1.37449f
C495 a_3022_486# a_5290_872# 0.03221f
C496 a_10124_n1132# a_11630_n1152# 0
C497 a_7894_n468# a_6498_208# 0
C498 a_14521_n1092# a_14223_n1092# 0.16529f
C499 q2p a_2192_n1472# 0.15541f
C500 a_11352_308# q4n 0
C501 a_14521_n1092# a_8154_n580# 0
C502 a_12974_872# a_14521_872# 0.16054f
C503 a_8154_486# a_6498_n1152# 0
C504 a_4038_n1222# a_4038_308# 0.45397f
C505 a_4038_n1222# a_2810_872# 0
C506 vdd a_360_n1472# 1.22406f
C507 vdd a_10422_872# 1.42157f
C508 a_5290_872# a_6498_n1152# 0.01977f
C509 a_7894_n468# q2p 0.00112f
C510 a_6220_n1222# a_7942_872# 0
C511 a_12974_n1152# a_11352_308# 0
C512 a_16405_n1132# a_14223_n1092# 0
C513 a_9170_308# a_8240_n1092# 0.04149f
C514 vdd a_17633_308# 0.21575f
C515 a_9170_308# a_10124_872# 0
C516 a_14521_n1092# a_2192_n1472# 0.15071f
C517 a_6498_208# a_7942_872# 0
C518 a_16703_872# a_2192_n1472# 0.3811f
C519 a_3022_486# a_14223_n1092# 0.13282f
C520 vdd a_16703_n1152# 1.41669f
C521 a_3022_486# a_8154_n580# 0.12286f
C522 vdd a_17911_208# 0.99234f
C523 a_7942_n1092# a_9170_n1222# 0
C524 a_8154_486# a_13066_872# 0.29331f
C525 a_11630_n1152# a_8154_486# 0.00519f
C526 a_16405_n1132# a_2192_n1472# 0.1346f
C527 a_11352_n1222# vdd 0.22279f
C528 a_7942_872# q2p 0.00787f
C529 a_10076_n468# vdd 0.02688f
C530 a_6220_308# a_3022_n580# 0
C531 a_17911_n1152# vdd 0.98801f
C532 clkp vdd 0.72049f
C533 a_8154_n580# a_6498_n1152# 0.00194f
C534 a_16357_n468# a_14223_872# 0
C535 a_8240_872# a_8240_n1092# 1.14148f
C536 a_3022_486# a_2192_n1472# 1.51313f
C537 a_3022_n580# a_4992_n1132# 0.00706f
C538 a_8240_872# a_10124_872# 0
C539 q4p vdd 0.8019f
C540 a_12974_872# a_10422_872# 0
C541 a_5290_n1152# a_3108_n1152# 0
C542 a_17633_n1222# a_2192_n1472# 0
C543 a_6220_n1222# a_7942_n1092# 0
C544 a_2810_n1132# a_2192_n1472# 0.15969f
C545 a_3022_486# a_7894_n468# 0.26339f
C546 a_12974_872# a_17633_308# 0
C547 q2n a_8240_n1092# 0.00199f
C548 a_2192_n1472# a_6498_n1152# 0.07114f
C549 a_16357_n468# a_16405_872# 0.28305f
C550 a_9170_n1222# a_10422_872# 0
C551 a_3108_n1152# a_3108_872# 1.17699f
C552 a_6498_208# a_7942_n1092# 0.00213f
C553 a_11352_308# a_10422_872# 0.29705f
C554 a_12974_872# a_16703_n1152# 0.03951f
C555 a_3022_486# a_10422_n1152# 0.00303f
C556 a_13066_872# a_14223_n1092# 0
C557 a_12974_872# a_17911_208# 0
C558 a_2762_n468# a_3108_n1152# 0.00998f
C559 a_8154_n580# a_13066_872# 0.36334f
C560 a_7894_n468# a_6498_n1152# 0
C561 a_11630_n1152# a_8154_n580# 0.01398f
C562 a_10124_n1132# a_8240_n1092# 0
C563 a_14521_n1092# a_12974_n1152# 0.16591f
C564 a_11352_n1222# a_12974_872# 0
C565 a_7942_n1092# q2p 0.00411f
C566 a_3022_n580# a_964_n1472# 0
C567 a_16703_872# a_12974_n1152# 0.02898f
C568 a_17911_n1152# a_12974_872# 0
C569 a_14521_n1092# a_14521_872# 1.14299f
C570 a_3022_486# a_7942_872# 0.12427f
C571 a_4992_872# a_3022_n580# 0.09937f
C572 a_5290_872# a_3108_n1152# 0
C573 a_13066_n1152# vdd 0.57936f
C574 a_16357_n468# a_15451_308# 0
C575 a_16703_872# a_14521_872# 0
C576 vdd a_14175_n468# 0.02734f
C577 a_13066_872# a_2192_n1472# 0.1613f
C578 a_3022_486# q4n 0.00762f
C579 a_12974_872# q4p 0.02667f
C580 a_3022_n580# vdd 2.08526f
C581 a_11630_n1152# a_2192_n1472# 0.06745f
C582 a_10076_n468# a_9170_n1222# 0
C583 a_12974_n1152# a_16405_n1132# 0.10393f
C584 a_11352_n1222# a_11352_308# 0.45158f
C585 vdd a_11630_208# 0.95792f
C586 a_7942_872# a_6498_n1152# 0.00212f
C587 a_360_228# a_964_n1472# 0.06303f
C588 a_8240_872# a_9170_308# 0.29705f
C589 a_10076_n468# a_11352_308# 0
C590 a_14521_872# a_16405_n1132# 0
C591 q8n a_17633_308# 0
C592 a_3022_486# a_12974_n1152# 0.07253f
C593 vdd a_14223_872# 0.14953f
C594 vdd a_360_228# 2.79455f
C595 q4p a_11352_308# 0.00166f
C596 a_3022_486# a_14521_872# 0.36908f
C597 a_4038_n1222# a_3022_n580# 0.13883f
C598 q8n a_16703_n1152# 0.01145f
C599 a_8154_486# a_8240_n1092# 0.20944f
C600 a_12974_n1152# a_17633_n1222# 0
C601 q8n a_17911_208# 0.43486f
C602 a_8154_486# a_10124_872# 0.00555f
C603 a_11630_n1152# a_10422_n1152# 0.12943f
C604 vdd q8p 0.86081f
C605 vdd a_16405_872# 0.16072f
C606 a_17911_n1152# q8n 0.06535f
C607 a_3022_486# a_7942_n1092# 0.12956f
C608 a_10124_n1132# a_9170_308# 0
C609 a_13066_n1152# a_12974_872# 0.29879f
C610 a_5290_n1152# a_4944_n468# 0.03106f
C611 a_12974_872# a_14175_n468# 0.00261f
C612 a_13066_872# q4n 0
C613 a_3108_n1152# a_2192_n1472# 0.58102f
C614 a_3022_486# a_4038_308# 0.14094f
C615 a_3022_486# a_2810_872# 0.11136f
C616 a_11630_n1152# q4n 0.06422f
C617 a_12974_872# a_11630_208# 0.00126f
C618 a_4944_n468# a_3108_872# 0
C619 a_7942_n1092# a_6498_n1152# 0
C620 a_8240_872# q2n 0
C621 a_16703_872# a_17633_308# 0.29705f
C622 a_2810_n1132# a_4038_308# 0
C623 a_12974_872# a_14223_872# 0.00272f
C624 a_12974_n1152# a_13066_872# 0.25152f
C625 vdd a_15451_308# 0.20889f
C626 a_11630_n1152# a_12974_n1152# 0
C627 a_14521_n1092# a_16703_n1152# 0
C628 a_8154_n580# a_8240_n1092# 0.1374f
C629 a_16703_872# a_16703_n1152# 1.1542f
C630 a_10124_872# a_8154_n580# 0.09977f
C631 a_14521_872# a_13066_872# 0.03732f
C632 a_11352_308# a_11630_208# 0.04572f
C633 a_16703_872# a_17911_208# 0.12976f
C634 a_16405_n1132# a_17633_308# 0
C635 a_3022_486# a_10422_872# 0.00155f
C636 a_8240_872# a_10124_n1132# 0
C637 a_12974_872# a_16405_872# 0.10679f
C638 a_4944_n468# a_5290_872# 0.00603f
C639 a_16405_n1132# a_16703_n1152# 0.16125f
C640 a_9170_308# a_8154_486# 0.13447f
C641 a_16405_n1132# a_17911_208# 0
C642 a_17911_n1152# a_16703_872# 0.01979f
C643 a_2192_n1472# a_8240_n1092# 0.15663f
C644 a_6220_n1222# a_3022_n580# 0
C645 a_10124_872# a_2192_n1472# 0.1548f
C646 a_17633_308# a_17633_n1222# 0.45158f
C647 a_3022_486# a_16703_n1152# 0
C648 a_6220_308# a_4992_n1132# 0
C649 a_17911_n1152# a_16405_n1132# 0
C650 a_3022_n580# a_6498_208# 0
C651 a_5290_n1152# q2n 0.01055f
C652 a_7894_n468# a_8240_n1092# 0.00877f
C653 a_16703_n1152# a_17633_n1222# 0.16551f
C654 a_17911_208# a_17633_n1222# 0.12933f
C655 a_3022_486# a_11352_n1222# 0
C656 a_3022_486# a_10076_n468# 0
C657 a_12974_872# a_15451_308# 0.05273f
C658 a_10422_n1152# a_8240_n1092# 0
C659 a_8240_872# a_8154_486# 0.04853f
C660 a_10124_872# a_10422_n1152# 0.11509f
C661 a_17911_n1152# a_17633_n1222# 0.13484f
C662 a_3022_486# q4p 0.00133f
C663 q8n q8p 0.6388f
C664 a_11630_n1152# a_10422_872# 0.01977f
C665 a_9170_308# a_8154_n580# 0.05183f
C666 q8n a_16405_872# 0
C667 a_7942_872# a_8240_n1092# 0.11473f
C668 a_8154_486# q2n 0.00252f
C669 a_13066_n1152# a_14521_n1092# 0.04681f
C670 a_10124_872# a_7942_872# 0
C671 a_14521_n1092# a_14175_n468# 0.03109f
C672 a_16357_n468# vdd 0.02831f
C673 a_4944_n468# a_2192_n1472# 0.28398f
C674 clkn vss 0.50808f
C675 q8n vss 0.97858f
C676 q8p vss 1.13414f
C677 q4n vss 0.86345f
C678 q4p vss 0.86697f
C679 q2n vss 0.86066f
C680 q2p vss 0.86552f
C681 clkp vss 0.51065f
C682 vdd vss 0.16098p
C683 a_16405_n1132# vss 0.25944f
C684 a_14223_n1092# vss 0.26541f
C685 a_13066_n1152# vss 0.60139f
C686 a_10124_n1132# vss 0.2558f
C687 a_7942_n1092# vss 0.25801f
C688 a_4992_n1132# vss 0.25704f
C689 a_2810_n1132# vss 0.2613f
C690 a_964_n1472# vss 1.20815f
C691 a_16357_n468# vss 0.78175f
C692 a_14175_n468# vss 0.78003f
C693 a_17633_n1222# vss 0.72361f
C694 a_15451_n1222# vss 0.72562f
C695 a_10076_n468# vss 0.78529f
C696 a_7894_n468# vss 0.71909f
C697 a_17911_208# vss 1.12568f
C698 a_17633_308# vss 0.68659f
C699 a_16405_872# vss 0.26018f
C700 a_16703_n1152# vss 0.98206f
C701 a_15451_308# vss 0.68872f
C702 a_14223_872# vss 0.26543f
C703 a_12974_n1152# vss 1.32565f
C704 a_13066_872# vss 0.60784f
C705 a_12974_872# vss 1.30776f
C706 a_14521_n1092# vss 0.97677f
C707 a_16703_872# vss 0.97722f
C708 a_14521_872# vss 0.97205f
C709 a_17911_n1152# vss 1.12129f
C710 a_11352_n1222# vss 0.7241f
C711 a_9170_n1222# vss 0.72384f
C712 a_4944_n468# vss 0.78327f
C713 a_2762_n468# vss 0.76846f
C714 a_11630_208# vss 1.10406f
C715 a_11352_308# vss 0.68625f
C716 a_10124_872# vss 0.25654f
C717 a_8154_486# vss 2.51297f
C718 a_10422_n1152# vss 0.97971f
C719 a_8154_n580# vss 2.32153f
C720 a_9170_308# vss 0.68833f
C721 a_7942_872# vss 0.26226f
C722 a_8240_n1092# vss 0.95258f
C723 a_10422_872# vss 0.9738f
C724 a_8240_872# vss 0.96356f
C725 a_11630_n1152# vss 1.09706f
C726 a_6220_n1222# vss 0.72185f
C727 a_4038_n1222# vss 0.73126f
C728 a_6498_208# vss 1.10196f
C729 a_6220_308# vss 0.68534f
C730 a_4992_872# vss 0.25778f
C731 a_3022_486# vss 3.57782f
C732 a_5290_n1152# vss 0.97884f
C733 a_5290_872# vss 0.97316f
C734 a_3022_n580# vss 1.42632f
C735 a_4038_308# vss 0.69758f
C736 a_2810_872# vss 0.26677f
C737 a_3108_n1152# vss 0.94034f
C738 a_3108_872# vss 0.95969f
C739 a_6498_n1152# vss 1.0944f
C740 a_2192_n1472# vss 7.98872f
C741 a_360_n1472# vss 1.23409f
C742 a_360_228# vss 3.09854f
.ends
