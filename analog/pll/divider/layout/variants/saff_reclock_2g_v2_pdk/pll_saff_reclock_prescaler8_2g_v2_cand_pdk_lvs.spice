* NGSPICE file created from pll_saff_reclock_prescaler8_2g_v2_cand_pdk.ext - technology: sky130A

.subckt pll_saff_reclock_prescaler8_2g_v2_cand_pdk clkp clkn q2p q2n q4p q4n q8p q8n
+ vdd vss
X0 vdd a_2192_n1492# a_3108_872# vdd sky130_fd_pr__pfet_01v8 ad=0.465 pd=3.62 as=0.2475 ps=1.83 w=1.5 l=0.15
X1 vss a_4038_n1392# a_3022_n580# vss sky130_fd_pr__nfet_01v8_lvt ad=0.558 pd=4.22 as=0.297 ps=2.13 w=1.8 l=0.15
X2 q4p q4n vss vss sky130_fd_pr__nfet_01v8 ad=0.174 pd=1.78 as=0.174 ps=1.78 w=0.6 l=0.15
X3 vdd a_2192_n1492# a_3108_n1172# vdd sky130_fd_pr__pfet_01v8 ad=0.465 pd=3.62 as=0.2475 ps=1.83 w=1.5 l=0.15
X4 a_3108_872# a_2192_n1492# a_3108_n1172# vdd sky130_fd_pr__pfet_01v8 ad=0.319 pd=2.78 as=0.319 ps=2.78 w=1.1 l=0.15
X5 a_11173_872# a_11173_n1152# vdd vdd sky130_fd_pr__pfet_01v8 ad=0.435 pd=3.58 as=0.435 ps=3.58 w=1.5 l=0.15
X6 a_17394_872# a_2192_n1492# a_17394_n1152# vdd sky130_fd_pr__pfet_01v8 ad=0.29 pd=2.58 as=0.29 ps=2.58 w=1 l=0.15
X7 a_3108_872# a_2192_n1492# vdd vdd sky130_fd_pr__pfet_01v8 ad=0.2475 pd=1.83 as=0.465 ps=3.62 w=1.5 l=0.15
X8 a_7830_872# a_3022_n580# vdd vdd sky130_fd_pr__pfet_01v8 ad=0.462 pd=3.13 as=0.868 ps=6.22 w=2.8 l=0.15
X9 a_3022_n580# a_4038_n1392# vss vss sky130_fd_pr__nfet_01v8_lvt ad=0.297 pd=2.13 as=0.558 ps=4.22 w=1.8 l=0.15
X10 vdd a_15212_872# a_13887_n854# vdd sky130_fd_pr__pfet_01v8 ad=0.527 pd=4.02 as=0.2805 ps=2.03 w=1.7 l=0.15
X11 a_17394_n1152# a_17394_872# vdd vdd sky130_fd_pr__pfet_01v8 ad=0.435 pd=3.58 as=0.435 ps=3.58 w=1.5 l=0.15
X12 vdd a_2192_n1492# a_11173_n1152# vdd sky130_fd_pr__pfet_01v8 ad=0.434 pd=3.42 as=0.231 ps=1.73 w=1.4 l=0.15
X13 a_6498_n1152# a_6498_208# vdd vdd sky130_fd_pr__pfet_01v8 ad=0.1885 pd=1.88 as=0.1885 ps=1.88 w=0.65 l=0.15
X14 vdd a_12381_n1152# q4p vdd sky130_fd_pr__pfet_01v8 ad=0.837 pd=6.02 as=0.4455 ps=3.03 w=2.7 l=0.15
X15 vss a_6220_308# a_6498_n1152# vss sky130_fd_pr__nfet_01v8_lvt ad=0.403 pd=3.22 as=0.2145 ps=1.63 w=1.3 l=0.15
X16 a_3022_n580# a_3022_486# vss vss sky130_fd_pr__nfet_01v8 ad=0.1595 pd=1.68 as=0.1595 ps=1.68 w=0.55 l=0.15
X17 vss a_2192_n1492# a_17048_n468# vss sky130_fd_pr__nfet_01v8_lvt ad=0.341 pd=2.82 as=0.1815 ps=1.43 w=1.1 l=0.15
X18 a_17048_n468# a_2192_n1492# vss vss sky130_fd_pr__nfet_01v8_lvt ad=0.1815 pd=1.43 as=0.341 ps=2.82 w=1.1 l=0.15
X19 vss a_360_208# a_2192_n1492# vss sky130_fd_pr__nfet_01v8 ad=0.465 pd=3.62 as=0.2475 ps=1.83 w=1.5 l=0.15
X20 a_6220_308# a_5290_872# vdd vdd sky130_fd_pr__pfet_01v8 ad=0.5075 pd=4.08 as=0.5075 ps=4.08 w=1.75 l=0.15
X21 vss a_18602_208# q8n vss sky130_fd_pr__nfet_01v8 ad=0.465 pd=3.62 as=0.2475 ps=1.83 w=1.5 l=0.15
X22 a_13841_168# a_8905_n580# vss vss sky130_fd_pr__nfet_01v8_lvt ad=0.2175 pd=1.79 as=0.435 ps=3.58 w=1.5 l=0.15
X23 a_14914_872# a_13929_168# a_14866_n468# vss sky130_fd_pr__nfet_01v8_lvt ad=0.2475 pd=1.83 as=0.465 ps=3.62 w=1.5 l=0.15
X24 vdd a_17394_n1152# a_18602_n1152# vdd sky130_fd_pr__pfet_01v8 ad=0.434 pd=3.42 as=0.231 ps=1.73 w=1.4 l=0.15
X25 a_10875_n1132# a_2192_n1492# vdd vdd sky130_fd_pr__pfet_01v8 ad=0.377 pd=3.18 as=0.377 ps=3.18 w=1.3 l=0.15
X26 vss a_16142_338# a_13887_n580# vss sky130_fd_pr__nfet_01v8_lvt ad=0.496 pd=3.82 as=0.264 ps=1.93 w=1.6 l=0.15
X27 a_13887_n854# a_13887_n580# vdd vdd sky130_fd_pr__pfet_01v8 ad=0.29 pd=2.58 as=0.29 ps=2.58 w=1 l=0.15
X28 q4n q4p vdd vdd sky130_fd_pr__pfet_01v8 ad=0.3625 pd=3.08 as=0.3625 ps=3.08 w=1.25 l=0.15
X29 a_8905_486# a_8905_n580# vdd vdd sky130_fd_pr__pfet_01v8 ad=0.174 pd=1.78 as=0.174 ps=1.78 w=0.6 l=0.15
X30 a_14866_n468# a_13929_168# a_14914_872# vss sky130_fd_pr__nfet_01v8_lvt ad=0.465 pd=3.62 as=0.2475 ps=1.83 w=1.5 l=0.15
X31 a_8693_n1052# a_8991_872# a_8991_n1052# vss sky130_fd_pr__nfet_01v8_lvt ad=0.403 pd=3.22 as=0.2145 ps=1.63 w=1.3 l=0.15
X32 vss a_2192_n1492# a_10827_n468# vss sky130_fd_pr__nfet_01v8_lvt ad=0.341 pd=2.82 as=0.1815 ps=1.43 w=1.1 l=0.15
X33 q8n a_18602_208# vdd vdd sky130_fd_pr__pfet_01v8 ad=0.5115 pd=3.43 as=0.961 ps=6.82 w=3.1 l=0.15
X34 a_17048_n468# a_13887_n580# a_17096_n1132# vss sky130_fd_pr__nfet_01v8_lvt ad=0.434 pd=3.42 as=0.231 ps=1.73 w=1.4 l=0.15
X35 a_360_208# clkp vdd vdd sky130_fd_pr__pfet_01v8 ad=0.5115 pd=3.43 as=0.961 ps=6.82 w=3.1 l=0.15
X36 vss a_7830_872# a_14866_n468# vss sky130_fd_pr__nfet_01v8_lvt ad=0.372 pd=3.02 as=0.198 ps=1.53 w=1.2 l=0.15
X37 a_5290_n1152# a_2192_n1492# a_5290_872# vdd sky130_fd_pr__pfet_01v8 ad=0.29 pd=2.58 as=0.29 ps=2.58 w=1 l=0.15
X38 a_8991_872# a_7830_872# vdd vdd sky130_fd_pr__pfet_01v8 ad=0.1485 pd=1.23 as=0.279 ps=2.42 w=0.9 l=0.15
X39 a_10875_872# a_2192_n1492# vdd vdd sky130_fd_pr__pfet_01v8 ad=0.377 pd=3.18 as=0.377 ps=3.18 w=1.3 l=0.15
X40 a_14866_n468# a_7830_872# vss vss sky130_fd_pr__nfet_01v8_lvt ad=0.198 pd=1.53 as=0.372 ps=3.02 w=1.2 l=0.15
X41 vdd a_18602_208# q8n vdd sky130_fd_pr__pfet_01v8 ad=0.961 pd=6.82 as=0.5115 ps=3.43 w=3.1 l=0.15
X42 a_3022_486# a_3108_n1172# vdd vdd sky130_fd_pr__pfet_01v8 ad=0.3465 pd=2.43 as=0.651 ps=4.82 w=2.1 l=0.15
X43 vdd clkp a_360_208# vdd sky130_fd_pr__pfet_01v8 ad=0.961 pd=6.82 as=0.5115 ps=3.43 w=3.1 l=0.15
X44 q2p q2n vss vss sky130_fd_pr__nfet_01v8 ad=0.174 pd=1.78 as=0.174 ps=1.78 w=0.6 l=0.15
X45 a_2192_n1492# a_360_208# vdd vdd sky130_fd_pr__pfet_01v8 ad=0.5115 pd=3.43 as=0.961 ps=6.82 w=3.1 l=0.15
X46 a_5290_872# a_5290_n1152# vdd vdd sky130_fd_pr__pfet_01v8 ad=0.435 pd=3.58 as=0.435 ps=3.58 w=1.5 l=0.15
X47 vdd a_360_208# a_2192_n1492# vdd sky130_fd_pr__pfet_01v8 ad=0.961 pd=6.82 as=0.5115 ps=3.43 w=3.1 l=0.15
X48 a_13887_n580# a_13887_n854# vss vss sky130_fd_pr__nfet_01v8 ad=0.261 pd=2.38 as=0.261 ps=2.38 w=0.9 l=0.15
X49 a_360_208# a_360_n1492# vdd vdd sky130_fd_pr__pfet_01v8 ad=0.29 pd=2.58 as=0.29 ps=2.58 w=1 l=0.15
X50 a_2192_n1492# a_360_208# vdd vdd sky130_fd_pr__pfet_01v8 ad=0.5115 pd=3.43 as=0.5115 ps=3.43 w=3.1 l=0.15
X51 a_13887_n854# a_13887_n580# vss vss sky130_fd_pr__nfet_01v8 ad=0.145 pd=1.58 as=0.145 ps=1.58 w=0.5 l=0.15
X52 vdd a_6498_n1152# q2p vdd sky130_fd_pr__pfet_01v8 ad=0.837 pd=6.02 as=0.4455 ps=3.03 w=2.7 l=0.15
X53 a_12381_208# a_11173_872# vdd vdd sky130_fd_pr__pfet_01v8 ad=0.231 pd=1.73 as=0.434 ps=3.42 w=1.4 l=0.15
X54 a_8905_486# a_9921_338# vss vss sky130_fd_pr__nfet_01v8_lvt ad=0.264 pd=1.93 as=0.496 ps=3.82 w=1.6 l=0.15
X55 vdd a_11173_n1152# a_12381_n1152# vdd sky130_fd_pr__pfet_01v8 ad=0.434 pd=3.42 as=0.231 ps=1.73 w=1.4 l=0.15
X56 vdd a_360_208# a_2192_n1492# vdd sky130_fd_pr__pfet_01v8 ad=0.5115 pd=3.43 as=0.5115 ps=3.43 w=3.1 l=0.15
X57 q2p a_6498_n1152# vdd vdd sky130_fd_pr__pfet_01v8 ad=0.4455 pd=3.03 as=0.837 ps=6.02 w=2.7 l=0.15
X58 vss a_964_n1492# vss vss sky130_fd_pr__nfet_01v8 ad=0.145 pd=1.29 as=41.2555 ps=340.88 w=1 l=0.5
X59 q2n q2p vss vss sky130_fd_pr__nfet_01v8 ad=0.174 pd=1.78 as=0.174 ps=1.78 w=0.6 l=0.15
X60 a_2810_n1132# a_3022_n580# a_2762_n468# vss sky130_fd_pr__nfet_01v8_lvt ad=0.297 pd=2.13 as=0.558 ps=4.22 w=1.8 l=0.15
X61 vdd a_11173_872# a_12381_208# vdd sky130_fd_pr__pfet_01v8 ad=0.434 pd=3.42 as=0.231 ps=1.73 w=1.4 l=0.15
X62 a_5290_n1152# a_5290_872# a_4992_n1132# vss sky130_fd_pr__nfet_01v8_lvt ad=0.18975 pd=1.48 as=0.3565 ps=2.92 w=1.15 l=0.15
X63 a_14323_n468# a_8905_486# vss vss sky130_fd_pr__nfet_01v8_lvt ad=0.2175 pd=1.79 as=0.435 ps=3.58 w=1.5 l=0.15
X64 a_17096_872# a_17394_n1152# a_17394_872# vss sky130_fd_pr__nfet_01v8_lvt ad=0.3565 pd=2.92 as=0.18975 ps=1.48 w=1.15 l=0.15
X65 a_6220_n1222# a_5290_n1152# vss vss sky130_fd_pr__nfet_01v8 ad=0.232 pd=2.18 as=0.232 ps=2.18 w=0.8 l=0.15
X66 a_15212_n1052# a_7830_872# vdd vdd sky130_fd_pr__pfet_01v8 ad=0.1485 pd=1.23 as=0.279 ps=2.42 w=0.9 l=0.15
X67 a_10875_n1132# a_8905_486# a_10827_n468# vss sky130_fd_pr__nfet_01v8_lvt ad=0.231 pd=1.73 as=0.434 ps=3.42 w=1.4 l=0.15
X68 vdd a_2192_n1492# a_17394_872# vdd sky130_fd_pr__pfet_01v8 ad=0.434 pd=3.42 as=0.231 ps=1.73 w=1.4 l=0.15
X69 a_13887_n854# a_16142_n1392# vss vss sky130_fd_pr__nfet_01v8_lvt ad=0.264 pd=1.93 as=0.496 ps=3.82 w=1.6 l=0.15
X70 a_17048_n468# a_13887_n854# a_17096_872# vss sky130_fd_pr__nfet_01v8_lvt ad=0.434 pd=3.42 as=0.231 ps=1.73 w=1.4 l=0.15
X71 a_17394_872# a_2192_n1492# vdd vdd sky130_fd_pr__pfet_01v8 ad=0.231 pd=1.73 as=0.434 ps=3.42 w=1.4 l=0.15
X72 a_8991_n1052# a_7830_872# vdd vdd sky130_fd_pr__pfet_01v8 ad=0.1485 pd=1.23 as=0.279 ps=2.42 w=0.9 l=0.15
X73 vdd a_3108_n1172# a_3022_486# vdd sky130_fd_pr__pfet_01v8 ad=0.651 pd=4.82 as=0.3465 ps=2.43 w=2.1 l=0.15
X74 a_17096_872# a_13887_n854# a_17048_n468# vss sky130_fd_pr__nfet_01v8_lvt ad=0.231 pd=1.73 as=0.434 ps=3.42 w=1.4 l=0.15
X75 a_15212_n1052# a_15212_872# a_14914_n1052# vss sky130_fd_pr__nfet_01v8_lvt ad=0.2145 pd=1.63 as=0.403 ps=3.22 w=1.3 l=0.15
X76 a_6498_n1152# a_6220_308# vss vss sky130_fd_pr__nfet_01v8_lvt ad=0.2145 pd=1.63 as=0.403 ps=3.22 w=1.3 l=0.15
X77 a_360_n1492# a_360_208# vdd vdd sky130_fd_pr__pfet_01v8 ad=0.29 pd=2.58 as=0.29 ps=2.58 w=1 l=0.15
X78 a_8991_872# a_8991_n1052# vdd vdd sky130_fd_pr__pfet_01v8 ad=0.377 pd=3.18 as=0.377 ps=3.18 w=1.3 l=0.15
X79 a_12381_208# a_12381_n1152# vdd vdd sky130_fd_pr__pfet_01v8 ad=0.1885 pd=1.88 as=0.1885 ps=1.88 w=0.65 l=0.15
X80 vss a_12381_n1152# q4p vss sky130_fd_pr__nfet_01v8 ad=0.403 pd=3.22 as=0.2145 ps=1.63 w=1.3 l=0.15
X81 vss a_16142_n1392# a_13887_n854# vss sky130_fd_pr__nfet_01v8_lvt ad=0.496 pd=3.82 as=0.264 ps=1.93 w=1.6 l=0.15
X82 a_18602_208# a_18602_n1152# vss vss sky130_fd_pr__nfet_01v8 ad=0.1595 pd=1.68 as=0.1595 ps=1.68 w=0.55 l=0.15
X83 a_2192_n1492# a_360_208# vss vss sky130_fd_pr__nfet_01v8 ad=0.2475 pd=1.83 as=0.2475 ps=1.83 w=1.5 l=0.15
X84 a_4992_872# a_2192_n1492# vdd vdd sky130_fd_pr__pfet_01v8 ad=0.377 pd=3.18 as=0.377 ps=3.18 w=1.3 l=0.15
X85 vdd a_2192_n1492# a_5290_n1152# vdd sky130_fd_pr__pfet_01v8 ad=0.434 pd=3.42 as=0.231 ps=1.73 w=1.4 l=0.15
X86 a_4038_n1392# a_3108_n1172# vss vss sky130_fd_pr__nfet_01v8 ad=0.1885 pd=1.88 as=0.1885 ps=1.88 w=0.65 l=0.15
X87 q8n a_18602_208# vss vss sky130_fd_pr__nfet_01v8 ad=0.2475 pd=1.83 as=0.465 ps=3.62 w=1.5 l=0.15
X88 q4p a_12381_n1152# vdd vdd sky130_fd_pr__pfet_01v8 ad=0.4455 pd=3.03 as=0.837 ps=6.02 w=2.7 l=0.15
X89 a_13929_n1432# a_13887_n580# a_13841_n468# vss sky130_fd_pr__nfet_01v8_lvt ad=0.645 pd=3.86 as=0.2175 ps=1.79 w=1.5 l=0.15
X90 q4p q4n vdd vdd sky130_fd_pr__pfet_01v8 ad=0.3625 pd=3.08 as=0.3625 ps=3.08 w=1.25 l=0.15
X91 a_2810_n1132# a_3108_872# a_3108_n1172# vss sky130_fd_pr__nfet_01v8_lvt ad=0.465 pd=3.62 as=0.2475 ps=1.83 w=1.5 l=0.15
X92 a_8991_n1052# a_8991_872# a_8693_n1052# vss sky130_fd_pr__nfet_01v8_lvt ad=0.2145 pd=1.63 as=0.403 ps=3.22 w=1.3 l=0.15
X93 vss a_2192_n1492# a_17048_n468# vss sky130_fd_pr__nfet_01v8_lvt ad=0.341 pd=2.82 as=0.1815 ps=1.43 w=1.1 l=0.15
X94 a_14323_872# a_8905_486# vdd vdd sky130_fd_pr__pfet_01v8 ad=0.406 pd=3.09 as=0.812 ps=6.18 w=2.8 l=0.15
X95 a_12381_208# a_12103_n1222# vss vss sky130_fd_pr__nfet_01v8_lvt ad=0.2145 pd=1.63 as=0.403 ps=3.22 w=1.3 l=0.15
X96 a_2762_n468# a_2192_n1492# vss vss sky130_fd_pr__nfet_01v8_lvt ad=0.23925 pd=1.78 as=0.4495 ps=3.52 w=1.45 l=0.15
X97 a_10875_n1132# a_11173_872# a_11173_n1152# vss sky130_fd_pr__nfet_01v8_lvt ad=0.3565 pd=2.92 as=0.18975 ps=1.48 w=1.15 l=0.15
X98 a_10827_n468# a_2192_n1492# vss vss sky130_fd_pr__nfet_01v8_lvt ad=0.1815 pd=1.43 as=0.341 ps=2.82 w=1.1 l=0.15
X99 vdd a_15212_n1052# a_13887_n580# vdd sky130_fd_pr__pfet_01v8 ad=0.527 pd=4.02 as=0.2805 ps=2.03 w=1.7 l=0.15
X100 a_8905_486# a_8991_n1052# vdd vdd sky130_fd_pr__pfet_01v8 ad=0.2805 pd=2.03 as=0.527 ps=4.02 w=1.7 l=0.15
X101 a_17096_n1132# a_13887_n580# a_17048_n468# vss sky130_fd_pr__nfet_01v8_lvt ad=0.231 pd=1.73 as=0.434 ps=3.42 w=1.4 l=0.15
X102 a_6498_n1152# a_5290_n1152# vdd vdd sky130_fd_pr__pfet_01v8 ad=0.231 pd=1.73 as=0.434 ps=3.42 w=1.4 l=0.15
X103 a_4992_n1132# a_2192_n1492# vdd vdd sky130_fd_pr__pfet_01v8 ad=0.377 pd=3.18 as=0.377 ps=3.18 w=1.3 l=0.15
X104 vdd a_5290_872# a_6498_208# vdd sky130_fd_pr__pfet_01v8 ad=0.434 pd=3.42 as=0.231 ps=1.73 w=1.4 l=0.15
X105 vss a_18602_n1152# q8p vss sky130_fd_pr__nfet_01v8 ad=0.465 pd=3.62 as=0.2475 ps=1.83 w=1.5 l=0.15
X106 a_2192_n1492# a_360_208# vdd vdd sky130_fd_pr__pfet_01v8 ad=0.5115 pd=3.43 as=0.961 ps=6.82 w=3.1 l=0.15
X107 a_360_208# clkp vss vss sky130_fd_pr__nfet_01v8 ad=0.2145 pd=1.63 as=0.403 ps=3.22 w=1.3 l=0.15
X108 a_6498_208# a_5290_872# vdd vdd sky130_fd_pr__pfet_01v8 ad=0.231 pd=1.73 as=0.434 ps=3.42 w=1.4 l=0.15
X109 vss a_12103_n1222# a_12381_208# vss sky130_fd_pr__nfet_01v8_lvt ad=0.403 pd=3.22 as=0.2145 ps=1.63 w=1.3 l=0.15
X110 q2n q2p vdd vdd sky130_fd_pr__pfet_01v8 ad=0.3625 pd=3.08 as=0.3625 ps=3.08 w=1.25 l=0.15
X111 a_4038_n1392# a_3108_n1172# vdd vdd sky130_fd_pr__pfet_01v8 ad=0.754 pd=5.78 as=0.754 ps=5.78 w=2.6 l=0.15
X112 a_3022_486# a_3022_n580# vdd vdd sky130_fd_pr__pfet_01v8 ad=0.1885 pd=1.88 as=0.1885 ps=1.88 w=0.65 l=0.15
X113 a_3108_872# a_3108_n1172# vdd vdd sky130_fd_pr__pfet_01v8 ad=0.464 pd=3.78 as=0.464 ps=3.78 w=1.6 l=0.15
X114 a_3108_n1172# a_3108_872# vdd vdd sky130_fd_pr__pfet_01v8 ad=0.464 pd=3.78 as=0.464 ps=3.78 w=1.6 l=0.15
X115 a_8693_872# a_7830_872# vdd vdd sky130_fd_pr__pfet_01v8 ad=0.261 pd=2.38 as=0.261 ps=2.38 w=0.9 l=0.15
X116 vss clkp a_360_208# vss sky130_fd_pr__nfet_01v8 ad=0.403 pd=3.22 as=0.2145 ps=1.63 w=1.3 l=0.15
X117 vss a_12103_308# a_12381_n1152# vss sky130_fd_pr__nfet_01v8_lvt ad=0.403 pd=3.22 as=0.2145 ps=1.63 w=1.3 l=0.15
X118 q8n q8p vdd vdd sky130_fd_pr__pfet_01v8 ad=0.3915 pd=3.28 as=0.3915 ps=3.28 w=1.35 l=0.15
X119 a_11173_n1152# a_11173_872# vdd vdd sky130_fd_pr__pfet_01v8 ad=0.435 pd=3.58 as=0.435 ps=3.58 w=1.5 l=0.15
X120 vss a_6498_n1152# q2p vss sky130_fd_pr__nfet_01v8 ad=0.403 pd=3.22 as=0.2145 ps=1.63 w=1.3 l=0.15
X121 a_4944_n468# a_3022_486# a_4992_n1132# vss sky130_fd_pr__nfet_01v8_lvt ad=0.434 pd=3.42 as=0.231 ps=1.73 w=1.4 l=0.15
X122 vss a_964_n1492# vss vss sky130_fd_pr__nfet_01v8 ad=0.145 pd=1.29 as=0 ps=0 w=1 l=0.5
X123 a_18602_n1152# a_18602_208# vdd vdd sky130_fd_pr__pfet_01v8 ad=0.1885 pd=1.88 as=0.1885 ps=1.88 w=0.65 l=0.15
X124 a_9921_338# a_8991_872# vdd vdd sky130_fd_pr__pfet_01v8 ad=0.754 pd=5.78 as=0.754 ps=5.78 w=2.6 l=0.15
X125 vdd a_8991_872# a_8905_n580# vdd sky130_fd_pr__pfet_01v8 ad=0.527 pd=4.02 as=0.2805 ps=2.03 w=1.7 l=0.15
X126 q2p a_6498_n1152# vss vss sky130_fd_pr__nfet_01v8 ad=0.2145 pd=1.63 as=0.403 ps=3.22 w=1.3 l=0.15
X127 a_9921_338# a_8991_872# vss vss sky130_fd_pr__nfet_01v8 ad=0.1885 pd=1.88 as=0.1885 ps=1.88 w=0.65 l=0.15
X128 vss a_2192_n1492# a_10827_n468# vss sky130_fd_pr__nfet_01v8_lvt ad=0.341 pd=2.82 as=0.1815 ps=1.43 w=1.1 l=0.15
X129 a_9921_n1392# a_8991_n1052# vdd vdd sky130_fd_pr__pfet_01v8 ad=0.754 pd=5.78 as=0.754 ps=5.78 w=2.6 l=0.15
X130 a_8905_n580# a_8991_872# vdd vdd sky130_fd_pr__pfet_01v8 ad=0.2805 pd=2.03 as=0.527 ps=4.02 w=1.7 l=0.15
X131 a_2762_n468# a_2192_n1492# vss vss sky130_fd_pr__nfet_01v8_lvt ad=0.23925 pd=1.78 as=0.4495 ps=3.52 w=1.45 l=0.15
X132 a_10827_n468# a_2192_n1492# vss vss sky130_fd_pr__nfet_01v8_lvt ad=0.1815 pd=1.43 as=0.341 ps=2.82 w=1.1 l=0.15
X133 vdd a_8991_n1052# a_8905_486# vdd sky130_fd_pr__pfet_01v8 ad=0.527 pd=4.02 as=0.2805 ps=2.03 w=1.7 l=0.15
X134 a_14866_n468# a_13929_n1432# a_14914_n1052# vss sky130_fd_pr__nfet_01v8_lvt ad=0.465 pd=3.62 as=0.2475 ps=1.83 w=1.5 l=0.15
X135 a_6498_208# a_6498_n1152# vdd vdd sky130_fd_pr__pfet_01v8 ad=0.1885 pd=1.88 as=0.1885 ps=1.88 w=0.65 l=0.15
X136 a_360_n1492# clkn vss vss sky130_fd_pr__nfet_01v8 ad=0.2145 pd=1.63 as=0.403 ps=3.22 w=1.3 l=0.15
X137 a_17096_n1132# a_17394_872# a_17394_n1152# vss sky130_fd_pr__nfet_01v8_lvt ad=0.3565 pd=2.92 as=0.18975 ps=1.48 w=1.15 l=0.15
X138 vdd a_5290_n1152# a_6498_n1152# vdd sky130_fd_pr__pfet_01v8 ad=0.434 pd=3.42 as=0.231 ps=1.73 w=1.4 l=0.15
X139 a_17394_872# a_17394_n1152# a_17096_872# vss sky130_fd_pr__nfet_01v8_lvt ad=0.18975 pd=1.48 as=0.3565 ps=2.92 w=1.15 l=0.15
X140 a_18324_308# a_17394_872# vss vss sky130_fd_pr__nfet_01v8 ad=0.232 pd=2.18 as=0.232 ps=2.18 w=0.8 l=0.15
X141 a_3022_486# a_3022_n580# vss vss sky130_fd_pr__nfet_01v8 ad=0.29 pd=2.58 as=0.29 ps=2.58 w=1 l=0.15
X142 q2p q2n vdd vdd sky130_fd_pr__pfet_01v8 ad=0.3625 pd=3.08 as=0.3625 ps=3.08 w=1.25 l=0.15
X143 a_15212_872# a_7830_872# vdd vdd sky130_fd_pr__pfet_01v8 ad=0.1485 pd=1.23 as=0.279 ps=2.42 w=0.9 l=0.15
X144 a_13929_168# a_13887_n854# a_13841_168# vss sky130_fd_pr__nfet_01v8_lvt ad=0.645 pd=3.86 as=0.2175 ps=1.79 w=1.5 l=0.15
X145 vss a_2192_n1492# a_2762_n468# vss sky130_fd_pr__nfet_01v8_lvt ad=0.4495 pd=3.52 as=0.23925 ps=1.78 w=1.45 l=0.15
X146 a_13841_872# a_8905_n580# vdd vdd sky130_fd_pr__pfet_01v8 ad=0.406 pd=3.09 as=0.812 ps=6.18 w=2.8 l=0.15
X147 a_12381_n1152# a_12381_208# vss vss sky130_fd_pr__nfet_01v8 ad=0.1595 pd=1.68 as=0.1595 ps=1.68 w=0.55 l=0.15
X148 a_13887_n580# a_13887_n854# vdd vdd sky130_fd_pr__pfet_01v8 ad=0.174 pd=1.78 as=0.174 ps=1.78 w=0.6 l=0.15
X149 a_2762_n468# a_3022_486# a_2810_872# vss sky130_fd_pr__nfet_01v8_lvt ad=0.558 pd=4.22 as=0.297 ps=2.13 w=1.8 l=0.15
X150 a_2810_872# a_3022_486# a_2762_n468# vss sky130_fd_pr__nfet_01v8_lvt ad=0.297 pd=2.13 as=0.558 ps=4.22 w=1.8 l=0.15
X151 vdd a_7830_872# a_8991_n1052# vdd sky130_fd_pr__pfet_01v8 ad=0.279 pd=2.42 as=0.1485 ps=1.23 w=0.9 l=0.15
X152 a_2810_872# a_2192_n1492# vdd vdd sky130_fd_pr__pfet_01v8 ad=0.377 pd=3.18 as=0.377 ps=3.18 w=1.3 l=0.15
X153 vss a_6220_n1222# a_6498_208# vss sky130_fd_pr__nfet_01v8_lvt ad=0.403 pd=3.22 as=0.2145 ps=1.63 w=1.3 l=0.15
X154 vdd a_7830_872# a_15212_872# vdd sky130_fd_pr__pfet_01v8 ad=0.279 pd=2.42 as=0.1485 ps=1.23 w=0.9 l=0.15
X155 a_15212_872# a_7830_872# a_15212_n1052# vdd sky130_fd_pr__pfet_01v8 ad=0.203 pd=1.98 as=0.203 ps=1.98 w=0.7 l=0.15
X156 vss a_360_208# a_2192_n1492# vss sky130_fd_pr__nfet_01v8 ad=0.2475 pd=1.83 as=0.2475 ps=1.83 w=1.5 l=0.15
X157 vss a_18324_308# a_18602_n1152# vss sky130_fd_pr__nfet_01v8_lvt ad=0.403 pd=3.22 as=0.2145 ps=1.63 w=1.3 l=0.15
X158 a_7830_n1432# a_3022_486# vdd vdd sky130_fd_pr__pfet_01v8 ad=0.462 pd=3.13 as=0.868 ps=6.22 w=2.8 l=0.15
X159 a_17096_872# a_2192_n1492# vdd vdd sky130_fd_pr__pfet_01v8 ad=0.377 pd=3.18 as=0.377 ps=3.18 w=1.3 l=0.15
X160 vss a_964_n1492# vss vss sky130_fd_pr__nfet_01v8 ad=0.29 pd=2.58 as=0 ps=0 w=1 l=0.5
X161 a_6498_208# a_6220_n1222# vss vss sky130_fd_pr__nfet_01v8_lvt ad=0.2145 pd=1.63 as=0.403 ps=3.22 w=1.3 l=0.15
X162 vdd a_3022_486# a_7830_n1432# vdd sky130_fd_pr__pfet_01v8 ad=0.462 pd=3.13 as=0.462 ps=3.13 w=2.8 l=0.15
X163 a_8645_n468# a_8905_n580# a_8693_n1052# vss sky130_fd_pr__nfet_01v8_lvt ad=0.465 pd=3.62 as=0.2475 ps=1.83 w=1.5 l=0.15
X164 a_12381_n1152# a_12381_208# vdd vdd sky130_fd_pr__pfet_01v8 ad=0.1885 pd=1.88 as=0.1885 ps=1.88 w=0.65 l=0.15
X165 a_8905_n580# a_8905_486# vdd vdd sky130_fd_pr__pfet_01v8 ad=0.29 pd=2.58 as=0.29 ps=2.58 w=1 l=0.15
X166 a_8645_n468# a_8905_486# a_8693_872# vss sky130_fd_pr__nfet_01v8_lvt ad=0.465 pd=3.62 as=0.2475 ps=1.83 w=1.5 l=0.15
X167 a_18324_n1222# a_17394_n1152# vdd vdd sky130_fd_pr__pfet_01v8 ad=0.5075 pd=4.08 as=0.5075 ps=4.08 w=1.75 l=0.15
X168 a_18324_308# a_17394_872# vdd vdd sky130_fd_pr__pfet_01v8 ad=0.5075 pd=4.08 as=0.5075 ps=4.08 w=1.75 l=0.15
X169 q4p a_12381_n1152# vss vss sky130_fd_pr__nfet_01v8 ad=0.2145 pd=1.63 as=0.403 ps=3.22 w=1.3 l=0.15
X170 vss a_7830_872# a_8645_n468# vss sky130_fd_pr__nfet_01v8_lvt ad=0.372 pd=3.02 as=0.198 ps=1.53 w=1.2 l=0.15
X171 a_13929_168# a_13887_n580# a_14323_168# vss sky130_fd_pr__nfet_01v8_lvt ad=0.645 pd=3.86 as=0.2175 ps=1.79 w=1.5 l=0.15
X172 a_3108_n1172# a_3108_872# a_2810_n1132# vss sky130_fd_pr__nfet_01v8_lvt ad=0.2475 pd=1.83 as=0.465 ps=3.62 w=1.5 l=0.15
X173 q4n q4p vss vss sky130_fd_pr__nfet_01v8 ad=0.174 pd=1.78 as=0.174 ps=1.78 w=0.6 l=0.15
X174 a_17048_n468# a_2192_n1492# vss vss sky130_fd_pr__nfet_01v8_lvt ad=0.1815 pd=1.43 as=0.341 ps=2.82 w=1.1 l=0.15
X175 a_8645_n468# a_7830_872# vss vss sky130_fd_pr__nfet_01v8_lvt ad=0.198 pd=1.53 as=0.372 ps=3.02 w=1.2 l=0.15
X176 a_13887_n580# a_16142_338# vss vss sky130_fd_pr__nfet_01v8_lvt ad=0.264 pd=1.93 as=0.496 ps=3.82 w=1.6 l=0.15
X177 vdd a_3108_872# a_3022_n580# vdd sky130_fd_pr__pfet_01v8 ad=0.651 pd=4.82 as=0.3465 ps=2.43 w=2.1 l=0.15
X178 vdd a_3022_n580# a_7830_872# vdd sky130_fd_pr__pfet_01v8 ad=0.868 pd=6.22 as=0.462 ps=3.13 w=2.8 l=0.15
X179 a_12103_n1222# a_11173_n1152# vss vss sky130_fd_pr__nfet_01v8 ad=0.232 pd=2.18 as=0.232 ps=2.18 w=0.8 l=0.15
X180 vss a_7830_872# a_14866_n468# vss sky130_fd_pr__nfet_01v8_lvt ad=0.372 pd=3.02 as=0.198 ps=1.53 w=1.2 l=0.15
X181 vss a_2192_n1492# a_4944_n468# vss sky130_fd_pr__nfet_01v8_lvt ad=0.341 pd=2.82 as=0.1815 ps=1.43 w=1.1 l=0.15
X182 a_17394_n1152# a_2192_n1492# vdd vdd sky130_fd_pr__pfet_01v8 ad=0.231 pd=1.73 as=0.434 ps=3.42 w=1.4 l=0.15
X183 a_4038_338# a_3108_872# vdd vdd sky130_fd_pr__pfet_01v8 ad=0.754 pd=5.78 as=0.754 ps=5.78 w=2.6 l=0.15
X184 a_3022_n580# a_3108_872# vdd vdd sky130_fd_pr__pfet_01v8 ad=0.3465 pd=2.43 as=0.651 ps=4.82 w=2.1 l=0.15
X185 a_4038_338# a_3108_872# vss vss sky130_fd_pr__nfet_01v8 ad=0.1885 pd=1.88 as=0.1885 ps=1.88 w=0.65 l=0.15
X186 q8p a_18602_n1152# vss vss sky130_fd_pr__nfet_01v8 ad=0.2475 pd=1.83 as=0.465 ps=3.62 w=1.5 l=0.15
X187 vdd a_7830_872# a_15212_n1052# vdd sky130_fd_pr__pfet_01v8 ad=0.279 pd=2.42 as=0.1485 ps=1.23 w=0.9 l=0.15
X188 a_18602_n1152# a_18602_208# vss vss sky130_fd_pr__nfet_01v8 ad=0.1595 pd=1.68 as=0.1595 ps=1.68 w=0.55 l=0.15
X189 a_11173_872# a_11173_n1152# a_10875_872# vss sky130_fd_pr__nfet_01v8_lvt ad=0.18975 pd=1.48 as=0.3565 ps=2.92 w=1.15 l=0.15
X190 a_17394_872# a_17394_n1152# vdd vdd sky130_fd_pr__pfet_01v8 ad=0.435 pd=3.58 as=0.435 ps=3.58 w=1.5 l=0.15
X191 a_15212_872# a_15212_n1052# a_14914_872# vss sky130_fd_pr__nfet_01v8_lvt ad=0.2145 pd=1.63 as=0.403 ps=3.22 w=1.3 l=0.15
X192 vss a_3022_486# a_7830_n1432# vss sky130_fd_pr__nfet_01v8_lvt ad=0.403 pd=3.22 as=0.2145 ps=1.63 w=1.3 l=0.15
X193 a_8905_n580# a_8905_486# vss vss sky130_fd_pr__nfet_01v8 ad=0.145 pd=1.58 as=0.145 ps=1.58 w=0.5 l=0.15
X194 a_10875_872# a_11173_n1152# a_11173_872# vss sky130_fd_pr__nfet_01v8_lvt ad=0.3565 pd=2.92 as=0.18975 ps=1.48 w=1.15 l=0.15
X195 a_360_n1492# clkn vdd vdd sky130_fd_pr__pfet_01v8 ad=0.5115 pd=3.43 as=0.961 ps=6.82 w=3.1 l=0.15
X196 a_7830_n1432# a_3022_486# vdd vdd sky130_fd_pr__pfet_01v8 ad=0.462 pd=3.13 as=0.462 ps=3.13 w=2.8 l=0.15
X197 a_2810_872# a_3108_n1172# a_3108_872# vss sky130_fd_pr__nfet_01v8_lvt ad=0.465 pd=3.62 as=0.2475 ps=1.83 w=1.5 l=0.15
X198 a_14914_872# a_15212_n1052# a_15212_872# vss sky130_fd_pr__nfet_01v8_lvt ad=0.403 pd=3.22 as=0.2145 ps=1.63 w=1.3 l=0.15
X199 vss a_6498_208# q2n vss sky130_fd_pr__nfet_01v8 ad=0.403 pd=3.22 as=0.2145 ps=1.63 w=1.3 l=0.15
X200 a_3108_872# a_3108_n1172# a_2810_872# vss sky130_fd_pr__nfet_01v8_lvt ad=0.2475 pd=1.83 as=0.465 ps=3.62 w=1.5 l=0.15
X201 vss a_4038_338# a_3022_486# vss sky130_fd_pr__nfet_01v8_lvt ad=0.558 pd=4.22 as=0.297 ps=2.13 w=1.8 l=0.15
X202 a_12103_n1222# a_11173_n1152# vdd vdd sky130_fd_pr__pfet_01v8 ad=0.5075 pd=4.08 as=0.5075 ps=4.08 w=1.75 l=0.15
X203 a_11173_872# a_2192_n1492# vdd vdd sky130_fd_pr__pfet_01v8 ad=0.231 pd=1.73 as=0.434 ps=3.42 w=1.4 l=0.15
X204 a_10875_872# a_8905_n580# a_10827_n468# vss sky130_fd_pr__nfet_01v8_lvt ad=0.231 pd=1.73 as=0.434 ps=3.42 w=1.4 l=0.15
X205 vss a_7830_872# a_8645_n468# vss sky130_fd_pr__nfet_01v8_lvt ad=0.372 pd=3.02 as=0.198 ps=1.53 w=1.2 l=0.15
X206 vdd a_18602_n1152# q8p vdd sky130_fd_pr__pfet_01v8 ad=0.961 pd=6.82 as=0.5115 ps=3.43 w=3.1 l=0.15
X207 a_12381_208# a_12381_n1152# vss vss sky130_fd_pr__nfet_01v8 ad=0.1595 pd=1.68 as=0.1595 ps=1.68 w=0.55 l=0.15
X208 a_17394_n1152# a_2192_n1492# a_17394_872# vdd sky130_fd_pr__pfet_01v8 ad=0.29 pd=2.58 as=0.29 ps=2.58 w=1 l=0.15
X209 q8n q8p vss vss sky130_fd_pr__nfet_01v8 ad=0.1885 pd=1.88 as=0.1885 ps=1.88 w=0.65 l=0.15
X210 a_5290_n1152# a_5290_872# vdd vdd sky130_fd_pr__pfet_01v8 ad=0.435 pd=3.58 as=0.435 ps=3.58 w=1.5 l=0.15
X211 a_3022_n580# a_3022_486# vdd vdd sky130_fd_pr__pfet_01v8 ad=0.319 pd=2.78 as=0.319 ps=2.78 w=1.1 l=0.15
X212 vss a_9921_n1392# a_8905_n580# vss sky130_fd_pr__nfet_01v8_lvt ad=0.496 pd=3.82 as=0.264 ps=1.93 w=1.6 l=0.15
X213 a_8693_n1052# a_8905_n580# a_8645_n468# vss sky130_fd_pr__nfet_01v8_lvt ad=0.2475 pd=1.83 as=0.465 ps=3.62 w=1.5 l=0.15
X214 vdd a_2192_n1492# a_11173_872# vdd sky130_fd_pr__pfet_01v8 ad=0.434 pd=3.42 as=0.231 ps=1.73 w=1.4 l=0.15
X215 a_11173_872# a_2192_n1492# a_11173_n1152# vdd sky130_fd_pr__pfet_01v8 ad=0.29 pd=2.58 as=0.29 ps=2.58 w=1 l=0.15
X216 a_8905_n580# a_9921_n1392# vss vss sky130_fd_pr__nfet_01v8_lvt ad=0.264 pd=1.93 as=0.496 ps=3.82 w=1.6 l=0.15
X217 a_10827_n468# a_8905_n580# a_10875_872# vss sky130_fd_pr__nfet_01v8_lvt ad=0.434 pd=3.42 as=0.231 ps=1.73 w=1.4 l=0.15
X218 a_2810_n1132# a_2192_n1492# vdd vdd sky130_fd_pr__pfet_01v8 ad=0.377 pd=3.18 as=0.377 ps=3.18 w=1.3 l=0.15
X219 a_13929_n1432# a_13887_n854# a_13841_n1432# vdd sky130_fd_pr__pfet_01v8 ad=1.204 pd=6.46 as=0.406 ps=3.09 w=2.8 l=0.15
X220 a_11173_n1152# a_2192_n1492# vdd vdd sky130_fd_pr__pfet_01v8 ad=0.231 pd=1.73 as=0.434 ps=3.42 w=1.4 l=0.15
X221 a_18324_n1222# a_17394_n1152# vss vss sky130_fd_pr__nfet_01v8 ad=0.232 pd=2.18 as=0.232 ps=2.18 w=0.8 l=0.15
X222 a_17394_n1152# a_17394_872# a_17096_n1132# vss sky130_fd_pr__nfet_01v8_lvt ad=0.18975 pd=1.48 as=0.3565 ps=2.92 w=1.15 l=0.15
X223 vdd a_2192_n1492# a_17394_n1152# vdd sky130_fd_pr__pfet_01v8 ad=0.434 pd=3.42 as=0.231 ps=1.73 w=1.4 l=0.15
X224 vdd a_360_208# a_2192_n1492# vdd sky130_fd_pr__pfet_01v8 ad=0.5115 pd=3.43 as=0.5115 ps=3.43 w=3.1 l=0.15
X225 vdd a_12381_208# q4n vdd sky130_fd_pr__pfet_01v8 ad=0.837 pd=6.02 as=0.4455 ps=3.03 w=2.7 l=0.15
X226 q4n a_12381_208# vdd vdd sky130_fd_pr__pfet_01v8 ad=0.4455 pd=3.03 as=0.837 ps=6.02 w=2.7 l=0.15
X227 vss a_360_n1492# a_964_n1492# vss sky130_fd_pr__nfet_01v8 ad=0.465 pd=3.62 as=0.2475 ps=1.83 w=1.5 l=0.15
X228 vss a_964_n1492# vss vss sky130_fd_pr__nfet_01v8 ad=0.145 pd=1.29 as=0 ps=0 w=1 l=0.5
X229 a_18602_n1152# a_17394_n1152# vdd vdd sky130_fd_pr__pfet_01v8 ad=0.231 pd=1.73 as=0.434 ps=3.42 w=1.4 l=0.15
X230 a_8693_872# a_8905_486# a_8645_n468# vss sky130_fd_pr__nfet_01v8_lvt ad=0.2475 pd=1.83 as=0.465 ps=3.62 w=1.5 l=0.15
X231 a_10827_n468# a_8905_486# a_10875_n1132# vss sky130_fd_pr__nfet_01v8_lvt ad=0.434 pd=3.42 as=0.231 ps=1.73 w=1.4 l=0.15
X232 a_16142_n1392# a_15212_n1052# vdd vdd sky130_fd_pr__pfet_01v8 ad=0.754 pd=5.78 as=0.754 ps=5.78 w=2.6 l=0.15
X233 a_13929_n1432# a_13887_n580# a_14323_n1432# vdd sky130_fd_pr__pfet_01v8 ad=1.204 pd=6.46 as=0.406 ps=3.09 w=2.8 l=0.15
X234 a_4992_872# a_5290_n1152# a_5290_872# vss sky130_fd_pr__nfet_01v8_lvt ad=0.3565 pd=2.92 as=0.18975 ps=1.48 w=1.15 l=0.15
X235 a_4944_n468# a_2192_n1492# vss vss sky130_fd_pr__nfet_01v8_lvt ad=0.1815 pd=1.43 as=0.341 ps=2.82 w=1.1 l=0.15
X236 a_13841_n468# a_8905_n580# vss vss sky130_fd_pr__nfet_01v8_lvt ad=0.2175 pd=1.79 as=0.435 ps=3.58 w=1.5 l=0.15
X237 a_8991_n1052# a_8991_872# vdd vdd sky130_fd_pr__pfet_01v8 ad=0.377 pd=3.18 as=0.377 ps=3.18 w=1.3 l=0.15
X238 a_5290_872# a_5290_n1152# a_4992_872# vss sky130_fd_pr__nfet_01v8_lvt ad=0.18975 pd=1.48 as=0.3565 ps=2.92 w=1.15 l=0.15
X239 a_5290_872# a_2192_n1492# vdd vdd sky130_fd_pr__pfet_01v8 ad=0.231 pd=1.73 as=0.434 ps=3.42 w=1.4 l=0.15
X240 a_4992_872# a_3022_n580# a_4944_n468# vss sky130_fd_pr__nfet_01v8_lvt ad=0.231 pd=1.73 as=0.434 ps=3.42 w=1.4 l=0.15
X241 a_8693_872# a_8991_n1052# a_8991_872# vss sky130_fd_pr__nfet_01v8_lvt ad=0.403 pd=3.22 as=0.2145 ps=1.63 w=1.3 l=0.15
X242 a_14914_n1052# a_15212_872# a_15212_n1052# vss sky130_fd_pr__nfet_01v8_lvt ad=0.403 pd=3.22 as=0.2145 ps=1.63 w=1.3 l=0.15
X243 a_7830_872# a_3022_n580# vdd vdd sky130_fd_pr__pfet_01v8 ad=0.462 pd=3.13 as=0.462 ps=3.13 w=2.8 l=0.15
X244 vdd a_360_n1492# a_964_n1492# vdd sky130_fd_pr__pfet_01v8 ad=0.961 pd=6.82 as=0.5115 ps=3.43 w=3.1 l=0.15
X245 a_14866_n468# a_7830_872# vss vss sky130_fd_pr__nfet_01v8_lvt ad=0.198 pd=1.53 as=0.372 ps=3.02 w=1.2 l=0.15
X246 a_13929_n1432# a_13887_n854# a_14323_n468# vss sky130_fd_pr__nfet_01v8_lvt ad=0.645 pd=3.86 as=0.2175 ps=1.79 w=1.5 l=0.15
X247 a_18602_208# a_17394_872# vdd vdd sky130_fd_pr__pfet_01v8 ad=0.231 pd=1.73 as=0.434 ps=3.42 w=1.4 l=0.15
X248 a_8991_872# a_8991_n1052# a_8693_872# vss sky130_fd_pr__nfet_01v8_lvt ad=0.2145 pd=1.63 as=0.403 ps=3.22 w=1.3 l=0.15
X249 a_8905_486# a_8905_n580# vss vss sky130_fd_pr__nfet_01v8 ad=0.261 pd=2.38 as=0.261 ps=2.38 w=0.9 l=0.15
X250 vdd a_3022_n580# a_7830_872# vdd sky130_fd_pr__pfet_01v8 ad=0.462 pd=3.13 as=0.462 ps=3.13 w=2.8 l=0.15
X251 a_360_n1492# a_360_208# vss vss sky130_fd_pr__nfet_01v8 ad=0.1305 pd=1.48 as=0.1305 ps=1.48 w=0.45 l=0.15
X252 vdd a_2192_n1492# a_5290_872# vdd sky130_fd_pr__pfet_01v8 ad=0.434 pd=3.42 as=0.231 ps=1.73 w=1.4 l=0.15
X253 a_5290_872# a_2192_n1492# a_5290_n1152# vdd sky130_fd_pr__pfet_01v8 ad=0.29 pd=2.58 as=0.29 ps=2.58 w=1 l=0.15
X254 a_4944_n468# a_3022_n580# a_4992_872# vss sky130_fd_pr__nfet_01v8_lvt ad=0.434 pd=3.42 as=0.231 ps=1.73 w=1.4 l=0.15
X255 a_2192_n1492# a_360_208# vdd vdd sky130_fd_pr__pfet_01v8 ad=0.5115 pd=3.43 as=0.5115 ps=3.43 w=3.1 l=0.15
X256 a_7830_n1432# a_3022_486# vss vss sky130_fd_pr__nfet_01v8_lvt ad=0.2145 pd=1.63 as=0.403 ps=3.22 w=1.3 l=0.15
X257 a_11173_n1152# a_11173_872# a_10875_n1132# vss sky130_fd_pr__nfet_01v8_lvt ad=0.18975 pd=1.48 as=0.3565 ps=2.92 w=1.15 l=0.15
X258 vdd a_17394_872# a_18602_208# vdd sky130_fd_pr__pfet_01v8 ad=0.434 pd=3.42 as=0.231 ps=1.73 w=1.4 l=0.15
X259 a_6498_208# a_6498_n1152# vss vss sky130_fd_pr__nfet_01v8 ad=0.1595 pd=1.68 as=0.1595 ps=1.68 w=0.55 l=0.15
X260 a_12381_n1152# a_11173_n1152# vdd vdd sky130_fd_pr__pfet_01v8 ad=0.231 pd=1.73 as=0.434 ps=3.42 w=1.4 l=0.15
X261 a_4944_n468# a_2192_n1492# vss vss sky130_fd_pr__nfet_01v8_lvt ad=0.1815 pd=1.43 as=0.341 ps=2.82 w=1.1 l=0.15
X262 q2n a_6498_208# vss vss sky130_fd_pr__nfet_01v8 ad=0.2145 pd=1.63 as=0.403 ps=3.22 w=1.3 l=0.15
X263 q4n a_12381_208# vss vss sky130_fd_pr__nfet_01v8 ad=0.2145 pd=1.63 as=0.403 ps=3.22 w=1.3 l=0.15
X264 a_13929_168# a_13887_n580# a_13841_872# vdd sky130_fd_pr__pfet_01v8 ad=1.204 pd=6.46 as=0.406 ps=3.09 w=2.8 l=0.15
X265 a_15212_872# a_15212_n1052# vdd vdd sky130_fd_pr__pfet_01v8 ad=0.377 pd=3.18 as=0.377 ps=3.18 w=1.3 l=0.15
X266 a_12103_308# a_11173_872# vss vss sky130_fd_pr__nfet_01v8 ad=0.232 pd=2.18 as=0.232 ps=2.18 w=0.8 l=0.15
X267 a_3022_486# a_4038_338# vss vss sky130_fd_pr__nfet_01v8_lvt ad=0.297 pd=2.13 as=0.558 ps=4.22 w=1.8 l=0.15
X268 a_8991_n1052# a_7830_872# a_8991_872# vdd sky130_fd_pr__pfet_01v8 ad=0.203 pd=1.98 as=0.203 ps=1.98 w=0.7 l=0.15
X269 vss a_2192_n1492# a_2762_n468# vss sky130_fd_pr__nfet_01v8_lvt ad=0.4495 pd=3.52 as=0.23925 ps=1.78 w=1.45 l=0.15
X270 a_15212_n1052# a_15212_872# vdd vdd sky130_fd_pr__pfet_01v8 ad=0.377 pd=3.18 as=0.377 ps=3.18 w=1.3 l=0.15
X271 q2n a_6498_208# vdd vdd sky130_fd_pr__pfet_01v8 ad=0.4455 pd=3.03 as=0.837 ps=6.02 w=2.7 l=0.15
X272 a_3108_n1172# a_2192_n1492# a_3108_872# vdd sky130_fd_pr__pfet_01v8 ad=0.319 pd=2.78 as=0.319 ps=2.78 w=1.1 l=0.15
X273 a_2192_n1492# a_360_208# vss vss sky130_fd_pr__nfet_01v8 ad=0.2475 pd=1.83 as=0.465 ps=3.62 w=1.5 l=0.15
X274 vss a_360_208# a_2192_n1492# vss sky130_fd_pr__nfet_01v8 ad=0.465 pd=3.62 as=0.2475 ps=1.83 w=1.5 l=0.15
X275 a_8645_n468# a_7830_872# vss vss sky130_fd_pr__nfet_01v8_lvt ad=0.198 pd=1.53 as=0.372 ps=3.02 w=1.2 l=0.15
X276 a_12381_n1152# a_12103_308# vss vss sky130_fd_pr__nfet_01v8_lvt ad=0.2145 pd=1.63 as=0.403 ps=3.22 w=1.3 l=0.15
X277 a_17096_n1132# a_2192_n1492# vdd vdd sky130_fd_pr__pfet_01v8 ad=0.377 pd=3.18 as=0.377 ps=3.18 w=1.3 l=0.15
X278 a_11173_n1152# a_2192_n1492# a_11173_872# vdd sky130_fd_pr__pfet_01v8 ad=0.29 pd=2.58 as=0.29 ps=2.58 w=1 l=0.15
X279 vdd a_3022_486# a_7830_n1432# vdd sky130_fd_pr__pfet_01v8 ad=0.868 pd=6.22 as=0.462 ps=3.13 w=2.8 l=0.15
X280 vss a_2192_n1492# a_4944_n468# vss sky130_fd_pr__nfet_01v8_lvt ad=0.341 pd=2.82 as=0.1815 ps=1.43 w=1.1 l=0.15
X281 a_6498_n1152# a_6498_208# vss vss sky130_fd_pr__nfet_01v8 ad=0.1595 pd=1.68 as=0.1595 ps=1.68 w=0.55 l=0.15
X282 a_964_n1492# a_360_n1492# vdd vdd sky130_fd_pr__pfet_01v8 ad=0.5115 pd=3.43 as=0.961 ps=6.82 w=3.1 l=0.15
X283 a_2192_n1492# a_360_208# vss vss sky130_fd_pr__nfet_01v8 ad=0.2475 pd=1.83 as=0.2475 ps=1.83 w=1.5 l=0.15
X284 a_18602_208# a_18602_n1152# vdd vdd sky130_fd_pr__pfet_01v8 ad=0.1885 pd=1.88 as=0.1885 ps=1.88 w=0.65 l=0.15
X285 vss a_360_208# a_2192_n1492# vss sky130_fd_pr__nfet_01v8 ad=0.2475 pd=1.83 as=0.2475 ps=1.83 w=1.5 l=0.15
X286 q8p a_18602_n1152# vdd vdd sky130_fd_pr__pfet_01v8 ad=0.5115 pd=3.43 as=0.961 ps=6.82 w=3.1 l=0.15
X287 a_4992_n1132# a_3022_486# a_4944_n468# vss sky130_fd_pr__nfet_01v8_lvt ad=0.231 pd=1.73 as=0.434 ps=3.42 w=1.4 l=0.15
X288 a_6220_n1222# a_5290_n1152# vdd vdd sky130_fd_pr__pfet_01v8 ad=0.5075 pd=4.08 as=0.5075 ps=4.08 w=1.75 l=0.15
X289 vdd a_7830_872# a_8991_872# vdd sky130_fd_pr__pfet_01v8 ad=0.279 pd=2.42 as=0.1485 ps=1.23 w=0.9 l=0.15
X290 a_8991_872# a_7830_872# a_8991_n1052# vdd sky130_fd_pr__pfet_01v8 ad=0.203 pd=1.98 as=0.203 ps=1.98 w=0.7 l=0.15
X291 vdd a_360_208# a_2192_n1492# vdd sky130_fd_pr__pfet_01v8 ad=0.961 pd=6.82 as=0.5115 ps=3.43 w=3.1 l=0.15
X292 a_3108_n1172# a_2192_n1492# vdd vdd sky130_fd_pr__pfet_01v8 ad=0.2475 pd=1.83 as=0.465 ps=3.62 w=1.5 l=0.15
X293 a_8693_n1052# a_7830_872# vdd vdd sky130_fd_pr__pfet_01v8 ad=0.261 pd=2.38 as=0.261 ps=2.38 w=0.9 l=0.15
X294 a_12103_308# a_11173_872# vdd vdd sky130_fd_pr__pfet_01v8 ad=0.5075 pd=4.08 as=0.5075 ps=4.08 w=1.75 l=0.15
X295 a_14914_n1052# a_13929_n1432# a_14866_n468# vss sky130_fd_pr__nfet_01v8_lvt ad=0.2475 pd=1.83 as=0.465 ps=3.62 w=1.5 l=0.15
X296 vss a_3022_n580# a_7830_872# vss sky130_fd_pr__nfet_01v8_lvt ad=0.403 pd=3.22 as=0.2145 ps=1.63 w=1.3 l=0.15
X297 a_13929_168# a_13887_n854# a_14323_872# vdd sky130_fd_pr__pfet_01v8 ad=1.204 pd=6.46 as=0.406 ps=3.09 w=2.8 l=0.15
X298 q8p q8n vdd vdd sky130_fd_pr__pfet_01v8 ad=0.3915 pd=3.28 as=0.3915 ps=3.28 w=1.35 l=0.15
X299 q8p q8n vss vss sky130_fd_pr__nfet_01v8 ad=0.1885 pd=1.88 as=0.1885 ps=1.88 w=0.65 l=0.15
X300 a_5290_n1152# a_2192_n1492# vdd vdd sky130_fd_pr__pfet_01v8 ad=0.231 pd=1.73 as=0.434 ps=3.42 w=1.4 l=0.15
X301 a_18602_208# a_18324_n1222# vss vss sky130_fd_pr__nfet_01v8_lvt ad=0.2145 pd=1.63 as=0.403 ps=3.22 w=1.3 l=0.15
X302 a_360_208# a_360_n1492# vss vss sky130_fd_pr__nfet_01v8 ad=0.1305 pd=1.48 as=0.1305 ps=1.48 w=0.45 l=0.15
X303 a_7830_872# a_3022_n580# vss vss sky130_fd_pr__nfet_01v8_lvt ad=0.2145 pd=1.63 as=0.403 ps=3.22 w=1.3 l=0.15
X304 a_14323_168# a_8905_486# vss vss sky130_fd_pr__nfet_01v8_lvt ad=0.2175 pd=1.79 as=0.435 ps=3.58 w=1.5 l=0.15
X305 a_15212_n1052# a_7830_872# a_15212_872# vdd sky130_fd_pr__pfet_01v8 ad=0.203 pd=1.98 as=0.203 ps=1.98 w=0.7 l=0.15
X306 vdd a_6498_208# q2n vdd sky130_fd_pr__pfet_01v8 ad=0.837 pd=6.02 as=0.4455 ps=3.03 w=2.7 l=0.15
X307 vss clkn a_360_n1492# vss sky130_fd_pr__nfet_01v8 ad=0.403 pd=3.22 as=0.2145 ps=1.63 w=1.3 l=0.15
X308 a_964_n1492# a_360_n1492# vss vss sky130_fd_pr__nfet_01v8 ad=0.2475 pd=1.83 as=0.465 ps=3.62 w=1.5 l=0.15
X309 vss a_9921_338# a_8905_486# vss sky130_fd_pr__nfet_01v8_lvt ad=0.496 pd=3.82 as=0.264 ps=1.93 w=1.6 l=0.15
X310 vss a_12381_208# q4n vss sky130_fd_pr__nfet_01v8 ad=0.403 pd=3.22 as=0.2145 ps=1.63 w=1.3 l=0.15
X311 vdd clkn a_360_n1492# vdd sky130_fd_pr__pfet_01v8 ad=0.961 pd=6.82 as=0.5115 ps=3.43 w=3.1 l=0.15
X312 a_14914_872# a_7830_872# vdd vdd sky130_fd_pr__pfet_01v8 ad=0.261 pd=2.38 as=0.261 ps=2.38 w=0.9 l=0.15
X313 vss a_18324_n1222# a_18602_208# vss sky130_fd_pr__nfet_01v8_lvt ad=0.403 pd=3.22 as=0.2145 ps=1.63 w=1.3 l=0.15
X314 a_2192_n1492# a_360_208# vss vss sky130_fd_pr__nfet_01v8 ad=0.2475 pd=1.83 as=0.465 ps=3.62 w=1.5 l=0.15
X315 a_18602_n1152# a_18324_308# vss vss sky130_fd_pr__nfet_01v8_lvt ad=0.2145 pd=1.63 as=0.403 ps=3.22 w=1.3 l=0.15
X316 a_6220_308# a_5290_872# vss vss sky130_fd_pr__nfet_01v8 ad=0.232 pd=2.18 as=0.232 ps=2.18 w=0.8 l=0.15
X317 a_2762_n468# a_3022_n580# a_2810_n1132# vss sky130_fd_pr__nfet_01v8_lvt ad=0.558 pd=4.22 as=0.297 ps=2.13 w=1.8 l=0.15
X318 a_13887_n580# a_15212_n1052# vdd vdd sky130_fd_pr__pfet_01v8 ad=0.2805 pd=2.03 as=0.527 ps=4.02 w=1.7 l=0.15
X319 a_4992_n1132# a_5290_872# a_5290_n1152# vss sky130_fd_pr__nfet_01v8_lvt ad=0.3565 pd=2.92 as=0.18975 ps=1.48 w=1.15 l=0.15
X320 a_9921_n1392# a_8991_n1052# vss vss sky130_fd_pr__nfet_01v8 ad=0.1885 pd=1.88 as=0.1885 ps=1.88 w=0.65 l=0.15
X321 a_14323_n1432# a_8905_486# vdd vdd sky130_fd_pr__pfet_01v8 ad=0.406 pd=3.09 as=0.812 ps=6.18 w=2.8 l=0.15
X322 a_16142_338# a_15212_872# vdd vdd sky130_fd_pr__pfet_01v8 ad=0.754 pd=5.78 as=0.754 ps=5.78 w=2.6 l=0.15
X323 a_13887_n854# a_15212_872# vdd vdd sky130_fd_pr__pfet_01v8 ad=0.2805 pd=2.03 as=0.527 ps=4.02 w=1.7 l=0.15
X324 a_16142_338# a_15212_872# vss vss sky130_fd_pr__nfet_01v8 ad=0.1885 pd=1.88 as=0.1885 ps=1.88 w=0.65 l=0.15
X325 a_14914_n1052# a_7830_872# vdd vdd sky130_fd_pr__pfet_01v8 ad=0.261 pd=2.38 as=0.261 ps=2.38 w=0.9 l=0.15
X326 a_13841_n1432# a_8905_n580# vdd vdd sky130_fd_pr__pfet_01v8 ad=0.406 pd=3.09 as=0.812 ps=6.18 w=2.8 l=0.15
X327 a_16142_n1392# a_15212_n1052# vss vss sky130_fd_pr__nfet_01v8 ad=0.1885 pd=1.88 as=0.1885 ps=1.88 w=0.65 l=0.15
.ends
