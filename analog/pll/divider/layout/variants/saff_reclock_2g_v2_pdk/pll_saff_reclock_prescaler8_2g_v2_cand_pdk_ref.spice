* PDK LVS reference netlist for pll_saff_reclock_prescaler8_2g_v2_cand_pdk (1-to-1 with pll_saff_reclock_prescaler8_2g v2_cand)
.subckt pll_saff_reclock_prescaler8_2g_v2_cand_pdk clkp clkn q2p q2n q4p q4n q8p q8n vdd vss
Xck_1p_n ck1n clkp vss vss sky130_fd_pr__nfet_01v8 w=2.6 l=0.15
Xck_1p_p ck1n clkp vdd vdd sky130_fd_pr__pfet_01v8 w=6.2 l=0.15
Xck_1n_n ck1p clkn vss vss sky130_fd_pr__nfet_01v8 w=2.6 l=0.15
Xck_1n_p ck1p clkn vdd vdd sky130_fd_pr__pfet_01v8 w=6.2 l=0.15
Xck_k1p_n ck1n ck1p vss vss sky130_fd_pr__nfet_01v8 w=0.45 l=0.15
Xck_k1p_p ck1n ck1p vdd vdd sky130_fd_pr__pfet_01v8 w=1.0 l=0.15
Xck_k1n_n ck1p ck1n vss vss sky130_fd_pr__nfet_01v8 w=0.45 l=0.15
Xck_k1n_p ck1p ck1n vdd vdd sky130_fd_pr__pfet_01v8 w=1.0 l=0.15
Xck_2p_n ck_2g ck1n vss vss sky130_fd_pr__nfet_01v8 w=12.0 l=0.15
Xck_2p_p ck_2g ck1n vdd vdd sky130_fd_pr__pfet_01v8 w=24.8 l=0.15
Xck_2n_dum_n ck_dum ck1p vss vss sky130_fd_pr__nfet_01v8 w=3.0 l=0.15
Xck_2n_dum_p ck_dum ck1p vdd vdd sky130_fd_pr__pfet_01v8 w=6.2 l=0.15
Xck_cdum vss ck_dum vss vss sky130_fd_pr__nfet_01v8 w=4.0 l=0.5
Xff0_tail ff0_tail ck_2g vss vss sky130_fd_pr__nfet_01v8_lvt w=5.8 l=0.15
Xff0_dp ff0_nsp b0n ff0_tail vss sky130_fd_pr__nfet_01v8_lvt w=3.6 l=0.15
Xff0_dn ff0_nsn b0p ff0_tail vss sky130_fd_pr__nfet_01v8_lvt w=3.6 l=0.15
Xff0_lnp ff0_sp ff0_sn ff0_nsp vss sky130_fd_pr__nfet_01v8_lvt w=3.0 l=0.15
Xff0_lnn ff0_sn ff0_sp ff0_nsn vss sky130_fd_pr__nfet_01v8_lvt w=3.0 l=0.15
Xff0_lpp ff0_sp ff0_sn vdd vdd sky130_fd_pr__pfet_01v8 w=1.6 l=0.15
Xff0_lpn ff0_sn ff0_sp vdd vdd sky130_fd_pr__pfet_01v8 w=1.6 l=0.15
Xff0_prep ff0_sp ck_2g vdd vdd sky130_fd_pr__pfet_01v8 w=3.0 l=0.15
Xff0_pren ff0_sn ck_2g vdd vdd sky130_fd_pr__pfet_01v8 w=3.0 l=0.15
Xff0_eq ff0_sp ck_2g ff0_sn vdd sky130_fd_pr__pfet_01v8 w=2.2 l=0.15
Xff0_pmp ff0_nsp ck_2g vdd vdd sky130_fd_pr__pfet_01v8 w=1.3 l=0.15
Xff0_pmn ff0_nsn ck_2g vdd vdd sky130_fd_pr__pfet_01v8 w=1.3 l=0.15
Xff0_invs_n ff0_sb ff0_sp vss vss sky130_fd_pr__nfet_01v8 w=0.65 l=0.15
Xff0_invs_p ff0_sb ff0_sp vdd vdd sky130_fd_pr__pfet_01v8 w=2.6 l=0.15
Xff0_invr_n ff0_rb ff0_sn vss vss sky130_fd_pr__nfet_01v8 w=0.65 l=0.15
Xff0_invr_p ff0_rb ff0_sn vdd vdd sky130_fd_pr__pfet_01v8 w=2.6 l=0.15
Xff0_pp_s b0p ff0_sp vdd vdd sky130_fd_pr__pfet_01v8 w=4.2 l=0.15
Xff0_dp_d b0p ff0_rb vss vss sky130_fd_pr__nfet_01v8_lvt w=3.6 l=0.15
Xff0_pn_s b0n ff0_sn vdd vdd sky130_fd_pr__pfet_01v8 w=4.2 l=0.15
Xff0_dn_d b0n ff0_sb vss vss sky130_fd_pr__nfet_01v8_lvt w=3.6 l=0.15
Xff0_kp_p b0p b0n vdd vdd sky130_fd_pr__pfet_01v8 w=1.1 l=0.15
Xff0_kp_n b0p b0n vss vss sky130_fd_pr__nfet_01v8 w=0.55 l=0.15
Xff0_kn_p b0n b0p vdd vdd sky130_fd_pr__pfet_01v8 w=0.65 l=0.15
Xff0_kn_n b0n b0p vss vss sky130_fd_pr__nfet_01v8 w=1.0 l=0.15
Xck1g_n ck_1g b0p vss vss sky130_fd_pr__nfet_01v8_lvt w=2.6 l=0.15
Xck1g_p ck_1g b0p vdd vdd sky130_fd_pr__pfet_01v8 w=11.2 l=0.15
Xck1g_dum_n ck_1g_dum b0n vss vss sky130_fd_pr__nfet_01v8_lvt w=2.6 l=0.15
Xck1g_dum_p ck_1g_dum b0n vdd vdd sky130_fd_pr__pfet_01v8 w=11.2 l=0.15
Xff1_tail ff1_tail ck_1g vss vss sky130_fd_pr__nfet_01v8_lvt w=4.8 l=0.15
Xff1_dp ff1_nsp b1n ff1_tail vss sky130_fd_pr__nfet_01v8_lvt w=3.0 l=0.15
Xff1_dn ff1_nsn b1p ff1_tail vss sky130_fd_pr__nfet_01v8_lvt w=3.0 l=0.15
Xff1_lnp ff1_sp ff1_sn ff1_nsp vss sky130_fd_pr__nfet_01v8_lvt w=2.6 l=0.15
Xff1_lnn ff1_sn ff1_sp ff1_nsn vss sky130_fd_pr__nfet_01v8_lvt w=2.6 l=0.15
Xff1_lpp ff1_sp ff1_sn vdd vdd sky130_fd_pr__pfet_01v8 w=1.3 l=0.15
Xff1_lpn ff1_sn ff1_sp vdd vdd sky130_fd_pr__pfet_01v8 w=1.3 l=0.15
Xff1_prep ff1_sp ck_1g vdd vdd sky130_fd_pr__pfet_01v8 w=1.8 l=0.15
Xff1_pren ff1_sn ck_1g vdd vdd sky130_fd_pr__pfet_01v8 w=1.8 l=0.15
Xff1_eq ff1_sp ck_1g ff1_sn vdd sky130_fd_pr__pfet_01v8 w=1.4 l=0.15
Xff1_pmp ff1_nsp ck_1g vdd vdd sky130_fd_pr__pfet_01v8 w=0.9 l=0.15
Xff1_pmn ff1_nsn ck_1g vdd vdd sky130_fd_pr__pfet_01v8 w=0.9 l=0.15
Xff1_invs_n ff1_sb ff1_sp vss vss sky130_fd_pr__nfet_01v8 w=0.65 l=0.15
Xff1_invs_p ff1_sb ff1_sp vdd vdd sky130_fd_pr__pfet_01v8 w=2.6 l=0.15
Xff1_invr_n ff1_rb ff1_sn vss vss sky130_fd_pr__nfet_01v8 w=0.65 l=0.15
Xff1_invr_p ff1_rb ff1_sn vdd vdd sky130_fd_pr__pfet_01v8 w=2.6 l=0.15
Xff1_pp_s b1p ff1_sp vdd vdd sky130_fd_pr__pfet_01v8 w=3.4 l=0.15
Xff1_dp_d b1p ff1_rb vss vss sky130_fd_pr__nfet_01v8_lvt w=3.2 l=0.15
Xff1_pn_s b1n ff1_sn vdd vdd sky130_fd_pr__pfet_01v8 w=3.4 l=0.15
Xff1_dn_d b1n ff1_sb vss vss sky130_fd_pr__nfet_01v8_lvt w=3.2 l=0.15
Xff1_kp_p b1p b1n vdd vdd sky130_fd_pr__pfet_01v8 w=1.0 l=0.15
Xff1_kp_n b1p b1n vss vss sky130_fd_pr__nfet_01v8 w=0.5 l=0.15
Xff1_kn_p b1n b1p vdd vdd sky130_fd_pr__pfet_01v8 w=0.6 l=0.15
Xff1_kn_n b1n b1p vss vss sky130_fd_pr__nfet_01v8 w=0.9 l=0.15
Xxor2_np1a xor2_np1 b1p vss vss sky130_fd_pr__nfet_01v8_lvt w=1.5 l=0.15
Xxor2_np1b d2p b2p xor2_np1 vss sky130_fd_pr__nfet_01v8_lvt w=1.5 l=0.15
Xxor2_np2a xor2_np2 b1n vss vss sky130_fd_pr__nfet_01v8_lvt w=1.5 l=0.15
Xxor2_np2b d2p b2n xor2_np2 vss sky130_fd_pr__nfet_01v8_lvt w=1.5 l=0.15
Xxor2_pp1a xor2_pp1 b1p vdd vdd sky130_fd_pr__pfet_01v8 w=2.8 l=0.15
Xxor2_pp1b d2p b2n xor2_pp1 vdd sky130_fd_pr__pfet_01v8 w=2.8 l=0.15
Xxor2_pp2a xor2_pp2 b1n vdd vdd sky130_fd_pr__pfet_01v8 w=2.8 l=0.15
Xxor2_pp2b d2p b2p xor2_pp2 vdd sky130_fd_pr__pfet_01v8 w=2.8 l=0.15
Xxor2_nn1a xor2_nn1 b1p vss vss sky130_fd_pr__nfet_01v8_lvt w=1.5 l=0.15
Xxor2_nn1b d2n b2n xor2_nn1 vss sky130_fd_pr__nfet_01v8_lvt w=1.5 l=0.15
Xxor2_nn2a xor2_nn2 b1n vss vss sky130_fd_pr__nfet_01v8_lvt w=1.5 l=0.15
Xxor2_nn2b d2n b2p xor2_nn2 vss sky130_fd_pr__nfet_01v8_lvt w=1.5 l=0.15
Xxor2_pn1a xor2_pn1 b1p vdd vdd sky130_fd_pr__pfet_01v8 w=2.8 l=0.15
Xxor2_pn1b d2n b2p xor2_pn1 vdd sky130_fd_pr__pfet_01v8 w=2.8 l=0.15
Xxor2_pn2a xor2_pn2 b1n vdd vdd sky130_fd_pr__pfet_01v8 w=2.8 l=0.15
Xxor2_pn2b d2n b2n xor2_pn2 vdd sky130_fd_pr__pfet_01v8 w=2.8 l=0.15
Xff2_tail ff2_tail ck_1g vss vss sky130_fd_pr__nfet_01v8_lvt w=4.8 l=0.15
Xff2_dp ff2_nsp d2p ff2_tail vss sky130_fd_pr__nfet_01v8_lvt w=3.0 l=0.15
Xff2_dn ff2_nsn d2n ff2_tail vss sky130_fd_pr__nfet_01v8_lvt w=3.0 l=0.15
Xff2_lnp ff2_sp ff2_sn ff2_nsp vss sky130_fd_pr__nfet_01v8_lvt w=2.6 l=0.15
Xff2_lnn ff2_sn ff2_sp ff2_nsn vss sky130_fd_pr__nfet_01v8_lvt w=2.6 l=0.15
Xff2_lpp ff2_sp ff2_sn vdd vdd sky130_fd_pr__pfet_01v8 w=1.3 l=0.15
Xff2_lpn ff2_sn ff2_sp vdd vdd sky130_fd_pr__pfet_01v8 w=1.3 l=0.15
Xff2_prep ff2_sp ck_1g vdd vdd sky130_fd_pr__pfet_01v8 w=1.8 l=0.15
Xff2_pren ff2_sn ck_1g vdd vdd sky130_fd_pr__pfet_01v8 w=1.8 l=0.15
Xff2_eq ff2_sp ck_1g ff2_sn vdd sky130_fd_pr__pfet_01v8 w=1.4 l=0.15
Xff2_pmp ff2_nsp ck_1g vdd vdd sky130_fd_pr__pfet_01v8 w=0.9 l=0.15
Xff2_pmn ff2_nsn ck_1g vdd vdd sky130_fd_pr__pfet_01v8 w=0.9 l=0.15
Xff2_invs_n ff2_sb ff2_sp vss vss sky130_fd_pr__nfet_01v8 w=0.65 l=0.15
Xff2_invs_p ff2_sb ff2_sp vdd vdd sky130_fd_pr__pfet_01v8 w=2.6 l=0.15
Xff2_invr_n ff2_rb ff2_sn vss vss sky130_fd_pr__nfet_01v8 w=0.65 l=0.15
Xff2_invr_p ff2_rb ff2_sn vdd vdd sky130_fd_pr__pfet_01v8 w=2.6 l=0.15
Xff2_pp_s b2p ff2_sp vdd vdd sky130_fd_pr__pfet_01v8 w=3.4 l=0.15
Xff2_dp_d b2p ff2_rb vss vss sky130_fd_pr__nfet_01v8_lvt w=3.2 l=0.15
Xff2_pn_s b2n ff2_sn vdd vdd sky130_fd_pr__pfet_01v8 w=3.4 l=0.15
Xff2_dn_d b2n ff2_sb vss vss sky130_fd_pr__nfet_01v8_lvt w=3.2 l=0.15
Xff2_kp_p b2p b2n vdd vdd sky130_fd_pr__pfet_01v8 w=1.0 l=0.15
Xff2_kp_n b2p b2n vss vss sky130_fd_pr__nfet_01v8 w=0.5 l=0.15
Xff2_kn_p b2n b2p vdd vdd sky130_fd_pr__pfet_01v8 w=0.6 l=0.15
Xff2_kn_n b2n b2p vss vss sky130_fd_pr__nfet_01v8 w=0.9 l=0.15
Xr0_tail r0_tail ck_2g vss vss sky130_fd_pr__nfet_01v8_lvt w=4.4 l=0.15
Xr0_dp r0_nsp b0p r0_tail vss sky130_fd_pr__nfet_01v8_lvt w=2.8 l=0.15
Xr0_dn r0_nsn b0n r0_tail vss sky130_fd_pr__nfet_01v8_lvt w=2.8 l=0.15
Xr0_lnp r0_sp r0_sn r0_nsp vss sky130_fd_pr__nfet_01v8_lvt w=2.3 l=0.15
Xr0_lnn r0_sn r0_sp r0_nsn vss sky130_fd_pr__nfet_01v8_lvt w=2.3 l=0.15
Xr0_lpp r0_sp r0_sn vdd vdd sky130_fd_pr__pfet_01v8 w=1.5 l=0.15
Xr0_lpn r0_sn r0_sp vdd vdd sky130_fd_pr__pfet_01v8 w=1.5 l=0.15
Xr0_prep r0_sp ck_2g vdd vdd sky130_fd_pr__pfet_01v8 w=2.8 l=0.15
Xr0_pren r0_sn ck_2g vdd vdd sky130_fd_pr__pfet_01v8 w=2.8 l=0.15
Xr0_eq r0_sp ck_2g r0_sn vdd sky130_fd_pr__pfet_01v8 w=2.0 l=0.15
Xr0_pmp r0_nsp ck_2g vdd vdd sky130_fd_pr__pfet_01v8 w=1.3 l=0.15
Xr0_pmn r0_nsn ck_2g vdd vdd sky130_fd_pr__pfet_01v8 w=1.3 l=0.15
Xr0_invs_n r0_sb r0_sp vss vss sky130_fd_pr__nfet_01v8 w=0.8 l=0.15
Xr0_invs_p r0_sb r0_sp vdd vdd sky130_fd_pr__pfet_01v8 w=1.75 l=0.15
Xr0_invr_n r0_rb r0_sn vss vss sky130_fd_pr__nfet_01v8 w=0.8 l=0.15
Xr0_invr_p r0_rb r0_sn vdd vdd sky130_fd_pr__pfet_01v8 w=1.75 l=0.15
Xr0_pp_s r0p r0_sp vdd vdd sky130_fd_pr__pfet_01v8 w=2.8 l=0.15
Xr0_dp_d r0p r0_rb vss vss sky130_fd_pr__nfet_01v8_lvt w=2.6 l=0.15
Xr0_pn_s r0n r0_sn vdd vdd sky130_fd_pr__pfet_01v8 w=2.8 l=0.15
Xr0_dn_d r0n r0_sb vss vss sky130_fd_pr__nfet_01v8_lvt w=2.6 l=0.15
Xr0_kp_p r0p r0n vdd vdd sky130_fd_pr__pfet_01v8 w=0.65 l=0.15
Xr0_kp_n r0p r0n vss vss sky130_fd_pr__nfet_01v8 w=0.55 l=0.15
Xr0_kn_p r0n r0p vdd vdd sky130_fd_pr__pfet_01v8 w=0.65 l=0.15
Xr0_kn_n r0n r0p vss vss sky130_fd_pr__nfet_01v8 w=0.55 l=0.15
Xr1_tail r1_tail ck_2g vss vss sky130_fd_pr__nfet_01v8_lvt w=4.4 l=0.15
Xr1_dp r1_nsp b1p r1_tail vss sky130_fd_pr__nfet_01v8_lvt w=2.8 l=0.15
Xr1_dn r1_nsn b1n r1_tail vss sky130_fd_pr__nfet_01v8_lvt w=2.8 l=0.15
Xr1_lnp r1_sp r1_sn r1_nsp vss sky130_fd_pr__nfet_01v8_lvt w=2.3 l=0.15
Xr1_lnn r1_sn r1_sp r1_nsn vss sky130_fd_pr__nfet_01v8_lvt w=2.3 l=0.15
Xr1_lpp r1_sp r1_sn vdd vdd sky130_fd_pr__pfet_01v8 w=1.5 l=0.15
Xr1_lpn r1_sn r1_sp vdd vdd sky130_fd_pr__pfet_01v8 w=1.5 l=0.15
Xr1_prep r1_sp ck_2g vdd vdd sky130_fd_pr__pfet_01v8 w=2.8 l=0.15
Xr1_pren r1_sn ck_2g vdd vdd sky130_fd_pr__pfet_01v8 w=2.8 l=0.15
Xr1_eq r1_sp ck_2g r1_sn vdd sky130_fd_pr__pfet_01v8 w=2.0 l=0.15
Xr1_pmp r1_nsp ck_2g vdd vdd sky130_fd_pr__pfet_01v8 w=1.3 l=0.15
Xr1_pmn r1_nsn ck_2g vdd vdd sky130_fd_pr__pfet_01v8 w=1.3 l=0.15
Xr1_invs_n r1_sb r1_sp vss vss sky130_fd_pr__nfet_01v8 w=0.8 l=0.15
Xr1_invs_p r1_sb r1_sp vdd vdd sky130_fd_pr__pfet_01v8 w=1.75 l=0.15
Xr1_invr_n r1_rb r1_sn vss vss sky130_fd_pr__nfet_01v8 w=0.8 l=0.15
Xr1_invr_p r1_rb r1_sn vdd vdd sky130_fd_pr__pfet_01v8 w=1.75 l=0.15
Xr1_pp_s r1p r1_sp vdd vdd sky130_fd_pr__pfet_01v8 w=2.8 l=0.15
Xr1_dp_d r1p r1_rb vss vss sky130_fd_pr__nfet_01v8_lvt w=2.6 l=0.15
Xr1_pn_s r1n r1_sn vdd vdd sky130_fd_pr__pfet_01v8 w=2.8 l=0.15
Xr1_dn_d r1n r1_sb vss vss sky130_fd_pr__nfet_01v8_lvt w=2.6 l=0.15
Xr1_kp_p r1p r1n vdd vdd sky130_fd_pr__pfet_01v8 w=0.65 l=0.15
Xr1_kp_n r1p r1n vss vss sky130_fd_pr__nfet_01v8 w=0.55 l=0.15
Xr1_kn_p r1n r1p vdd vdd sky130_fd_pr__pfet_01v8 w=0.65 l=0.15
Xr1_kn_n r1n r1p vss vss sky130_fd_pr__nfet_01v8 w=0.55 l=0.15
Xr2_tail r2_tail ck_2g vss vss sky130_fd_pr__nfet_01v8_lvt w=4.4 l=0.15
Xr2_dp r2_nsp b2p r2_tail vss sky130_fd_pr__nfet_01v8_lvt w=2.8 l=0.15
Xr2_dn r2_nsn b2n r2_tail vss sky130_fd_pr__nfet_01v8_lvt w=2.8 l=0.15
Xr2_lnp r2_sp r2_sn r2_nsp vss sky130_fd_pr__nfet_01v8_lvt w=2.3 l=0.15
Xr2_lnn r2_sn r2_sp r2_nsn vss sky130_fd_pr__nfet_01v8_lvt w=2.3 l=0.15
Xr2_lpp r2_sp r2_sn vdd vdd sky130_fd_pr__pfet_01v8 w=1.5 l=0.15
Xr2_lpn r2_sn r2_sp vdd vdd sky130_fd_pr__pfet_01v8 w=1.5 l=0.15
Xr2_prep r2_sp ck_2g vdd vdd sky130_fd_pr__pfet_01v8 w=2.8 l=0.15
Xr2_pren r2_sn ck_2g vdd vdd sky130_fd_pr__pfet_01v8 w=2.8 l=0.15
Xr2_eq r2_sp ck_2g r2_sn vdd sky130_fd_pr__pfet_01v8 w=2.0 l=0.15
Xr2_pmp r2_nsp ck_2g vdd vdd sky130_fd_pr__pfet_01v8 w=1.3 l=0.15
Xr2_pmn r2_nsn ck_2g vdd vdd sky130_fd_pr__pfet_01v8 w=1.3 l=0.15
Xr2_invs_n r2_sb r2_sp vss vss sky130_fd_pr__nfet_01v8 w=0.8 l=0.15
Xr2_invs_p r2_sb r2_sp vdd vdd sky130_fd_pr__pfet_01v8 w=1.75 l=0.15
Xr2_invr_n r2_rb r2_sn vss vss sky130_fd_pr__nfet_01v8 w=0.8 l=0.15
Xr2_invr_p r2_rb r2_sn vdd vdd sky130_fd_pr__pfet_01v8 w=1.75 l=0.15
Xr2_pp_s r2p r2_sp vdd vdd sky130_fd_pr__pfet_01v8 w=2.8 l=0.15
Xr2_dp_d r2p r2_rb vss vss sky130_fd_pr__nfet_01v8_lvt w=2.6 l=0.15
Xr2_pn_s r2n r2_sn vdd vdd sky130_fd_pr__pfet_01v8 w=2.8 l=0.15
Xr2_dn_d r2n r2_sb vss vss sky130_fd_pr__nfet_01v8_lvt w=2.6 l=0.15
Xr2_kp_p r2p r2n vdd vdd sky130_fd_pr__pfet_01v8 w=0.65 l=0.15
Xr2_kp_n r2p r2n vss vss sky130_fd_pr__nfet_01v8 w=0.55 l=0.15
Xr2_kn_p r2n r2p vdd vdd sky130_fd_pr__pfet_01v8 w=0.65 l=0.15
Xr2_kn_n r2n r2p vss vss sky130_fd_pr__nfet_01v8 w=0.55 l=0.15
Xo0_obp_n q2p r0n vss vss sky130_fd_pr__nfet_01v8 w=2.6 l=0.15
Xo0_obp_p q2p r0n vdd vdd sky130_fd_pr__pfet_01v8 w=5.4 l=0.15
Xo0_obn_n q2n r0p vss vss sky130_fd_pr__nfet_01v8 w=2.6 l=0.15
Xo0_obn_p q2n r0p vdd vdd sky130_fd_pr__pfet_01v8 w=5.4 l=0.15
Xo0_kp_n q2n q2p vss vss sky130_fd_pr__nfet_01v8 w=0.6 l=0.15
Xo0_kp_p q2n q2p vdd vdd sky130_fd_pr__pfet_01v8 w=1.25 l=0.15
Xo0_kn_n q2p q2n vss vss sky130_fd_pr__nfet_01v8 w=0.6 l=0.15
Xo0_kn_p q2p q2n vdd vdd sky130_fd_pr__pfet_01v8 w=1.25 l=0.15
Xo1_obp_n q4p r1n vss vss sky130_fd_pr__nfet_01v8 w=2.6 l=0.15
Xo1_obp_p q4p r1n vdd vdd sky130_fd_pr__pfet_01v8 w=5.4 l=0.15
Xo1_obn_n q4n r1p vss vss sky130_fd_pr__nfet_01v8 w=2.6 l=0.15
Xo1_obn_p q4n r1p vdd vdd sky130_fd_pr__pfet_01v8 w=5.4 l=0.15
Xo1_kp_n q4n q4p vss vss sky130_fd_pr__nfet_01v8 w=0.6 l=0.15
Xo1_kp_p q4n q4p vdd vdd sky130_fd_pr__pfet_01v8 w=1.25 l=0.15
Xo1_kn_n q4p q4n vss vss sky130_fd_pr__nfet_01v8 w=0.6 l=0.15
Xo1_kn_p q4p q4n vdd vdd sky130_fd_pr__pfet_01v8 w=1.25 l=0.15
Xo2_obp_n q8p r2n vss vss sky130_fd_pr__nfet_01v8 w=3.0 l=0.15
Xo2_obp_p q8p r2n vdd vdd sky130_fd_pr__pfet_01v8 w=6.2 l=0.15
Xo2_obn_n q8n r2p vss vss sky130_fd_pr__nfet_01v8 w=3.0 l=0.15
Xo2_obn_p q8n r2p vdd vdd sky130_fd_pr__pfet_01v8 w=6.2 l=0.15
Xo2_kp_n q8n q8p vss vss sky130_fd_pr__nfet_01v8 w=0.65 l=0.15
Xo2_kp_p q8n q8p vdd vdd sky130_fd_pr__pfet_01v8 w=1.35 l=0.15
Xo2_kn_n q8p q8n vss vss sky130_fd_pr__nfet_01v8 w=0.65 l=0.15
Xo2_kn_p q8p q8n vdd vdd sky130_fd_pr__pfet_01v8 w=1.35 l=0.15
.ends pll_saff_reclock_prescaler8_2g_v2_cand_pdk
