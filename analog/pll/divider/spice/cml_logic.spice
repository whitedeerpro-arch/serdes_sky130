* Static CML logic for the programmable synchronous counter.
* Data/outputs are high-CM CML; each gate locally shifts its SELECT input down.
* Logic reference: VDD = logical high, vlo = logical low; neither is a CMOS input.
.subckt pll_cml_mux2 ap an bp bn sp sn qp qn vbias vdd vss
+ params: wdata=12 wselect=24 wtail=9.6 rload=1000 wsf=20 wsf_sink=2
Rp vdd qp {rload}
Rn vdd qn {rload}
Xap qn ap ta vss serdes_nfet_lvt w={wdata} nf=4
Xan qp an ta vss serdes_nfet_lvt w={wdata} nf=4
Xbp qn bp tb vss serdes_nfet_lvt w={wdata} nf=4
Xbn qp bn tb vss serdes_nfet_lvt w={wdata} nf=4
Xsp vdd sp slp vss serdes_nfet_lvt w={wsf} nf=4
Xsn vdd sn sln vss serdes_nfet_lvt w={wsf} nf=4
Xisp slp vbias vss vss serdes_nfet w={wsf_sink} l=0.5
Xisn sln vbias vss vss serdes_nfet w={wsf_sink} l=0.5
Xsa ta sln tail vss serdes_nfet_lvt w={wselect} nf=4
Xsb tb slp tail vss serdes_nfet_lvt w={wselect} nf=4
Xtail tail vbias vss vss serdes_nfet w={wtail} l=0.5 nf=4
.ends pll_cml_mux2

.subckt pll_cml_xor ap an bp bn qp qn vbias vdd vss
Xgate ap an an ap bp bn qp qn vbias vdd vss pll_cml_mux2
.ends pll_cml_xor

.subckt pll_cml_xnor ap an bp bn qp qn vbias vdd vss
Xgate ap an an ap bp bn qn qp vbias vdd vss pll_cml_mux2
.ends pll_cml_xnor

.subckt pll_cml_and ap an bp bn qp qn vlo vbias vdd vss
Xgate vlo vdd ap an bp bn qp qn vbias vdd vss pll_cml_mux2
.ends pll_cml_and

* Configuration bits are static full-swing CMOS, converted once to CML.
.subckt pll_cml_config_bit cp cn qp qn vbias vdd vss
Rp vdd qp 1000
Rn vdd qn 1000
Xip qn cp tail vss serdes_nfet_lvt w=12 nf=4
Xin qp cn tail vss serdes_nfet_lvt w=12 nf=4
Xtail tail vbias vss vss serdes_nfet w=9.6 l=0.5 nf=4
.ends pll_cml_config_bit
