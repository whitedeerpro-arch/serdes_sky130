* Pure-CMOS 2 GHz /8 prescaler (three cascaded differential C2MOS /2 stages -> 1 GHz, 500 MHz, 250 MHz).
* Driven directly by complementary rail-to-rail outputs of serdes_cml_to_cmos_r4_pdk (or _v4).
* Fully differential C2MOS topology with zero-contention common-mode killers (Xcm_*):
*   - Series NMOS/PMOS CM detectors fire ONLY when (mp==mn==1) or (mp==mn==0), eliminating in-phase lockup
*     even under overlapping clocks, while drawing zero contention/static current during differential toggling.
*   - Symmetric clock load on clkp/clkn and balanced output inverters for ~50% duty across all 45 PVT corners.
* Dependencies: sky130_primitives.spice, cmos_logic.spice.

.subckt pll_cmos_c2mos_latch d ck ckb q vdd vss params: wn=2.0 wp=4.0
Xp1 n1 d vdd vdd serdes_pfet w={wp} nf=1
Xp2 q ckb n1 vdd serdes_pfet w={wp} nf=1
Xn1 q ck n2 vss serdes_nfet w={wn} nf=1
Xn2 n2 d vss vss serdes_nfet w={wn} nf=1
.ends pll_cmos_c2mos_latch

.subckt pll_cmos_c2mos_div2 ckp ckn qp qn vdd vss params: wn=2.4 wp=6.2 wbuf_n=3.0 wbuf_p=4.6 wcm_n=1.2 wcm_p=2.6
* Master transparent when ckp=1 (ckn=0)
Xmp qn_i ckp ckn mp vdd vss pll_cmos_c2mos_latch wn={wn} wp={wp}
Xmn qp_i ckp ckn mn vdd vss pll_cmos_c2mos_latch wn={wn} wp={wp}
Xk_mp mp mn vdd vss serdes_cmos_inv wn=0.6 wp=1.3
Xk_mn mn mp vdd vss serdes_cmos_inv wn=0.6 wp=1.3
* Zero-contention common-mode killers on master (mp, mn)
Xcm_mn1 mn mp n_cmm vss serdes_nfet w={wcm_n} nf=1
Xcm_mn2 n_cmm mn vss vss serdes_nfet w={wcm_n} nf=1
Xcm_mp1 mp mn p_cmm vdd serdes_pfet w={wcm_p} nf=1
Xcm_mp2 p_cmm mp vdd vdd serdes_pfet w={wcm_p} nf=1
* Slave transparent when ckp=0 (ckn=1)
Xsp mp ckn ckp qp_i vdd vss pll_cmos_c2mos_latch wn={wn} wp={wp}
Xsn mn ckn ckp qn_i vdd vss pll_cmos_c2mos_latch wn={wn} wp={wp}
Xk_qp qp_i qn_i vdd vss serdes_cmos_inv wn=0.6 wp=1.3
Xk_qn qn_i qp_i vdd vss serdes_cmos_inv wn=0.6 wp=1.3
* Zero-contention common-mode killers on slave (qp_i, qn_i)
Xcm_qn1 qn_i qp_i n_cmq vss serdes_nfet w={wcm_n} nf=1
Xcm_qn2 n_cmq qn_i vss vss serdes_nfet w={wcm_n} nf=1
Xcm_qp1 qp_i qn_i p_cmq vdd serdes_pfet w={wcm_p} nf=1
Xcm_qp2 p_cmq qp_i vdd vdd serdes_pfet w={wcm_p} nf=1
* Symmetric output inverters
Xobp qp_i qp vdd vss serdes_cmos_inv wn={wbuf_n} wp={wbuf_p}
Xobn qn_i qn vdd vss serdes_cmos_inv wn={wbuf_n} wp={wbuf_p}
.ends pll_cmos_c2mos_div2

* Pure-CMOS /8 prescaler with balanced differential outputs q2p/n (1 GHz), q4p/n (500 MHz), q8p/n (250 MHz).
.subckt pll_cmos_prescaler8_2g clkp clkn q2p q2n q4p q4n q8p q8n vdd vss
Xdiv2 clkp clkn q2p q2n vdd vss pll_cmos_c2mos_div2 wn=2.4 wp=6.2 wbuf_n=3.0 wbuf_p=4.6 wcm_n=0.7 wcm_p=1.4
Xdiv4 q2p  q2n  q4p q4n vdd vss pll_cmos_c2mos_div2 wn=1.8 wp=4.6 wbuf_n=2.2 wbuf_p=4.2 wcm_n=0.6 wcm_p=1.3
Xdiv8 q4p  q4n  q8p q8n vdd vss pll_cmos_c2mos_div2 wn=1.5 wp=3.6 wbuf_n=2.0 wbuf_p=4.2 wcm_n=0.6 wcm_p=1.3
.ends pll_cmos_prescaler8_2g
