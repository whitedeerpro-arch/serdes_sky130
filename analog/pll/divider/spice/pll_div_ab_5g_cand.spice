* Dual-Rate 4G/5G PLL Feedback Divider A (2.0 GHz /8 & 2.5 GHz /10 -> 250 MHz, 50% Duty, Fast-Clock Retimed)
* SKY130A, 1.8 V, 100% real SKY130 devices (W/nf >= 0.42 um, L >= 0.15 um; zero ideal passives or B-sources).
* Dependencies: sky130_primitives.spice, sky130_pfet_lvt.spice.
*
* Interface:
*   clkp, clkn : 2.0 GHz (mode_5g=0) or 2.5 GHz (mode_5g=1) differential clock input (sinusoid or CMOS)
*   mode_5g    : 0 -> divide-by-8 (2.0 GHz -> 250 MHz), 1 -> divide-by-10 (2.5 GHz -> 250 MHz)
*   rst_n      : active-low asynchronous reset (1 = run, 0 = deterministic reset)
*   fb250      : clean fast-clock-retimed 250 MHz PFD feedback output (45-55% duty cycle)
*   fb250_b    : complementary 250 MHz feedback output
*
* Architecture:
*   1. Low-C_in differential-to-CMOS input buffer (LVT-NMOS/LVT-PMOS stage 1 + fast cross-coupled stage 2)
*      producing matched complementary 2.0/2.5 GHz clocks (ckp, ckn) + isolated retimer clock (ck_rt).
*   2. High-speed static differential Johnson /2 (2.0 -> 1.0 GHz, 2.5 -> 1.25 GHz) generating balanced
*      complementary half-rate clocks (ckh_p, ckh_n).
*   3. Self-starting 3-FF synchronous /4 or /5 counter at 1.0 / 1.25 GHz (zero illegal lockup states):
*        d0 = ~(q1 | (q2 & mode_5g)),  d1 = q0,  d2 = q1
*        mode_5g=0: /4 cycle (00->01->11->10), q0 has 2/4 = 50% duty.
*        mode_5g=1: /5 cycle (000->001->011->110->100), q0 has 2/5 = 40% duty.
*   4. Glitch-free dual-edge 50% duty shaper:
*        q0_dly = half-cycle (falling-edge ckh_p) latched copy of q0
*        q_shaped = q0 | (q0_dly & mode_5g)  -> 2.0/4 = 50% (/8) and 2.5/5 = 50% (/10).
*        Implemented with matched complementary AOI21 / OAI21 gates for identical rising/falling delay.
*   5. Equalized Nikolic SAFF-TSPC final retimer clocked directly by clean 2.0/2.5 GHz ck_rt:
*        Locks both rising and falling edges of fb250 to the clean full-rate clock, stripping ripple/jitter
*        and delivering exact 4.000/8.000 (mode_5g=0) or 5.000/10.000 (mode_5g=1) = 50.0% duty cycle.

* -----------------------------------------------------------------------------
* Local CMOS Primitives (all W/nf >= 0.42 um, L >= 0.15 um)
* -----------------------------------------------------------------------------
.subckt divab_inv a y vdd vss params: wn=1.0 wp=4.2 nfn=1 nfp=2
Xn y a vss vss serdes_nfet_lvt w={wn} l=0.15 nf={nfn}
Xp y a vdd vdd serdes_pfet     w={wp} l=0.15 nf={nfp}
.ends divab_inv

.subckt divab_inv_lvt a y vdd vss params: wn=1.0 wp=4.0 nfn=1 nfp=2
Xn y a vss vss serdes_nfet_lvt w={wn} l=0.15 nf={nfn}
Xp y a vdd vdd serdes_pfet_lvt w={wp} l=0.35 nf={nfp}
.ends divab_inv_lvt

.subckt divab_inv_static a y vdd vss params: wn=0.50 wp=1.00
Xn y a vss vss serdes_nfet w={wn} l=0.18 nf=1
Xp y a vdd vdd serdes_pfet w={wp} l=0.18 nf=1
.ends divab_inv_static

.subckt divab_cc_align ap an vdd vss params: wn=0.45 wp=1.80
X1 ap an vdd vss divab_inv wn={wn} wp={wp} nfn=1 nfp=1
X2 an ap vdd vss divab_inv wn={wn} wp={wp} nfn=1 nfp=1
.ends divab_cc_align

* Single-stage static AOI21: y = ~(a | (b & c))
.subckt divab_aoi21 a b c y vdd vss params: wn=1.40 wp=5.60 nfn=1 nfp=2
* Pull-down: a OR (b AND c)
Xna  y   a vss vss serdes_nfet_lvt w={wn}       l=0.15 nf={nfn}
Xnb  y   b mid vss serdes_nfet_lvt w={1.5*wn}   l=0.15 nf={nfn}
Xnc  mid c vss vss serdes_nfet_lvt w={1.5*wn}   l=0.15 nf={nfn}
* Pull-up: ~a AND (~b OR ~c)
Xpa  p1  a vdd vdd serdes_pfet     w={wp}       l=0.15 nf={nfp}
Xpb  y   b p1  vdd serdes_pfet     w={wp}       l=0.15 nf={nfp}
Xpc  y   c p1  vdd serdes_pfet     w={wp}       l=0.15 nf={nfp}
.ends divab_aoi21

* Single-stage static OAI21: y = ~(a & (b | c))
.subckt divab_oai21 a b c y vdd vss params: wn=1.40 wp=5.60 nfn=1 nfp=2
* Pull-down: a AND (b OR c)
Xna  n1  a vss vss serdes_nfet_lvt w={1.5*wn}   l=0.15 nf={nfn}
Xnb  y   b n1  vss serdes_nfet_lvt w={1.5*wn}   l=0.15 nf={nfn}
Xnc  y   c n1  vss serdes_nfet_lvt w={1.5*wn}   l=0.15 nf={nfn}
* Pull-up: ~a OR (~b AND ~c)
Xpa  y   a vdd vdd serdes_pfet     w={0.75*wp}  l=0.15 nf={nfp}
Xpb  p1  b vdd vdd serdes_pfet     w={1.25*wp}  l=0.15 nf={nfp}
Xpc  y   c p1  vdd serdes_pfet     w={1.25*wp}  l=0.15 nf={nfp}
.ends divab_oai21

* -----------------------------------------------------------------------------
* Differential-to-CMOS 2.0/2.5 GHz Input Receiver & Clock Buffer
* Low C_in (~12 fF/leg), 3-stage FO~2 amplification so even 1.0 Vpp sinusoid
* produces crisp full-rail 2.5 GHz clocks at SS 1.65 V -40 C!
* Dedicated PVT-tracking ck_rt branch centers retimer setup/hold across all corners.
* -----------------------------------------------------------------------------
.subckt divab_inbuf clkp clkn ckp ckn ck_rt vdd vss
* Stage 1: low-C_in balanced LVT N/P receiver (V_M ~ VDD/2 across SS/TT/FF)
X1p clkp s1n vdd vss divab_inv_lvt wn=1.20 wp=4.80 nfn=1 nfp=2
X1n clkn s1p vdd vss divab_inv_lvt wn=1.20 wp=4.80 nfn=1 nfp=2
Xcc1 s1p s1n vdd vss divab_cc_align wn=0.42 wp=1.76
* Stage 2: high-f_T l=0.15 balanced gain stage (wp/wn=4.20 for crisp 50% duty at 2.5 GHz SS -40 C!)
X2p s1n s2p vdd vss divab_inv wn=1.60 wp=6.72 nfn=1 nfp=3
X2n s1p s2n vdd vss divab_inv wn=1.60 wp=6.72 nfn=1 nfp=3
Xcc2 s2p s2n vdd vss divab_cc_align wn=0.45 wp=1.89
* Stage 3A: crisp complementary 2.0/2.5 GHz driver for Johnson /2 (wp/wn=4.20 matching proven 5G qdiv2)
X3p s2p ckn vdd vss divab_inv wn=2.40 wp=10.08 nfn=2 nfp=4
X3n s2n ckp vdd vss divab_inv wn=2.40 wp=10.08 nfn=2 nfp=4
Xcc3 ckp ckn vdd vss divab_cc_align wn=0.50 wp=2.10
* Stage 3B: PVT-tracking retimer clock branch (ck_rt in phase with ckp, +2-inv delay for centered setup/hold)
Xrt1     s2n rt_a     vdd vss divab_inv wn=1.20 wp=5.04 nfn=1 nfp=2
Xrt1_dum s2p rt_a_dum vdd vss divab_inv wn=1.20 wp=5.04 nfn=1 nfp=2
Xrt2     rt_a rt_b    vdd vss divab_inv wn=1.60 wp=6.72 nfn=1 nfp=3
Xrt3     rt_b ck_rt   vdd vss divab_inv wn=2.40 wp=10.08 nfn=2 nfp=4
.ends divab_inbuf

* -----------------------------------------------------------------------------
* High-Speed Zero-Stacked-PMOS Differential Resettable TG Latch
* Transparent when ck=1 (ckb=0); holds when ck=0 (ckb=1).
* Non-inverting: qp = dp_in, qn = dn_in. Reset (rst_n=0, rst=1) -> qp=0, qn=1.
* -----------------------------------------------------------------------------
.subckt divab_diff_latch dp_in dn_in ck ckb rst_n rst qp qn vdd vss
+ params: wn_tg=2.20 wp_tg=5.40 nfn_tg=2 nfp_tg=2 wn_out=2.20 wp_out=9.24 nfn_out=2 nfp_out=4
Xtgp_n dp_in ck  int_p vss serdes_nfet_lvt w={wn_tg} l=0.15 nf={nfn_tg}
Xtgp_p dp_in ckb int_p vdd serdes_pfet     w={wp_tg} l=0.15 nf={nfp_tg}
Xtgn_n dn_in ck  int_n vss serdes_nfet_lvt w={wn_tg} l=0.15 nf={nfn_tg}
Xtgn_p dn_in ckb int_n vdd serdes_pfet     w={wp_tg} l=0.15 nf={nfp_tg}
* Weak cross-coupled keeper (0 Hz static retention, fast TG overwrite at 2.5 GHz SS -40 C)
Xkp1 int_p int_n vdd vdd serdes_pfet w=0.42 l=0.28 nf=1
Xkn1 int_p int_n vss vss serdes_nfet w=0.42 l=0.28 nf=1
Xkp2 int_n int_p vdd vdd serdes_pfet w=0.42 l=0.28 nf=1
Xkn2 int_n int_p vss vss serdes_nfet w=0.42 l=0.28 nf=1
* Asynchronous reset clamps (rst_n=0 -> int_p=0, int_n=1 -> qp=0, qn=1)
Xrp int_p rst   vss vss serdes_nfet w=0.90 l=0.18 nf=1
Xrn int_n rst_n vdd vdd serdes_pfet w=1.60 l=0.18 nf=1
* Output restoring inverters
Xop int_n qp vdd vss divab_inv wn={wn_out} wp={wp_out} nfn={nfn_out} nfp={nfp_out}
Xon int_p qn vdd vss divab_inv wn={wn_out} wp={wp_out} nfn={nfn_out} nfp={nfp_out}
Xcc qp    qn vdd vss divab_cc_align wn=0.42 wp=1.76
.ends divab_diff_latch

* Rising-Edge-Triggered Differential Master-Slave TG-DFF (for 1.0/1.25 GHz counter)
.subckt divab_ms_dff dp dn ck ckb rst_n rst qp qn vdd vss
+ params: wn_tg=1.20 wp_tg=3.00 wn_m=1.20 wp_m=5.04 wn_s=1.80 wp_s=7.56
Xm dp dn ckb ck rst_n rst mp mn vdd vss divab_diff_latch
+ wn_tg={wn_tg} wp_tg={wp_tg} nfn_tg=1 nfp_tg=2 wn_out={wn_m} wp_out={wp_m} nfn_out=1 nfp_out=2
Xs mp mn ck ckb rst_n rst qp qn vdd vss divab_diff_latch
+ wn_tg={wn_tg} wp_tg={wp_tg} nfn_tg=1 nfp_tg=2 wn_out={wn_s} wp_out={wp_s} nfn_out=1 nfp_out=3
.ends divab_ms_dff

* -----------------------------------------------------------------------------
* Equalized Nikolic SAFF-TSPC DFF (2.0 / 2.5 GHz, rising-edge triggered, zero race-through)
* Optional rst_n/rst initializes slave cleanly to qp=0, qn=1 when rst_n=0.
* -----------------------------------------------------------------------------
.subckt divab_saff_dff dp dn ck rst_n rst qp qn vdd vss
+ params: wt=5.8 nft=2 wd=3.6 nfd=2 wl=3.0 nfl=2 wlp=1.6 nflp=1 wpre=3.2 wmid=1.4 weq=2.2
+         wop=4.2 nfop=2 wdn=3.6 nfdn=2 winv_n=0.65 winv_p=2.60 wkp=0.65 wkn=0.55 seed_k=0.0
* Stage 1: Differential Sense-Amplifier (active when ck=1)
Xtail tail ck   vss  vss serdes_nfet_lvt w={wt}  l=0.15 nf={nft}
Xdp   n_sp dp   tail vss serdes_nfet_lvt w={wd}  l=0.15 nf={nfd}
Xdn   n_sn dn   tail vss serdes_nfet_lvt w={wd}  l=0.15 nf={nfd}
Xlnp  sp   sn   n_sp vss serdes_nfet_lvt w={wl}  l=0.15 nf={nfl}
Xlnn  sn   sp   n_sn vss serdes_nfet_lvt w={wl}  l=0.15 nf={nfl}
Xlpp  sp   sn   vdd  vdd serdes_pfet     w={wlp} l=0.15 nf={nflp}
Xlpn  sn   sp   vdd  vdd serdes_pfet     w={wlp} l=0.15 nf={nflp}
* Precharge + equalization when ck=0 (200 ps window at 2.5 GHz)
Xprep sp   ck   vdd  vdd serdes_pfet     w={wpre} l=0.15 nf=2
Xpren sn   ck   vdd  vdd serdes_pfet     w={wpre} l=0.15 nf=2
Xeq   sp   ck   sn   vdd serdes_pfet     w={weq}  l=0.15 nf=1
Xpmp  n_sp ck   vdd  vdd serdes_pfet     w={wmid} l=0.15 nf=1
Xpmn  n_sn ck   vdd  vdd serdes_pfet     w={wmid} l=0.15 nf=1
* Fast HI-skewed local inverters generating active-HIGH pulldown pulses (sb=~sp, rb=~sn)
Xinvs sp   sb   vdd  vss divab_inv       wn={winv_n} wp={winv_p} nfn=1 nfp=1
Xinvr sn   rb   vdd  vss divab_inv       wn={winv_n} wp={winv_p} nfn=1 nfp=1
* Stage 2: Symmetric Direct-Push-Pull Static Slave Latch
Xpp_s qp   sp   vdd  vdd serdes_pfet     w={wop} l=0.15 nf={nfop}
Xdp_d qp   rb   vss  vss serdes_nfet_lvt w={wdn} l=0.15 nf={nfdn}
Xpn_s qn   sn   vdd  vdd serdes_pfet     w={wop} l=0.15 nf={nfop}
Xdn_d qn   sb   vss  vss serdes_nfet_lvt w={wdn} l=0.15 nf={nfdn}
* Static cross-coupled keeper
Xkp_p qp   qn   vdd  vdd serdes_pfet     w={wkp+seed_k} l=0.15 nf=1
Xkp_n qp   qn   vss  vss serdes_nfet     w={wkn}        l=0.15 nf=1
Xkn_p qn   qp   vdd  vdd serdes_pfet     w={wkp}        l=0.15 nf=1
Xkn_n qn   qp   vss  vss serdes_nfet     w={wkn+seed_k} l=0.15 nf=1
* Reset clamps (rst_n=0 -> qp=0, qn=1)
Xrstp qp   rst   vss vss serdes_nfet     w=1.20 l=0.18 nf=1
Xrstn qn   rst_n vdd vdd serdes_pfet     w=2.40 l=0.18 nf=1
.ends divab_saff_dff

* =============================================================================
* Top-Level Dual-Rate 4G/5G Feedback Divider A (/8 at 2.0 GHz, /10 at 2.5 GHz)
* =============================================================================
.subckt pll_div_ab_5g clkp clkn mode_5g rst_n fb250 fb250_b vdd vss
* Static control inversions
Xrst  rst_n   rst       vdd vss divab_inv_static wn=0.60 wp=1.20
Xmode mode_5g mode_5g_b vdd vss divab_inv_static wn=0.60 wp=1.20

* Stage 1: Fast differential-to-CMOS input receiver & clock buffer
Xin clkp clkn ckp ckn ck_rt vdd vss divab_inbuf

* Stage 2: High-speed rising-edge SAFF-TSPC Toggle /2 (2.0->1.0 GHz, 2.5->1.25 GHz)
* True edge-triggered sense-amp topology: zero transparency overlap, zero race-through across PVT!
Xdiv2 h0n h0p ckp rst_n rst h0p h0n vdd vss divab_saff_dff
+ wt=5.8 nft=2 wd=3.6 nfd=2 wl=3.0 nfl=2 wlp=1.6 wpre=3.2 wmid=1.4 weq=2.2
+ wop=4.2 nfop=2 wdn=3.6 nfdn=2 winv_n=0.65 winv_p=2.60 wkp=0.65 wkn=0.55 seed_k=0.35

* Balanced 1.0/1.25 GHz complementary clock buffers on (h0p, h0n)
Xckhp   h0n ckh_p vdd vss divab_inv wn=2.40 wp=10.08 nfn=2 nfp=4
Xckhn   h0p ckh_n vdd vss divab_inv wn=2.40 wp=10.08 nfn=2 nfp=4
Xcc_ckh ckh_p ckh_n vdd vss divab_cc_align wn=0.50 wp=2.10

* Stage 3: Switchable 3-FF Synchronous /4 (mode_5g=0) or /5 (mode_5g=1) Counter at 1.0/1.25 GHz
* d0p = ~(q1p | (q2p & mode_5g)),  d0n = ~(q1n & (q2n | mode_5g_b))
Xfb_p q1p q2p mode_5g   d0p vdd vss divab_aoi21 wn=1.20 wp=4.80 nfn=1 nfp=2
Xfb_n q1n q2n mode_5g_b d0n vdd vss divab_oai21 wn=1.20 wp=4.80 nfn=1 nfp=2

Xff0 d0p d0n ckh_p ckh_n rst_n rst q0p q0n vdd vss divab_ms_dff wn_tg=1.60 wp_tg=4.00 wn_m=1.40 wp_m=5.60 wn_s=2.40 wp_s=9.60
Xff1 q0p q0n ckh_p ckh_n rst_n rst q1p q1n vdd vss divab_ms_dff wn_tg=1.20 wp_tg=3.00 wn_m=1.20 wp_m=5.04 wn_s=1.60 wp_s=6.72
Xff2 q1p q1n ckh_p ckh_n rst_n rst q2p q2n vdd vss divab_ms_dff wn_tg=1.20 wp_tg=3.00 wn_m=1.20 wp_m=5.04 wn_s=1.60 wp_s=6.72

* Stage 4: Glitch-free dual-edge 50% duty shaper
* Half-cycle latch (transparent when ckh_n=1 / ckh_p=0) delays q0 by 0.5 T_half = 1.0 T_fast
Xdly q0p q0n ckh_n ckh_p rst_n rst q0dp q0dn vdd vss divab_diff_latch
+ wn_tg=1.80 wp_tg=4.40 nfn_tg=1 nfp_tg=2 wn_out=2.40 wp_out=9.60 nfn_out=2 nfp_out=4
* qsh_n = ~(q0p | (q0dp & mode_5g)),  qsh_p = ~(q0n & (q0dn | mode_5g_b))
Xsh_n q0p q0dp mode_5g   qsh_n vdd vss divab_aoi21 wn=2.00 wp=8.00 nfn=2 nfp=4
Xsh_p q0n q0dn mode_5g_b qsh_p vdd vss divab_oai21 wn=2.00 wp=8.00 nfn=2 nfp=4

* Stage 5: Clean full-rate (2.0/2.5 GHz) SAFF-TSPC final retimer -> exact 50.0% duty & low jitter
Xretime qsh_p qsh_n ck_rt rst_n rst rp rn vdd vss divab_saff_dff
+ wt=4.8 nft=2 wd=3.0 nfd=2 wl=2.6 nfl=2 wlp=1.6 wpre=3.2 wmid=1.4 weq=2.2
+ wop=3.2 nfop=2 wdn=2.8 nfdn=2 winv_n=0.70 winv_p=2.80 wkp=0.65 wkn=0.55 seed_k=0.0

* Stage 6: Matched deskewed 250 MHz output buffer driving 15 fF PFD load
Xout_p rn fb250   vdd vss divab_inv wn=2.40 wp=10.08 nfn=2 nfp=4
Xout_n rp fb250_b vdd vss divab_inv wn=2.40 wp=10.08 nfn=2 nfp=4
Xcc_out fb250 fb250_b vdd vss divab_cc_align wn=0.50 wp=2.10
.ends pll_div_ab_5g
