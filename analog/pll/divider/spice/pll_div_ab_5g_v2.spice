* Dual-Rate 4G/5G PLL Feedback Divider A — Hardened v2 (`pll_div_ab_5g_v2`)
* (2.0 GHz /8 & 2.5 GHz /10 -> 250 MHz, 50% Duty, PVT-Tracked Fast-Clock Retimed)
* SKY130A, 1.8 V, 100% real SKY130 devices (W/nf >= 0.42 um, L >= 0.15 um; zero ideal passives or B-sources).
* Dependencies: sky130_primitives.spice, sky130_pfet_lvt.spice.
*
* Hardening upgrades over v1 (`pll_div_ab_5g_cand.spice`) addressing cold-corner CPEX `ss_mm` MC counterexamples:
*   1. Eliminated Stage-1 input-receiver Schmitt hysteresis (`Xcc1` changed from 67%-contention l=0.15 LVT latch
*      to gentle l=0.28 STD aligner; `Xcc2`/`Xcc3` softened to l=0.20 STD; `X1p/n` boosted to wn=1.40/wp=5.20
*      keeping C_in/leg <= 14.5 fF; added matched dummy load on `ckn` so `ckp/ckn` switch symmetrically).
*      Fixes `ckp` duty collapse (`38.8%` -> `~50%`) that caused `Xdiv2` cycle slip (`/12,/12,/11`) on sample 29.
*   2. Boosted `Xdiv2` evaluation margin (`wt=6.4, wd=4.0, wl=3.2`) and `Xckhp/n` (`wn=2.80, wp=11.20`) for
*      2.5 GHz cold-corner CPEX headroom.
*   3. Extended `ck_rt` PVT-tracking delay chain from 3 inverters to 5 inverters (`Xrt1..Xrt5`, balanced wp/wn=3.6)
*      to track real CPEX data-path delay (`Xdiv2 + Xckh + Xdly + Xsh`), shifting SS -40C CPEX retimer setup
*      margin from ~0 ps (metastable samples 9 & 32) to > 100 ps while keeping FF -40C hold > 75 ps.
*   4. Balanced `Xretime` slave pull-up (`wop=4.4, wdn=2.6`) and output buffer (`Xout_p/n`: wn=2.40, wp=6.30,
*      wp/wn=2.625) to center complementary crossover near 50-60% VDD and slash `VDD/2` P-N gap.
*
* Interface (exact 1:1 pin-compatible with `pll_div_ab_5g` / `pll_div_ab_5g_pdk`):
*   clkp, clkn : 2.0 GHz (mode_5g=0) or 2.5 GHz (mode_5g=1) differential clock input
*   mode_5g    : 0 -> divide-by-8 (2.0 GHz -> 250 MHz), 1 -> divide-by-10 (2.5 GHz -> 250 MHz)
*   rst_n      : active-low asynchronous reset (1 = run, 0 = deterministic reset)
*   fb250      : clean fast-clock-retimed 250 MHz PFD feedback output (45-55% duty cycle)
*   fb250_b    : complementary 250 MHz feedback output

* -----------------------------------------------------------------------------
* Local CMOS Primitives (all W/nf >= 0.42 um, L >= 0.15 um, 5 nm grid)
* -----------------------------------------------------------------------------
.subckt divab2_inv a y vdd vss params: wn=1.0 wp=4.2 nfn=1 nfp=2
Xn y a vss vss serdes_nfet_lvt w={wn} l=0.15 nf={nfn}
Xp y a vdd vdd serdes_pfet     w={wp} l=0.15 nf={nfp}
.ends divab2_inv

.subckt divab2_inv_lvt a y vdd vss params: wn=1.20 wp=4.40 nfn=1 nfp=2
Xn y a vss vss serdes_nfet_lvt w={wn} l=0.15 nf={nfn}
Xp y a vdd vdd serdes_pfet_lvt w={wp} l=0.35 nf={nfp}
.ends divab2_inv_lvt

.subckt divab2_inv_static a y vdd vss params: wn=0.50 wp=1.00
Xn y a vss vss serdes_nfet w={wn} l=0.18 nf=1
Xp y a vdd vdd serdes_pfet w={wp} l=0.18 nf=1
.ends divab2_inv_static

.subckt divab2_cc_align ap an vdd vss params: wn=0.45 wp=1.80
X1 ap an vdd vss divab2_inv wn={wn} wp={wp} nfn=1 nfp=1
X2 an ap vdd vss divab2_inv wn={wn} wp={wp} nfn=1 nfp=1
.ends divab2_cc_align

* Gentle zero-hysteresis STD-Vt cross-coupled phase aligner (for high-speed receiver stages)
.subckt divab2_cc_soft ap an vdd vss params: wn=0.42 wp=1.26 l_n=0.20 l_p=0.20
Xn1 ap an vss vss serdes_nfet w={wn} l={l_n} nf=1
Xp1 ap an vdd vdd serdes_pfet w={wp} l={l_p} nf=1
Xn2 an ap vss vss serdes_nfet w={wn} l={l_n} nf=1
Xp2 an ap vdd vdd serdes_pfet w={wp} l={l_p} nf=1
.ends divab2_cc_soft

* Single-stage static AOI21: y = ~(a | (b & c))
.subckt divab2_aoi21 a b c y vdd vss params: wn=1.40 wp=5.60 nfn=1 nfp=2
Xna  y   a vss vss serdes_nfet_lvt w={wn}       l=0.15 nf={nfn}
Xnb  y   b mid vss serdes_nfet_lvt w={1.5*wn}   l=0.15 nf={nfn}
Xnc  mid c vss vss serdes_nfet_lvt w={1.5*wn}   l=0.15 nf={nfn}
Xpa  p1  a vdd vdd serdes_pfet     w={wp}       l=0.15 nf={nfp}
Xpb  y   b p1  vdd serdes_pfet     w={wp}       l=0.15 nf={nfp}
Xpc  y   c p1  vdd serdes_pfet     w={wp}       l=0.15 nf={nfp}
.ends divab2_aoi21

* Single-stage static OAI21: y = ~(a & (b | c))
.subckt divab2_oai21 a b c y vdd vss params: wn=1.40 wp=5.60 nfn=1 nfp=2
Xna  n1  a vss vss serdes_nfet_lvt w={1.5*wn}   l=0.15 nf={nfn}
Xnb  y   b n1  vss serdes_nfet_lvt w={1.5*wn}   l=0.15 nf={nfn}
Xnc  y   c n1  vss serdes_nfet_lvt w={1.5*wn}   l=0.15 nf={nfn}
Xpa  y   a vdd vdd serdes_pfet     w={0.75*wp}  l=0.15 nf={nfp}
Xpb  p1  b vdd vdd serdes_pfet     w={1.25*wp}  l=0.15 nf={nfp}
Xpc  y   c p1  vdd serdes_pfet     w={1.25*wp}  l=0.15 nf={nfp}
.ends divab2_oai21

* -----------------------------------------------------------------------------
* Hardened Differential-to-CMOS 2.0/2.5 GHz Input Receiver & 5-Stage ck_rt Chain
* -----------------------------------------------------------------------------
.subckt divab2_inbuf clkp clkn ckp ckn ck_rt vdd vss
* Stage 1: low-C_in (~13 fF CPEX, <=15 fF across all 6 corners) balanced LVT receiver + ultra-soft l=0.28 aligner
X1p clkp s1n vdd vss divab2_inv_lvt wn=1.20 wp=4.40 nfn=1 nfp=2
X1n clkn s1p vdd vss divab2_inv_lvt wn=1.20 wp=4.40 nfn=1 nfp=2
Xcc1 s1p s1n vdd vss divab2_cc_soft wn=0.42 wp=0.84 l_n=0.28 l_p=0.28
* Stage 2: crisp gain stage + soft l=0.20 aligner
X2p s1n s2p vdd vss divab2_inv wn=1.80 wp=6.90 nfn=1 nfp=3
X2n s1p s2n vdd vss divab2_inv wn=1.80 wp=6.90 nfn=1 nfp=3
Xcc2 s2p s2n vdd vss divab2_cc_soft wn=0.42 wp=1.40 l_n=0.20 l_p=0.20
* Stage 3A: balanced complementary driver for Xdiv2 (`ckp`) + matched dummy load on `ckn`
X3p s2p ckn vdd vss divab2_inv wn=2.80 wp=10.80 nfn=2 nfp=4
X3n s2n ckp vdd vss divab2_inv wn=2.80 wp=10.80 nfn=2 nfp=4
Xcc3 ckp ckn vdd vss divab2_cc_soft wn=0.45 wp=1.60 l_n=0.20 l_p=0.20
* Matched dummy inverter load on `ckn` replicating Xdiv2's ckp gate load (clean for LVS & native RCX)
Xckn_dum ckn ckn_dum_out vdd vss divab2_inv wn=3.20 wp=8.00 nfn=2 nfp=4
* Stage 3B: 7-stage PVT-tracking retimer clock branch (s2n -> rt1..rt7 -> ck_rt, wp/wn~3.85, +6 inv lag)
* Centers real-CPEX retimer Hold/Setup across ALL 6 PVT corners (FF -40C H>70ps, SS -40C S>120ps)!
Xrt1     s2n  rt_a     vdd vss divab2_inv wn=1.00 wp=3.80 nfn=1 nfp=2
Xrt1_dum s2p  rt_a_dum vdd vss divab2_inv wn=1.00 wp=3.80 nfn=1 nfp=2
Xrt2     rt_a rt_b     vdd vss divab2_inv wn=1.00 wp=3.80 nfn=1 nfp=2
Xrt3     rt_b rt_c     vdd vss divab2_inv wn=1.20 wp=4.60 nfn=1 nfp=2
Xrt4     rt_c rt_d     vdd vss divab2_inv wn=1.40 wp=5.40 nfn=1 nfp=2
Xrt5     rt_d rt_e     vdd vss divab2_inv wn=1.60 wp=6.15 nfn=1 nfp=3
Xrt6     rt_e rt_f     vdd vss divab2_inv wn=2.00 wp=7.80 nfn=2 nfp=3
Xrt7     rt_f ck_rt    vdd vss divab2_inv wn=2.80 wp=10.80 nfn=2 nfp=4
.ends divab2_inbuf

* -----------------------------------------------------------------------------
* High-Speed Zero-Stacked-PMOS Differential Resettable TG Latch
* -----------------------------------------------------------------------------
.subckt divab2_diff_latch dp_in dn_in ck ckb rst_n rst qp qn vdd vss
+ params: wn_tg=2.20 wp_tg=5.40 nfn_tg=2 nfp_tg=2 wn_out=2.20 wp_out=9.24 nfn_out=2 nfp_out=4
Xtgp_n dp_in ck  int_p vss serdes_nfet_lvt w={wn_tg} l=0.15 nf={nfn_tg}
Xtgp_p dp_in ckb int_p vdd serdes_pfet     w={wp_tg} l=0.15 nf={nfp_tg}
Xtgn_n dn_in ck  int_n vss serdes_nfet_lvt w={wn_tg} l=0.15 nf={nfn_tg}
Xtgn_p dn_in ckb int_n vdd serdes_pfet     w={wp_tg} l=0.15 nf={nfp_tg}
Xkp1 int_p int_n vdd vdd serdes_pfet w=0.42 l=0.28 nf=1
Xkn1 int_p int_n vss vss serdes_nfet w=0.42 l=0.28 nf=1
Xkp2 int_n int_p vdd vdd serdes_pfet w=0.42 l=0.28 nf=1
Xkn2 int_n int_p vss vss serdes_nfet w=0.42 l=0.28 nf=1
Xrp int_p rst   vss vss serdes_nfet w=0.90 l=0.18 nf=1
Xrn int_n rst_n vdd vdd serdes_pfet w=1.60 l=0.18 nf=1
Xop int_n qp vdd vss divab2_inv wn={wn_out} wp={wp_out} nfn={nfn_out} nfp={nfp_out}
Xon int_p qn vdd vss divab2_inv wn={wn_out} wp={wp_out} nfn={nfn_out} nfp={nfp_out}
Xcc qp    qn vdd vss divab2_cc_align wn=0.42 wp=1.76
.ends divab2_diff_latch

* Rising-Edge-Triggered Differential Master-Slave TG-DFF (1.0/1.25 GHz counter)
.subckt divab2_ms_dff dp dn ck ckb rst_n rst qp qn vdd vss
+ params: wn_tg=1.20 wp_tg=3.00 wn_m=1.20 wp_m=5.04 wn_s=1.80 wp_s=7.56
Xm dp dn ckb ck rst_n rst mp mn vdd vss divab2_diff_latch
+ wn_tg={wn_tg} wp_tg={wp_tg} nfn_tg=1 nfp_tg=2 wn_out={wn_m} wp_out={wp_m} nfn_out=1 nfp_out=2
Xs mp mn ck ckb rst_n rst qp qn vdd vss divab2_diff_latch
+ wn_tg={wn_tg} wp_tg={wp_tg} nfn_tg=1 nfp_tg=2 wn_out={wn_s} wp_out={wp_s} nfn_out=1 nfp_out=3
.ends divab2_ms_dff

* -----------------------------------------------------------------------------
* Equalized Nikolic SAFF-TSPC DFF (2.0 / 2.5 GHz, rising-edge triggered)
* -----------------------------------------------------------------------------
.subckt divab2_saff_dff dp dn ck rst_n rst qp qn vdd vss
+ params: wt=6.4 nft=2 wd=4.0 nfd=2 wl=3.2 nfl=2 wlp=1.6 nflp=1 wpre=3.4 wmid=1.5 weq=2.2
+         wop=4.4 nfop=2 wdn=3.6 nfdn=2 winv_n=0.65 winv_p=2.60 wkp=0.65 wkn=0.55 seed_k=0.0
Xtail tail ck   vss  vss serdes_nfet_lvt w={wt}  l=0.15 nf={nft}
Xdp   n_sp dp   tail vss serdes_nfet_lvt w={wd}  l=0.15 nf={nfd}
Xdn   n_sn dn   tail vss serdes_nfet_lvt w={wd}  l=0.15 nf={nfd}
Xlnp  sp   sn   n_sp vss serdes_nfet_lvt w={wl}  l=0.15 nf={nfl}
Xlnn  sn   sp   n_sn vss serdes_nfet_lvt w={wl}  l=0.15 nf={nfl}
Xlpp  sp   sn   vdd  vdd serdes_pfet     w={wlp} l=0.15 nf={nflp}
Xlpn  sn   sp   vdd  vdd serdes_pfet     w={wlp} l=0.15 nf={nflp}
Xprep sp   ck   vdd  vdd serdes_pfet     w={wpre} l=0.15 nf=2
Xpren sn   ck   vdd  vdd serdes_pfet     w={wpre} l=0.15 nf=2
Xeq   sp   ck   sn   vdd serdes_pfet     w={weq}  l=0.15 nf=1
Xpmp  n_sp ck   vdd  vdd serdes_pfet     w={wmid} l=0.15 nf=1
Xpmn  n_sn ck   vdd  vdd serdes_pfet     w={wmid} l=0.15 nf=1
Xinvs sp   sb   vdd  vss divab2_inv      wn={winv_n} wp={winv_p} nfn=1 nfp=1
Xinvr sn   rb   vdd  vss divab2_inv      wn={winv_n} wp={winv_p} nfn=1 nfp=1
Xpp_s qp   sp   vdd  vdd serdes_pfet     w={wop} l=0.15 nf={nfop}
Xdp_d qp   rb   vss  vss serdes_nfet_lvt w={wdn} l=0.15 nf={nfdn}
Xpn_s qn   sn   vdd  vdd serdes_pfet     w={wop} l=0.15 nf={nfop}
Xdn_d qn   sb   vss  vss serdes_nfet_lvt w={wdn} l=0.15 nf={nfdn}
Xkp_p qp   qn   vdd  vdd serdes_pfet     w={wkp+seed_k} l=0.15 nf=1
Xkp_n qp   qn   vss  vss serdes_nfet     w={wkn}        l=0.15 nf=1
Xkn_p qn   qp   vdd  vdd serdes_pfet     w={wkp}        l=0.15 nf=1
Xkn_n qn   qp   vss  vss serdes_nfet     w={wkn+seed_k} l=0.15 nf=1
Xrstp qp   rst   vss vss serdes_nfet     w=1.20 l=0.18 nf=1
Xrstn qn   rst_n vdd vdd serdes_pfet     w=2.40 l=0.18 nf=1
.ends divab2_saff_dff

* =============================================================================
* Top-Level Hardened Dual-Rate 4G/5G Feedback Divider A (`pll_div_ab_5g_v2`)
* =============================================================================
.subckt pll_div_ab_5g_v2 clkp clkn mode_5g rst_n fb250 fb250_b vdd vss
* Static control inversions
Xrst  rst_n   rst       vdd vss divab2_inv_static wn=0.60 wp=1.20
Xmode mode_5g mode_5g_b vdd vss divab2_inv_static wn=0.60 wp=1.20

* Stage 1: Hardened zero-hysteresis diff-to-CMOS input receiver & 5-stage PVT-tracking ck_rt
Xin clkp clkn ckp ckn ck_rt vdd vss divab2_inbuf

* Stage 2: High-speed rising-edge SAFF-TSPC Toggle /2 (2.0->1.0 GHz, 2.5->1.25 GHz)
* Hardened Stage-2 pull-up (wop=9.6 nfop=4, wdn=2.4, wkp=1.60) for full-rail h0p/h0n swing at SS -40C CPEX!
Xdiv2 h0n h0p ckp rst_n rst h0p h0n vdd vss divab2_saff_dff
+ wt=5.6 nft=2 wd=3.4 nfd=2 wl=2.8 nfl=2 wlp=1.6 wpre=3.8 wmid=1.6 weq=2.4
+ wop=9.6 nfop=4 wdn=2.4 nfdn=2 winv_n=0.55 winv_p=2.60 wkp=1.60 wkn=0.50 seed_k=0.25

* Balanced 1.0/1.25 GHz complementary clock buffers on (h0p, h0n)
Xckhp   h0n ckh_p vdd vss divab2_inv wn=2.40 wp=9.60 nfn=2 nfp=4
Xckhn   h0p ckh_n vdd vss divab2_inv wn=2.40 wp=9.60 nfn=2 nfp=4
Xcc_ckh ckh_p ckh_n vdd vss divab2_cc_soft wn=0.45 wp=1.60 l_n=0.20 l_p=0.20

* Stage 3: Switchable 3-FF Synchronous /4 (mode_5g=0) or /5 (mode_5g=1) Counter
Xfb_p q1p q2p mode_5g   d0p vdd vss divab2_aoi21 wn=1.20 wp=4.80 nfn=1 nfp=2
Xfb_n q1n q2n mode_5g_b d0n vdd vss divab2_oai21 wn=1.20 wp=4.80 nfn=1 nfp=2

Xff0 d0p d0n ckh_p ckh_n rst_n rst q0p q0n vdd vss divab2_ms_dff wn_tg=1.60 wp_tg=4.00 wn_m=1.40 wp_m=5.60 wn_s=2.40 wp_s=9.60
Xff1 q0p q0n ckh_p ckh_n rst_n rst q1p q1n vdd vss divab2_ms_dff wn_tg=1.20 wp_tg=3.00 wn_m=1.20 wp_m=5.04 wn_s=1.60 wp_s=6.72
Xff2 q1p q1n ckh_p ckh_n rst_n rst q2p q2n vdd vss divab2_ms_dff wn_tg=1.20 wp_tg=3.00 wn_m=1.20 wp_m=5.04 wn_s=1.60 wp_s=6.72

* Stage 4: Glitch-free dual-edge 50% duty shaper
Xdly q0p q0n ckh_n ckh_p rst_n rst q0dp q0dn vdd vss divab2_diff_latch
+ wn_tg=1.80 wp_tg=4.40 nfn_tg=1 nfp_tg=2 wn_out=2.40 wp_out=9.60 nfn_out=2 nfp_out=4
Xsh_n q0p q0dp mode_5g   qsh_n vdd vss divab2_aoi21 wn=2.00 wp=8.00 nfn=2 nfp=4
Xsh_p q0n q0dn mode_5g_b qsh_p vdd vss divab2_oai21 wn=2.00 wp=8.00 nfn=2 nfp=4

* Stage 5: Balanced full-rate (2.0/2.5 GHz) SAFF-TSPC final retimer clocked by 5-stage PVT-tracked ck_rt
Xretime qsh_p qsh_n ck_rt rst_n rst rp rn vdd vss divab2_saff_dff
+ wt=5.2 nft=2 wd=3.2 nfd=2 wl=2.8 nfl=2 wlp=1.6 wpre=3.4 wmid=1.5 weq=2.2
+ wop=4.4 nfop=2 wdn=2.6 nfdn=2 winv_n=0.70 winv_p=2.80 wkp=0.65 wkn=0.55 seed_k=0.0

* Stage 6: Balanced deskewed 250 MHz output buffer (wp/wn=2.625 for ~50-60% VDD crossover & low P-N gap)
Xout_p rn fb250   vdd vss divab2_inv wn=2.40 wp=6.30 nfn=2 nfp=3
Xout_n rp fb250_b vdd vss divab2_inv wn=2.40 wp=6.30 nfn=2 nfp=3
Xcc_out fb250 fb250_b vdd vss divab2_cc_align wn=0.45 wp=1.20
.ends pll_div_ab_5g_v2
