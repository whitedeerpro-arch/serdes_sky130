* NGSPICE file created from pll_loop_filter_k4_fused_pdk.ext - technology: sky130A

.subckt pll_loop_filter_k4_fused_pdk ctrl z pre_ref pre_en vdd vss
X0 vdd z sky130_fd_pr__cap_mim_m3_2 l=27.22 w=27.22
X1 pre_ref pre_en ctrl vss sky130_fd_pr__nfet_01v8 ad=0.62 pd=4.62 as=0.33 ps=2.33 w=2 l=0.15
X2 vss pre_en a_n2029_n3650# vss sky130_fd_pr__nfet_01v8 ad=0.62 pd=4.62 as=0.33 ps=2.33 w=2 l=0.15
X3 z pre_en pre_ref vss sky130_fd_pr__nfet_01v8 ad=0.33 pd=2.33 as=0.62 ps=4.62 w=2 l=0.15
X4 z vdd sky130_fd_pr__cap_mim_m3_1 l=27.22 w=27.22
X5 z vdd sky130_fd_pr__cap_mim_m3_1 l=27.22 w=27.22
X6 a_n2029_n3650# pre_en vss vss sky130_fd_pr__nfet_01v8 ad=0.33 pd=2.33 as=0.62 ps=4.62 w=2 l=0.15
X7 a_n2029_n3650# pre_en vdd vdd sky130_fd_pr__pfet_01v8 ad=0.33 pd=2.33 as=0.33 ps=2.33 w=2 l=0.15
X8 pre_ref a_n2029_n3650# z vdd sky130_fd_pr__pfet_01v8_lvt ad=0.29 pd=2.29 as=0.29 ps=2.29 w=2 l=0.35
X9 pre_ref pre_en z vss sky130_fd_pr__nfet_01v8 ad=0.62 pd=4.62 as=0.33 ps=2.33 w=2 l=0.15
X10 vdd z sky130_fd_pr__cap_mim_m3_2 l=27.22 w=27.22
X11 vdd pre_en a_n2029_n3650# vdd sky130_fd_pr__pfet_01v8 ad=0.33 pd=2.33 as=0.33 ps=2.33 w=2 l=0.15
X12 z a_n2029_n3650# pre_ref vdd sky130_fd_pr__pfet_01v8_lvt ad=0.29 pd=2.29 as=0.29 ps=2.29 w=2 l=0.35
X13 vss z sky130_fd_pr__cap_mim_m3_2 l=27.22 w=27.22
X14 z a_n2029_n3650# pre_ref vdd sky130_fd_pr__pfet_01v8_lvt ad=0.29 pd=2.29 as=0.58 ps=4.58 w=2 l=0.35
X15 z vdd sky130_fd_pr__cap_mim_m3_1 l=27.22 w=27.22
X16 pre_ref a_n2029_n3650# ctrl vdd sky130_fd_pr__pfet_01v8_lvt ad=0.58 pd=4.58 as=0.29 ps=2.29 w=2 l=0.35
X17 z a_n2029_n3650# pre_ref vdd sky130_fd_pr__pfet_01v8_lvt ad=0.29 pd=2.29 as=0.29 ps=2.29 w=2 l=0.35
X18 z ctrl vss sky130_fd_pr__res_high_po_0p69 l=7.59
X19 z vss sky130_fd_pr__cap_mim_m3_1 l=27.22 w=27.22
X20 pre_ref a_n2029_n3650# z vdd sky130_fd_pr__pfet_01v8_lvt ad=0.29 pd=2.29 as=0.29 ps=2.29 w=2 l=0.35
X21 a_n2029_n3650# pre_en vdd vdd sky130_fd_pr__pfet_01v8 ad=0.33 pd=2.33 as=0.62 ps=4.62 w=2 l=0.15
X22 pre_ref a_n2029_n3650# ctrl vdd sky130_fd_pr__pfet_01v8_lvt ad=0.29 pd=2.29 as=0.29 ps=2.29 w=2 l=0.35
X23 z pre_en pre_ref vss sky130_fd_pr__nfet_01v8 ad=0.33 pd=2.33 as=0.33 ps=2.33 w=2 l=0.15
X24 ctrl a_n2029_n3650# pre_ref vdd sky130_fd_pr__pfet_01v8_lvt ad=0.29 pd=2.29 as=0.29 ps=2.29 w=2 l=0.35
X25 pre_ref a_n2029_n3650# z vdd sky130_fd_pr__pfet_01v8_lvt ad=0.29 pd=2.29 as=0.29 ps=2.29 w=2 l=0.35
X26 vss z sky130_fd_pr__cap_mim_m3_2 l=27.22 w=27.22
X27 pre_ref pre_en z vss sky130_fd_pr__nfet_01v8 ad=0.33 pd=2.33 as=0.33 ps=2.33 w=2 l=0.15
X28 z a_n2029_n3650# pre_ref vdd sky130_fd_pr__pfet_01v8_lvt ad=0.29 pd=2.29 as=0.29 ps=2.29 w=2 l=0.35
X29 vdd z sky130_fd_pr__cap_mim_m3_2 l=27.22 w=27.22
X30 z vss sky130_fd_pr__cap_mim_m3_1 l=27.22 w=27.22
X31 ctrl a_n2029_n3650# pre_ref vdd sky130_fd_pr__pfet_01v8_lvt ad=0.29 pd=2.29 as=0.58 ps=4.58 w=2 l=0.35
X32 z vdd sky130_fd_pr__cap_mim_m3_1 l=27.22 w=27.22
X33 vdd pre_en a_n2029_n3650# vdd sky130_fd_pr__pfet_01v8 ad=0.62 pd=4.62 as=0.33 ps=2.33 w=2 l=0.15
X34 ctrl pre_en pre_ref vss sky130_fd_pr__nfet_01v8 ad=0.33 pd=2.33 as=0.62 ps=4.62 w=2 l=0.15
X35 vdd z sky130_fd_pr__cap_mim_m3_2 l=27.22 w=27.22
X36 pre_ref a_n2029_n3650# z vdd sky130_fd_pr__pfet_01v8_lvt ad=0.58 pd=4.58 as=0.29 ps=2.29 w=2 l=0.35
.ends
