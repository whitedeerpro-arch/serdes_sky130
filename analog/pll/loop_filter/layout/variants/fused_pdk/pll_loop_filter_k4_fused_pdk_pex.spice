* NGSPICE file created from pll_loop_filter_k4_fused_pdk.ext - technology: sky130A

.subckt pll_loop_filter_k4_fused_pdk ctrl z pre_ref pre_en vdd vss
X0 pre_ref a_n987_323# z vdd sky130_fd_pr__pfet_01v8_lvt ad=0.29 pd=2.29 as=0.29 ps=2.29 w=2 l=0.35
X1 a_n987_323# pre_en vss vss sky130_fd_pr__nfet_01v8 ad=0.33 pd=2.33 as=0.62 ps=4.62 w=2 l=0.15
X2 vdd z sky130_fd_pr__cap_mim_m3_2 l=27.22 w=27.22
X3 ctrl a_n987_323# pre_ref vdd sky130_fd_pr__pfet_01v8_lvt ad=0.29 pd=2.29 as=0.29 ps=2.29 w=2 l=0.35
X4 z vdd sky130_fd_pr__cap_mim_m3_1 l=27.22 w=27.22
X5 pre_ref pre_en ctrl vss sky130_fd_pr__nfet_01v8 ad=0.62 pd=4.62 as=0.33 ps=2.33 w=2 l=0.15
X6 z vdd sky130_fd_pr__cap_mim_m3_1 l=27.22 w=27.22
X7 vss pre_en a_n987_323# vss sky130_fd_pr__nfet_01v8 ad=0.62 pd=4.62 as=0.33 ps=2.33 w=2 l=0.15
X8 z pre_en pre_ref vss sky130_fd_pr__nfet_01v8 ad=0.33 pd=2.33 as=0.62 ps=4.62 w=2 l=0.15
X9 z ctrl vss sky130_fd_pr__res_high_po_0p69 l=7.59
X10 ctrl a_n987_323# pre_ref vdd sky130_fd_pr__pfet_01v8_lvt ad=0.29 pd=2.29 as=0.58 ps=4.58 w=2 l=0.35
X11 vdd z sky130_fd_pr__cap_mim_m3_2 l=27.22 w=27.22
X12 a_n987_323# pre_en vdd vdd sky130_fd_pr__pfet_01v8 ad=0.33 pd=2.33 as=0.33 ps=2.33 w=2 l=0.15
X13 pre_ref a_n987_323# z vdd sky130_fd_pr__pfet_01v8_lvt ad=0.29 pd=2.29 as=0.29 ps=2.29 w=2 l=0.35
X14 vss z sky130_fd_pr__cap_mim_m3_2 l=27.22 w=27.22
X15 vdd pre_en a_n987_323# vdd sky130_fd_pr__pfet_01v8 ad=0.62 pd=4.62 as=0.33 ps=2.33 w=2 l=0.15
X16 z vdd sky130_fd_pr__cap_mim_m3_1 l=27.22 w=27.22
X17 z pre_en pre_ref vss sky130_fd_pr__nfet_01v8 ad=0.33 pd=2.33 as=0.33 ps=2.33 w=2 l=0.15
X18 z a_n987_323# pre_ref vdd sky130_fd_pr__pfet_01v8_lvt ad=0.29 pd=2.29 as=0.29 ps=2.29 w=2 l=0.35
X19 pre_ref a_n987_323# z vdd sky130_fd_pr__pfet_01v8_lvt ad=0.58 pd=4.58 as=0.29 ps=2.29 w=2 l=0.35
X20 z vss sky130_fd_pr__cap_mim_m3_1 l=27.22 w=27.22
X21 pre_ref a_n987_323# ctrl vdd sky130_fd_pr__pfet_01v8_lvt ad=0.58 pd=4.58 as=0.29 ps=2.29 w=2 l=0.35
X22 z a_n987_323# pre_ref vdd sky130_fd_pr__pfet_01v8_lvt ad=0.29 pd=2.29 as=0.29 ps=2.29 w=2 l=0.35
X23 pre_ref pre_en z vss sky130_fd_pr__nfet_01v8 ad=0.33 pd=2.33 as=0.33 ps=2.33 w=2 l=0.15
X24 pre_ref a_n987_323# ctrl vdd sky130_fd_pr__pfet_01v8_lvt ad=0.29 pd=2.29 as=0.29 ps=2.29 w=2 l=0.35
X25 vdd pre_en a_n987_323# vdd sky130_fd_pr__pfet_01v8 ad=0.33 pd=2.33 as=0.33 ps=2.33 w=2 l=0.15
X26 vss z sky130_fd_pr__cap_mim_m3_2 l=27.22 w=27.22
X27 z a_n987_323# pre_ref vdd sky130_fd_pr__pfet_01v8_lvt ad=0.29 pd=2.29 as=0.58 ps=4.58 w=2 l=0.35
X28 vdd z sky130_fd_pr__cap_mim_m3_2 l=27.22 w=27.22
X29 z vss sky130_fd_pr__cap_mim_m3_1 l=27.22 w=27.22
X30 pre_ref a_n987_323# z vdd sky130_fd_pr__pfet_01v8_lvt ad=0.29 pd=2.29 as=0.29 ps=2.29 w=2 l=0.35
X31 z vdd sky130_fd_pr__cap_mim_m3_1 l=27.22 w=27.22
X32 ctrl pre_en pre_ref vss sky130_fd_pr__nfet_01v8 ad=0.33 pd=2.33 as=0.62 ps=4.62 w=2 l=0.15
X33 a_n987_323# pre_en vdd vdd sky130_fd_pr__pfet_01v8 ad=0.33 pd=2.33 as=0.62 ps=4.62 w=2 l=0.15
X34 z a_n987_323# pre_ref vdd sky130_fd_pr__pfet_01v8_lvt ad=0.29 pd=2.29 as=0.29 ps=2.29 w=2 l=0.35
X35 pre_ref pre_en z vss sky130_fd_pr__nfet_01v8 ad=0.62 pd=4.62 as=0.33 ps=2.33 w=2 l=0.15
X36 vdd z sky130_fd_pr__cap_mim_m3_2 l=27.22 w=27.22
C0 ctrl pre_en 0.34571f
C1 z pre_en 0.66649f
C2 vdd pre_ref 2.52938f
C3 vdd ctrl 0.42566f
C4 vdd z 0.5051p
C5 a_n987_323# pre_ref 2.30134f
C6 a_n987_323# ctrl 0.66972f
C7 a_n987_323# z 1.26055f
C8 vdd pre_en 2.2577f
C9 a_n987_323# pre_en 1.15951f
C10 vdd a_n987_323# 3.17136f
C11 ctrl pre_ref 1.38142f
C12 z pre_ref 2.92267f
C13 z ctrl 0.18498f
C14 pre_en pre_ref 1.97254f
C15 pre_en vss 7.47689f
C16 pre_ref vss 10.5395f
C17 ctrl vss 8.91276f
C18 z vss 0.29051p
C19 vdd vss 89.31261f
C20 a_n987_323# vss 3.18873f
.ends
