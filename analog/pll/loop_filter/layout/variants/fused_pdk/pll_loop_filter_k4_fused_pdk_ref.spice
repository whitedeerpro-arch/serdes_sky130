* Physical LVS reference for pll_loop_filter_k4_fused (Vlink cp_in ctrl 0 merged into ctrl)
.subckt pll_loop_filter_k4_fused_pdk ctrl z pre_ref pre_en vdd vss
Xrz ctrl z vss sky130_fd_pr__res_high_po_0p69 l=7.594
Xcg1_0 z vss sky130_fd_pr__cap_mim_m3_1 w=27.22 l=27.22
Xcg2_0 vss z sky130_fd_pr__cap_mim_m3_2 w=27.22 l=27.22
Xcg1_1 z vss sky130_fd_pr__cap_mim_m3_1 w=27.22 l=27.22
Xcg2_1 vss z sky130_fd_pr__cap_mim_m3_2 w=27.22 l=27.22
Xcv1_0 z vdd sky130_fd_pr__cap_mim_m3_1 w=27.22 l=27.22
Xcv2_0 vdd z sky130_fd_pr__cap_mim_m3_2 w=27.22 l=27.22
Xcv1_1 z vdd sky130_fd_pr__cap_mim_m3_1 w=27.22 l=27.22
Xcv2_1 vdd z sky130_fd_pr__cap_mim_m3_2 w=27.22 l=27.22
Xcv1_2 z vdd sky130_fd_pr__cap_mim_m3_1 w=27.22 l=27.22
Xcv2_2 vdd z sky130_fd_pr__cap_mim_m3_2 w=27.22 l=27.22
Xcv1_3 z vdd sky130_fd_pr__cap_mim_m3_1 w=27.22 l=27.22
Xcv2_3 vdd z sky130_fd_pr__cap_mim_m3_2 w=27.22 l=27.22
Xinv_n pre_b pre_en vss vss sky130_fd_pr__nfet_01v8 w=4 l=0.15
Xinv_p pre_b pre_en vdd vdd sky130_fd_pr__pfet_01v8 w=8 l=0.15
Xfast_n pre_ref pre_en ctrl vss sky130_fd_pr__nfet_01v8 w=4 l=0.15
Xfast_p pre_ref pre_b ctrl vdd sky130_fd_pr__pfet_01v8_lvt w=8 l=0.35
Xint_n pre_ref pre_en z vss sky130_fd_pr__nfet_01v8 w=8 l=0.15
Xint_p pre_ref pre_b z vdd sky130_fd_pr__pfet_01v8_lvt w=16 l=0.35
.ends pll_loop_filter_k4_fused_pdk
