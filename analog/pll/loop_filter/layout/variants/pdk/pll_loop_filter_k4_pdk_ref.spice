* Physical LVS reference for pll_loop_filter_k4 (Vlink cp_in ctrl 0 merged into ctrl)
.subckt pll_loop_filter_k4_pdk ctrl z pre_ref pre_en vdd vss
Xrz ctrl z vss sky130_fd_pr__res_high_po_0p69 l=7.594
Xcg00 z vss sky130_fd_pr__cap_mim_m3_1 w=22.1965 l=22.1965
Xcg01 z vss sky130_fd_pr__cap_mim_m3_1 w=22.1965 l=22.1965
Xcg02 z vss sky130_fd_pr__cap_mim_m3_1 w=22.1965 l=22.1965
Xcg03 z vss sky130_fd_pr__cap_mim_m3_1 w=22.1965 l=22.1965
Xcg04 z vss sky130_fd_pr__cap_mim_m3_1 w=22.1965 l=22.1965
Xcg05 z vss sky130_fd_pr__cap_mim_m3_1 w=22.1965 l=22.1965
Xcv00 z vdd sky130_fd_pr__cap_mim_m3_1 w=22.1965 l=22.1965
Xcv01 z vdd sky130_fd_pr__cap_mim_m3_1 w=22.1965 l=22.1965
Xcv02 z vdd sky130_fd_pr__cap_mim_m3_1 w=22.1965 l=22.1965
Xcv03 z vdd sky130_fd_pr__cap_mim_m3_1 w=22.1965 l=22.1965
Xcv04 z vdd sky130_fd_pr__cap_mim_m3_1 w=22.1965 l=22.1965
Xcv05 z vdd sky130_fd_pr__cap_mim_m3_1 w=22.1965 l=22.1965
Xcv06 z vdd sky130_fd_pr__cap_mim_m3_1 w=22.1965 l=22.1965
Xcv07 z vdd sky130_fd_pr__cap_mim_m3_1 w=22.1965 l=22.1965
Xcv08 z vdd sky130_fd_pr__cap_mim_m3_1 w=22.1965 l=22.1965
Xcv09 z vdd sky130_fd_pr__cap_mim_m3_1 w=22.1965 l=22.1965
Xcv10 z vdd sky130_fd_pr__cap_mim_m3_1 w=22.1965 l=22.1965
Xcv11 z vdd sky130_fd_pr__cap_mim_m3_1 w=22.1965 l=22.1965
Xinv_n pre_b pre_en vss vss sky130_fd_pr__nfet_01v8 w=4 l=0.15
Xinv_p pre_b pre_en vdd vdd sky130_fd_pr__pfet_01v8 w=8 l=0.15
Xfast_n pre_ref pre_en ctrl vss sky130_fd_pr__nfet_01v8 w=4 l=0.15
Xfast_p pre_ref pre_b ctrl vdd sky130_fd_pr__pfet_01v8_lvt w=8 l=0.35
Xint_n pre_ref pre_en z vss sky130_fd_pr__nfet_01v8 w=8 l=0.15
Xint_p pre_ref pre_b z vdd sky130_fd_pr__pfet_01v8_lvt w=16 l=0.35
.ends pll_loop_filter_k4_pdk
