* Candidate physical-device mapping; legacy nominal LF remains unchanged.
* Fixed geometry: 0.69um precision poly and parallel ~1pF MIM units.
* Geometry/model view, not extracted layout; no calibrated pad/wire parasitics.
.subckt pll_loop_filter_pdk_candidate cp_in vctrl vss params: rlength=12.44 cside=22.1965
Vlink cp_in vctrl 0
Xrz vctrl z vss sky130_fd_pr__res_high_po_0p69 l={rlength}
Xcf00 vctrl vss sky130_fd_pr__cap_mim_m3_1 w={cside} l={cside}
Xcf01 vctrl vss sky130_fd_pr__cap_mim_m3_1 w={cside} l={cside}
Xci00 z vss sky130_fd_pr__cap_mim_m3_1 w={cside} l={cside}
Xci01 z vss sky130_fd_pr__cap_mim_m3_1 w={cside} l={cside}
Xci02 z vss sky130_fd_pr__cap_mim_m3_1 w={cside} l={cside}
Xci03 z vss sky130_fd_pr__cap_mim_m3_1 w={cside} l={cside}
Xci04 z vss sky130_fd_pr__cap_mim_m3_1 w={cside} l={cside}
Xci05 z vss sky130_fd_pr__cap_mim_m3_1 w={cside} l={cside}
Xci06 z vss sky130_fd_pr__cap_mim_m3_1 w={cside} l={cside}
Xci07 z vss sky130_fd_pr__cap_mim_m3_1 w={cside} l={cside}
Xci08 z vss sky130_fd_pr__cap_mim_m3_1 w={cside} l={cside}
Xci09 z vss sky130_fd_pr__cap_mim_m3_1 w={cside} l={cside}
Xci10 z vss sky130_fd_pr__cap_mim_m3_1 w={cside} l={cside}
Xci11 z vss sky130_fd_pr__cap_mim_m3_1 w={cside} l={cside}
Xci12 z vss sky130_fd_pr__cap_mim_m3_1 w={cside} l={cside}
Xci13 z vss sky130_fd_pr__cap_mim_m3_1 w={cside} l={cside}
Xci14 z vss sky130_fd_pr__cap_mim_m3_1 w={cside} l={cside}
Xci15 z vss sky130_fd_pr__cap_mim_m3_1 w={cside} l={cside}
Xci16 z vss sky130_fd_pr__cap_mim_m3_1 w={cside} l={cside}
Xci17 z vss sky130_fd_pr__cap_mim_m3_1 w={cside} l={cside}
Xci18 z vss sky130_fd_pr__cap_mim_m3_1 w={cside} l={cside}
Xci19 z vss sky130_fd_pr__cap_mim_m3_1 w={cside} l={cside}
Xci20 z vss sky130_fd_pr__cap_mim_m3_1 w={cside} l={cside}
Xci21 z vss sky130_fd_pr__cap_mim_m3_1 w={cside} l={cside}
Xci22 z vss sky130_fd_pr__cap_mim_m3_1 w={cside} l={cside}
Xci23 z vss sky130_fd_pr__cap_mim_m3_1 w={cside} l={cside}
Xci24 z vss sky130_fd_pr__cap_mim_m3_1 w={cside} l={cside}
Xci25 z vss sky130_fd_pr__cap_mim_m3_1 w={cside} l={cside}
Xci26 z vss sky130_fd_pr__cap_mim_m3_1 w={cside} l={cside}
Xci27 z vss sky130_fd_pr__cap_mim_m3_1 w={cside} l={cside}
Xci28 z vss sky130_fd_pr__cap_mim_m3_1 w={cside} l={cside}
Xci29 z vss sky130_fd_pr__cap_mim_m3_1 w={cside} l={cside}
Xci30 z vss sky130_fd_pr__cap_mim_m3_1 w={cside} l={cside}
Xci31 z vss sky130_fd_pr__cap_mim_m3_1 w={cside} l={cside}
Xci32 z vss sky130_fd_pr__cap_mim_m3_1 w={cside} l={cside}
Xci33 z vss sky130_fd_pr__cap_mim_m3_1 w={cside} l={cside}
Xci34 z vss sky130_fd_pr__cap_mim_m3_1 w={cside} l={cside}
Xci35 z vss sky130_fd_pr__cap_mim_m3_1 w={cside} l={cside}
Xci36 z vss sky130_fd_pr__cap_mim_m3_1 w={cside} l={cside}
Xci37 z vss sky130_fd_pr__cap_mim_m3_1 w={cside} l={cside}
Xci38 z vss sky130_fd_pr__cap_mim_m3_1 w={cside} l={cside}
Xci39 z vss sky130_fd_pr__cap_mim_m3_1 w={cside} l={cside}
.ends pll_loop_filter_pdk_candidate
