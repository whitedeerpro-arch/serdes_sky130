* NGSPICE file created from pll_pfd_sc_dly_pdk.ext - technology: sky130A

.subckt pll_pfd_sc_dly_pdk ref fb rst_b up dn vdd vss
X0 vdd a_3790_591# a_4107_929# vdd sky130_fd_pr__pfet_01v8_hvt ad=0.16655 pd=1.39 as=0.0567 ps=0.69 w=0.42 l=0.15
X1 a_1362_413# a_285_47# a_1200_47# vdd sky130_fd_pr__pfet_01v8_hvt ad=0.0567 pd=0.69 as=0.0588 ps=0.7 w=0.42 l=0.15
X2 vss a_2051_47# up vss sky130_fd_pr__nfet_01v8 ad=0.169 pd=1.82 as=0.08775 ps=0.92 w=0.65 l=0.15
X3 a_1554_47# a_939_21# vss vss sky130_fd_pr__nfet_01v8 ad=0.06405 pd=0.725 as=0.12495 ps=1.015 w=0.42 l=0.15
X4 a_285_47# a_119_47# vdd vdd sky130_fd_pr__pfet_01v8_hvt ad=0.1664 pd=1.8 as=0.0864 ps=0.91 w=0.64 l=0.15
X5 a_1375_21# a_939_21# vdd vdd sky130_fd_pr__pfet_01v8_hvt ad=0.0567 pd=0.69 as=0.0819 ps=0.81 w=0.42 l=0.15
X6 vss fb a_119_597# vss sky130_fd_pr__nfet_01v8 ad=0.0567 pd=0.69 as=0.1092 ps=1.36 w=0.42 l=0.15
X7 a_635_47# a_119_47# a_540_47# vss sky130_fd_pr__special_nfet_01v8 ad=0.0594 pd=0.69 as=0.066 ps=0.745 w=0.36 l=0.15
X8 a_4107_929# rst_b vdd vdd sky130_fd_pr__pfet_01v8_hvt ad=0.0567 pd=0.69 as=0.1176 ps=1.4 w=0.42 l=0.15
X9 vdd a_853_289# a_743_413# vdd sky130_fd_pr__pfet_01v8_hvt ad=0.07035 pd=0.755 as=0.1155 ps=0.97 w=0.42 l=0.15
X10 vdd ref a_119_47# vdd sky130_fd_pr__pfet_01v8_hvt ad=0.0864 pd=0.91 as=0.1664 ps=1.8 w=0.64 l=0.15
X11 vss a_939_21# a_897_957# vss sky130_fd_pr__nfet_01v8 ad=0.1346 pd=1.15 as=0.0441 ps=0.63 w=0.42 l=0.15
X12 a_1200_47# a_285_47# a_853_289# vss sky130_fd_pr__special_nfet_01v8 ad=0.0711 pd=0.755 as=0.0999 ps=0.985 w=0.36 l=0.15
X13 a_2051_47# a_1853_47# vss vss sky130_fd_pr__nfet_01v8 ad=0.08775 pd=0.92 as=0.169 ps=1.82 w=0.65 l=0.15
X14 vdd a_2051_47# up vdd sky130_fd_pr__pfet_01v8_hvt ad=0.135 pd=1.27 as=0.135 ps=1.27 w=1 l=0.15
X15 a_3790_591# a_3611_911# vss vss sky130_fd_pr__nfet_01v8 ad=0.169 pd=1.82 as=0.10025 ps=0.985 w=0.65 l=0.15
X16 a_540_957# vdd vdd vdd sky130_fd_pr__pfet_01v8_hvt ad=0.0651 pd=0.73 as=0.1092 ps=1.36 w=0.42 l=0.15
X17 a_3609_47# a_1853_591# vss vss sky130_fd_pr__nfet_01v8 ad=0.08775 pd=0.92 as=0.169 ps=1.82 w=0.65 l=0.15
X18 vss a_1853_591# a_2051_591# vss sky130_fd_pr__nfet_01v8 ad=0.169 pd=1.82 as=0.08775 ps=0.92 w=0.65 l=0.15
X19 vdd a_2051_591# dn vdd sky130_fd_pr__pfet_01v8_hvt ad=0.135 pd=1.27 as=0.135 ps=1.27 w=1 l=0.15
X20 up a_2051_47# vdd vdd sky130_fd_pr__pfet_01v8_hvt ad=0.135 pd=1.27 as=0.135 ps=1.27 w=1 l=0.15
X21 dn a_2051_591# vss vss sky130_fd_pr__nfet_01v8 ad=0.08775 pd=0.92 as=0.08775 ps=0.92 w=0.65 l=0.15
X22 vdd a_1853_47# a_2051_47# vdd sky130_fd_pr__pfet_01v8_hvt ad=0.135 pd=1.27 as=0.135 ps=1.27 w=1 l=0.15
X23 a_540_957# vdd vss vss sky130_fd_pr__nfet_01v8 ad=0.066 pd=0.745 as=0.2205 ps=1.89 w=0.42 l=0.15
X24 up a_2051_47# vss vss sky130_fd_pr__nfet_01v8 ad=0.08775 pd=0.92 as=0.08775 ps=0.92 w=0.65 l=0.15
X25 dn a_2051_591# vss vss sky130_fd_pr__nfet_01v8 ad=0.08775 pd=0.92 as=0.169 ps=1.82 w=0.65 l=0.15
X26 a_939_21# a_4107_929# vss vss sky130_fd_pr__nfet_01v8 ad=0.182 pd=1.86 as=0.1118 ps=1.04 w=0.65 l=0.15
X27 dn a_2051_591# vdd vdd sky130_fd_pr__pfet_01v8_hvt ad=0.135 pd=1.27 as=0.135 ps=1.27 w=1 l=0.15
X28 vdd a_1853_591# a_2051_591# vdd sky130_fd_pr__pfet_01v8_hvt ad=0.135 pd=1.27 as=0.135 ps=1.27 w=1 l=0.15
X29 a_3347_823# a_4014_47# vss vss sky130_fd_pr__nfet_01v8 ad=0.169 pd=1.82 as=0.169 ps=1.82 w=0.65 l=0.15
X30 vdd a_3505_591# a_3611_911# vdd sky130_fd_pr__pfet_01v8_hvt ad=0.14075 pd=1.325 as=0.1092 ps=1.36 w=0.42 l=0.15
X31 vss a_1375_895# a_1309_969# vss sky130_fd_pr__nfet_01v8 ad=0.12495 pd=1.015 as=0.0669 ps=0.75 w=0.42 l=0.15
X32 a_2051_591# a_1853_591# vss vss sky130_fd_pr__nfet_01v8 ad=0.08775 pd=0.92 as=0.08775 ps=0.92 w=0.65 l=0.15
X33 a_743_413# a_939_21# vdd vdd sky130_fd_pr__pfet_01v8_hvt ad=0.1092 pd=1.36 as=0.07035 ps=0.755 w=0.42 l=0.15
X34 a_2051_47# a_1853_47# vdd vdd sky130_fd_pr__pfet_01v8_hvt ad=0.135 pd=1.27 as=0.26 ps=2.52 w=1 l=0.15
X35 a_897_957# a_853_565# a_731_969# vss sky130_fd_pr__nfet_01v8 ad=0.0441 pd=0.63 as=0.1401 ps=1.1 w=0.42 l=0.15
X36 a_853_289# a_635_47# vdd vdd sky130_fd_pr__pfet_01v8_hvt ad=0.12915 pd=1.185 as=0.2184 ps=2.2 w=0.84 l=0.15
X37 a_1853_47# a_1375_21# vss vss sky130_fd_pr__nfet_01v8 ad=0.169 pd=1.82 as=0.2087 ps=2.02 w=0.65 l=0.15
X38 a_3347_823# a_4014_47# vdd vdd sky130_fd_pr__pfet_01v8_hvt ad=0.26 pd=2.52 as=0.26 ps=2.52 w=1 l=0.15
X39 vdd a_2051_47# up vdd sky130_fd_pr__pfet_01v8_hvt ad=0.135 pd=1.27 as=0.135 ps=1.27 w=1 l=0.15
X40 a_853_289# a_635_47# vss vss sky130_fd_pr__nfet_01v8 ad=0.0999 pd=0.985 as=0.1346 ps=1.15 w=0.64 l=0.15
X41 a_3505_591# a_3339_591# vdd vdd sky130_fd_pr__pfet_01v8_hvt ad=0.1092 pd=1.36 as=0.0567 ps=0.69 w=0.42 l=0.15
X42 a_2051_591# a_1853_591# vdd vdd sky130_fd_pr__pfet_01v8_hvt ad=0.135 pd=1.27 as=0.26 ps=2.52 w=1 l=0.15
X43 a_853_565# a_635_969# vss vss sky130_fd_pr__nfet_01v8 ad=0.0999 pd=0.985 as=0.1346 ps=1.15 w=0.64 l=0.15
X44 a_4014_47# a_3609_297# vdd vdd sky130_fd_pr__pfet_01v8_hvt ad=0.26 pd=2.52 as=0.26 ps=2.52 w=1 l=0.15
X45 vdd a_2051_591# dn vdd sky130_fd_pr__pfet_01v8_hvt ad=0.135 pd=1.27 as=0.135 ps=1.27 w=1 l=0.15
X46 a_1200_969# a_119_597# a_853_565# vdd sky130_fd_pr__pfet_01v8_hvt ad=0.0588 pd=0.7 as=0.12915 ps=1.185 w=0.42 l=0.15
X47 vss a_1853_47# a_2051_47# vss sky130_fd_pr__nfet_01v8 ad=0.08775 pd=0.92 as=0.08775 ps=0.92 w=0.65 l=0.15
X48 a_1200_969# a_285_597# a_853_565# vss sky130_fd_pr__special_nfet_01v8 ad=0.0711 pd=0.755 as=0.0999 ps=0.985 w=0.36 l=0.15
X49 up a_2051_47# vss vss sky130_fd_pr__nfet_01v8 ad=0.08775 pd=0.92 as=0.169 ps=1.82 w=0.65 l=0.15
X50 up a_2051_47# vdd vdd sky130_fd_pr__pfet_01v8_hvt ad=0.135 pd=1.27 as=0.135 ps=1.27 w=1 l=0.15
X51 vdd a_3347_823# a_3339_591# vdd sky130_fd_pr__pfet_01v8_hvt ad=0.0567 pd=0.69 as=0.1092 ps=1.36 w=0.42 l=0.15
X52 vss a_1375_21# a_1309_47# vss sky130_fd_pr__nfet_01v8 ad=0.12495 pd=1.015 as=0.0669 ps=0.75 w=0.42 l=0.15
X53 vdd a_2051_47# up vdd sky130_fd_pr__pfet_01v8_hvt ad=0.26 pd=2.52 as=0.135 ps=1.27 w=1 l=0.15
X54 dn a_2051_591# vdd vdd sky130_fd_pr__pfet_01v8_hvt ad=0.135 pd=1.27 as=0.135 ps=1.27 w=1 l=0.15
X55 vss a_1853_47# a_2051_47# vss sky130_fd_pr__nfet_01v8 ad=0.169 pd=1.82 as=0.08775 ps=0.92 w=0.65 l=0.15
X56 a_743_413# a_119_47# a_635_47# vdd sky130_fd_pr__pfet_01v8_hvt ad=0.1155 pd=0.97 as=0.07245 ps=0.765 w=0.42 l=0.15
X57 up a_2051_47# vss vss sky130_fd_pr__nfet_01v8 ad=0.08775 pd=0.92 as=0.08775 ps=0.92 w=0.65 l=0.15
X58 a_731_969# a_285_597# a_635_969# vss sky130_fd_pr__special_nfet_01v8 ad=0.1401 pd=1.1 as=0.0594 ps=0.69 w=0.36 l=0.15
X59 a_635_969# a_119_597# a_540_957# vss sky130_fd_pr__special_nfet_01v8 ad=0.0594 pd=0.69 as=0.066 ps=0.745 w=0.36 l=0.15
X60 a_635_969# a_285_597# a_540_957# vdd sky130_fd_pr__pfet_01v8_hvt ad=0.07245 pd=0.765 as=0.0651 ps=0.73 w=0.42 l=0.15
X61 vdd a_2051_591# dn vdd sky130_fd_pr__pfet_01v8_hvt ad=0.26 pd=2.52 as=0.135 ps=1.27 w=1 l=0.15
X62 up a_2051_47# vss vss sky130_fd_pr__nfet_01v8 ad=0.08775 pd=0.92 as=0.08775 ps=0.92 w=0.65 l=0.15
X63 a_3505_591# a_3339_591# vss vss sky130_fd_pr__nfet_01v8 ad=0.1092 pd=1.36 as=0.0567 ps=0.69 w=0.42 l=0.15
X64 a_4014_47# a_3609_297# vss vss sky130_fd_pr__nfet_01v8 ad=0.169 pd=1.82 as=0.169 ps=1.82 w=0.65 l=0.15
X65 a_1853_47# a_1375_21# vdd vdd sky130_fd_pr__pfet_01v8_hvt ad=0.26 pd=2.52 as=0.3012 ps=2.66 w=1 l=0.15
X66 vdd a_2051_47# up vdd sky130_fd_pr__pfet_01v8_hvt ad=0.135 pd=1.27 as=0.135 ps=1.27 w=1 l=0.15
X67 vdd a_1375_895# a_1362_591# vdd sky130_fd_pr__pfet_01v8_hvt ad=0.0819 pd=0.81 as=0.0567 ps=0.69 w=0.42 l=0.15
X68 vss a_2051_591# dn vss sky130_fd_pr__nfet_01v8 ad=0.08775 pd=0.92 as=0.08775 ps=0.92 w=0.65 l=0.15
X69 a_1853_591# a_1375_895# vdd vdd sky130_fd_pr__pfet_01v8_hvt ad=0.26 pd=2.52 as=0.3012 ps=2.66 w=1 l=0.15
X70 vdd a_1200_969# a_1375_895# vdd sky130_fd_pr__pfet_01v8_hvt ad=0.1134 pd=1.38 as=0.0567 ps=0.69 w=0.42 l=0.15
X71 a_897_47# a_853_289# a_731_47# vss sky130_fd_pr__nfet_01v8 ad=0.0441 pd=0.63 as=0.1401 ps=1.1 w=0.42 l=0.15
X72 vdd a_2051_591# dn vdd sky130_fd_pr__pfet_01v8_hvt ad=0.135 pd=1.27 as=0.135 ps=1.27 w=1 l=0.15
X73 a_1309_47# a_119_47# a_1200_47# vss sky130_fd_pr__special_nfet_01v8 ad=0.0669 pd=0.75 as=0.0711 ps=0.755 w=0.36 l=0.15
X74 vss a_3347_823# a_3339_591# vss sky130_fd_pr__nfet_01v8 ad=0.0567 pd=0.69 as=0.1092 ps=1.36 w=0.42 l=0.15
X75 a_1375_21# a_1200_47# a_1554_47# vss sky130_fd_pr__nfet_01v8 ad=0.1092 pd=1.36 as=0.06405 ps=0.725 w=0.42 l=0.15
X76 vss a_3790_591# a_4193_929# vss sky130_fd_pr__nfet_01v8 ad=0.1118 pd=1.04 as=0.0567 ps=0.69 w=0.42 l=0.15
X77 vdd a_1853_47# a_3609_297# vdd sky130_fd_pr__pfet_01v8_hvt ad=0.26 pd=2.52 as=0.135 ps=1.27 w=1 l=0.15
X78 a_1362_591# a_285_597# a_1200_969# vdd sky130_fd_pr__pfet_01v8_hvt ad=0.0567 pd=0.69 as=0.0588 ps=0.7 w=0.42 l=0.15
X79 a_540_47# vdd vdd vdd sky130_fd_pr__pfet_01v8_hvt ad=0.0651 pd=0.73 as=0.1092 ps=1.36 w=0.42 l=0.15
X80 dn a_2051_591# vss vss sky130_fd_pr__nfet_01v8 ad=0.08775 pd=0.92 as=0.08775 ps=0.92 w=0.65 l=0.15
X81 vss a_1853_591# a_2051_591# vss sky130_fd_pr__nfet_01v8 ad=0.08775 pd=0.92 as=0.08775 ps=0.92 w=0.65 l=0.15
X82 a_1375_895# a_939_21# vdd vdd sky130_fd_pr__pfet_01v8_hvt ad=0.0567 pd=0.69 as=0.0819 ps=0.81 w=0.42 l=0.15
X83 a_4193_929# rst_b a_4107_929# vss sky130_fd_pr__nfet_01v8 ad=0.0567 pd=0.69 as=0.1176 ps=1.4 w=0.42 l=0.15
X84 a_2051_47# a_1853_47# vss vss sky130_fd_pr__nfet_01v8 ad=0.08775 pd=0.92 as=0.08775 ps=0.92 w=0.65 l=0.15
X85 a_540_47# vdd vss vss sky130_fd_pr__nfet_01v8 ad=0.066 pd=0.745 as=0.2205 ps=1.89 w=0.42 l=0.15
X86 vdd a_853_565# a_743_591# vdd sky130_fd_pr__pfet_01v8_hvt ad=0.07035 pd=0.755 as=0.1155 ps=0.97 w=0.42 l=0.15
X87 vss a_2051_47# up vss sky130_fd_pr__nfet_01v8 ad=0.08775 pd=0.92 as=0.08775 ps=0.92 w=0.65 l=0.15
X88 a_2051_591# a_1853_591# vss vss sky130_fd_pr__nfet_01v8 ad=0.08775 pd=0.92 as=0.169 ps=1.82 w=0.65 l=0.15
X89 vss a_939_21# a_897_47# vss sky130_fd_pr__nfet_01v8 ad=0.1346 pd=1.15 as=0.0441 ps=0.63 w=0.42 l=0.15
X90 a_1309_969# a_119_597# a_1200_969# vss sky130_fd_pr__special_nfet_01v8 ad=0.0669 pd=0.75 as=0.0711 ps=0.755 w=0.36 l=0.15
X91 vss a_2051_47# up vss sky130_fd_pr__nfet_01v8 ad=0.08775 pd=0.92 as=0.08775 ps=0.92 w=0.65 l=0.15
X92 a_3609_297# a_1853_591# vdd vdd sky130_fd_pr__pfet_01v8_hvt ad=0.135 pd=1.27 as=0.26 ps=2.52 w=1 l=0.15
X93 vss a_2051_591# dn vss sky130_fd_pr__nfet_01v8 ad=0.08775 pd=0.92 as=0.08775 ps=0.92 w=0.65 l=0.15
X94 vss a_2051_47# up vss sky130_fd_pr__nfet_01v8 ad=0.08775 pd=0.92 as=0.08775 ps=0.92 w=0.65 l=0.15
X95 vss ref a_119_47# vss sky130_fd_pr__nfet_01v8 ad=0.0567 pd=0.69 as=0.1092 ps=1.36 w=0.42 l=0.15
X96 vdd a_1853_47# a_2051_47# vdd sky130_fd_pr__pfet_01v8_hvt ad=0.26 pd=2.52 as=0.135 ps=1.27 w=1 l=0.15
X97 a_1554_957# a_939_21# vss vss sky130_fd_pr__nfet_01v8 ad=0.06405 pd=0.725 as=0.12495 ps=1.015 w=0.42 l=0.15
X98 a_3790_591# a_3611_911# vdd vdd sky130_fd_pr__pfet_01v8_hvt ad=0.26 pd=2.52 as=0.14075 ps=1.325 w=1 l=0.15
X99 dn a_2051_591# vss vss sky130_fd_pr__nfet_01v8 ad=0.08775 pd=0.92 as=0.08775 ps=0.92 w=0.65 l=0.15
X100 a_1200_47# a_119_47# a_853_289# vdd sky130_fd_pr__pfet_01v8_hvt ad=0.0588 pd=0.7 as=0.12915 ps=1.185 w=0.42 l=0.15
X101 up a_2051_47# vdd vdd sky130_fd_pr__pfet_01v8_hvt ad=0.135 pd=1.27 as=0.135 ps=1.27 w=1 l=0.15
X102 vdd a_1853_591# a_2051_591# vdd sky130_fd_pr__pfet_01v8_hvt ad=0.26 pd=2.52 as=0.135 ps=1.27 w=1 l=0.15
X103 a_853_565# a_635_969# vdd vdd sky130_fd_pr__pfet_01v8_hvt ad=0.12915 pd=1.185 as=0.2184 ps=2.2 w=0.84 l=0.15
X104 vss a_2051_591# dn vss sky130_fd_pr__nfet_01v8 ad=0.169 pd=1.82 as=0.08775 ps=0.92 w=0.65 l=0.15
X105 a_743_591# a_939_21# vdd vdd sky130_fd_pr__pfet_01v8_hvt ad=0.1092 pd=1.36 as=0.07035 ps=0.755 w=0.42 l=0.15
X106 up a_2051_47# vdd vdd sky130_fd_pr__pfet_01v8_hvt ad=0.135 pd=1.27 as=0.26 ps=2.52 w=1 l=0.15
X107 dn a_2051_591# vdd vdd sky130_fd_pr__pfet_01v8_hvt ad=0.135 pd=1.27 as=0.135 ps=1.27 w=1 l=0.15
X108 a_285_597# a_119_597# vdd vdd sky130_fd_pr__pfet_01v8_hvt ad=0.1664 pd=1.8 as=0.0864 ps=0.91 w=0.64 l=0.15
X109 dn a_2051_591# vdd vdd sky130_fd_pr__pfet_01v8_hvt ad=0.135 pd=1.27 as=0.26 ps=2.52 w=1 l=0.15
X110 a_2051_47# a_1853_47# vdd vdd sky130_fd_pr__pfet_01v8_hvt ad=0.135 pd=1.27 as=0.135 ps=1.27 w=1 l=0.15
X111 a_939_21# a_4107_929# vdd vdd sky130_fd_pr__pfet_01v8_hvt ad=0.475 pd=2.95 as=0.16655 ps=1.39 w=1 l=0.15
X112 a_1853_591# a_1375_895# vss vss sky130_fd_pr__nfet_01v8 ad=0.169 pd=1.82 as=0.2087 ps=2.02 w=0.65 l=0.15
X113 vss a_2051_591# dn vss sky130_fd_pr__nfet_01v8 ad=0.08775 pd=0.92 as=0.08775 ps=0.92 w=0.65 l=0.15
X114 a_1375_895# a_1200_969# a_1554_957# vss sky130_fd_pr__nfet_01v8 ad=0.1092 pd=1.36 as=0.06405 ps=0.725 w=0.42 l=0.15
X115 a_635_47# a_285_47# a_540_47# vdd sky130_fd_pr__pfet_01v8_hvt ad=0.07245 pd=0.765 as=0.0651 ps=0.73 w=0.42 l=0.15
X116 a_2051_591# a_1853_591# vdd vdd sky130_fd_pr__pfet_01v8_hvt ad=0.135 pd=1.27 as=0.135 ps=1.27 w=1 l=0.15
X117 vdd fb a_119_597# vdd sky130_fd_pr__pfet_01v8_hvt ad=0.0864 pd=0.91 as=0.1664 ps=1.8 w=0.64 l=0.15
X118 a_3609_297# a_1853_47# a_3609_47# vss sky130_fd_pr__nfet_01v8 ad=0.169 pd=1.82 as=0.08775 ps=0.92 w=0.65 l=0.15
X119 vdd a_1375_21# a_1362_413# vdd sky130_fd_pr__pfet_01v8_hvt ad=0.0819 pd=0.81 as=0.0567 ps=0.69 w=0.42 l=0.15
X120 a_731_47# a_285_47# a_635_47# vss sky130_fd_pr__special_nfet_01v8 ad=0.1401 pd=1.1 as=0.0594 ps=0.69 w=0.36 l=0.15
X121 a_285_47# a_119_47# vss vss sky130_fd_pr__nfet_01v8 ad=0.1092 pd=1.36 as=0.0567 ps=0.69 w=0.42 l=0.15
X122 vdd a_1200_47# a_1375_21# vdd sky130_fd_pr__pfet_01v8_hvt ad=0.1134 pd=1.38 as=0.0567 ps=0.69 w=0.42 l=0.15
X123 vss a_3505_591# a_3611_911# vss sky130_fd_pr__nfet_01v8 ad=0.10025 pd=0.985 as=0.1092 ps=1.36 w=0.42 l=0.15
X124 a_285_597# a_119_597# vss vss sky130_fd_pr__nfet_01v8 ad=0.1092 pd=1.36 as=0.0567 ps=0.69 w=0.42 l=0.15
X125 a_743_591# a_119_597# a_635_969# vdd sky130_fd_pr__pfet_01v8_hvt ad=0.1155 pd=0.97 as=0.07245 ps=0.765 w=0.42 l=0.15
C0 up a_3339_591# 0
C1 a_285_47# a_1375_21# 0.02182f
C2 vdd a_1200_969# 0.23816f
C3 a_853_289# a_635_47# 0.14035f
C4 a_3611_911# a_3339_591# 0.00264f
C5 a_853_565# a_743_591# 0.05795f
C6 vdd a_3339_591# 0.20953f
C7 a_285_47# ref 0.00528f
C8 a_540_47# a_635_47# 0.02667f
C9 a_1853_591# a_1200_969# 0.0097f
C10 vdd a_635_47# 0.17081f
C11 a_119_597# a_1200_969# 0.06246f
C12 a_540_957# rst_b 0.00757f
C13 a_119_47# a_285_597# 0
C14 a_731_969# a_285_597# 0
C15 a_1853_591# a_3339_591# 0.02666f
C16 a_119_47# fb 0.00232f
C17 a_3609_297# a_2051_47# 0
C18 a_853_289# a_897_47# 0
C19 a_939_21# a_635_969# 0.10415f
C20 a_3347_823# dn 0.0639f
C21 a_853_289# a_1853_47# 0.00119f
C22 a_4014_47# up 0.03656f
C23 a_3790_591# a_3339_591# 0.00197f
C24 a_939_21# dn 0.09529f
C25 a_119_597# a_635_47# 0
C26 a_1853_47# up 0.27925f
C27 a_540_47# a_1853_47# 0
C28 a_4014_47# vdd 0.26759f
C29 a_1853_47# a_3611_911# 0.00158f
C30 a_853_289# a_1362_413# 0
C31 a_285_47# a_2051_47# 0
C32 a_1853_47# vdd 0.54331f
C33 a_1309_969# rst_b 0
C34 a_853_565# a_853_289# 0.00624f
C35 a_4014_47# a_1853_591# 0.00227f
C36 a_285_47# a_731_47# 0
C37 vdd a_1362_413# 0
C38 a_1200_969# a_1375_895# 0.16144f
C39 a_3347_823# rst_b 0.06337f
C40 a_1853_591# a_1853_47# 0.10529f
C41 a_1200_969# a_285_597# 0.07685f
C42 a_939_21# rst_b 0.87098f
C43 a_4014_47# a_3790_591# 0
C44 a_1200_969# fb 0
C45 a_853_565# vdd 0.17472f
C46 a_743_413# a_119_47# 0
C47 up a_4107_929# 0
C48 a_939_21# a_1200_47# 0.1816f
C49 a_3611_911# a_4107_929# 0
C50 a_285_597# a_635_47# 0
C51 vdd a_4107_929# 0.16282f
C52 a_853_565# a_1853_591# 0.00119f
C53 a_1375_21# a_3347_823# 0
C54 a_853_565# a_119_597# 0.05641f
C55 a_1375_21# a_939_21# 0.19804f
C56 a_939_21# ref 0.00292f
C57 a_1309_47# a_119_47# 0
C58 a_1853_591# a_4107_929# 0.00165f
C59 a_939_21# a_1554_47# 0.00387f
C60 a_1853_47# a_1375_895# 0
C61 a_939_21# a_897_957# 0.00449f
C62 a_119_47# a_1200_969# 0
C63 rst_b a_635_969# 0.01321f
C64 a_3790_591# a_4107_929# 0.16686f
C65 a_3505_591# a_3339_591# 0.08838f
C66 a_3347_823# a_2051_591# 0.01352f
C67 rst_b dn 0.35848f
C68 a_939_21# a_2051_591# 0.01496f
C69 up a_3609_297# 0.03816f
C70 a_119_47# a_635_47# 0.10647f
C71 a_3609_297# a_3611_911# 0
C72 a_1853_591# a_1554_957# 0
C73 a_3347_823# a_2051_47# 0.00902f
C74 a_1853_591# a_4193_929# 0
C75 a_285_47# a_853_289# 0.12921f
C76 vdd a_3609_297# 0.26178f
C77 a_743_413# a_635_47# 0.03269f
C78 a_939_21# a_2051_47# 0.05017f
C79 a_853_565# a_285_597# 0.12921f
C80 a_853_565# fb 0
C81 a_285_47# up 0
C82 a_285_47# a_540_47# 0.04878f
C83 a_3790_591# a_4193_929# 0.00249f
C84 a_939_21# a_731_47# 0.00266f
C85 a_1853_591# a_3609_297# 0.05444f
C86 a_285_47# vdd 0.54566f
C87 a_3505_591# a_1853_47# 0.00595f
C88 a_635_969# a_897_957# 0.00171f
C89 a_939_21# a_1362_591# 0
C90 a_119_47# a_1853_47# 0.00171f
C91 a_3609_297# a_3790_591# 0
C92 rst_b a_1200_47# 0
C93 a_285_47# a_119_597# 0
C94 a_2051_591# dn 0.70024f
C95 a_1375_21# rst_b 0
C96 a_939_21# a_743_591# 0.01938f
C97 a_1554_957# a_1375_895# 0.00806f
C98 ref rst_b 0.01048f
C99 a_853_565# a_731_969# 0
C100 a_1375_21# a_1200_47# 0.16144f
C101 dn a_2051_47# 0.00522f
C102 a_743_413# a_853_565# 0
C103 rst_b a_897_957# 0
C104 a_1309_47# a_1853_47# 0
C105 ref a_1200_47# 0
C106 a_3505_591# a_4107_929# 0
C107 a_540_957# vdd 0.16082f
C108 rst_b a_2051_591# 0.09173f
C109 a_1375_21# ref 0
C110 a_1853_47# a_3339_591# 0
C111 a_285_47# a_1375_895# 0
C112 a_540_957# a_1853_591# 0
C113 a_1375_21# a_1554_47# 0.00806f
C114 a_285_47# a_285_597# 0.01403f
C115 a_540_957# a_119_597# 0.06089f
C116 a_897_47# a_635_47# 0.00171f
C117 rst_b a_2051_47# 0.0027f
C118 a_1853_47# a_635_47# 0.00114f
C119 a_635_969# a_743_591# 0.03269f
C120 a_853_565# a_1200_969# 0.02725f
C121 a_853_289# a_939_21# 0.14221f
C122 a_3347_823# up 0.31846f
C123 a_1200_47# a_2051_47# 0.00102f
C124 rst_b a_731_47# 0
C125 a_3347_823# a_3611_911# 0.00121f
C126 a_939_21# up 0.05831f
C127 a_540_47# a_939_21# 0.00219f
C128 a_939_21# a_3611_911# 0.0019f
C129 a_3609_47# up 0
C130 a_3347_823# vdd 0.57685f
C131 rst_b a_1362_591# 0
C132 a_939_21# vdd 1.16889f
C133 a_853_565# a_635_47# 0
C134 a_3505_591# a_3609_297# 0
C135 a_4014_47# a_1853_47# 0.00814f
C136 a_1309_969# a_1853_591# 0
C137 a_3609_47# vdd 0
C138 a_1853_47# a_897_47# 0
C139 a_1309_969# a_119_597# 0
C140 a_3339_591# a_4107_929# 0
C141 a_3347_823# a_1853_591# 0.15206f
C142 rst_b a_743_591# 0.00717f
C143 a_1853_591# a_939_21# 0.09265f
C144 a_540_957# a_285_597# 0.04878f
C145 a_939_21# a_119_597# 0.21433f
C146 a_285_47# a_119_47# 0.53895f
C147 a_3347_823# a_3790_591# 0
C148 a_540_957# fb 0
C149 a_939_21# a_3790_591# 0.01514f
C150 a_743_413# a_285_47# 0.03462f
C151 a_2051_591# a_2051_47# 0.07001f
C152 a_853_289# a_635_969# 0
C153 a_4014_47# a_4107_929# 0.0053f
C154 up dn 0.01987f
C155 dn a_3611_911# 0.01328f
C156 vdd a_635_969# 0.17081f
C157 vdd dn 0.57194f
C158 a_1309_969# a_285_597# 0
C159 a_285_47# a_1309_47# 0
C160 a_3347_823# a_1375_895# 0
C161 a_939_21# a_1375_895# 0.18551f
C162 a_1853_591# a_635_969# 0.00114f
C163 a_285_47# a_1200_969# 0
C164 a_119_47# a_540_957# 0
C165 a_853_289# rst_b 0.00385f
C166 a_119_597# a_635_969# 0.10647f
C167 a_939_21# a_285_597# 0.08871f
C168 a_540_957# a_731_969# 0
C169 a_1853_591# dn 0.23775f
C170 a_939_21# fb 0.00292f
C171 a_119_597# dn 0
C172 up rst_b 0.00116f
C173 a_540_47# rst_b 0.00386f
C174 rst_b a_3611_911# 0.01719f
C175 dn a_3790_591# 0.05124f
C176 a_853_289# a_1200_47# 0.02725f
C177 a_285_47# a_635_47# 0.1477f
C178 rst_b vdd 0.49736f
C179 up a_1200_47# 0
C180 a_4014_47# a_3609_297# 0.07998f
C181 vdd a_1200_47# 0.23816f
C182 a_1853_47# a_3609_297# 0.19488f
C183 a_1375_21# up 0
C184 a_1853_591# rst_b 0.2741f
C185 a_853_289# ref 0
C186 a_119_597# rst_b 0.04193f
C187 a_3505_591# a_3347_823# 0.00272f
C188 a_1375_21# vdd 0.27992f
C189 a_540_47# ref 0
C190 a_3505_591# a_939_21# 0
C191 rst_b a_3790_591# 0.12884f
C192 a_635_969# a_285_597# 0.1477f
C193 a_285_47# a_1853_47# 0.00254f
C194 dn a_1375_895# 0
C195 a_119_47# a_939_21# 0.21819f
C196 a_731_969# a_939_21# 0.00266f
C197 ref vdd 0.16466f
C198 a_119_597# a_1200_47# 0
C199 dn a_285_597# 0
C200 fb a_635_969# 0
C201 a_743_413# a_939_21# 0.01938f
C202 a_4193_929# a_4107_929# 0.00658f
C203 a_1375_21# a_1853_591# 0
C204 a_285_47# a_1362_413# 0
C205 up a_2051_591# 0.00522f
C206 a_119_597# ref 0.00232f
C207 a_285_47# a_853_565# 0
C208 vdd a_2051_591# 0.69524f
C209 a_1853_591# a_897_957# 0
C210 up a_2051_47# 0.70077f
C211 a_1309_969# a_1200_969# 0.00742f
C212 rst_b a_1375_895# 0.02133f
C213 a_1309_47# a_939_21# 0.00136f
C214 rst_b a_285_597# 0.07223f
C215 a_853_289# a_731_47# 0
C216 vdd a_2051_47# 0.69709f
C217 a_1853_591# a_2051_591# 0.43446f
C218 rst_b fb 0.07127f
C219 a_119_597# a_2051_591# 0
C220 a_939_21# a_1200_969# 0.17236f
C221 a_1200_47# a_1375_895# 0
C222 a_540_47# a_731_47# 0
C223 a_119_47# a_635_969# 0
C224 a_731_969# a_635_969# 0.01379f
C225 a_3347_823# a_3339_591# 0.19156f
C226 a_3505_591# dn 0.00759f
C227 a_1200_47# a_285_597# 0
C228 a_2051_591# a_3790_591# 0
C229 a_939_21# a_3339_591# 0
C230 a_1853_591# a_2051_47# 0.00767f
C231 a_1375_21# a_1375_895# 0.01271f
C232 a_1375_21# a_285_597# 0
C233 vdd a_1362_591# 0
C234 a_939_21# a_635_47# 0.10437f
C235 a_853_289# a_743_591# 0
C236 ref fb 0.02293f
C237 vdd a_743_591# 0.10128f
C238 a_3505_591# rst_b 0.00706f
C239 a_119_47# rst_b 0.01576f
C240 a_4014_47# a_3347_823# 0.06814f
C241 a_731_969# rst_b 0.00119f
C242 a_4014_47# a_939_21# 0.00186f
C243 a_3347_823# a_1853_47# 0.0129f
C244 a_939_21# a_897_47# 0.00449f
C245 a_743_413# rst_b 0.00335f
C246 a_1200_969# a_635_969# 0
C247 a_2051_591# a_285_597# 0
C248 a_939_21# a_1853_47# 0.14193f
C249 a_1200_969# dn 0
C250 a_119_47# a_1200_47# 0.06246f
C251 a_3609_47# a_1853_47# 0
C252 a_119_597# a_743_591# 0
C253 dn a_3339_591# 0.01085f
C254 a_853_565# a_1309_969# 0
C255 a_939_21# a_1362_413# 0
C256 a_1375_21# a_119_47# 0.02289f
C257 a_635_969# a_635_47# 0.00756f
C258 a_119_47# ref 0.17104f
C259 a_853_565# a_939_21# 0.14055f
C260 rst_b a_1200_969# 0.02114f
C261 a_3347_823# a_4107_929# 0.00207f
C262 a_285_597# a_1362_591# 0
C263 a_1309_47# a_1200_47# 0.00742f
C264 a_853_289# vdd 0.17472f
C265 a_939_21# a_4107_929# 0.08616f
C266 up a_3611_911# 0
C267 a_3505_591# a_2051_591# 0
C268 rst_b a_3339_591# 0.00688f
C269 a_4014_47# dn 0
C270 up vdd 0.58379f
C271 a_540_47# vdd 0.16082f
C272 a_1200_969# a_1200_47# 0.00625f
C273 vdd a_3611_911# 0.14769f
C274 a_1853_47# dn 0
C275 rst_b a_635_47# 0.00747f
C276 a_285_597# a_743_591# 0.03462f
C277 a_1375_21# a_1200_969# 0
C278 a_119_47# a_2051_47# 0
C279 a_1853_591# up 0.07274f
C280 a_1200_47# a_635_47# 0
C281 a_1853_591# a_3611_911# 0.01843f
C282 a_540_47# a_119_597# 0
C283 a_939_21# a_1554_957# 0.00346f
C284 a_853_565# a_635_969# 0.14035f
C285 a_1853_591# vdd 0.71058f
C286 a_939_21# a_4193_929# 0
C287 up a_3790_591# 0
C288 a_119_47# a_731_47# 0.00188f
C289 a_119_597# vdd 0.49581f
C290 a_3790_591# a_3611_911# 0.07004f
C291 a_4014_47# rst_b 0.00228f
C292 rst_b a_897_47# 0
C293 vdd a_3790_591# 0.2198f
C294 a_1853_47# rst_b 0.00281f
C295 ref a_635_47# 0
C296 a_3347_823# a_3609_297# 0.01534f
C297 a_939_21# a_3609_297# 0.00186f
C298 a_2051_591# a_1200_969# 0.00102f
C299 a_1853_591# a_119_597# 0.00171f
C300 dn a_4107_929# 0.01525f
C301 a_3609_47# a_3609_297# 0.01004f
C302 a_1853_47# a_1200_47# 0.0097f
C303 a_1853_591# a_3790_591# 0.01538f
C304 a_285_47# a_939_21# 0.09605f
C305 a_853_289# a_285_597# 0
C306 a_853_565# rst_b 0.0109f
C307 a_1375_21# a_1853_47# 0.07437f
C308 a_1200_47# a_1362_413# 0.00645f
C309 vdd a_1375_895# 0.27992f
C310 vdd a_285_597# 0.54566f
C311 rst_b a_4107_929# 0.06689f
C312 dn a_4193_929# 0
C313 a_1853_47# a_1554_47# 0
C314 vdd fb 0.16466f
C315 a_1200_969# a_1362_591# 0.00645f
C316 a_1853_591# a_1375_895# 0.07437f
C317 a_731_47# a_635_47# 0.01379f
C318 a_1853_591# a_285_597# 0.00254f
C319 a_119_597# a_1375_895# 0.02289f
C320 a_1853_47# a_2051_591# 0.00315f
C321 dn a_3609_297# 0
C322 a_119_597# a_285_597# 0.53895f
C323 a_119_597# fb 0.17104f
C324 a_853_565# a_897_957# 0
C325 a_540_957# a_939_21# 0.00219f
C326 a_119_47# a_853_289# 0.05641f
C327 rst_b a_1554_957# 0
C328 a_285_47# a_635_969# 0
C329 a_1853_47# a_2051_47# 0.44711f
C330 a_3505_591# up 0
C331 a_743_413# a_853_289# 0.05795f
C332 a_3505_591# a_3611_911# 0.17532f
C333 a_119_47# up 0
C334 a_540_47# a_119_47# 0.06089f
C335 a_3505_591# vdd 0.20675f
C336 a_1853_47# a_731_47# 0
C337 a_119_47# vdd 0.49581f
C338 rst_b a_3609_297# 0
C339 a_743_413# vdd 0.10128f
C340 a_3505_591# a_1853_591# 0.03788f
C341 a_1375_895# a_285_597# 0.02182f
C342 a_1309_969# a_939_21# 0.00117f
C343 a_731_969# a_1853_591# 0
C344 a_1309_47# a_853_289# 0
C345 a_119_47# a_119_597# 0.01849f
C346 a_285_47# rst_b 0.01398f
C347 fb a_1375_895# 0
C348 a_731_969# a_119_597# 0.00188f
C349 a_3505_591# a_3790_591# 0.0056f
C350 fb a_285_597# 0.00528f
C351 a_3347_823# a_939_21# 0.34996f
C352 a_540_957# a_635_969# 0.02667f
C353 a_853_565# a_1362_591# 0
C354 a_285_47# a_1200_47# 0.07685f
C355 up vss 0.73766f
C356 ref vss 0.25483f
C357 rst_b vss 0.78688f
C358 dn vss 0.76072f
C359 fb vss 0.25483f
C360 vdd vss 8.20446f
C361 a_3609_47# vss 0.00189f
C362 a_1554_47# vss 0.00255f
C363 a_1309_47# vss 0.00108f
C364 a_897_47# vss 0.00593f
C365 a_731_47# vss 0.0099f
C366 a_743_413# vss 0
C367 a_540_47# vss 0.05753f
C368 a_4014_47# vss 0.31652f
C369 a_3609_297# vss 0.43083f
C370 a_2051_47# vss 0.81006f
C371 a_1853_47# vss 1.21667f
C372 a_1200_47# vss 0.18826f
C373 a_1375_21# vss 0.35716f
C374 a_635_47# vss 0.19702f
C375 a_853_289# vss 0.12952f
C376 a_285_47# vss 0.22948f
C377 a_119_47# vss 0.51119f
C378 a_4193_929# vss 0.00419f
C379 a_3790_591# vss 0.35733f
C380 a_4107_929# vss 0.19274f
C381 a_3611_911# vss 0.16334f
C382 a_3505_591# vss 0.19593f
C383 a_743_591# vss 0
C384 a_1554_957# vss 0.00255f
C385 a_1309_969# vss 0.00108f
C386 a_897_957# vss 0.00593f
C387 a_731_969# vss 0.0099f
C388 a_540_957# vss 0.05753f
C389 a_3339_591# vss 0.1925f
C390 a_3347_823# vss 0.35052f
C391 a_2051_591# vss 0.80683f
C392 a_1853_591# vss 1.23076f
C393 a_1200_969# vss 0.18826f
C394 a_1375_895# vss 0.35716f
C395 a_635_969# vss 0.19702f
C396 a_939_21# vss 1.17371f
C397 a_853_565# vss 0.12952f
C398 a_285_597# vss 0.22948f
C399 a_119_597# vss 0.51119f
.ends
