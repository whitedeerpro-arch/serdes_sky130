* Working r5 candidate: the r4 frontend with the 4-bit VCO (vco_ring4_4b.spice, code 0..15 in half units).
* Working r4: r3 frontend with the r4 full-rate receivers (serdes_cml_to_cmos_r4)
* on all four extraction branches; the 250 MHz feedback receivers are unchanged.
* Working r3: two real interstage CML buffers in EVERY active/dummy prescaler.
* Active low-overdrive divider integration revision. Uses the preceding VCO
* and receiver refinement cells; every real/dummy prescaler has its own MOS bias mirror.
* PVT refinement candidate: exact same balanced wiring and powered dummy.
* Reusable wiring of the native balanced extraction fixture; external bias.
* Three powered dummy feedback paths are a conservative reference, not final power optimization.
* Dummy DFF reset differs from PFD internal reset; see docs/history/pll_first_debug.md.
* Trailing ports expose the extraction-buffer output b0 and the divider taps
* the TX clocks and the start-state detector use; they add no circuitry.
.subckt pll_clock_frontend_r5 ctrl cfg0 cfg1 cfg2 cfg3 vbias rst_b fb0 cm0p cm0n cm1p cm1n cm2p cm2n cm3p cm3n vdd vdd_dummy vss
+ b0p b0n d02p d02n d04p d04n d08p d08n d22p d22n d24p d24n d32p d32n params: cwire=0.5f
Xvco v0p v0n v1p v1n v2p v2n v3p v3n ctrl cfg0 cfg1 cfg2 cfg3 vbias vdd vss pll_vco_ring4_4b
Cw0p v0p vss {cwire}
Cw0n v0n vss {cwire}
Xbuf0 v0p v0n b0p b0n vbias vdd vss serdes_cml_buffer
Xrx0 b0p b0n cm0p cm0n vbias vdd vss serdes_cml_to_cmos_r4
Ccm0p cm0p vss 20f
Ccm0n cm0n vss 20f
Xpre0 b0p b0n d02p d02n d04p d04n d08p d08n vbias vdd vss pll_cml_prescaler8
Xfb0 d08p d08n fb0 fb0n vbias vdd vss serdes_cml_to_cmos_pvt_candidate
Cfb0 fb0 vss 20f
Cfb0n fb0n vss 20f
Cdiv02p d02p vss 5f
Cdiv02n d02n vss 5f
Cdiv04p d04p vss 5f
Cdiv04n d04n vss 5f
Cdiv08p d08p vss 5f
Cdiv08n d08n vss 5f
Cw1p v1p vss {cwire}
Cw1n v1n vss {cwire}
Xbuf1 v1p v1n b1p b1n vbias vdd vss serdes_cml_buffer
Xrx1 b1p b1n cm1p cm1n vbias vdd vss serdes_cml_to_cmos_r4
Ccm1p cm1p vss 20f
Ccm1n cm1n vss 20f
Xpre1 b1p b1n d12p d12n d14p d14n d18p d18n vbias vdd_dummy vss pll_cml_prescaler8
Xfb1 d18p d18n fb1 fb1n vbias vdd_dummy vss serdes_cml_to_cmos_pvt_candidate
Cfb1 fb1 vss 20f
Cfb1n fb1n vss 20f
Cdiv12p d12p vss 5f
Cdiv12n d12n vss 5f
Cdiv14p d14p vss 5f
Cdiv14n d14n vss 5f
Cdiv18p d18p vss 5f
Cdiv18n d18n vss 5f
Xload1 vdd_dummy fb1 rst_b dq1 vdd_dummy vss serdes_cmos_dff_reset
Cdq1 dq1 vss 20f
Cw2p v2p vss {cwire}
Cw2n v2n vss {cwire}
Xbuf2 v2p v2n b2p b2n vbias vdd vss serdes_cml_buffer
Xrx2 b2p b2n cm2p cm2n vbias vdd vss serdes_cml_to_cmos_r4
Ccm2p cm2p vss 20f
Ccm2n cm2n vss 20f
Xpre2 b2p b2n d22p d22n d24p d24n d28p d28n vbias vdd_dummy vss pll_cml_prescaler8
Xfb2 d28p d28n fb2 fb2n vbias vdd_dummy vss serdes_cml_to_cmos_pvt_candidate
Cfb2 fb2 vss 20f
Cfb2n fb2n vss 20f
Cdiv22p d22p vss 5f
Cdiv22n d22n vss 5f
Cdiv24p d24p vss 5f
Cdiv24n d24n vss 5f
Cdiv28p d28p vss 5f
Cdiv28n d28n vss 5f
Xload2 vdd_dummy fb2 rst_b dq2 vdd_dummy vss serdes_cmos_dff_reset
Cdq2 dq2 vss 20f
Cw3p v3p vss {cwire}
Cw3n v3n vss {cwire}
Xbuf3 v3p v3n b3p b3n vbias vdd vss serdes_cml_buffer
Xrx3 b3p b3n cm3p cm3n vbias vdd vss serdes_cml_to_cmos_r4
Ccm3p cm3p vss 20f
Ccm3n cm3n vss 20f
Xpre3 b3p b3n d32p d32n d34p d34n d38p d38n vbias vdd_dummy vss pll_cml_prescaler8
Xfb3 d38p d38n fb3 fb3n vbias vdd_dummy vss serdes_cml_to_cmos_pvt_candidate
Cfb3 fb3 vss 20f
Cfb3n fb3n vss 20f
Cdiv32p d32p vss 5f
Cdiv32n d32n vss 5f
Cdiv34p d34p vss 5f
Cdiv34n d34n vss 5f
Cdiv38p d38p vss 5f
Cdiv38n d38n vss 5f
Xload3 vdd_dummy fb3 rst_b dq3 vdd_dummy vss serdes_cmos_dff_reset
Cdq3 dq3 vss 20f
.ends pll_clock_frontend_r5
