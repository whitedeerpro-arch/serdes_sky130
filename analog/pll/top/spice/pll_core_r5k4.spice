* PLL core, r5 frontend + k = 4 loop (candidate, docs/design/pll_loop.md "收口计划"): pll_clock_frontend_r5 (4-bit VCO,
* four extraction branches, real prescaler and feedback receiver on branch 0, powered dummies on 1-3), transistor PFD,
* current-steering CP at 200 uA (pll_cp_steer, k = 4 sizes, follower tail 100 uA from ibias = 10 uA), PDK loop filter
* pll_loop_filter_k4 (Rz 4.13 k, 18 x 1 pF MIM, no Cf) with its precharge gates.  Bias and reference external; no
* calibration controller (the code comes in on cfg0..3).  Needs the files of the frontend, pfd, cp, cp steer, loop filter.
.subckt pll_core_r5k4 ref rst_b vbn vbp ibias vbias cfg0 cfg1 cfg2 cfg3 pre_ref pre_en ctrl z up dn fb0 cm0p cm0n cm1p cm1n
+ cm2p cm2n cm3p cm3n vdd vdd_dummy vss
Xclock ctrl cfg0 cfg1 cfg2 cfg3 vbias rst_b fb0 cm0p cm0n cm1p cm1n cm2p cm2n cm3p cm3n vdd vdd_dummy vss
+ pb0p pb0n p02p p02n p04p p04n p08p p08n p22p p22n p24p p24n p32p p32n pll_clock_frontend_r5
Xpfd ref fb0 rst_b up dn vdd vss pll_pfd
Xcp up dn cpo vbn vbp ibias vdd vss pll_cp_steer wn=20 wp=80 wsn=8 wsp=16 up_wn=2 up_wp=8 dn_wn=4 dn_wp=8 pnf=16 nnf=4
+ ntail=2 cdum=0.3p
Xlf cpo ctrl z pre_ref pre_en vdd vss pll_loop_filter_k4
.ends pll_core_r5k4
