* Loop-isolation plant, fitted to SAME-CORNER measured r3 native VCO points.
* This model replaces VCO and divide8 dynamics; PFD/CP/LF remain transistor/PDK.
* A trajectory outside [vlo,vhi] is INVALID even if the clipped frequency locks.
* No VCO noise, power, startup, divider state or transport delay is modeled.
.subckt pll_measured_feedback ctrl fb phase f_ghz valid vdd vss
+ params: vlo=1 vmi=1.2 vhi=1.4 flo=1.9G fmi=2G fhi=2.1G
+ ndiv=8 edge_shape=.04
Bfreq f_ghz vss V={max(min(flo,min(fmi,fhi)),min(max(flo,max(fmi,fhi)),(v(ctrl,vss)<vmi ? fmi+(fmi-flo)*(v(ctrl,vss)-vmi)/(vmi-vlo) : fmi+(fhi-fmi)*(v(ctrl,vss)-vmi)/(vhi-vmi))))/1G}
Bvalid valid vss V={(v(ctrl,vss)>=vlo && v(ctrl,vss)<=vhi) ? 1 : 0}
Bint vss phase I={v(f_ghz,vss)*1G/ndiv*1n}
Cphase phase vss 1n
Rphase phase vss 1T
Bclock fb vss V={v(vdd,vss)*(.5+.5*tanh(sin(6.283185307179586*v(phase,vss))/edge_shape))}
.ends pll_measured_feedback
