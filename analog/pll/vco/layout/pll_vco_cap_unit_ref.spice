* Official layout reference (Claude, 2026-11-11; docs/layout/tasks.md T3).  Device values from analog/pll/vco/spice/vco_ring4_4b.spice
* (bank x1.15 of 2026-11-11) and the tasks.md device table; resistors are the fixed-width high_po cards (3 terminals, body vss).
* MIM: the FIRST pin is the top plate (capm, Magic's extraction order) and must be 'node'; the bottom plate (met3) goes to
* the switch drain 'plate'.  LVS treats the capacitor as symmetric and does not check this: read it in *_lvs.spice.
* 2026-11-12: switch as two fingers sharing the drain (nf=2, total W unchanged): the off-state residual of the unit
* (15 per phase node at code 0) is dominated by the drain junction and the bottom plate; one finger 1.34 um2 drain.
.subckt pll_vco_cap_unit node en vss
Xcap node plate sky130_fd_pr__cap_mim_m3_1 w=2.52 l=2.68
Xsw plate en vss vss sky130_fd_pr__nfet_01v8 w=2.68 l=0.15 nf=2
.ends pll_vco_cap_unit
