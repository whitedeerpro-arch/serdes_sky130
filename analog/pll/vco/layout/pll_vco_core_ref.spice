* Official layout reference (Claude, 2026-11-11; docs/layout/tasks.md T3).  Device values from analog/pll/vco/spice/vco_ring4_4b.spice
* (bank x1.15 of 2026-11-11) and the tasks.md device table; resistors are the fixed-width high_po cards (3 terminals, body vss).
* Hierarchical: pll_vco_ring4_4b = 4 x pll_vco_delay_stage (ring with one differential crossing) + per phase node one
* pll_vco_varactor and one pll_vco_cap_bank; pll_vco_core = ring + the four first-stage buffers (the quiet-domain block
* of analog/pll/top/spice/clock_frontend_r5q.spice; its 0.5 fF wire capacitors are simulation proxies, not drawn).
.subckt pll_vco_delay_stage inp inn outp outn vbias vdd vss
Xmp outp inp tail vss sky130_fd_pr__nfet_01v8_lvt w=40 l=0.15
Xmn outn inn tail vss sky130_fd_pr__nfet_01v8_lvt w=40 l=0.15
Xtail tail vbias vss vss sky130_fd_pr__nfet_01v8 w=20 l=0.5
Xrp vdd outp vss sky130_fd_pr__res_high_po_2p85 l=2.44
Xrn vdd outn vss sky130_fd_pr__res_high_po_2p85 l=2.44
.ends pll_vco_delay_stage
.subckt serdes_cml_buffer inp inn outp outn vbias vdd vss
Xmp outn inp tail vss sky130_fd_pr__nfet_01v8_lvt w=12 l=0.15
Xmn outp inn tail vss sky130_fd_pr__nfet_01v8_lvt w=12 l=0.15
Xtail tail vbias vss vss sky130_fd_pr__nfet_01v8 w=12 l=0.5
Xrp vdd outn vss sky130_fd_pr__res_high_po_2p85 l=4.22
Xrn vdd outp vss sky130_fd_pr__res_high_po_2p85 l=4.22
.ends serdes_cml_buffer
.subckt pll_vco_varactor node vctrl vss
Xv0 node vctrl vss sky130_fd_pr__cap_var_lvt w=4.5 l=0.5
Xv1 node vctrl vss sky130_fd_pr__cap_var_lvt w=4.5 l=0.5
Xv2 node vctrl vss sky130_fd_pr__cap_var_lvt w=4.5 l=0.5
Xv3 node vctrl vss sky130_fd_pr__cap_var_lvt w=4.5 l=0.5
.ends pll_vco_varactor
.subckt pll_vco_cap_bank node b0 b1 b2 b3 vss
Xc00 node p00 sky130_fd_pr__cap_mim_m3_1 w=2.52 l=2.68
Xs00 p00 b0 vss vss sky130_fd_pr__nfet_01v8 w=2.68 l=0.15
Xc01 node p01 sky130_fd_pr__cap_mim_m3_1 w=2.52 l=2.68
Xs01 p01 b1 vss vss sky130_fd_pr__nfet_01v8 w=2.68 l=0.15
Xc02 node p02 sky130_fd_pr__cap_mim_m3_1 w=2.52 l=2.68
Xs02 p02 b1 vss vss sky130_fd_pr__nfet_01v8 w=2.68 l=0.15
Xc03 node p03 sky130_fd_pr__cap_mim_m3_1 w=2.52 l=2.68
Xs03 p03 b2 vss vss sky130_fd_pr__nfet_01v8 w=2.68 l=0.15
Xc04 node p04 sky130_fd_pr__cap_mim_m3_1 w=2.52 l=2.68
Xs04 p04 b2 vss vss sky130_fd_pr__nfet_01v8 w=2.68 l=0.15
Xc05 node p05 sky130_fd_pr__cap_mim_m3_1 w=2.52 l=2.68
Xs05 p05 b2 vss vss sky130_fd_pr__nfet_01v8 w=2.68 l=0.15
Xc06 node p06 sky130_fd_pr__cap_mim_m3_1 w=2.52 l=2.68
Xs06 p06 b2 vss vss sky130_fd_pr__nfet_01v8 w=2.68 l=0.15
Xc07 node p07 sky130_fd_pr__cap_mim_m3_1 w=2.52 l=2.68
Xs07 p07 b3 vss vss sky130_fd_pr__nfet_01v8 w=2.68 l=0.15
Xc08 node p08 sky130_fd_pr__cap_mim_m3_1 w=2.52 l=2.68
Xs08 p08 b3 vss vss sky130_fd_pr__nfet_01v8 w=2.68 l=0.15
Xc09 node p09 sky130_fd_pr__cap_mim_m3_1 w=2.52 l=2.68
Xs09 p09 b3 vss vss sky130_fd_pr__nfet_01v8 w=2.68 l=0.15
Xc10 node p10 sky130_fd_pr__cap_mim_m3_1 w=2.52 l=2.68
Xs10 p10 b3 vss vss sky130_fd_pr__nfet_01v8 w=2.68 l=0.15
Xc11 node p11 sky130_fd_pr__cap_mim_m3_1 w=2.52 l=2.68
Xs11 p11 b3 vss vss sky130_fd_pr__nfet_01v8 w=2.68 l=0.15
Xc12 node p12 sky130_fd_pr__cap_mim_m3_1 w=2.52 l=2.68
Xs12 p12 b3 vss vss sky130_fd_pr__nfet_01v8 w=2.68 l=0.15
Xc13 node p13 sky130_fd_pr__cap_mim_m3_1 w=2.52 l=2.68
Xs13 p13 b3 vss vss sky130_fd_pr__nfet_01v8 w=2.68 l=0.15
Xc14 node p14 sky130_fd_pr__cap_mim_m3_1 w=2.52 l=2.68
Xs14 p14 b3 vss vss sky130_fd_pr__nfet_01v8 w=2.68 l=0.15
.ends pll_vco_cap_bank
.subckt pll_vco_ring4_4b q0p q0n q1p q1n q2p q2n q3p q3n vctrl b0 b1 b2 b3 vbias vdd vss
X0 q3n q3p q0p q0n vbias vdd vss pll_vco_delay_stage
X1 q0p q0n q1p q1n vbias vdd vss pll_vco_delay_stage
X2 q1p q1n q2p q2n vbias vdd vss pll_vco_delay_stage
X3 q2p q2n q3p q3n vbias vdd vss pll_vco_delay_stage
Xv0p q0p vctrl vss pll_vco_varactor
Xv0n q0n vctrl vss pll_vco_varactor
Xv1p q1p vctrl vss pll_vco_varactor
Xv1n q1n vctrl vss pll_vco_varactor
Xv2p q2p vctrl vss pll_vco_varactor
Xv2n q2n vctrl vss pll_vco_varactor
Xv3p q3p vctrl vss pll_vco_varactor
Xv3n q3n vctrl vss pll_vco_varactor
Xc0p q0p b0 b1 b2 b3 vss pll_vco_cap_bank
Xc0n q0n b0 b1 b2 b3 vss pll_vco_cap_bank
Xc1p q1p b0 b1 b2 b3 vss pll_vco_cap_bank
Xc1n q1n b0 b1 b2 b3 vss pll_vco_cap_bank
Xc2p q2p b0 b1 b2 b3 vss pll_vco_cap_bank
Xc2n q2n b0 b1 b2 b3 vss pll_vco_cap_bank
Xc3p q3p b0 b1 b2 b3 vss pll_vco_cap_bank
Xc3n q3n b0 b1 b2 b3 vss pll_vco_cap_bank
.ends pll_vco_ring4_4b
.subckt pll_vco_core ctrl cfg0 cfg1 cfg2 cfg3 vbias_q b0p b0n b1p b1n b2p b2n b3p b3n vdd_q vss
Xvco v0p v0n v1p v1n v2p v2n v3p v3n ctrl cfg0 cfg1 cfg2 cfg3 vbias_q vdd_q vss pll_vco_ring4_4b
Xbuf0 v0p v0n b0p b0n vbias_q vdd_q vss serdes_cml_buffer
Xbuf1 v1p v1n b1p b1n vbias_q vdd_q vss serdes_cml_buffer
Xbuf2 v2p v2n b2p b2n vbias_q vdd_q vss serdes_cml_buffer
Xbuf3 v3p v3n b3p b3n vbias_q vdd_q vss serdes_cml_buffer
.ends pll_vco_core
