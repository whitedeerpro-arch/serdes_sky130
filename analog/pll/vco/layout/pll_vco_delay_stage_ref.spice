* Official layout reference (Claude, 2026-11-12, VCO r6; docs/layout/tasks.md T3).  Device values from
* analog/pll/vco/spice/vco_ring4_r6.spice, vco_delay_r6.spice, cap_bank_5b.spice.  Resistors are fixed-width high_po
* (3 terminals, body vss).
* One stage of the ring.  Input pair 8 fingers of 5 um (w=40), tail 4 fingers of 6.3 um (w=25.2).  Each load is TWO
* 2.85 um wide high_po of l=4.77 in parallel (about 676 ohm each, 338 ohm per side): one short resistor of the same
* value spreads +-20.7 % over the resistor corners, the long pair +-14.7 %.  Do not merge them into one device.
.subckt pll_vco_delay_stage inp inn outp outn vbias vdd vss
Xmp outp inp tail vss sky130_fd_pr__nfet_01v8_lvt w=40 l=0.15
Xmn outn inn tail vss sky130_fd_pr__nfet_01v8_lvt w=40 l=0.15
Xtail tail vbias vss vss sky130_fd_pr__nfet_01v8 w=25.2 l=0.5
Xrp1 vdd outp vss sky130_fd_pr__res_high_po_2p85 l=4.77
Xrp2 vdd outp vss sky130_fd_pr__res_high_po_2p85 l=4.77
Xrn1 vdd outn vss sky130_fd_pr__res_high_po_2p85 l=4.77
Xrn2 vdd outn vss sky130_fd_pr__res_high_po_2p85 l=4.77
.ends pll_vco_delay_stage
