* Official layout reference (Claude, 2026-11-11; docs/layout/tasks.md T3).  Device values from analog/pll/vco/spice/vco_ring4_4b.spice
* (bank x1.15 of 2026-11-11) and the tasks.md device table; resistors are the fixed-width high_po cards (3 terminals, body vss).
* Four separate fingers W 4.5 / L 0.5 (vm = 4 in simulation), NOT one W 18 device: the poly series resistance scales with
* W / L per finger and set the r3 VCO's loss (docs/design/pll_vco.md).  Gate (poly) = 'node', n-well = 'vctrl', body vss.
.subckt pll_vco_varactor node vctrl vss
Xv0 node vctrl vss sky130_fd_pr__cap_var_lvt w=4.5 l=0.5
Xv1 node vctrl vss sky130_fd_pr__cap_var_lvt w=4.5 l=0.5
Xv2 node vctrl vss sky130_fd_pr__cap_var_lvt w=4.5 l=0.5
Xv3 node vctrl vss sky130_fd_pr__cap_var_lvt w=4.5 l=0.5
.ends pll_vco_varactor
