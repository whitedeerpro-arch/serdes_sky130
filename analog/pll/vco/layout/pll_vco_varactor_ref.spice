* Official layout reference (Claude, 2026-11-12, VCO r6; docs/layout/tasks.md T3).  Device values from
* analog/pll/vco/spice/vco_ring4_r6.spice, vco_delay_r6.spice, cap_bank_5b.spice.  Resistors are fixed-width high_po
* (3 terminals, body vss).
* Four separate fingers W 5.2 / L 0.5 (vm = 4 in simulation), NOT one W 20.8 device: the poly series resistance scales
* with W / L per finger.  Gate (poly) = 'node', n-well = 'vctrl', body vss.
.subckt pll_vco_varactor node vctrl vss
Xv0 node vctrl vss sky130_fd_pr__cap_var_lvt w=5.2 l=0.5
Xv1 node vctrl vss sky130_fd_pr__cap_var_lvt w=5.2 l=0.5
Xv2 node vctrl vss sky130_fd_pr__cap_var_lvt w=5.2 l=0.5
Xv3 node vctrl vss sky130_fd_pr__cap_var_lvt w=5.2 l=0.5
.ends pll_vco_varactor
