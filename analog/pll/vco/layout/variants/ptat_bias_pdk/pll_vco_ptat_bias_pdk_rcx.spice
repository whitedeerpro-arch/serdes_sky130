* NGSPICE file created from pll_vco_ptat_bias_pdk.ext - technology: sky130A

.subckt pll_vco_ptat_bias_pdk out vgi vg vdd
X0 vdd.t70 vg.t48 out vdd.t69 sky130_fd_pr__pfet_01v8_lvt ad=2.03 pd=14.29 as=2.03 ps=14.29 w=14 l=6
X1 out vg.t63 vdd.t46 vdd.t47 sky130_fd_pr__pfet_01v8_lvt ad=2.03 pd=14.29 as=2.03 ps=14.29 w=14 l=6
X2 vdd.t118 vg.t2 out vdd.t72 sky130_fd_pr__pfet_01v8_lvt ad=2.03 pd=14.29 as=2.03 ps=14.29 w=14 l=6
X3 out vgi.t9 vdd.t27 vdd.t28 sky130_fd_pr__pfet_01v8_lvt ad=1.16 pd=8.29 as=1.16 ps=8.29 w=8 l=4
X4 out vg.t45 vdd.t73 vdd.t74 sky130_fd_pr__pfet_01v8_lvt ad=2.03 pd=14.29 as=2.03 ps=14.29 w=14 l=6
X5 vdd.t86 vg.t34 out vdd.t57 sky130_fd_pr__pfet_01v8_lvt ad=2.03 pd=14.29 as=2.03 ps=14.29 w=14 l=6
X6 vdd.t114 vg.t6 out vdd.t66 sky130_fd_pr__pfet_01v8_lvt ad=2.03 pd=14.29 as=2.03 ps=14.29 w=14 l=6
X7 out vg.t39 vdd.t80 vdd.t50 sky130_fd_pr__pfet_01v8_lvt ad=2.03 pd=14.29 as=2.03 ps=14.29 w=14 l=6
X8 vdd.t15 vgi.t18 out vdd.t14 sky130_fd_pr__pfet_01v8_lvt ad=1.16 pd=8.29 as=1.16 ps=8.29 w=8 l=4
X9 vdd.t98 vg.t22 out vdd.t75 sky130_fd_pr__pfet_01v8_lvt ad=4.06 pd=28.58 as=2.03 ps=14.29 w=14 l=6
X10 out vgi.t3 vdd.t36 vdd.t37 sky130_fd_pr__pfet_01v8_lvt ad=1.16 pd=8.29 as=1.16 ps=8.29 w=8 l=4
X11 vdd.t73 vg.t46 out vdd.t72 sky130_fd_pr__pfet_01v8_lvt ad=2.03 pd=14.29 as=2.03 ps=14.29 w=14 l=6
X12 vdd.t84 vg.t36 out vdd.t54 sky130_fd_pr__pfet_01v8_lvt ad=2.03 pd=14.29 as=2.03 ps=14.29 w=14 l=6
X13 out vg.t29 vdd.t90 vdd.t65 sky130_fd_pr__pfet_01v8_lvt ad=2.03 pd=14.29 as=2.03 ps=14.29 w=14 l=6
X14 out vgi.t15 vdd.t18 vdd.t19 sky130_fd_pr__pfet_01v8_lvt ad=1.16 pd=8.29 as=1.16 ps=8.29 w=8 l=4
X15 out vgi.t27 vdd.t1 vdd.t0 sky130_fd_pr__pfet_01v8_lvt ad=1.16 pd=8.29 as=2.32 ps=16.58 w=8 l=4
X16 vdd.t67 vg.t50 out vdd.t66 sky130_fd_pr__pfet_01v8_lvt ad=2.03 pd=14.29 as=2.03 ps=14.29 w=14 l=6
X17 vdd.t6 vgi.t24 out vdd.t5 sky130_fd_pr__pfet_01v8_lvt ad=1.16 pd=8.29 as=1.16 ps=8.29 w=8 l=4
X18 out vgi.t7 vdd.t30 vdd.t31 sky130_fd_pr__pfet_01v8_lvt ad=1.16 pd=8.29 as=1.16 ps=8.29 w=8 l=4
X19 vdd.t88 vg.t32 out vdd.t60 sky130_fd_pr__pfet_01v8_lvt ad=2.03 pd=14.29 as=2.03 ps=14.29 w=14 l=6
X20 vdd.t90 vg.t30 out vdd.t63 sky130_fd_pr__pfet_01v8_lvt ad=2.03 pd=14.29 as=2.03 ps=14.29 w=14 l=6
X21 out vg.t27 vdd.t92 vdd.t68 sky130_fd_pr__pfet_01v8_lvt ad=2.03 pd=14.29 as=2.03 ps=14.29 w=14 l=6
X22 vdd.t78 vg.t42 out vdd.t45 sky130_fd_pr__pfet_01v8_lvt ad=2.03 pd=14.29 as=2.03 ps=14.29 w=14 l=6
X23 vdd.t80 vg.t40 out vdd.t48 sky130_fd_pr__pfet_01v8_lvt ad=2.03 pd=14.29 as=2.03 ps=14.29 w=14 l=6
X24 out vg.t37 vdd.t82 vdd.t53 sky130_fd_pr__pfet_01v8_lvt ad=2.03 pd=14.29 as=2.03 ps=14.29 w=14 l=6
X25 out vg.t25 vdd.t94 vdd.t71 sky130_fd_pr__pfet_01v8_lvt ad=2.03 pd=14.29 as=2.03 ps=14.29 w=14 l=6
X26 out vgi.t21 vdd.t9 vdd.t10 sky130_fd_pr__pfet_01v8_lvt ad=1.16 pd=8.29 as=1.16 ps=8.29 w=8 l=4
X27 out vg.t11 vdd.t108 vdd.t59 sky130_fd_pr__pfet_01v8_lvt ad=2.03 pd=14.29 as=2.03 ps=14.29 w=14 l=6
X28 out vgi.t1 vdd.t39 vdd.t40 sky130_fd_pr__pfet_01v8_lvt ad=1.16 pd=8.29 as=1.16 ps=8.29 w=8 l=4
X29 out vg.t21 vdd.t99 vdd.t43 sky130_fd_pr__pfet_01v8_lvt ad=2.03 pd=14.29 as=4.06 ps=28.58 w=14 l=6
X30 vdd.t104 vg.t16 out vdd.t51 sky130_fd_pr__pfet_01v8_lvt ad=2.03 pd=14.29 as=2.03 ps=14.29 w=14 l=6
X31 out vg.t13 vdd.t106 vdd.t56 sky130_fd_pr__pfet_01v8_lvt ad=2.03 pd=14.29 as=2.03 ps=14.29 w=14 l=6
X32 out vg.t31 vdd.t88 vdd.t62 sky130_fd_pr__pfet_01v8_lvt ad=2.03 pd=14.29 as=2.03 ps=14.29 w=14 l=6
X33 vdd.t36 vgi.t4 out vdd.t35 sky130_fd_pr__pfet_01v8_lvt ad=1.16 pd=8.29 as=1.16 ps=8.29 w=8 l=4
X34 out vg.t41 vdd.t78 vdd.t47 sky130_fd_pr__pfet_01v8_lvt ad=2.03 pd=14.29 as=2.03 ps=14.29 w=14 l=6
X35 vdd.t94 vg.t26 out vdd.t69 sky130_fd_pr__pfet_01v8_lvt ad=2.03 pd=14.29 as=2.03 ps=14.29 w=14 l=6
X36 out vgi.t13 vdd.t21 vdd.t22 sky130_fd_pr__pfet_01v8_lvt ad=1.16 pd=8.29 as=1.16 ps=8.29 w=8 l=4
X37 out vg.t55 vdd.t58 vdd.t59 sky130_fd_pr__pfet_01v8_lvt ad=2.03 pd=14.29 as=2.03 ps=14.29 w=14 l=6
X38 out vg.t23 vdd.t96 vdd.t74 sky130_fd_pr__pfet_01v8_lvt ad=2.03 pd=14.29 as=2.03 ps=14.29 w=14 l=6
X39 out vg.t17 vdd.t102 vdd.t50 sky130_fd_pr__pfet_01v8_lvt ad=2.03 pd=14.29 as=2.03 ps=14.29 w=14 l=6
X40 vdd.t108 vg.t12 out vdd.t57 sky130_fd_pr__pfet_01v8_lvt ad=2.03 pd=14.29 as=2.03 ps=14.29 w=14 l=6
X41 vdd.t3 vgi.t26 out vdd.t2 sky130_fd_pr__pfet_01v8_lvt ad=1.16 pd=8.29 as=1.16 ps=8.29 w=8 l=4
X42 out vgi.t23 vdd.t6 vdd.t7 sky130_fd_pr__pfet_01v8_lvt ad=1.16 pd=8.29 as=1.16 ps=8.29 w=8 l=4
X43 out vg.t65 vdd.t44 vdd.t43 sky130_fd_pr__pfet_01v8_lvt ad=2.03 pd=14.29 as=4.06 ps=28.58 w=14 l=6
X44 vdd.t52 vg.t60 out vdd.t51 sky130_fd_pr__pfet_01v8_lvt ad=2.03 pd=14.29 as=2.03 ps=14.29 w=14 l=6
X45 out vg.t57 vdd.t55 vdd.t56 sky130_fd_pr__pfet_01v8_lvt ad=2.03 pd=14.29 as=2.03 ps=14.29 w=14 l=6
X46 vdd.t120 vg.t0 out vdd.t75 sky130_fd_pr__pfet_01v8_lvt ad=4.06 pd=28.58 as=2.03 ps=14.29 w=14 l=6
X47 vdd.t21 vgi.t14 out vdd.t20 sky130_fd_pr__pfet_01v8_lvt ad=1.16 pd=8.29 as=1.16 ps=8.29 w=8 l=4
X48 vdd.t27 vgi.t10 out vdd.t26 sky130_fd_pr__pfet_01v8_lvt ad=1.16 pd=8.29 as=1.16 ps=8.29 w=8 l=4
X49 vdd.t96 vg.t24 out vdd.t72 sky130_fd_pr__pfet_01v8_lvt ad=2.03 pd=14.29 as=2.03 ps=14.29 w=14 l=6
X50 vdd.t106 vg.t14 out vdd.t54 sky130_fd_pr__pfet_01v8_lvt ad=2.03 pd=14.29 as=2.03 ps=14.29 w=14 l=6
X51 out vg.t7 vdd.t112 vdd.t65 sky130_fd_pr__pfet_01v8_lvt ad=2.03 pd=14.29 as=2.03 ps=14.29 w=14 l=6
X52 vdd.t12 vgi.t20 out vdd.t11 sky130_fd_pr__pfet_01v8_lvt ad=1.16 pd=8.29 as=1.16 ps=8.29 w=8 l=4
X53 vdd.t39 vgi.t2 out vdd.t38 sky130_fd_pr__pfet_01v8_lvt ad=1.16 pd=8.29 as=1.16 ps=8.29 w=8 l=4
X54 vdd.t58 vg.t56 out vdd.t57 sky130_fd_pr__pfet_01v8_lvt ad=2.03 pd=14.29 as=2.03 ps=14.29 w=14 l=6
X55 vdd.t92 vg.t28 out vdd.t66 sky130_fd_pr__pfet_01v8_lvt ad=2.03 pd=14.29 as=2.03 ps=14.29 w=14 l=6
X56 out vgi.t17 vdd.t15 vdd.t16 sky130_fd_pr__pfet_01v8_lvt ad=1.16 pd=8.29 as=1.16 ps=8.29 w=8 l=4
X57 out vg.t61 vdd.t49 vdd.t50 sky130_fd_pr__pfet_01v8_lvt ad=2.03 pd=14.29 as=2.03 ps=14.29 w=14 l=6
X58 vdd.t76 vg.t44 out vdd.t75 sky130_fd_pr__pfet_01v8_lvt ad=4.06 pd=28.58 as=2.03 ps=14.29 w=14 l=6
X59 out vgi.t5 vdd.t33 vdd.t34 sky130_fd_pr__pfet_01v8_lvt ad=1.16 pd=8.29 as=1.16 ps=8.29 w=8 l=4
X60 vdd.t102 vg.t18 out vdd.t48 sky130_fd_pr__pfet_01v8_lvt ad=2.03 pd=14.29 as=2.03 ps=14.29 w=14 l=6
X61 vdd.t110 vg.t10 out vdd.t60 sky130_fd_pr__pfet_01v8_lvt ad=2.03 pd=14.29 as=2.03 ps=14.29 w=14 l=6
X62 vdd.t112 vg.t8 out vdd.t63 sky130_fd_pr__pfet_01v8_lvt ad=2.03 pd=14.29 as=2.03 ps=14.29 w=14 l=6
X63 out vg.t5 vdd.t114 vdd.t68 sky130_fd_pr__pfet_01v8_lvt ad=2.03 pd=14.29 as=2.03 ps=14.29 w=14 l=6
X64 out vg.t3 vdd.t116 vdd.t71 sky130_fd_pr__pfet_01v8_lvt ad=2.03 pd=14.29 as=2.03 ps=14.29 w=14 l=6
X65 out vg.t51 vdd.t64 vdd.t65 sky130_fd_pr__pfet_01v8_lvt ad=2.03 pd=14.29 as=2.03 ps=14.29 w=14 l=6
X66 vdd.t100 vg.t20 out vdd.t45 sky130_fd_pr__pfet_01v8_lvt ad=2.03 pd=14.29 as=2.03 ps=14.29 w=14 l=6
X67 out vg.t15 vdd.t104 vdd.t53 sky130_fd_pr__pfet_01v8_lvt ad=2.03 pd=14.29 as=2.03 ps=14.29 w=14 l=6
X68 vdd.t55 vg.t58 out vdd.t54 sky130_fd_pr__pfet_01v8_lvt ad=2.03 pd=14.29 as=2.03 ps=14.29 w=14 l=6
X69 out vgi.t25 vdd.t3 vdd.t4 sky130_fd_pr__pfet_01v8_lvt ad=1.16 pd=8.29 as=1.16 ps=8.29 w=8 l=4
X70 vdd.t9 vgi.t22 out vdd.t8 sky130_fd_pr__pfet_01v8_lvt ad=1.16 pd=8.29 as=1.16 ps=8.29 w=8 l=4
X71 vdd.t24 vgi.t12 out vdd.t23 sky130_fd_pr__pfet_01v8_lvt ad=1.16 pd=8.29 as=1.16 ps=8.29 w=8 l=4
X72 vdd.t30 vgi.t8 out vdd.t29 sky130_fd_pr__pfet_01v8_lvt ad=1.16 pd=8.29 as=1.16 ps=8.29 w=8 l=4
X73 vdd.t42 vgi.t0 out vdd.t41 sky130_fd_pr__pfet_01v8_lvt ad=2.32 pd=16.58 as=1.16 ps=8.29 w=8 l=4
X74 out vg.t9 vdd.t110 vdd.t62 sky130_fd_pr__pfet_01v8_lvt ad=2.03 pd=14.29 as=2.03 ps=14.29 w=14 l=6
X75 out vg.t19 vdd.t100 vdd.t47 sky130_fd_pr__pfet_01v8_lvt ad=2.03 pd=14.29 as=2.03 ps=14.29 w=14 l=6
X76 vdd.t116 vg.t4 out vdd.t69 sky130_fd_pr__pfet_01v8_lvt ad=2.03 pd=14.29 as=2.03 ps=14.29 w=14 l=6
X77 out vgi.t11 vdd.t24 vdd.t25 sky130_fd_pr__pfet_01v8_lvt ad=1.16 pd=8.29 as=1.16 ps=8.29 w=8 l=4
X78 vdd.t49 vg.t62 out vdd.t48 sky130_fd_pr__pfet_01v8_lvt ad=2.03 pd=14.29 as=2.03 ps=14.29 w=14 l=6
X79 vdd.t61 vg.t54 out vdd.t60 sky130_fd_pr__pfet_01v8_lvt ad=2.03 pd=14.29 as=2.03 ps=14.29 w=14 l=6
X80 vdd.t64 vg.t52 out vdd.t63 sky130_fd_pr__pfet_01v8_lvt ad=2.03 pd=14.29 as=2.03 ps=14.29 w=14 l=6
X81 out vg.t49 vdd.t67 vdd.t68 sky130_fd_pr__pfet_01v8_lvt ad=2.03 pd=14.29 as=2.03 ps=14.29 w=14 l=6
X82 out vgi.t19 vdd.t12 vdd.t13 sky130_fd_pr__pfet_01v8_lvt ad=1.16 pd=8.29 as=1.16 ps=8.29 w=8 l=4
X83 vdd.t46 vg.t64 out vdd.t45 sky130_fd_pr__pfet_01v8_lvt ad=2.03 pd=14.29 as=2.03 ps=14.29 w=14 l=6
X84 out vg.t59 vdd.t52 vdd.t53 sky130_fd_pr__pfet_01v8_lvt ad=2.03 pd=14.29 as=2.03 ps=14.29 w=14 l=6
X85 out vg.t47 vdd.t70 vdd.t71 sky130_fd_pr__pfet_01v8_lvt ad=2.03 pd=14.29 as=2.03 ps=14.29 w=14 l=6
X86 out vg.t1 vdd.t118 vdd.t74 sky130_fd_pr__pfet_01v8_lvt ad=2.03 pd=14.29 as=2.03 ps=14.29 w=14 l=6
X87 vdd.t18 vgi.t16 out vdd.t17 sky130_fd_pr__pfet_01v8_lvt ad=1.16 pd=8.29 as=1.16 ps=8.29 w=8 l=4
X88 out vg.t33 vdd.t86 vdd.t59 sky130_fd_pr__pfet_01v8_lvt ad=2.03 pd=14.29 as=2.03 ps=14.29 w=14 l=6
X89 out vg.t53 vdd.t61 vdd.t62 sky130_fd_pr__pfet_01v8_lvt ad=2.03 pd=14.29 as=2.03 ps=14.29 w=14 l=6
X90 out vg.t43 vdd.t77 vdd.t43 sky130_fd_pr__pfet_01v8_lvt ad=2.03 pd=14.29 as=4.06 ps=28.58 w=14 l=6
X91 vdd.t82 vg.t38 out vdd.t51 sky130_fd_pr__pfet_01v8_lvt ad=2.03 pd=14.29 as=2.03 ps=14.29 w=14 l=6
X92 out vg.t35 vdd.t84 vdd.t56 sky130_fd_pr__pfet_01v8_lvt ad=2.03 pd=14.29 as=2.03 ps=14.29 w=14 l=6
X93 vdd.t33 vgi.t6 out vdd.t32 sky130_fd_pr__pfet_01v8_lvt ad=1.16 pd=8.29 as=1.16 ps=8.29 w=8 l=4
R0 vgi.t26 vgi.t25 2.49506
R1 vgi.t25 vgi.t24 2.49506
R2 vgi.n1 vgi.t24 2.49506
R3 vgi.n1 vgi.n2 2.49506
R4 vgi.n2 vgi.n3 2.49506
R5 vgi.n3 vgi.n4 2.49506
R6 vgi.n5 vgi.n4 2.49506
R7 vgi.n6 vgi.n5 2.49506
R8 vgi.n7 vgi.n6 2.49506
R9 vgi.n9 vgi.n7 2.49506
R10 vgi.n9 vgi.n8 2.49506
R11 vgi.n8 vgi.n10 2.49506
R12 vgi.n10 vgi.n11 2.49506
R13 vgi.n11 vgi.n12 2.49506
R14 vgi.n14 vgi.n12 2.49506
R15 vgi.n14 vgi.n15 2.49506
R16 vgi.n15 vgi.n16 2.49506
R17 vgi.n16 vgi.n17 2.49506
R18 vgi.n18 vgi.n17 2.49506
R19 vgi.n19 vgi.n18 2.49506
R20 vgi.n20 vgi.n19 2.49506
R21 vgi.n22 vgi.n20 2.49506
R22 vgi.n22 vgi.n21 2.49506
R23 vgi.n21 vgi.n23 2.49506
R24 vgi.n23 vgi.n24 2.49506
R25 vgi.n24 vgi.n25 2.49623
R26 vgi.n25 vgi.t0 65.8747
R27 vgi.n24 vgi.t1 65.8747
R28 vgi.n23 vgi.t2 65.8747
R29 vgi.n21 vgi.t3 65.8747
R30 vgi.n22 vgi.t4 65.8747
R31 vgi.n20 vgi.t5 65.8747
R32 vgi.n19 vgi.t6 65.8747
R33 vgi.n18 vgi.t7 65.8747
R34 vgi.n17 vgi.t8 65.8747
R35 vgi.n16 vgi.t9 65.8747
R36 vgi.n15 vgi.t10 65.8747
R37 vgi.n14 vgi.t11 65.8747
R38 vgi.n12 vgi.t12 65.8747
R39 vgi.n11 vgi.t13 65.8747
R40 vgi.n10 vgi.t14 65.8747
R41 vgi.n8 vgi.t15 65.8747
R42 vgi.n9 vgi.t16 65.8747
R43 vgi.n7 vgi.t17 65.8747
R44 vgi.n6 vgi.t18 65.8747
R45 vgi.n5 vgi.t19 65.8747
R46 vgi.n4 vgi.t20 65.8747
R47 vgi.n3 vgi.t21 65.8747
R48 vgi.n2 vgi.t22 65.8747
R49 vgi.n1 vgi.t23 65.8747
R50 vgi.n26 vgi.n25 8.96925
R51 vgi.n30 vgi.n0 5.95883
R52 vgi.n29 vgi.n0 5.95883
R53 vgi.n29 vgi.n28 5.95883
R54 vgi.n28 vgi.n13 5.95883
R55 vgi.n27 vgi.n13 5.95883
R56 vgi.n27 vgi.n26 5.95883
R57 vgi vgi.n30 5.58557
R58 vgi.n26 vgi.n21 4.5005
R59 vgi.n18 vgi.n27 4.5005
R60 vgi.n14 vgi.n13 4.5005
R61 vgi.n28 vgi.n8 4.5005
R62 vgi.n5 vgi.n29 4.5005
R63 vgi.n1 vgi.n0 4.5005
R64 vgi.n30 vgi.t27 4.50753
R65 vgi.t27 vgi.t26 2.49506
R66 vg.t41 vg.n0 3.01624
R67 vg.n20 vg.n1 3.01624
R68 vg.n22 vg.n2 3.01624
R69 vg.n24 vg.n3 3.01624
R70 vg.n26 vg.n4 3.01624
R71 vg.n5 vg.n29 3.01652
R72 vg.n29 vg.n30 3.01652
R73 vg.n30 vg.n31 3.01624
R74 vg.n33 vg.n32 2.44583
R75 vg.n34 vg.n6 3.01624
R76 vg.n36 vg.n7 3.01624
R77 vg.n38 vg.n8 3.01624
R78 vg.n40 vg.n9 3.01624
R79 vg.n42 vg.n10 3.01624
R80 vg.n11 vg.n45 3.01652
R81 vg.n45 vg.n46 3.01652
R82 vg.n46 vg.n47 3.01624
R83 vg.n49 vg.n48 2.44583
R84 vg.n50 vg.n12 3.01624
R85 vg.n52 vg.n13 3.01624
R86 vg.n54 vg.n14 3.01624
R87 vg.n56 vg.n15 3.01624
R88 vg.n58 vg.n16 3.01624
R89 vg.n17 vg.n61 3.01652
R90 vg.n61 vg.n62 3.01652
R91 vg.n62 vg.n63 3.01624
R92 vg.n31 vg.t22 67.7457
R93 vg.n30 vg.t23 67.7457
R94 vg.n29 vg.t24 67.7457
R95 vg.n5 vg.t25 67.7457
R96 vg.n28 vg.t26 67.7457
R97 vg.n27 vg.t27 67.7457
R98 vg.n4 vg.t28 67.7457
R99 vg.n26 vg.t29 67.7457
R100 vg.n25 vg.t30 67.7457
R101 vg.n3 vg.t31 67.7457
R102 vg.n24 vg.t32 67.7457
R103 vg.n23 vg.t33 67.7457
R104 vg.n2 vg.t34 67.7457
R105 vg.n22 vg.t35 67.7457
R106 vg.n21 vg.t36 67.7457
R107 vg.n1 vg.t37 67.7457
R108 vg.n20 vg.t38 67.7457
R109 vg.n19 vg.t39 67.7457
R110 vg.n0 vg.t40 67.7457
R111 vg.n47 vg.t0 67.7457
R112 vg.n46 vg.t1 67.7457
R113 vg.n45 vg.t2 67.7457
R114 vg.n11 vg.t3 67.7457
R115 vg.n44 vg.t4 67.7457
R116 vg.n43 vg.t5 67.7457
R117 vg.n10 vg.t6 67.7457
R118 vg.n42 vg.t7 67.7457
R119 vg.n41 vg.t8 67.7457
R120 vg.n9 vg.t9 67.7457
R121 vg.n40 vg.t10 67.7457
R122 vg.n39 vg.t11 67.7457
R123 vg.n8 vg.t12 67.7457
R124 vg.n38 vg.t13 67.7457
R125 vg.n37 vg.t14 67.7457
R126 vg.n7 vg.t15 67.7457
R127 vg.n36 vg.t16 67.7457
R128 vg.n35 vg.t17 67.7457
R129 vg.n6 vg.t18 67.7457
R130 vg.n34 vg.t19 67.7457
R131 vg.n32 vg.t20 67.7457
R132 vg.n33 vg.t21 68.3237
R133 vg.n63 vg.t44 67.7457
R134 vg.n62 vg.t45 67.7457
R135 vg.n61 vg.t46 67.7457
R136 vg.n17 vg.t47 67.7457
R137 vg.n60 vg.t48 67.7457
R138 vg.n59 vg.t49 67.7457
R139 vg.n16 vg.t50 67.7457
R140 vg.n58 vg.t51 67.7457
R141 vg.n57 vg.t52 67.7457
R142 vg.n15 vg.t53 67.7457
R143 vg.n56 vg.t54 67.7457
R144 vg.n55 vg.t55 67.7457
R145 vg.n14 vg.t56 67.7457
R146 vg.n54 vg.t57 67.7457
R147 vg.n53 vg.t58 67.7457
R148 vg.n13 vg.t59 67.7457
R149 vg.n52 vg.t60 67.7457
R150 vg.n51 vg.t61 67.7457
R151 vg.n12 vg.t62 67.7457
R152 vg.n50 vg.t63 67.7457
R153 vg.n48 vg.t64 67.7457
R154 vg.n49 vg.t65 68.3237
R155 vg.n66 vg.n31 11.0526
R156 vg.n79 vg.n47 11.0526
R157 vg.n72 vg.n63 11.0526
R158 vg.n84 vg.n83 7.42765
R159 vg.n84 vg.n76 7.42765
R160 vg.n18 vg.n64 6.55258
R161 vg.n69 vg.n64 6.55258
R162 vg.n69 vg.n68 6.55258
R163 vg.n68 vg.n65 6.55258
R164 vg.n67 vg.n65 6.55258
R165 vg.n67 vg.n66 6.55258
R166 vg.n83 vg.n77 6.55258
R167 vg.n82 vg.n77 6.55258
R168 vg.n82 vg.n81 6.55258
R169 vg.n81 vg.n78 6.55258
R170 vg.n80 vg.n78 6.55258
R171 vg.n80 vg.n79 6.55258
R172 vg.n76 vg.n70 6.55258
R173 vg.n75 vg.n70 6.55258
R174 vg.n75 vg.n74 6.55258
R175 vg.n74 vg.n71 6.55258
R176 vg.n73 vg.n71 6.55258
R177 vg.n73 vg.n72 6.55258
R178 vg vg.n84 3.4105
R179 vg.n72 vg.n17 4.5047
R180 vg.n73 vg.n16 4.5047
R181 vg.n15 vg.n71 4.5047
R182 vg.n74 vg.n14 4.5047
R183 vg.n75 vg.n13 4.5047
R184 vg.n12 vg.n70 4.5047
R185 vg.n60 vg.n59 3.02041
R186 vg.n57 vg.n58 3.02041
R187 vg.n55 vg.n56 3.02041
R188 vg.n54 vg.n53 3.02041
R189 vg.n51 vg.n52 3.02041
R190 vg.n48 vg.n50 3.02041
R191 vg vg.n18 2.47793
R192 vg.t43 vg.n18 4.504
R193 vg.n33 vg.n83 4.504
R194 vg.n49 vg.n76 4.504
R195 vg.n79 vg.n11 4.5047
R196 vg.n80 vg.n10 4.5047
R197 vg.n9 vg.n78 4.5047
R198 vg.n81 vg.n8 4.5047
R199 vg.n82 vg.n7 4.5047
R200 vg.n6 vg.n77 4.5047
R201 vg.n66 vg.n5 4.5047
R202 vg.n67 vg.n4 4.5047
R203 vg.n3 vg.n65 4.5047
R204 vg.n68 vg.n2 4.5047
R205 vg.n69 vg.n1 4.5047
R206 vg.n0 vg.n64 4.5047
R207 vg.n60 vg.n17 3.59387
R208 vg.n44 vg.n11 3.59387
R209 vg.n28 vg.n5 3.59387
R210 vg.n16 vg.n59 3.02346
R211 vg.n57 vg.n15 3.02346
R212 vg.n14 vg.n55 3.02346
R213 vg.n13 vg.n53 3.02346
R214 vg.n51 vg.n12 3.02346
R215 vg.n10 vg.n43 3.02346
R216 vg.n41 vg.n9 3.02346
R217 vg.n8 vg.n39 3.02346
R218 vg.n7 vg.n37 3.02346
R219 vg.n35 vg.n6 3.02346
R220 vg.n4 vg.n27 3.02346
R221 vg.n25 vg.n3 3.02346
R222 vg.n2 vg.n23 3.02346
R223 vg.n1 vg.n21 3.02346
R224 vg.n19 vg.n0 3.02346
R225 vg.n44 vg.n43 3.02041
R226 vg.n41 vg.n42 3.02041
R227 vg.n39 vg.n40 3.02041
R228 vg.n38 vg.n37 3.02041
R229 vg.n35 vg.n36 3.02041
R230 vg.n32 vg.n34 3.02041
R231 vg.n28 vg.n27 3.02041
R232 vg.n25 vg.n26 3.02041
R233 vg.n23 vg.n24 3.02041
R234 vg.n22 vg.n21 3.02041
R235 vg.n19 vg.n20 3.02041
R236 vg.t42 vg.t41 3.02041
R237 vg.t43 vg.t42 2.44583
R238 vdd.n429 vdd.n9 23940
R239 vdd.n558 vdd.n9 23940
R240 vdd.n11 vdd.n100 750
R241 vdd.n12 vdd.n211 750
R242 vdd.n9 vdd.n11 10770
R243 vdd.n12 vdd.n9 10770
R244 vdd.n10 vdd.n102 21540
R245 vdd.n10 vdd.n432 21540
R246 vdd.n13 vdd.n103 21540
R247 vdd.n428 vdd.n13 21540
R248 vdd.n431 vdd.n12 3101.17
R249 vdd.n432 vdd.n431 2400
R250 vdd.n11 vdd.n172 3101.17
R251 vdd.n172 vdd.n102 2400
R252 vdd.n560 vdd.n102 2400
R253 vdd.n560 vdd.n103 2400
R254 vdd.n432 vdd.n285 2400
R255 vdd.n428 vdd.n285 2400
R256 vdd.n429 vdd.n428 2400
R257 vdd.n558 vdd.n103 2400
R258 vdd.n466 vdd.n18 86.1505
R259 vdd.n124 vdd.n58 157.724
R260 vdd.n15 vdd.n286 86.1505
R261 vdd.n123 vdd.n56 157.724
R262 vdd.n563 vdd.n169 151.29
R263 vdd.n495 vdd.n494 151.29
R264 vdd.n262 vdd.n171 151.29
R265 vdd.n562 vdd.n154 155.59
R266 vdd.n340 vdd.n336 151.29
R267 vdd.n339 vdd.n155 155.59
R268 vdd.n464 vdd.n205 145.957
R269 vdd.n445 vdd.n442 145.957
R270 vdd.n447 vdd.n446 145.957
R271 vdd.n449 vdd.n133 145.957
R272 vdd.n450 vdd.n449 145.957
R273 vdd.n451 vdd.n439 145.957
R274 vdd.n456 vdd.n455 145.957
R275 vdd.n457 vdd.n438 145.957
R276 vdd.n438 vdd.n437 145.957
R277 vdd.n433 vdd.n208 145.957
R278 vdd.n309 vdd.n210 145.957
R279 vdd.n312 vdd.n308 145.957
R280 vdd.n313 vdd.n312 145.957
R281 vdd.n314 vdd.n306 145.957
R282 vdd.n319 vdd.n318 145.957
R283 vdd.n320 vdd.n304 145.957
R284 vdd.n323 vdd.n304 145.957
R285 vdd.n326 vdd.n325 145.957
R286 vdd.n327 vdd.n302 145.957
R287 vdd.n332 vdd.n331 145.957
R288 vdd.n565 vdd.n564 145.957
R289 vdd.n569 vdd.n168 145.957
R290 vdd.n571 vdd.n570 145.957
R291 vdd.n268 vdd.n167 145.957
R292 vdd.n268 vdd.n267 145.957
R293 vdd.n273 vdd.n272 145.957
R294 vdd.n274 vdd.n233 145.957
R295 vdd.n279 vdd.n278 145.957
R296 vdd.n280 vdd.n279 145.957
R297 vdd.n284 vdd.n213 145.957
R298 vdd.n230 vdd.n212 145.957
R299 vdd.n229 vdd.n228 145.957
R300 vdd.n228 vdd.n214 145.957
R301 vdd.n226 vdd.n225 145.957
R302 vdd.n224 vdd.n216 145.957
R303 vdd.n220 vdd.n219 145.957
R304 vdd.n219 vdd.n218 145.957
R305 vdd.n488 vdd.n187 145.957
R306 vdd.n490 vdd.n489 145.957
R307 vdd.n493 vdd.n185 145.957
R308 vdd.n548 vdd.n173 145.957
R309 vdd.n552 vdd.n549 145.957
R310 vdd.n554 vdd.n553 145.957
R311 vdd.n547 vdd.n546 145.957
R312 vdd.n546 vdd.n176 145.957
R313 vdd.n542 vdd.n541 145.957
R314 vdd.n540 vdd.n178 145.957
R315 vdd.n536 vdd.n535 145.957
R316 vdd.n535 vdd.n179 145.957
R317 vdd.n532 vdd.n531 145.957
R318 vdd.n530 vdd.n181 145.957
R319 vdd.n526 vdd.n525 145.957
R320 vdd.n525 vdd.n524 145.957
R321 vdd.n503 vdd.n182 145.957
R322 vdd.n507 vdd.n506 145.957
R323 vdd.n508 vdd.n501 145.957
R324 vdd.n511 vdd.n501 145.957
R325 vdd.n512 vdd.n500 145.957
R326 vdd.n517 vdd.n516 145.957
R327 vdd.n518 vdd.n498 145.957
R328 vdd.n467 vdd.n466 145.957
R329 vdd.n471 vdd.n202 145.957
R330 vdd.n473 vdd.n472 145.957
R331 vdd.n386 vdd.n201 145.957
R332 vdd.n386 vdd.n385 145.957
R333 vdd.n391 vdd.n390 145.957
R334 vdd.n392 vdd.n295 145.957
R335 vdd.n397 vdd.n396 145.957
R336 vdd.n398 vdd.n397 145.957
R337 vdd.n402 vdd.n294 145.957
R338 vdd.n404 vdd.n403 145.957
R339 vdd.n407 vdd.n292 145.957
R340 vdd.n408 vdd.n407 145.957
R341 vdd.n409 vdd.n291 145.957
R342 vdd.n414 vdd.n413 145.957
R343 vdd.n415 vdd.n289 145.957
R344 vdd.n418 vdd.n289 145.957
R345 vdd.n419 vdd.n288 145.957
R346 vdd.n424 vdd.n423 145.957
R347 vdd.n425 vdd.n286 145.957
R348 vdd.n261 vdd.n259 145.957
R349 vdd.n255 vdd.n237 145.957
R350 vdd.n254 vdd.n253 145.957
R351 vdd.n250 vdd.n148 145.957
R352 vdd.n250 vdd.n249 145.957
R353 vdd.n248 vdd.n240 145.957
R354 vdd.n244 vdd.n243 145.957
R355 vdd.n242 vdd.n79 145.957
R356 vdd.n476 vdd.n79 145.957
R357 vdd.n478 vdd.n477 145.957
R358 vdd.n482 vdd.n101 145.957
R359 vdd.n484 vdd.n483 145.957
R360 vdd.n484 vdd.n197 145.957
R361 vdd.n347 vdd.n346 145.957
R362 vdd.n351 vdd.n344 145.957
R363 vdd.n353 vdd.n352 145.957
R364 vdd.n353 vdd.n150 145.957
R365 vdd.n357 vdd.n356 145.957
R366 vdd.n358 vdd.n341 145.957
R367 vdd.n363 vdd.n362 145.957
R368 vdd.n442 vdd.n205 145.779
R369 vdd.n446 vdd.n445 145.779
R370 vdd.n447 vdd.n133 145.779
R371 vdd.n451 vdd.n450 145.779
R372 vdd.n455 vdd.n439 145.779
R373 vdd.n457 vdd.n456 145.779
R374 vdd.n437 vdd.n208 145.779
R375 vdd.n309 vdd.n308 145.779
R376 vdd.n314 vdd.n313 145.779
R377 vdd.n318 vdd.n306 145.779
R378 vdd.n320 vdd.n319 145.779
R379 vdd.n325 vdd.n323 145.779
R380 vdd.n327 vdd.n326 145.779
R381 vdd.n331 vdd.n302 145.779
R382 vdd.n565 vdd.n168 145.779
R383 vdd.n570 vdd.n569 145.779
R384 vdd.n571 vdd.n167 145.779
R385 vdd.n272 vdd.n267 145.779
R386 vdd.n274 vdd.n273 145.779
R387 vdd.n278 vdd.n233 145.779
R388 vdd.n280 vdd.n213 145.779
R389 vdd.n230 vdd.n229 145.779
R390 vdd.n226 vdd.n214 145.779
R391 vdd.n225 vdd.n224 145.779
R392 vdd.n220 vdd.n216 145.779
R393 vdd.n218 vdd.n187 145.779
R394 vdd.n489 vdd.n488 145.779
R395 vdd.n490 vdd.n185 145.779
R396 vdd.n549 vdd.n548 145.779
R397 vdd.n553 vdd.n552 145.779
R398 vdd.n554 vdd.n547 145.779
R399 vdd.n542 vdd.n176 145.779
R400 vdd.n541 vdd.n540 145.779
R401 vdd.n536 vdd.n178 145.779
R402 vdd.n532 vdd.n179 145.779
R403 vdd.n526 vdd.n181 145.779
R404 vdd.n524 vdd.n182 145.779
R405 vdd.n506 vdd.n503 145.779
R406 vdd.n508 vdd.n507 145.779
R407 vdd.n512 vdd.n511 145.779
R408 vdd.n516 vdd.n500 145.779
R409 vdd.n518 vdd.n517 145.779
R410 vdd.n467 vdd.n202 145.779
R411 vdd.n472 vdd.n471 145.779
R412 vdd.n473 vdd.n201 145.779
R413 vdd.n390 vdd.n385 145.779
R414 vdd.n392 vdd.n391 145.779
R415 vdd.n396 vdd.n295 145.779
R416 vdd.n398 vdd.n294 145.779
R417 vdd.n404 vdd.n292 145.779
R418 vdd.n409 vdd.n408 145.779
R419 vdd.n413 vdd.n291 145.779
R420 vdd.n415 vdd.n414 145.779
R421 vdd.n419 vdd.n418 145.779
R422 vdd.n423 vdd.n288 145.779
R423 vdd.n425 vdd.n424 145.779
R424 vdd.n259 vdd.n237 145.779
R425 vdd.n255 vdd.n254 145.779
R426 vdd.n253 vdd.n148 145.779
R427 vdd.n249 vdd.n248 145.779
R428 vdd.n244 vdd.n240 145.779
R429 vdd.n243 vdd.n242 145.779
R430 vdd.n477 vdd.n476 145.779
R431 vdd.n483 vdd.n482 145.779
R432 vdd.n346 vdd.n197 145.779
R433 vdd.n347 vdd.n344 145.779
R434 vdd.n352 vdd.n351 145.779
R435 vdd.n356 vdd.n150 145.779
R436 vdd.n358 vdd.n357 145.779
R437 vdd.n362 vdd.n341 145.779
R438 vdd.n556 vdd.n173 144.889
R439 vdd.n498 vdd.n497 144.889
R440 vdd.n465 vdd.n464 144.889
R441 vdd.n333 vdd.n332 144.889
R442 vdd.n557 vdd.n556 140.268
R443 vdd.n497 vdd.n184 140.268
R444 vdd.n564 vdd.n563 122.668
R445 vdd.n494 vdd.n493 122.668
R446 vdd.n562 vdd.n561 117.868
R447 vdd.n339 vdd.n338 117.868
R448 vdd.n262 vdd.n261 100.267
R449 vdd.n363 vdd.n340 100.267
R450 vdd.t45 vdd.t43 97.0054
R451 vdd.t75 vdd.t74 97.0054
R452 vdd.n58 vdd.n260 95.4672
R453 vdd.n427 vdd.n56 95.4672
R454 vdd.n559 vdd.t43 88.7546
R455 vdd.n430 vdd.t75 88.7546
R456 vdd.n433 vdd.n9 72.8894
R457 vdd.n9 vdd.n210 72.8894
R458 vdd.n13 vdd.n284 72.8894
R459 vdd.n13 vdd.n212 72.8894
R460 vdd.n531 vdd.n9 72.8894
R461 vdd.n9 vdd.n530 72.8894
R462 vdd.n9 vdd.n402 72.8894
R463 vdd.n403 vdd.n9 72.8894
R464 vdd.n478 vdd.n10 72.8894
R465 vdd.n10 vdd.n101 72.8894
R466 vdd.t2 vdd.t0 66.1612
R467 vdd.t8 vdd.t7 66.1612
R468 vdd.t13 vdd.t11 66.1612
R469 vdd.t17 vdd.t16 66.1612
R470 vdd.t26 vdd.t25 66.1612
R471 vdd.t31 vdd.t29 66.1612
R472 vdd.t35 vdd.t34 66.1612
R473 vdd.t41 vdd.t40 66.1612
R474 vdd.t50 vdd.t5 64.1563
R475 vdd.t37 vdd.t69 64.1563
R476 vdd.t4 vdd.t47 63.6937
R477 vdd.t72 vdd.t38 63.6937
R478 vdd.n55 vdd.n204 124.984
R479 vdd.n301 vdd.n53 124.984
R480 vdd.t53 vdd.t10 59.6839
R481 vdd.t32 vdd.t66 59.6839
R482 vdd.n260 vdd.n18 64.1061
R483 vdd.n427 vdd.n15 64.1061
R484 vdd.t56 vdd.t14 55.2115
R485 vdd.t28 vdd.t63 55.2115
R486 vdd.t59 vdd.t19 50.7391
R487 vdd.t23 vdd.t60 50.7391
R488 vdd.t19 vdd.t57 46.2667
R489 vdd.t62 vdd.t23 46.2667
R490 vdd.t14 vdd.t54 41.7943
R491 vdd.t65 vdd.t28 41.7943
R492 vdd.n261 vdd.n124 6.25677
R493 vdd.n123 vdd.n363 6.25677
R494 vdd.t10 vdd.t51 37.3219
R495 vdd.t68 vdd.t32 37.3219
R496 vdd.n465 vdd.n204 33.6005
R497 vdd.n561 vdd.n171 33.6005
R498 vdd.n338 vdd.n336 33.6005
R499 vdd.n333 vdd.n301 33.6005
R500 vdd.t48 vdd.t4 33.3122
R501 vdd.t38 vdd.t71 33.3122
R502 vdd.n9 vdd.t20 33.0809
R503 vdd.n9 vdd.t22 33.0809
R504 vdd.t5 vdd.t48 32.8495
R505 vdd.t71 vdd.t37 32.8495
R506 vdd.t51 vdd.t8 28.8398
R507 vdd.t34 vdd.t68 28.8398
R508 vdd.t0 vdd.t45 28.3771
R509 vdd.t74 vdd.t41 28.3771
R510 vdd.t54 vdd.t13 24.3674
R511 vdd.t29 vdd.t65 24.3674
R512 vdd.t57 vdd.t17 19.895
R513 vdd.t25 vdd.t62 19.895
R514 vdd.n564 vdd.n154 4.30158
R515 vdd.n493 vdd.n155 4.30158
R516 vdd.t20 vdd.t59 15.4226
R517 vdd.t60 vdd.t22 15.4226
R518 vdd.n557 vdd.n169 11.2005
R519 vdd.n495 vdd.n184 11.2005
R520 vdd.t16 vdd.t56 10.9502
R521 vdd.t63 vdd.t26 10.9502
R522 vdd.n332 vdd.n64 9.3005
R523 vdd.n331 vdd.n330 9.3005
R524 vdd.n329 vdd.n302 9.3005
R525 vdd.n328 vdd.n327 9.3005
R526 vdd.n326 vdd.n303 9.3005
R527 vdd.n325 vdd.n324 9.3005
R528 vdd.n323 vdd.n137 9.3005
R529 vdd.n322 vdd.n304 9.3005
R530 vdd.n321 vdd.n320 9.3005
R531 vdd.n319 vdd.n305 9.3005
R532 vdd.n318 vdd.n317 9.3005
R533 vdd.n316 vdd.n306 9.3005
R534 vdd.n315 vdd.n314 9.3005
R535 vdd.n313 vdd.n307 9.3005
R536 vdd.n312 vdd.n68 9.3005
R537 vdd.n311 vdd.n308 9.3005
R538 vdd.n310 vdd.n309 9.3005
R539 vdd.n210 vdd.n209 9.3005
R540 vdd.n434 vdd.n433 9.3005
R541 vdd.n435 vdd.n208 9.3005
R542 vdd.n437 vdd.n436 9.3005
R543 vdd.n438 vdd.n67 9.3005
R544 vdd.n66 vdd.n457 9.3005
R545 vdd.n456 vdd.n207 9.3005
R546 vdd.n455 vdd.n454 9.3005
R547 vdd.n453 vdd.n439 9.3005
R548 vdd.n452 vdd.n451 9.3005
R549 vdd.n450 vdd.n440 9.3005
R550 vdd.n449 vdd.n448 9.3005
R551 vdd.n136 vdd.n133 9.3005
R552 vdd.n134 vdd.n447 9.3005
R553 vdd.n446 vdd.n441 9.3005
R554 vdd.n445 vdd.n444 9.3005
R555 vdd.n443 vdd.n442 9.3005
R556 vdd.n206 vdd.n205 9.3005
R557 vdd.n464 vdd.n463 9.3005
R558 vdd.n563 vdd.n0 9.3005
R559 vdd.n125 vdd.n169 9.3005
R560 vdd.n556 vdd.n127 9.3005
R561 vdd.n155 vdd.n2 2.50071
R562 vdd.n492 vdd.n185 9.3005
R563 vdd.n491 vdd.n490 9.3005
R564 vdd.n489 vdd.n186 9.3005
R565 vdd.n488 vdd.n487 9.3005
R566 vdd.n486 vdd.n187 9.3005
R567 vdd.n218 vdd.n140 9.3005
R568 vdd.n219 vdd.n217 9.3005
R569 vdd.n221 vdd.n220 9.3005
R570 vdd.n222 vdd.n216 9.3005
R571 vdd.n224 vdd.n223 9.3005
R572 vdd.n225 vdd.n215 9.3005
R573 vdd.n227 vdd.n226 9.3005
R574 vdd.n71 vdd.n214 9.3005
R575 vdd.n228 vdd.n72 9.3005
R576 vdd.n229 vdd.n70 9.3005
R577 vdd.n231 vdd.n230 9.3005
R578 vdd.n232 vdd.n212 9.3005
R579 vdd.n284 vdd.n283 9.3005
R580 vdd.n282 vdd.n213 9.3005
R581 vdd.n281 vdd.n280 9.3005
R582 vdd.n279 vdd.n69 9.3005
R583 vdd.n278 vdd.n277 9.3005
R584 vdd.n276 vdd.n233 9.3005
R585 vdd.n275 vdd.n274 9.3005
R586 vdd.n273 vdd.n266 9.3005
R587 vdd.n272 vdd.n271 9.3005
R588 vdd.n270 vdd.n267 9.3005
R589 vdd.n269 vdd.n268 9.3005
R590 vdd.n167 vdd.n139 9.3005
R591 vdd.n138 vdd.n571 9.3005
R592 vdd.n570 vdd.n166 9.3005
R593 vdd.n569 vdd.n568 9.3005
R594 vdd.n567 vdd.n168 9.3005
R595 vdd.n566 vdd.n565 9.3005
R596 vdd.n154 vdd.n0 2.50071
R597 vdd.n520 vdd.n498 9.3005
R598 vdd.n519 vdd.n518 9.3005
R599 vdd.n517 vdd.n499 9.3005
R600 vdd.n516 vdd.n515 9.3005
R601 vdd.n514 vdd.n500 9.3005
R602 vdd.n513 vdd.n512 9.3005
R603 vdd.n511 vdd.n144 9.3005
R604 vdd.n510 vdd.n501 9.3005
R605 vdd.n509 vdd.n508 9.3005
R606 vdd.n507 vdd.n502 9.3005
R607 vdd.n506 vdd.n505 9.3005
R608 vdd.n504 vdd.n503 9.3005
R609 vdd.n183 vdd.n182 9.3005
R610 vdd.n524 vdd.n523 9.3005
R611 vdd.n525 vdd.n75 9.3005
R612 vdd.n527 vdd.n526 9.3005
R613 vdd.n528 vdd.n181 9.3005
R614 vdd.n530 vdd.n529 9.3005
R615 vdd.n531 vdd.n180 9.3005
R616 vdd.n533 vdd.n532 9.3005
R617 vdd.n534 vdd.n179 9.3005
R618 vdd.n535 vdd.n74 9.3005
R619 vdd.n537 vdd.n536 9.3005
R620 vdd.n538 vdd.n178 9.3005
R621 vdd.n540 vdd.n539 9.3005
R622 vdd.n541 vdd.n177 9.3005
R623 vdd.n543 vdd.n542 9.3005
R624 vdd.n544 vdd.n176 9.3005
R625 vdd.n546 vdd.n545 9.3005
R626 vdd.n547 vdd.n142 9.3005
R627 vdd.n141 vdd.n554 9.3005
R628 vdd.n553 vdd.n175 9.3005
R629 vdd.n552 vdd.n551 9.3005
R630 vdd.n550 vdd.n549 9.3005
R631 vdd.n548 vdd.n174 9.3005
R632 vdd.n126 vdd.n173 9.3005
R633 vdd.n497 vdd.n109 9.3005
R634 vdd.n496 vdd.n495 9.3005
R635 vdd.n494 vdd.n2 9.3005
R636 vdd.n53 vdd.n286 7.11752
R637 vdd.n426 vdd.n425 9.3005
R638 vdd.n424 vdd.n287 9.3005
R639 vdd.n423 vdd.n422 9.3005
R640 vdd.n421 vdd.n288 9.3005
R641 vdd.n420 vdd.n419 9.3005
R642 vdd.n418 vdd.n147 9.3005
R643 vdd.n417 vdd.n289 9.3005
R644 vdd.n416 vdd.n415 9.3005
R645 vdd.n414 vdd.n290 9.3005
R646 vdd.n413 vdd.n412 9.3005
R647 vdd.n411 vdd.n291 9.3005
R648 vdd.n410 vdd.n409 9.3005
R649 vdd.n408 vdd.n77 9.3005
R650 vdd.n407 vdd.n78 9.3005
R651 vdd.n406 vdd.n292 9.3005
R652 vdd.n405 vdd.n404 9.3005
R653 vdd.n403 vdd.n293 9.3005
R654 vdd.n402 vdd.n401 9.3005
R655 vdd.n400 vdd.n294 9.3005
R656 vdd.n399 vdd.n398 9.3005
R657 vdd.n397 vdd.n76 9.3005
R658 vdd.n396 vdd.n395 9.3005
R659 vdd.n394 vdd.n295 9.3005
R660 vdd.n393 vdd.n392 9.3005
R661 vdd.n391 vdd.n384 9.3005
R662 vdd.n390 vdd.n389 9.3005
R663 vdd.n388 vdd.n385 9.3005
R664 vdd.n387 vdd.n386 9.3005
R665 vdd.n201 vdd.n146 9.3005
R666 vdd.n145 vdd.n473 9.3005
R667 vdd.n472 vdd.n200 9.3005
R668 vdd.n471 vdd.n470 9.3005
R669 vdd.n469 vdd.n202 9.3005
R670 vdd.n468 vdd.n467 9.3005
R671 vdd.n466 vdd.n55 7.11752
R672 vdd.n18 vdd.n17 0.509565
R673 vdd.n6 vdd.n58 9.3005
R674 vdd.n63 vdd.n465 9.3005
R675 vdd.n16 vdd.n55 1.09274
R676 vdd.n123 vdd.n4 1.52312
R677 vdd.n362 vdd.n361 9.3005
R678 vdd.n360 vdd.n341 9.3005
R679 vdd.n359 vdd.n358 9.3005
R680 vdd.n357 vdd.n342 9.3005
R681 vdd.n356 vdd.n355 9.3005
R682 vdd.n151 vdd.n150 9.3005
R683 vdd.n354 vdd.n353 9.3005
R684 vdd.n352 vdd.n343 9.3005
R685 vdd.n351 vdd.n350 9.3005
R686 vdd.n349 vdd.n344 9.3005
R687 vdd.n348 vdd.n347 9.3005
R688 vdd.n346 vdd.n345 9.3005
R689 vdd.n197 vdd.n82 9.3005
R690 vdd.n83 vdd.n484 9.3005
R691 vdd.n483 vdd.n196 9.3005
R692 vdd.n482 vdd.n481 9.3005
R693 vdd.n480 vdd.n101 9.3005
R694 vdd.n479 vdd.n478 9.3005
R695 vdd.n477 vdd.n198 9.3005
R696 vdd.n476 vdd.n475 9.3005
R697 vdd.n81 vdd.n79 9.3005
R698 vdd.n242 vdd.n80 9.3005
R699 vdd.n243 vdd.n241 9.3005
R700 vdd.n245 vdd.n244 9.3005
R701 vdd.n246 vdd.n240 9.3005
R702 vdd.n248 vdd.n247 9.3005
R703 vdd.n249 vdd.n239 9.3005
R704 vdd.n251 vdd.n250 9.3005
R705 vdd.n149 vdd.n148 9.3005
R706 vdd.n253 vdd.n252 9.3005
R707 vdd.n254 vdd.n238 9.3005
R708 vdd.n256 vdd.n255 9.3005
R709 vdd.n257 vdd.n237 9.3005
R710 vdd.n259 vdd.n258 9.3005
R711 vdd.n124 vdd.n7 1.52312
R712 vdd.n7 vdd.n262 9.3005
R713 vdd.n171 vdd.n152 9.3005
R714 vdd.n104 vdd.n562 9.3005
R715 vdd.n106 vdd.n339 9.3005
R716 vdd.n105 vdd.n336 9.3005
R717 vdd.n340 vdd.n4 9.3005
R718 vdd.n57 vdd.n56 9.3005
R719 vdd.n14 vdd.n15 0.509565
R720 vdd.n53 vdd.n51 1.09274
R721 vdd.n65 vdd.n333 9.3005
R722 vdd.n3 vdd.n20 1.706
R723 vdd.n5 vdd.n4 2.251
R724 vdd.n20 vdd.n52 1.706
R725 vdd.n62 vdd.n1 1.706
R726 vdd.n7 vdd.n8 2.251
R727 vdd.n31 vdd.n54 1.706
R728 vdd.n69 vdd.n60 7.9105
R729 vdd.n81 vdd.n59 7.9105
R730 vdd.n76 vdd.n32 7.9105
R731 vdd.n23 vdd.n139 7.9105
R732 vdd.n72 vdd.n22 7.9105
R733 vdd.n140 vdd.n37 7.9105
R734 vdd.n151 vdd.n33 7.9105
R735 vdd.n34 vdd.n147 7.9105
R736 vdd.n22 vdd.n83 7.9105
R737 vdd.n22 vdd.n78 7.9105
R738 vdd.n23 vdd.n146 7.9105
R739 vdd.n149 vdd.n23 7.9105
R740 vdd.t76 vdd.n112 7.07387
R741 vdd.n191 vdd.t73 7.07387
R742 vdd.n40 vdd.t70 7.07387
R743 vdd.t67 vdd.n192 7.07387
R744 vdd.t64 vdd.n87 7.07387
R745 vdd.n195 vdd.t61 7.07387
R746 vdd.n189 vdd.t58 7.07387
R747 vdd.t55 vdd.n86 7.07387
R748 vdd.n572 vdd.t52 7.07387
R749 vdd.n39 vdd.t49 7.07387
R750 vdd.n170 vdd.t46 7.07387
R751 vdd.t44 vdd.n111 7.07387
R752 vdd.t98 vdd.n114 7.07387
R753 vdd.n337 vdd.t96 7.07387
R754 vdd.t94 vdd.n42 7.07387
R755 vdd.n485 vdd.t92 7.07387
R756 vdd.n89 vdd.t90 7.07387
R757 vdd.n235 vdd.t88 7.07387
R758 vdd.n236 vdd.t86 7.07387
R759 vdd.t84 vdd.n88 7.07387
R760 vdd.n265 vdd.t82 7.07387
R761 vdd.n41 vdd.t80 7.07387
R762 vdd.t78 vdd.n263 7.07387
R763 vdd.n113 vdd.t77 7.07387
R764 vdd.t120 vdd.n122 7.07387
R765 vdd.t118 vdd.n335 7.07387
R766 vdd.n50 vdd.t116 7.07387
R767 vdd.t114 vdd.n96 7.07387
R768 vdd.t112 vdd.n97 7.07387
R769 vdd.n367 vdd.t110 7.07387
R770 vdd.n365 vdd.t108 7.07387
R771 vdd.t106 vdd.n95 7.07387
R772 vdd.n474 vdd.t104 7.07387
R773 vdd.n49 vdd.t102 7.07387
R774 vdd.n203 vdd.t100 7.07387
R775 vdd.t99 vdd.n121 7.07387
R776 vdd.n110 vdd.t76 6.98691
R777 vdd.t73 vdd.n190 6.98691
R778 vdd.t70 vdd.n38 6.98691
R779 vdd.n193 vdd.t67 6.98691
R780 vdd.n85 vdd.t64 6.98691
R781 vdd.t61 vdd.n194 6.98691
R782 vdd.t58 vdd.n165 6.98691
R783 vdd.n84 vdd.t55 6.98691
R784 vdd.t52 vdd.n35 6.98691
R785 vdd.t49 vdd.n36 6.98691
R786 vdd.t46 vdd.n107 6.98691
R787 vdd.n108 vdd.t44 6.98691
R788 vdd.n117 vdd.t98 6.98691
R789 vdd.t96 vdd.n116 6.98691
R790 vdd.n45 vdd.t94 6.98691
R791 vdd.t92 vdd.n91 6.98691
R792 vdd.t90 vdd.n92 6.98691
R793 vdd.t88 vdd.n188 6.98691
R794 vdd.t86 vdd.n234 6.98691
R795 vdd.n90 vdd.t84 6.98691
R796 vdd.t82 vdd.n43 6.98691
R797 vdd.t80 vdd.n44 6.98691
R798 vdd.n264 vdd.t78 6.98691
R799 vdd.t77 vdd.n115 6.98691
R800 vdd.n120 vdd.t120 6.98691
R801 vdd.n364 vdd.t118 6.98691
R802 vdd.t116 vdd.n48 6.98691
R803 vdd.n368 vdd.t114 6.98691
R804 vdd.n94 vdd.t112 6.98691
R805 vdd.t110 vdd.n366 6.98691
R806 vdd.t108 vdd.n199 6.98691
R807 vdd.n93 vdd.t106 6.98691
R808 vdd.t104 vdd.n46 6.98691
R809 vdd.t102 vdd.n47 6.98691
R810 vdd.t100 vdd.n118 6.98691
R811 vdd.n119 vdd.t99 6.98691
R812 vdd.t11 vdd.t53 6.47777
R813 vdd.t66 vdd.t31 6.47777
R814 vdd.n559 vdd.n100 6.37981
R815 vdd.n204 vdd.n100 6.37981
R816 vdd.n430 vdd.n211 6.37981
R817 vdd.n301 vdd.n211 6.37981
R818 vdd.t42 vdd.n299 5.98691
R819 vdd.n26 vdd.t39 5.98691
R820 vdd.t36 vdd.n369 5.98691
R821 vdd.t33 vdd.n298 5.98691
R822 vdd.n373 vdd.t30 5.98691
R823 vdd.n130 vdd.t27 5.98691
R824 vdd.t24 vdd.n129 5.98691
R825 vdd.n376 vdd.t21 5.98691
R826 vdd.n377 vdd.t18 5.98691
R827 vdd.t15 vdd.n128 5.98691
R828 vdd.n383 vdd.t12 5.98691
R829 vdd.n382 vdd.t9 5.98691
R830 vdd.t6 vdd.n24 5.98691
R831 vdd.t3 vdd.n25 5.98691
R832 vdd.n379 vdd.t1 5.98691
R833 vdd.n334 vdd.t42 5.89996
R834 vdd.t39 vdd.n29 5.89996
R835 vdd.n370 vdd.t36 5.89996
R836 vdd.n371 vdd.t33 5.89996
R837 vdd.t30 vdd.n372 5.89996
R838 vdd.t27 vdd.n132 5.89996
R839 vdd.n374 vdd.t24 5.89996
R840 vdd.t21 vdd.n375 5.89996
R841 vdd.t18 vdd.n296 5.89996
R842 vdd.n131 vdd.t15 5.89996
R843 vdd.t12 vdd.n297 5.89996
R844 vdd.t9 vdd.n381 5.89996
R845 vdd.n380 vdd.t6 5.89996
R846 vdd.n28 vdd.t3 5.89996
R847 vdd.t1 vdd.n27 5.89996
R848 vdd.n458 vdd.n135 5.0005
R849 vdd.n459 vdd.n458 5.0005
R850 vdd.n460 vdd.n459 5.0005
R851 vdd.n163 vdd.n73 5.0005
R852 vdd.n522 vdd.n73 5.0005
R853 vdd.n522 vdd.n143 5.0005
R854 vdd.n461 vdd.n64 4.5005
R855 vdd.n463 vdd.n462 4.5005
R856 vdd.n136 vdd.n135 4.5005
R857 vdd.n458 vdd.n67 4.5005
R858 vdd.n459 vdd.n68 4.5005
R859 vdd.n460 vdd.n137 4.5005
R860 vdd.n126 vdd.n555 4.5005
R861 vdd.n163 vdd.n142 4.5005
R862 vdd.n74 vdd.n73 4.5005
R863 vdd.n75 vdd.n522 4.5005
R864 vdd.n144 vdd.n143 4.5005
R865 vdd.n521 vdd.n520 4.5005
R866 vdd.n3 vdd.n2 2.251
R867 vdd.n110 vdd.n109 4.5005
R868 vdd.n127 vdd.n108 4.5005
R869 vdd.n0 vdd.n1 2.251
R870 vdd.n54 vdd.n16 2.251
R871 vdd.n378 vdd.n63 4.5005
R872 vdd.n65 vdd.n300 4.5005
R873 vdd.n52 vdd.n51 2.251
R874 vdd.n115 vdd.n104 4.5005
R875 vdd.n113 vdd.n8 0.970975
R876 vdd.n5 vdd.n114 0.970975
R877 vdd.n117 vdd.n106 4.5005
R878 vdd.n14 vdd.n122 4.5005
R879 vdd.n120 vdd.n57 4.5005
R880 vdd.n6 vdd.n119 4.5005
R881 vdd.n17 vdd.n121 4.5005
R882 vdd.n431 vdd.n430 4.02224
R883 vdd.n431 vdd.n427 4.02224
R884 vdd.n559 vdd.n172 4.02224
R885 vdd.n260 vdd.n172 4.02224
R886 vdd.n560 vdd.n559 4.02224
R887 vdd.n561 vdd.n560 4.02224
R888 vdd.n430 vdd.n285 4.02224
R889 vdd.n338 vdd.n285 4.02224
R890 vdd.n430 vdd.n429 4.02224
R891 vdd.n429 vdd.n184 4.02224
R892 vdd.n559 vdd.n558 4.02224
R893 vdd.n558 vdd.n557 4.02224
R894 vdd.n462 vdd.n135 3.71925
R895 vdd.n461 vdd.n460 3.71925
R896 vdd.n555 vdd.n163 3.71925
R897 vdd.n521 vdd.n143 3.71925
R898 vdd.n19 vdd.n521 3.41782
R899 vdd.n98 vdd.n461 3.41782
R900 vdd.n462 vdd.n31 3.41782
R901 vdd.n555 vdd.n62 3.41782
R902 vdd.n300 vdd.n98 3.4105
R903 vdd.n122 vdd.n20 3.4105
R904 vdd.n120 vdd.n20 3.4105
R905 vdd.n5 vdd.n20 1.706
R906 vdd.n20 vdd.n117 3.4105
R907 vdd.n112 vdd.n3 0.970975
R908 vdd.n110 vdd.n19 3.4105
R909 vdd.n158 vdd.n157 1.25498
R910 vdd.n159 vdd.n158 1.25498
R911 vdd.n160 vdd.n159 1.25498
R912 vdd.n31 vdd.n160 1.77244
R913 vdd.n378 vdd.n31 3.4105
R914 vdd.n121 vdd.n31 3.4105
R915 vdd.n119 vdd.n30 3.4105
R916 vdd.n8 vdd.n30 1.706
R917 vdd.n62 vdd.n115 3.4105
R918 vdd.n111 vdd.n1 0.970975
R919 vdd.n108 vdd.n62 3.4105
R920 vdd.n161 vdd.n60 0.850255
R921 vdd.n73 vdd.n60 3.4105
R922 vdd.n128 vdd.n32 3.4105
R923 vdd.n32 vdd.n131 3.4105
R924 vdd.n95 vdd.n32 3.4105
R925 vdd.n59 vdd.n93 3.4105
R926 vdd.n88 vdd.n59 3.4105
R927 vdd.n60 vdd.n90 3.4105
R928 vdd.n86 vdd.n60 3.4105
R929 vdd.n60 vdd.n84 3.4105
R930 vdd.n458 vdd.n32 3.4105
R931 vdd.n156 vdd.n135 3.4105
R932 vdd.n459 vdd.n99 3.4105
R933 vdd.n460 vdd.n34 3.4105
R934 vdd.n26 vdd.n34 3.4105
R935 vdd.n34 vdd.n29 3.4105
R936 vdd.n34 vdd.n50 3.4105
R937 vdd.n48 vdd.n33 3.4105
R938 vdd.n42 vdd.n33 3.4105
R939 vdd.n37 vdd.n45 3.4105
R940 vdd.n40 vdd.n37 3.4105
R941 vdd.n38 vdd.n37 3.4105
R942 vdd.n37 vdd.n143 3.4105
R943 vdd.n153 vdd.n163 3.4105
R944 vdd.n522 vdd.n21 3.4105
R945 vdd.n36 vdd.n153 3.4105
R946 vdd.n85 vdd.n21 3.4105
R947 vdd.n23 vdd.n39 3.4105
R948 vdd.n22 vdd.n87 3.4105
R949 vdd.n99 vdd.n130 3.4105
R950 vdd.n132 vdd.n22 3.4105
R951 vdd.n97 vdd.n22 3.4105
R952 vdd.n94 vdd.n22 3.4105
R953 vdd.n22 vdd.n89 3.4105
R954 vdd.n92 vdd.n22 3.4105
R955 vdd.n25 vdd.n156 3.4105
R956 vdd.n28 vdd.n23 3.4105
R957 vdd.n23 vdd.n49 3.4105
R958 vdd.n47 vdd.n23 3.4105
R959 vdd.n41 vdd.n23 3.4105
R960 vdd.n44 vdd.n23 3.4105
R961 vdd.t47 vdd.t2 2.46803
R962 vdd.t40 vdd.t72 2.46803
R963 vdd.n379 vdd.n378 2.44633
R964 vdd.n300 vdd.n299 2.44633
R965 vdd.n54 vdd.n27 3.41681
R966 vdd.n334 vdd.n52 3.41681
R967 vdd.n9 vdd.n13 2.64336
R968 vdd.n335 vdd.n122 2.37394
R969 vdd.n121 vdd.n203 2.37394
R970 vdd.n364 vdd.n120 2.37394
R971 vdd.n119 vdd.n118 2.37394
R972 vdd.n117 vdd.n116 2.37394
R973 vdd.n264 vdd.n115 2.37394
R974 vdd.n114 vdd.n337 2.37394
R975 vdd.n263 vdd.n113 2.37394
R976 vdd.n191 vdd.n112 2.37394
R977 vdd.n111 vdd.n170 2.37394
R978 vdd.n190 vdd.n110 2.37394
R979 vdd.n108 vdd.n107 2.37394
R980 vdd.n2 vdd.n492 2.13544
R981 vdd.n566 vdd.n0 2.13544
R982 vdd.n6 vdd.n17 2.0701
R983 vdd.n14 vdd.n57 2.0701
R984 vdd.t7 vdd.t50 2.00537
R985 vdd.t69 vdd.t35 2.00537
R986 vdd.n7 vdd.n152 1.99908
R987 vdd.n4 vdd.n105 1.99908
R988 vdd.n36 vdd.n35 1.96613
R989 vdd.n84 vdd.n35 1.96613
R990 vdd.n194 vdd.n165 1.96613
R991 vdd.n85 vdd.n193 1.96613
R992 vdd.n193 vdd.n38 1.96613
R993 vdd.n572 vdd.n39 1.96613
R994 vdd.n86 vdd.n572 1.96613
R995 vdd.n195 vdd.n189 1.96613
R996 vdd.n192 vdd.n87 1.96613
R997 vdd.n192 vdd.n40 1.96613
R998 vdd.n265 vdd.n41 1.96613
R999 vdd.n88 vdd.n265 1.96613
R1000 vdd.n236 vdd.n235 1.96613
R1001 vdd.n485 vdd.n89 1.96613
R1002 vdd.n42 vdd.n485 1.96613
R1003 vdd.n44 vdd.n43 1.96613
R1004 vdd.n90 vdd.n43 1.96613
R1005 vdd.n234 vdd.n188 1.96613
R1006 vdd.n92 vdd.n91 1.96613
R1007 vdd.n45 vdd.n91 1.96613
R1008 vdd.n47 vdd.n46 1.96613
R1009 vdd.n93 vdd.n46 1.96613
R1010 vdd.n366 vdd.n199 1.96613
R1011 vdd.n368 vdd.n94 1.96613
R1012 vdd.n48 vdd.n368 1.96613
R1013 vdd.n474 vdd.n49 1.96613
R1014 vdd.n95 vdd.n474 1.96613
R1015 vdd.n367 vdd.n365 1.96613
R1016 vdd.n97 vdd.n96 1.96613
R1017 vdd.n50 vdd.n96 1.96613
R1018 vdd.n97 vdd.n367 1.96613
R1019 vdd.n365 vdd.n95 1.96613
R1020 vdd.n366 vdd.n94 1.96613
R1021 vdd.n93 vdd.n199 1.96613
R1022 vdd.n92 vdd.n188 1.96613
R1023 vdd.n90 vdd.n234 1.96613
R1024 vdd.n235 vdd.n89 1.96613
R1025 vdd.n88 vdd.n236 1.96613
R1026 vdd.n87 vdd.n195 1.96613
R1027 vdd.n189 vdd.n86 1.96613
R1028 vdd.n194 vdd.n85 1.96613
R1029 vdd.n84 vdd.n165 1.96613
R1030 vdd.n50 vdd.n335 1.96613
R1031 vdd.n203 vdd.n49 1.96613
R1032 vdd.n48 vdd.n364 1.96613
R1033 vdd.n47 vdd.n118 1.96613
R1034 vdd.n45 vdd.n116 1.96613
R1035 vdd.n44 vdd.n264 1.96613
R1036 vdd.n337 vdd.n42 1.96613
R1037 vdd.n263 vdd.n41 1.96613
R1038 vdd.n40 vdd.n191 1.96613
R1039 vdd.n170 vdd.n39 1.96613
R1040 vdd.n190 vdd.n38 1.96613
R1041 vdd.n36 vdd.n107 1.96613
R1042 vdd.n25 vdd.n379 1.788
R1043 vdd.n382 vdd.n24 1.788
R1044 vdd.n383 vdd.n382 1.788
R1045 vdd.n128 vdd.n383 1.788
R1046 vdd.n377 vdd.n376 1.788
R1047 vdd.n376 vdd.n129 1.788
R1048 vdd.n130 vdd.n373 1.788
R1049 vdd.n373 vdd.n298 1.788
R1050 vdd.n369 vdd.n298 1.788
R1051 vdd.n26 vdd.n299 1.788
R1052 vdd.n28 vdd.n27 1.788
R1053 vdd.n381 vdd.n380 1.788
R1054 vdd.n381 vdd.n297 1.788
R1055 vdd.n131 vdd.n297 1.788
R1056 vdd.n375 vdd.n296 1.788
R1057 vdd.n375 vdd.n374 1.788
R1058 vdd.n372 vdd.n132 1.788
R1059 vdd.n372 vdd.n371 1.788
R1060 vdd.n371 vdd.n370 1.788
R1061 vdd.n29 vdd.n334 1.788
R1062 vdd.n374 vdd.n132 1.788
R1063 vdd.n131 vdd.n296 1.788
R1064 vdd.n130 vdd.n129 1.788
R1065 vdd.n128 vdd.n377 1.788
R1066 vdd.n370 vdd.n29 1.788
R1067 vdd.n380 vdd.n28 1.788
R1068 vdd.n369 vdd.n26 1.788
R1069 vdd.n25 vdd.n24 1.788
R1070 vdd.n62 vdd.n164 1.77992
R1071 vdd.n61 vdd.n19 1.77967
R1072 vdd.n157 vdd.n98 1.78709
R1073 vdd.n9 vdd.n10 1.7624
R1074 vdd.n153 vdd.n23 1.69626
R1075 vdd.n22 vdd.n21 1.69626
R1076 vdd.n20 vdd.n19 1.68988
R1077 vdd.n17 vdd.n16 1.58005
R1078 vdd.n51 vdd.n14 1.58005
R1079 vdd.n7 vdd.n6 1.50476
R1080 vdd.n57 vdd.n4 1.50476
R1081 vdd.n31 vdd.n30 1.41728
R1082 vdd.n34 vdd.n33 1.41001
R1083 vdd.n59 vdd.n32 1.41001
R1084 vdd.n37 vdd.n33 1.36726
R1085 vdd.n60 vdd.n59 1.36726
R1086 vdd.n62 vdd.n30 1.36088
R1087 vdd.n21 vdd.n162 0.850255
R1088 vdd.n37 vdd.n61 0.850255
R1089 vdd.n164 vdd.n153 0.850255
R1090 vdd.n34 vdd.n157 0.853449
R1091 vdd.n99 vdd.n158 0.853449
R1092 vdd.n32 vdd.n159 0.853449
R1093 vdd.n156 vdd.n160 0.853449
R1094 vdd.n106 vdd.n2 1.32578
R1095 vdd.n104 vdd.n0 1.32578
R1096 vdd.n162 vdd.n61 1.25504
R1097 vdd.n164 vdd.n161 1.25504
R1098 vdd.n161 vdd.n162 1.25504
R1099 vdd.n109 vdd.n496 1.21073
R1100 vdd.n127 vdd.n125 1.21073
R1101 vdd.n104 vdd.n152 1.21073
R1102 vdd.n106 vdd.n105 1.21073
R1103 vdd.n496 vdd.n2 1.20931
R1104 vdd.n0 vdd.n125 1.20931
R1105 vdd.n463 vdd.n206 1.16669
R1106 vdd.n444 vdd.n443 1.16669
R1107 vdd.n134 vdd.n441 1.16669
R1108 vdd.n448 vdd.n136 1.16669
R1109 vdd.n448 vdd.n440 1.16669
R1110 vdd.n453 vdd.n452 1.16669
R1111 vdd.n454 vdd.n207 1.16669
R1112 vdd.n436 vdd.n67 1.16669
R1113 vdd.n435 vdd.n434 1.16669
R1114 vdd.n310 vdd.n209 1.16669
R1115 vdd.n68 vdd.n311 1.16669
R1116 vdd.n316 vdd.n315 1.16669
R1117 vdd.n317 vdd.n305 1.16669
R1118 vdd.n322 vdd.n321 1.16669
R1119 vdd.n137 vdd.n322 1.16669
R1120 vdd.n324 vdd.n303 1.16669
R1121 vdd.n329 vdd.n328 1.16669
R1122 vdd.n330 vdd.n64 1.16669
R1123 vdd.n568 vdd.n567 1.16669
R1124 vdd.n138 vdd.n166 1.16669
R1125 vdd.n269 vdd.n139 1.16669
R1126 vdd.n270 vdd.n269 1.16669
R1127 vdd.n271 vdd.n266 1.16669
R1128 vdd.n276 vdd.n275 1.16669
R1129 vdd.n281 vdd.n69 1.16669
R1130 vdd.n283 vdd.n282 1.16669
R1131 vdd.n232 vdd.n231 1.16669
R1132 vdd.n72 vdd.n70 1.16669
R1133 vdd.n227 vdd.n215 1.16669
R1134 vdd.n223 vdd.n222 1.16669
R1135 vdd.n221 vdd.n217 1.16669
R1136 vdd.n217 vdd.n140 1.16669
R1137 vdd.n487 vdd.n486 1.16669
R1138 vdd.n491 vdd.n186 1.16669
R1139 vdd.n126 vdd.n174 1.16669
R1140 vdd.n551 vdd.n550 1.16669
R1141 vdd.n141 vdd.n175 1.16669
R1142 vdd.n545 vdd.n142 1.16669
R1143 vdd.n545 vdd.n544 1.16669
R1144 vdd.n543 vdd.n177 1.16669
R1145 vdd.n539 vdd.n538 1.16669
R1146 vdd.n74 vdd.n534 1.16669
R1147 vdd.n533 vdd.n180 1.16669
R1148 vdd.n529 vdd.n528 1.16669
R1149 vdd.n527 vdd.n75 1.16669
R1150 vdd.n504 vdd.n183 1.16669
R1151 vdd.n505 vdd.n502 1.16669
R1152 vdd.n510 vdd.n509 1.16669
R1153 vdd.n144 vdd.n510 1.16669
R1154 vdd.n514 vdd.n513 1.16669
R1155 vdd.n515 vdd.n499 1.16669
R1156 vdd.n520 vdd.n519 1.16669
R1157 vdd.n468 vdd.n16 1.16669
R1158 vdd.n145 vdd.n200 1.16669
R1159 vdd.n387 vdd.n146 1.16669
R1160 vdd.n388 vdd.n387 1.16669
R1161 vdd.n389 vdd.n384 1.16669
R1162 vdd.n394 vdd.n393 1.16669
R1163 vdd.n399 vdd.n76 1.16669
R1164 vdd.n401 vdd.n400 1.16669
R1165 vdd.n405 vdd.n293 1.16669
R1166 vdd.n78 vdd.n406 1.16669
R1167 vdd.n411 vdd.n410 1.16669
R1168 vdd.n412 vdd.n290 1.16669
R1169 vdd.n417 vdd.n416 1.16669
R1170 vdd.n147 vdd.n417 1.16669
R1171 vdd.n421 vdd.n420 1.16669
R1172 vdd.n51 vdd.n426 1.16669
R1173 vdd.n258 vdd.n7 1.16669
R1174 vdd.n257 vdd.n256 1.16669
R1175 vdd.n252 vdd.n238 1.16669
R1176 vdd.n149 vdd.n251 1.16669
R1177 vdd.n251 vdd.n239 1.16669
R1178 vdd.n247 vdd.n246 1.16669
R1179 vdd.n245 vdd.n241 1.16669
R1180 vdd.n475 vdd.n81 1.16669
R1181 vdd.n479 vdd.n198 1.16669
R1182 vdd.n481 vdd.n480 1.16669
R1183 vdd.n83 vdd.n196 1.16669
R1184 vdd.n348 vdd.n345 1.16669
R1185 vdd.n350 vdd.n349 1.16669
R1186 vdd.n354 vdd.n343 1.16669
R1187 vdd.n151 vdd.n354 1.16669
R1188 vdd.n355 vdd.n342 1.16669
R1189 vdd.n360 vdd.n359 1.16669
R1190 vdd.n361 vdd.n4 1.16669
R1191 vdd.n83 vdd.n82 1.16669
R1192 vdd.n81 vdd.n80 1.16669
R1193 vdd.n78 vdd.n77 1.16669
R1194 vdd.n395 vdd.n76 1.16669
R1195 vdd.n523 vdd.n75 1.16669
R1196 vdd.n537 vdd.n74 1.16669
R1197 vdd.n72 vdd.n71 1.16669
R1198 vdd.n277 vdd.n69 1.16669
R1199 vdd.n307 vdd.n68 1.16669
R1200 vdd.n67 vdd.n66 1.16669
R1201 vdd.n470 vdd.n469 1.16669
R1202 vdd.n422 vdd.n287 1.16669
R1203 vdd.n443 vdd.n206 1.16527
R1204 vdd.n444 vdd.n441 1.16527
R1205 vdd.n452 vdd.n440 1.16527
R1206 vdd.n454 vdd.n453 1.16527
R1207 vdd.n66 vdd.n207 1.16527
R1208 vdd.n436 vdd.n435 1.16527
R1209 vdd.n434 vdd.n209 1.16527
R1210 vdd.n311 vdd.n310 1.16527
R1211 vdd.n315 vdd.n307 1.16527
R1212 vdd.n317 vdd.n316 1.16527
R1213 vdd.n321 vdd.n305 1.16527
R1214 vdd.n328 vdd.n303 1.16527
R1215 vdd.n330 vdd.n329 1.16527
R1216 vdd.n567 vdd.n566 1.16527
R1217 vdd.n568 vdd.n166 1.16527
R1218 vdd.n271 vdd.n270 1.16527
R1219 vdd.n275 vdd.n266 1.16527
R1220 vdd.n277 vdd.n276 1.16527
R1221 vdd.n282 vdd.n281 1.16527
R1222 vdd.n283 vdd.n232 1.16527
R1223 vdd.n231 vdd.n70 1.16527
R1224 vdd.n71 vdd.n227 1.16527
R1225 vdd.n223 vdd.n215 1.16527
R1226 vdd.n222 vdd.n221 1.16527
R1227 vdd.n487 vdd.n186 1.16527
R1228 vdd.n492 vdd.n491 1.16527
R1229 vdd.n550 vdd.n174 1.16527
R1230 vdd.n551 vdd.n175 1.16527
R1231 vdd.n544 vdd.n543 1.16527
R1232 vdd.n539 vdd.n177 1.16527
R1233 vdd.n538 vdd.n537 1.16527
R1234 vdd.n534 vdd.n533 1.16527
R1235 vdd.n529 vdd.n180 1.16527
R1236 vdd.n528 vdd.n527 1.16527
R1237 vdd.n523 vdd.n183 1.16527
R1238 vdd.n505 vdd.n504 1.16527
R1239 vdd.n509 vdd.n502 1.16527
R1240 vdd.n515 vdd.n514 1.16527
R1241 vdd.n519 vdd.n499 1.16527
R1242 vdd.n469 vdd.n468 1.16527
R1243 vdd.n470 vdd.n200 1.16527
R1244 vdd.n389 vdd.n388 1.16527
R1245 vdd.n393 vdd.n384 1.16527
R1246 vdd.n395 vdd.n394 1.16527
R1247 vdd.n400 vdd.n399 1.16527
R1248 vdd.n401 vdd.n293 1.16527
R1249 vdd.n406 vdd.n405 1.16527
R1250 vdd.n410 vdd.n77 1.16527
R1251 vdd.n412 vdd.n411 1.16527
R1252 vdd.n416 vdd.n290 1.16527
R1253 vdd.n422 vdd.n421 1.16527
R1254 vdd.n426 vdd.n287 1.16527
R1255 vdd.n258 vdd.n257 1.16527
R1256 vdd.n256 vdd.n238 1.16527
R1257 vdd.n247 vdd.n239 1.16527
R1258 vdd.n246 vdd.n245 1.16527
R1259 vdd.n241 vdd.n80 1.16527
R1260 vdd.n475 vdd.n198 1.16527
R1261 vdd.n480 vdd.n479 1.16527
R1262 vdd.n481 vdd.n196 1.16527
R1263 vdd.n345 vdd.n82 1.16527
R1264 vdd.n349 vdd.n348 1.16527
R1265 vdd.n350 vdd.n343 1.16527
R1266 vdd.n359 vdd.n342 1.16527
R1267 vdd.n361 vdd.n360 1.16527
R1268 vdd.n355 vdd.n151 1.16527
R1269 vdd.n252 vdd.n149 1.16527
R1270 vdd.n420 vdd.n147 1.16527
R1271 vdd.n146 vdd.n145 1.16527
R1272 vdd.n513 vdd.n144 1.16527
R1273 vdd.n142 vdd.n141 1.16527
R1274 vdd.n486 vdd.n140 1.16527
R1275 vdd.n139 vdd.n138 1.16527
R1276 vdd.n324 vdd.n137 1.16527
R1277 vdd.n136 vdd.n134 1.16527
R1278 vdd.n127 vdd.n126 1.14681
R1279 vdd.n520 vdd.n109 1.14681
R1280 vdd.n65 vdd.n64 1.14681
R1281 vdd.n463 vdd.n63 1.14681
R1282 vdd.n20 vdd.n98 1.08828
R1283 vdd.n156 vdd.n23 1.08101
R1284 vdd.n22 vdd.n99 1.08101
R1285 vdd.n16 vdd.n63 1.06442
R1286 vdd.n51 vdd.n65 1.06442
R1287 vdd vdd.n0 0.0005
C0 vdd out 0.11054p
C1 vdd vgi 81.8481f
C2 vdd vg 0.30305p
C3 out vgi 26.8047f
C4 out vg 0.14889p
C5 vgi vg 1.22706f
C6 vgi w_n14840_n200# 1.97057f
C7 out w_n14840_n200# 4.37544f
C8 vg w_n14840_n200# 5.12427f
C9 vdd w_n14840_n200# 0.97228p
C10 vdd.n0 w_n14840_n200# 0.3481f
C11 vdd.n2 w_n14840_n200# 0.3481f
C12 vdd.n4 w_n14840_n200# 0.34779f
C13 vdd.n6 w_n14840_n200# 0.09438f
C14 vdd.n7 w_n14840_n200# 0.34779f
C15 vdd.n9 w_n14840_n200# 9.10996f
C16 vdd.n10 w_n14840_n200# 1.18885f
C17 vdd.n11 w_n14840_n200# 0.5322f
C18 vdd.n12 w_n14840_n200# 0.5322f
C19 vdd.n13 w_n14840_n200# 1.18885f
C20 vdd.n14 w_n14840_n200# 0.13251f
C21 vdd.n15 w_n14840_n200# 0.07923f
C22 vdd.n16 w_n14840_n200# 0.13419f
C23 vdd.n17 w_n14840_n200# 0.13251f
C24 vdd.n18 w_n14840_n200# 0.07923f
C25 vdd.n19 w_n14840_n200# 0.6828f
C26 vdd.n20 w_n14840_n200# 1.87553f
C27 vdd.n21 w_n14840_n200# 0.36375f
C28 vdd.n22 w_n14840_n200# 1.87553f
C29 vdd.n23 w_n14840_n200# 1.87553f
C30 vdd.n24 w_n14840_n200# 0.17198f
C31 vdd.n25 w_n14840_n200# 0.25624f
C32 vdd.n26 w_n14840_n200# 0.25624f
C33 vdd.n27 w_n14840_n200# 0.2947f
C34 vdd.n28 w_n14840_n200# 0.25614f
C35 vdd.n29 w_n14840_n200# 0.25614f
C36 vdd.n30 w_n14840_n200# 0.66553f
C37 vdd.n31 w_n14840_n200# 1.11073f
C38 vdd.n32 w_n14840_n200# 0.79504f
C39 vdd.n33 w_n14840_n200# 0.66553f
C40 vdd.n34 w_n14840_n200# 0.79504f
C41 vdd.n35 w_n14840_n200# 0.42213f
C42 vdd.n36 w_n14840_n200# 0.48622f
C43 vdd.n37 w_n14840_n200# 1.02928f
C44 vdd.n38 w_n14840_n200# 0.48622f
C45 vdd.n39 w_n14840_n200# 0.48631f
C46 vdd.n40 w_n14840_n200# 0.48631f
C47 vdd.n41 w_n14840_n200# 0.48631f
C48 vdd.n42 w_n14840_n200# 0.48631f
C49 vdd.n43 w_n14840_n200# 0.42213f
C50 vdd.n44 w_n14840_n200# 0.48622f
C51 vdd.n45 w_n14840_n200# 0.48622f
C52 vdd.n46 w_n14840_n200# 0.42213f
C53 vdd.n47 w_n14840_n200# 0.48622f
C54 vdd.n48 w_n14840_n200# 0.48622f
C55 vdd.n49 w_n14840_n200# 0.48631f
C56 vdd.n50 w_n14840_n200# 0.48631f
C57 vdd.n51 w_n14840_n200# 0.13419f
C58 vdd.n52 w_n14840_n200# 0.10696f
C59 vdd.n53 w_n14840_n200# 0.03439f
C60 vdd.n54 w_n14840_n200# 0.10696f
C61 vdd.n55 w_n14840_n200# 0.03439f
C62 vdd.n56 w_n14840_n200# 0.05199f
C63 vdd.n57 w_n14840_n200# 0.09438f
C64 vdd.n58 w_n14840_n200# 0.05199f
C65 vdd.n59 w_n14840_n200# 0.66553f
C66 vdd.n60 w_n14840_n200# 1.02928f
C67 vdd.n61 w_n14840_n200# 1.64255f
C68 vdd.n62 w_n14840_n200# 1.34846f
C69 vdd.n63 w_n14840_n200# 0.08377f
C70 vdd.n64 w_n14840_n200# 0.06148f
C71 vdd.n65 w_n14840_n200# 0.08377f
C72 vdd.n66 w_n14840_n200# 0.05829f
C73 vdd.n67 w_n14840_n200# 0.08745f
C74 vdd.n68 w_n14840_n200# 0.08745f
C75 vdd.n69 w_n14840_n200# 0.09024f
C76 vdd.n70 w_n14840_n200# 0.07285f
C77 vdd.n71 w_n14840_n200# 0.05829f
C78 vdd.n72 w_n14840_n200# 0.09024f
C79 vdd.n73 w_n14840_n200# 1.03315f
C80 vdd.n74 w_n14840_n200# 0.08745f
C81 vdd.n75 w_n14840_n200# 0.08745f
C82 vdd.n76 w_n14840_n200# 0.09024f
C83 vdd.n77 w_n14840_n200# 0.05829f
C84 vdd.n78 w_n14840_n200# 0.09024f
C85 vdd.n79 w_n14840_n200# 0.05964f
C86 vdd.n80 w_n14840_n200# 0.05829f
C87 vdd.n81 w_n14840_n200# 0.09024f
C88 vdd.n82 w_n14840_n200# 0.05829f
C89 vdd.n83 w_n14840_n200# 0.09024f
C90 vdd.n84 w_n14840_n200# 0.46846f
C91 vdd.n85 w_n14840_n200# 0.46846f
C92 vdd.n86 w_n14840_n200# 0.46855f
C93 vdd.n87 w_n14840_n200# 0.46855f
C94 vdd.n88 w_n14840_n200# 0.46855f
C95 vdd.n89 w_n14840_n200# 0.46855f
C96 vdd.n90 w_n14840_n200# 0.46846f
C97 vdd.n91 w_n14840_n200# 0.42213f
C98 vdd.n92 w_n14840_n200# 0.46846f
C99 vdd.n93 w_n14840_n200# 0.46846f
C100 vdd.n94 w_n14840_n200# 0.46846f
C101 vdd.n95 w_n14840_n200# 0.46855f
C102 vdd.n96 w_n14840_n200# 0.42222f
C103 vdd.n97 w_n14840_n200# 0.46855f
C104 vdd.n98 w_n14840_n200# 0.57341f
C105 vdd.n99 w_n14840_n200# 0.25058f
C106 vdd.n100 w_n14840_n200# 0.66326f
C107 vdd.n101 w_n14840_n200# 0.04471f
C108 vdd.n102 w_n14840_n200# 0.7119f
C109 vdd.n103 w_n14840_n200# 0.7119f
C110 vdd.n104 w_n14840_n200# 0.08879f
C111 vdd.n105 w_n14840_n200# 0.07027f
C112 vdd.n106 w_n14840_n200# 0.08879f
C113 vdd.n107 w_n14840_n200# 0.35805f
C114 vdd.n108 w_n14840_n200# 0.31623f
C115 vdd.n109 w_n14840_n200# 0.08124f
C116 vdd.n110 w_n14840_n200# 0.31623f
C117 vdd.n111 w_n14840_n200# 0.31632f
C118 vdd.n112 w_n14840_n200# 0.31632f
C119 vdd.n113 w_n14840_n200# 0.31632f
C120 vdd.n114 w_n14840_n200# 0.31632f
C121 vdd.n115 w_n14840_n200# 0.31623f
C122 vdd.n116 w_n14840_n200# 0.35805f
C123 vdd.n117 w_n14840_n200# 0.31623f
C124 vdd.n118 w_n14840_n200# 0.35805f
C125 vdd.n119 w_n14840_n200# 0.31623f
C126 vdd.n120 w_n14840_n200# 0.31623f
C127 vdd.n121 w_n14840_n200# 0.31632f
C128 vdd.n122 w_n14840_n200# 0.31632f
C129 vdd.n123 w_n14840_n200# 0.03722f
C130 vdd.n124 w_n14840_n200# 0.03722f
C131 vdd.n125 w_n14840_n200# 0.0756f
C132 vdd.n126 w_n14840_n200# 0.24335f
C133 vdd.n127 w_n14840_n200# 0.08124f
C134 vdd.n128 w_n14840_n200# 0.22815f
C135 vdd.n129 w_n14840_n200# 0.20007f
C136 vdd.n130 w_n14840_n200# 0.22815f
C137 vdd.n131 w_n14840_n200# 0.22805f
C138 vdd.n132 w_n14840_n200# 0.22805f
C139 vdd.n133 w_n14840_n200# 0.0596f
C140 vdd.n134 w_n14840_n200# 0.06561f
C141 vdd.n135 w_n14840_n200# 0.90078f
C142 vdd.n136 w_n14840_n200# 0.08009f
C143 vdd.n137 w_n14840_n200# 0.08009f
C144 vdd.n138 w_n14840_n200# 0.06561f
C145 vdd.n139 w_n14840_n200# 0.08287f
C146 vdd.n140 w_n14840_n200# 0.08287f
C147 vdd.n141 w_n14840_n200# 0.06561f
C148 vdd.n142 w_n14840_n200# 0.08009f
C149 vdd.n143 w_n14840_n200# 0.90078f
C150 vdd.n144 w_n14840_n200# 0.08009f
C151 vdd.n145 w_n14840_n200# 0.06561f
C152 vdd.n146 w_n14840_n200# 0.08287f
C153 vdd.n147 w_n14840_n200# 0.08287f
C154 vdd.n148 w_n14840_n200# 0.0596f
C155 vdd.n149 w_n14840_n200# 0.08287f
C156 vdd.n150 w_n14840_n200# 0.0596f
C157 vdd.n151 w_n14840_n200# 0.08287f
C158 vdd.n152 w_n14840_n200# 0.07027f
C159 vdd.n153 w_n14840_n200# 0.36375f
C160 vdd.n154 w_n14840_n200# 0.03323f
C161 vdd.n155 w_n14840_n200# 0.03323f
C162 vdd.n156 w_n14840_n200# 0.25058f
C163 vdd.n157 w_n14840_n200# 1.64834f
C164 vdd.n158 w_n14840_n200# 1.55207f
C165 vdd.n159 w_n14840_n200# 1.55207f
C166 vdd.n160 w_n14840_n200# 1.63735f
C167 vdd.n161 w_n14840_n200# 1.5519f
C168 vdd.n162 w_n14840_n200# 1.5519f
C169 vdd.n163 w_n14840_n200# 0.90078f
C170 vdd.n164 w_n14840_n200# 1.64274f
C171 vdd.n165 w_n14840_n200# 0.3758f
C172 vdd.n166 w_n14840_n200# 0.07285f
C173 vdd.n167 w_n14840_n200# 0.0596f
C174 vdd.n168 w_n14840_n200# 0.0596f
C175 vdd.n169 w_n14840_n200# 0.0332f
C176 vdd.t46 w_n14840_n200# 0.36041f
C177 vdd.n170 w_n14840_n200# 0.35813f
C178 vdd.n171 w_n14840_n200# 0.03777f
C179 vdd.t43 w_n14840_n200# 14.972f
C180 vdd.n172 w_n14840_n200# 0.28463f
C181 vdd.n173 w_n14840_n200# 0.06262f
C182 vdd.n174 w_n14840_n200# 0.19825f
C183 vdd.n175 w_n14840_n200# 0.07285f
C184 vdd.n176 w_n14840_n200# 0.0596f
C185 vdd.n177 w_n14840_n200# 0.07285f
C186 vdd.n178 w_n14840_n200# 0.0596f
C187 vdd.n179 w_n14840_n200# 0.0596f
C188 vdd.n180 w_n14840_n200# 0.07285f
C189 vdd.n181 w_n14840_n200# 0.0596f
C190 vdd.n182 w_n14840_n200# 0.0596f
C191 vdd.n183 w_n14840_n200# 0.07285f
C192 vdd.n184 w_n14840_n200# 0.03095f
C193 vdd.n185 w_n14840_n200# 0.0596f
C194 vdd.n186 w_n14840_n200# 0.07285f
C195 vdd.n187 w_n14840_n200# 0.0596f
C196 vdd.n188 w_n14840_n200# 0.3758f
C197 vdd.t58 w_n14840_n200# 0.36041f
C198 vdd.n189 w_n14840_n200# 0.37589f
C199 vdd.t76 w_n14840_n200# 0.36041f
C200 vdd.n190 w_n14840_n200# 0.35805f
C201 vdd.t73 w_n14840_n200# 0.36041f
C202 vdd.n191 w_n14840_n200# 0.35813f
C203 vdd.t70 w_n14840_n200# 0.36041f
C204 vdd.n192 w_n14840_n200# 0.42222f
C205 vdd.t67 w_n14840_n200# 0.36041f
C206 vdd.n193 w_n14840_n200# 0.42213f
C207 vdd.t64 w_n14840_n200# 0.36041f
C208 vdd.n194 w_n14840_n200# 0.3758f
C209 vdd.t61 w_n14840_n200# 0.36041f
C210 vdd.n195 w_n14840_n200# 0.37589f
C211 vdd.n196 w_n14840_n200# 0.07285f
C212 vdd.n197 w_n14840_n200# 0.0596f
C213 vdd.n198 w_n14840_n200# 0.07285f
C214 vdd.n199 w_n14840_n200# 0.3758f
C215 vdd.n200 w_n14840_n200# 0.07285f
C216 vdd.n201 w_n14840_n200# 0.0596f
C217 vdd.n202 w_n14840_n200# 0.0596f
C218 vdd.t100 w_n14840_n200# 0.36041f
C219 vdd.n203 w_n14840_n200# 0.35813f
C220 vdd.n204 w_n14840_n200# 0.03302f
C221 vdd.n205 w_n14840_n200# 0.0596f
C222 vdd.n206 w_n14840_n200# 0.07285f
C223 vdd.n207 w_n14840_n200# 0.07285f
C224 vdd.n208 w_n14840_n200# 0.0596f
C225 vdd.n209 w_n14840_n200# 0.07285f
C226 vdd.n210 w_n14840_n200# 0.04471f
C227 vdd.n211 w_n14840_n200# 0.66326f
C228 vdd.t22 w_n14840_n200# 3.90925f
C229 vdd.n212 w_n14840_n200# 0.04471f
C230 vdd.n213 w_n14840_n200# 0.0596f
C231 vdd.n214 w_n14840_n200# 0.0596f
C232 vdd.n215 w_n14840_n200# 0.07285f
C233 vdd.n216 w_n14840_n200# 0.0596f
C234 vdd.n217 w_n14840_n200# 0.07289f
C235 vdd.n218 w_n14840_n200# 0.0596f
C236 vdd.n219 w_n14840_n200# 0.05964f
C237 vdd.n220 w_n14840_n200# 0.0596f
C238 vdd.n221 w_n14840_n200# 0.07285f
C239 vdd.n222 w_n14840_n200# 0.07285f
C240 vdd.n223 w_n14840_n200# 0.07285f
C241 vdd.n224 w_n14840_n200# 0.0596f
C242 vdd.n225 w_n14840_n200# 0.0596f
C243 vdd.n226 w_n14840_n200# 0.0596f
C244 vdd.n227 w_n14840_n200# 0.07285f
C245 vdd.n228 w_n14840_n200# 0.05964f
C246 vdd.n229 w_n14840_n200# 0.0596f
C247 vdd.n230 w_n14840_n200# 0.0596f
C248 vdd.n231 w_n14840_n200# 0.07285f
C249 vdd.n232 w_n14840_n200# 0.07285f
C250 vdd.n233 w_n14840_n200# 0.0596f
C251 vdd.n234 w_n14840_n200# 0.3758f
C252 vdd.t88 w_n14840_n200# 0.36041f
C253 vdd.n235 w_n14840_n200# 0.37589f
C254 vdd.t86 w_n14840_n200# 0.36041f
C255 vdd.n236 w_n14840_n200# 0.37589f
C256 vdd.n237 w_n14840_n200# 0.0596f
C257 vdd.n238 w_n14840_n200# 0.07285f
C258 vdd.n239 w_n14840_n200# 0.07285f
C259 vdd.n240 w_n14840_n200# 0.0596f
C260 vdd.n241 w_n14840_n200# 0.07285f
C261 vdd.n242 w_n14840_n200# 0.0596f
C262 vdd.n243 w_n14840_n200# 0.0596f
C263 vdd.n244 w_n14840_n200# 0.0596f
C264 vdd.n245 w_n14840_n200# 0.07285f
C265 vdd.n246 w_n14840_n200# 0.07285f
C266 vdd.n247 w_n14840_n200# 0.07285f
C267 vdd.n248 w_n14840_n200# 0.0596f
C268 vdd.n249 w_n14840_n200# 0.0596f
C269 vdd.n250 w_n14840_n200# 0.05964f
C270 vdd.n251 w_n14840_n200# 0.07289f
C271 vdd.n252 w_n14840_n200# 0.06561f
C272 vdd.n253 w_n14840_n200# 0.0596f
C273 vdd.n254 w_n14840_n200# 0.0596f
C274 vdd.n255 w_n14840_n200# 0.0596f
C275 vdd.n256 w_n14840_n200# 0.07285f
C276 vdd.n257 w_n14840_n200# 0.07285f
C277 vdd.n258 w_n14840_n200# 0.19825f
C278 vdd.n259 w_n14840_n200# 0.0596f
C279 vdd.n260 w_n14840_n200# 0.03638f
C280 vdd.t99 w_n14840_n200# 0.36041f
C281 vdd.n261 w_n14840_n200# 0.06102f
C282 vdd.n262 w_n14840_n200# 0.0514f
C283 vdd.t77 w_n14840_n200# 0.36041f
C284 vdd.n263 w_n14840_n200# 0.35813f
C285 vdd.t78 w_n14840_n200# 0.36041f
C286 vdd.n264 w_n14840_n200# 0.35805f
C287 vdd.t80 w_n14840_n200# 0.36041f
C288 vdd.t82 w_n14840_n200# 0.36041f
C289 vdd.n265 w_n14840_n200# 0.42222f
C290 vdd.t84 w_n14840_n200# 0.36041f
C291 vdd.n266 w_n14840_n200# 0.07285f
C292 vdd.n267 w_n14840_n200# 0.0596f
C293 vdd.n268 w_n14840_n200# 0.05964f
C294 vdd.n269 w_n14840_n200# 0.07289f
C295 vdd.n270 w_n14840_n200# 0.07285f
C296 vdd.n271 w_n14840_n200# 0.07285f
C297 vdd.n272 w_n14840_n200# 0.0596f
C298 vdd.n273 w_n14840_n200# 0.0596f
C299 vdd.n274 w_n14840_n200# 0.0596f
C300 vdd.n275 w_n14840_n200# 0.07285f
C301 vdd.n276 w_n14840_n200# 0.07285f
C302 vdd.n277 w_n14840_n200# 0.05829f
C303 vdd.n278 w_n14840_n200# 0.0596f
C304 vdd.n279 w_n14840_n200# 0.05964f
C305 vdd.n280 w_n14840_n200# 0.0596f
C306 vdd.n281 w_n14840_n200# 0.07285f
C307 vdd.n282 w_n14840_n200# 0.07285f
C308 vdd.n283 w_n14840_n200# 0.07285f
C309 vdd.n284 w_n14840_n200# 0.04471f
C310 vdd.t45 w_n14840_n200# 10.1056f
C311 vdd.t0 w_n14840_n200# 7.61962f
C312 vdd.t2 w_n14840_n200# 5.53137f
C313 vdd.t47 w_n14840_n200# 5.33249f
C314 vdd.t4 w_n14840_n200# 7.8185f
C315 vdd.t48 w_n14840_n200# 5.33249f
C316 vdd.t5 w_n14840_n200# 7.8185f
C317 vdd.t50 w_n14840_n200# 5.33249f
C318 vdd.t7 w_n14840_n200# 5.49408f
C319 vdd.t8 w_n14840_n200# 7.65691f
C320 vdd.t51 w_n14840_n200# 5.33249f
C321 vdd.t10 w_n14840_n200# 7.8185f
C322 vdd.t53 w_n14840_n200# 5.33249f
C323 vdd.t11 w_n14840_n200# 5.85455f
C324 vdd.t13 w_n14840_n200# 7.29644f
C325 vdd.t54 w_n14840_n200# 5.33249f
C326 vdd.t14 w_n14840_n200# 7.8185f
C327 vdd.t56 w_n14840_n200# 5.33249f
C328 vdd.t16 w_n14840_n200# 6.21503f
C329 vdd.t17 w_n14840_n200# 6.93597f
C330 vdd.t57 w_n14840_n200# 5.33249f
C331 vdd.t19 w_n14840_n200# 7.8185f
C332 vdd.t59 w_n14840_n200# 5.33249f
C333 vdd.t20 w_n14840_n200# 3.90925f
C334 vdd.n285 w_n14840_n200# 0.12914f
C335 vdd.n286 w_n14840_n200# 0.06553f
C336 vdd.n287 w_n14840_n200# 0.13676f
C337 vdd.n288 w_n14840_n200# 0.0596f
C338 vdd.n289 w_n14840_n200# 0.05964f
C339 vdd.n290 w_n14840_n200# 0.07285f
C340 vdd.n291 w_n14840_n200# 0.0596f
C341 vdd.n292 w_n14840_n200# 0.0596f
C342 vdd.n293 w_n14840_n200# 0.07285f
C343 vdd.n294 w_n14840_n200# 0.0596f
C344 vdd.n295 w_n14840_n200# 0.0596f
C345 vdd.n296 w_n14840_n200# 0.19996f
C346 vdd.n297 w_n14840_n200# 0.214f
C347 vdd.n298 w_n14840_n200# 0.21411f
C348 vdd.n299 w_n14840_n200# 0.25237f
C349 vdd.n300 w_n14840_n200# 0.1494f
C350 vdd.n301 w_n14840_n200# 0.03302f
C351 vdd.n302 w_n14840_n200# 0.0596f
C352 vdd.n303 w_n14840_n200# 0.07285f
C353 vdd.n304 w_n14840_n200# 0.05964f
C354 vdd.n305 w_n14840_n200# 0.07285f
C355 vdd.n306 w_n14840_n200# 0.0596f
C356 vdd.n307 w_n14840_n200# 0.05829f
C357 vdd.n308 w_n14840_n200# 0.0596f
C358 vdd.n309 w_n14840_n200# 0.0596f
C359 vdd.n310 w_n14840_n200# 0.07285f
C360 vdd.n311 w_n14840_n200# 0.07285f
C361 vdd.n312 w_n14840_n200# 0.05964f
C362 vdd.n313 w_n14840_n200# 0.0596f
C363 vdd.n314 w_n14840_n200# 0.0596f
C364 vdd.n315 w_n14840_n200# 0.07285f
C365 vdd.n316 w_n14840_n200# 0.07285f
C366 vdd.n317 w_n14840_n200# 0.07285f
C367 vdd.n318 w_n14840_n200# 0.0596f
C368 vdd.n319 w_n14840_n200# 0.0596f
C369 vdd.n320 w_n14840_n200# 0.0596f
C370 vdd.n321 w_n14840_n200# 0.07285f
C371 vdd.n322 w_n14840_n200# 0.07289f
C372 vdd.n323 w_n14840_n200# 0.0596f
C373 vdd.n324 w_n14840_n200# 0.06561f
C374 vdd.n325 w_n14840_n200# 0.0596f
C375 vdd.n326 w_n14840_n200# 0.0596f
C376 vdd.n327 w_n14840_n200# 0.0596f
C377 vdd.n328 w_n14840_n200# 0.07285f
C378 vdd.n329 w_n14840_n200# 0.07285f
C379 vdd.n330 w_n14840_n200# 0.07285f
C380 vdd.n331 w_n14840_n200# 0.0596f
C381 vdd.n332 w_n14840_n200# 0.06262f
C382 vdd.n333 w_n14840_n200# 0.03647f
C383 vdd.t42 w_n14840_n200# 0.21278f
C384 vdd.n334 w_n14840_n200# 0.2947f
C385 vdd.t39 w_n14840_n200# 0.21278f
C386 vdd.n335 w_n14840_n200# 0.35813f
C387 vdd.n336 w_n14840_n200# 0.03777f
C388 vdd.t96 w_n14840_n200# 0.36041f
C389 vdd.n337 w_n14840_n200# 0.35813f
C390 vdd.n338 w_n14840_n200# 0.03095f
C391 vdd.n339 w_n14840_n200# 0.05594f
C392 vdd.t98 w_n14840_n200# 0.36041f
C393 vdd.n340 w_n14840_n200# 0.0514f
C394 vdd.n341 w_n14840_n200# 0.0596f
C395 vdd.n342 w_n14840_n200# 0.07285f
C396 vdd.n343 w_n14840_n200# 0.07285f
C397 vdd.n344 w_n14840_n200# 0.0596f
C398 vdd.n345 w_n14840_n200# 0.07285f
C399 vdd.n346 w_n14840_n200# 0.0596f
C400 vdd.n347 w_n14840_n200# 0.0596f
C401 vdd.n348 w_n14840_n200# 0.07285f
C402 vdd.n349 w_n14840_n200# 0.07285f
C403 vdd.n350 w_n14840_n200# 0.07285f
C404 vdd.n351 w_n14840_n200# 0.0596f
C405 vdd.n352 w_n14840_n200# 0.0596f
C406 vdd.n353 w_n14840_n200# 0.05964f
C407 vdd.n354 w_n14840_n200# 0.07289f
C408 vdd.n355 w_n14840_n200# 0.06561f
C409 vdd.n356 w_n14840_n200# 0.0596f
C410 vdd.n357 w_n14840_n200# 0.0596f
C411 vdd.n358 w_n14840_n200# 0.0596f
C412 vdd.n359 w_n14840_n200# 0.07285f
C413 vdd.n360 w_n14840_n200# 0.07285f
C414 vdd.n361 w_n14840_n200# 0.19825f
C415 vdd.n362 w_n14840_n200# 0.0596f
C416 vdd.n363 w_n14840_n200# 0.06102f
C417 vdd.t120 w_n14840_n200# 0.36041f
C418 vdd.t118 w_n14840_n200# 0.36041f
C419 vdd.n364 w_n14840_n200# 0.35805f
C420 vdd.t108 w_n14840_n200# 0.36041f
C421 vdd.n365 w_n14840_n200# 0.37589f
C422 vdd.n366 w_n14840_n200# 0.3758f
C423 vdd.t110 w_n14840_n200# 0.36041f
C424 vdd.n367 w_n14840_n200# 0.37589f
C425 vdd.t112 w_n14840_n200# 0.36041f
C426 vdd.t114 w_n14840_n200# 0.36041f
C427 vdd.n368 w_n14840_n200# 0.42213f
C428 vdd.t116 w_n14840_n200# 0.36041f
C429 vdd.n369 w_n14840_n200# 0.17198f
C430 vdd.t36 w_n14840_n200# 0.21278f
C431 vdd.n370 w_n14840_n200# 0.17187f
C432 vdd.t33 w_n14840_n200# 0.21278f
C433 vdd.n371 w_n14840_n200# 0.214f
C434 vdd.n372 w_n14840_n200# 0.214f
C435 vdd.t30 w_n14840_n200# 0.21278f
C436 vdd.n373 w_n14840_n200# 0.21411f
C437 vdd.t27 w_n14840_n200# 0.21278f
C438 vdd.t24 w_n14840_n200# 0.21278f
C439 vdd.n374 w_n14840_n200# 0.19996f
C440 vdd.n375 w_n14840_n200# 0.214f
C441 vdd.t21 w_n14840_n200# 0.21278f
C442 vdd.n376 w_n14840_n200# 0.21411f
C443 vdd.t18 w_n14840_n200# 0.21278f
C444 vdd.n377 w_n14840_n200# 0.20007f
C445 vdd.n378 w_n14840_n200# 0.1494f
C446 vdd.t1 w_n14840_n200# 0.21278f
C447 vdd.n379 w_n14840_n200# 0.25237f
C448 vdd.t3 w_n14840_n200# 0.21278f
C449 vdd.t6 w_n14840_n200# 0.21278f
C450 vdd.n380 w_n14840_n200# 0.17187f
C451 vdd.n381 w_n14840_n200# 0.214f
C452 vdd.t9 w_n14840_n200# 0.21278f
C453 vdd.n382 w_n14840_n200# 0.21411f
C454 vdd.t12 w_n14840_n200# 0.21278f
C455 vdd.n383 w_n14840_n200# 0.21411f
C456 vdd.t15 w_n14840_n200# 0.21278f
C457 vdd.n384 w_n14840_n200# 0.07285f
C458 vdd.n385 w_n14840_n200# 0.0596f
C459 vdd.n386 w_n14840_n200# 0.05964f
C460 vdd.n387 w_n14840_n200# 0.07289f
C461 vdd.n388 w_n14840_n200# 0.07285f
C462 vdd.n389 w_n14840_n200# 0.07285f
C463 vdd.n390 w_n14840_n200# 0.0596f
C464 vdd.n391 w_n14840_n200# 0.0596f
C465 vdd.n392 w_n14840_n200# 0.0596f
C466 vdd.n393 w_n14840_n200# 0.07285f
C467 vdd.n394 w_n14840_n200# 0.07285f
C468 vdd.n395 w_n14840_n200# 0.05829f
C469 vdd.n396 w_n14840_n200# 0.0596f
C470 vdd.n397 w_n14840_n200# 0.05964f
C471 vdd.n398 w_n14840_n200# 0.0596f
C472 vdd.n399 w_n14840_n200# 0.07285f
C473 vdd.n400 w_n14840_n200# 0.07285f
C474 vdd.n401 w_n14840_n200# 0.07285f
C475 vdd.n402 w_n14840_n200# 0.04471f
C476 vdd.n403 w_n14840_n200# 0.04471f
C477 vdd.n404 w_n14840_n200# 0.0596f
C478 vdd.n405 w_n14840_n200# 0.07285f
C479 vdd.n406 w_n14840_n200# 0.07285f
C480 vdd.n407 w_n14840_n200# 0.05964f
C481 vdd.n408 w_n14840_n200# 0.0596f
C482 vdd.n409 w_n14840_n200# 0.0596f
C483 vdd.n410 w_n14840_n200# 0.07285f
C484 vdd.n411 w_n14840_n200# 0.07285f
C485 vdd.n412 w_n14840_n200# 0.07285f
C486 vdd.n413 w_n14840_n200# 0.0596f
C487 vdd.n414 w_n14840_n200# 0.0596f
C488 vdd.n415 w_n14840_n200# 0.0596f
C489 vdd.n416 w_n14840_n200# 0.07285f
C490 vdd.n417 w_n14840_n200# 0.07289f
C491 vdd.n418 w_n14840_n200# 0.0596f
C492 vdd.n419 w_n14840_n200# 0.0596f
C493 vdd.n420 w_n14840_n200# 0.06561f
C494 vdd.n421 w_n14840_n200# 0.07285f
C495 vdd.n422 w_n14840_n200# 0.18802f
C496 vdd.n423 w_n14840_n200# 0.0596f
C497 vdd.n424 w_n14840_n200# 0.0596f
C498 vdd.n425 w_n14840_n200# 0.0596f
C499 vdd.n426 w_n14840_n200# 0.07285f
C500 vdd.n427 w_n14840_n200# 0.03638f
C501 vdd.t60 w_n14840_n200# 5.33249f
C502 vdd.t23 w_n14840_n200# 7.8185f
C503 vdd.t62 w_n14840_n200# 5.33249f
C504 vdd.t25 w_n14840_n200# 6.93597f
C505 vdd.t26 w_n14840_n200# 6.21503f
C506 vdd.t63 w_n14840_n200# 5.33249f
C507 vdd.t28 w_n14840_n200# 7.8185f
C508 vdd.t65 w_n14840_n200# 5.33249f
C509 vdd.t29 w_n14840_n200# 7.29644f
C510 vdd.t31 w_n14840_n200# 5.85455f
C511 vdd.t66 w_n14840_n200# 5.33249f
C512 vdd.t32 w_n14840_n200# 7.8185f
C513 vdd.t68 w_n14840_n200# 5.33249f
C514 vdd.t34 w_n14840_n200# 7.65691f
C515 vdd.t35 w_n14840_n200# 5.49408f
C516 vdd.t69 w_n14840_n200# 5.33249f
C517 vdd.t37 w_n14840_n200# 7.8185f
C518 vdd.t71 w_n14840_n200# 5.33249f
C519 vdd.t38 w_n14840_n200# 7.8185f
C520 vdd.t72 w_n14840_n200# 5.33249f
C521 vdd.t40 w_n14840_n200# 5.53137f
C522 vdd.t41 w_n14840_n200# 7.61962f
C523 vdd.t74 w_n14840_n200# 10.1056f
C524 vdd.t75 w_n14840_n200# 14.972f
C525 vdd.n428 w_n14840_n200# 0.7119f
C526 vdd.n429 w_n14840_n200# 0.71158f
C527 vdd.n430 w_n14840_n200# 9.6395f
C528 vdd.n431 w_n14840_n200# 0.28463f
C529 vdd.n432 w_n14840_n200# 0.7119f
C530 vdd.n433 w_n14840_n200# 0.04471f
C531 vdd.n434 w_n14840_n200# 0.07285f
C532 vdd.n435 w_n14840_n200# 0.07285f
C533 vdd.n436 w_n14840_n200# 0.07285f
C534 vdd.n437 w_n14840_n200# 0.0596f
C535 vdd.n438 w_n14840_n200# 0.05964f
C536 vdd.n439 w_n14840_n200# 0.0596f
C537 vdd.n440 w_n14840_n200# 0.07285f
C538 vdd.n441 w_n14840_n200# 0.07285f
C539 vdd.n442 w_n14840_n200# 0.0596f
C540 vdd.n443 w_n14840_n200# 0.07285f
C541 vdd.n444 w_n14840_n200# 0.07285f
C542 vdd.n445 w_n14840_n200# 0.0596f
C543 vdd.n446 w_n14840_n200# 0.0596f
C544 vdd.n447 w_n14840_n200# 0.0596f
C545 vdd.n448 w_n14840_n200# 0.07289f
C546 vdd.n449 w_n14840_n200# 0.05964f
C547 vdd.n450 w_n14840_n200# 0.0596f
C548 vdd.n451 w_n14840_n200# 0.0596f
C549 vdd.n452 w_n14840_n200# 0.07285f
C550 vdd.n453 w_n14840_n200# 0.07285f
C551 vdd.n454 w_n14840_n200# 0.07285f
C552 vdd.n455 w_n14840_n200# 0.0596f
C553 vdd.n456 w_n14840_n200# 0.0596f
C554 vdd.n457 w_n14840_n200# 0.0596f
C555 vdd.n458 w_n14840_n200# 1.03315f
C556 vdd.n459 w_n14840_n200# 1.03315f
C557 vdd.n460 w_n14840_n200# 0.90078f
C558 vdd.n461 w_n14840_n200# 0.3972f
C559 vdd.n462 w_n14840_n200# 0.3972f
C560 vdd.n463 w_n14840_n200# 0.06148f
C561 vdd.n464 w_n14840_n200# 0.06262f
C562 vdd.n465 w_n14840_n200# 0.03647f
C563 vdd.n466 w_n14840_n200# 0.06553f
C564 vdd.n467 w_n14840_n200# 0.0596f
C565 vdd.n468 w_n14840_n200# 0.07285f
C566 vdd.n469 w_n14840_n200# 0.13676f
C567 vdd.n470 w_n14840_n200# 0.18802f
C568 vdd.n471 w_n14840_n200# 0.0596f
C569 vdd.n472 w_n14840_n200# 0.0596f
C570 vdd.n473 w_n14840_n200# 0.0596f
C571 vdd.t102 w_n14840_n200# 0.36041f
C572 vdd.t104 w_n14840_n200# 0.36041f
C573 vdd.n474 w_n14840_n200# 0.42222f
C574 vdd.t106 w_n14840_n200# 0.36041f
C575 vdd.n475 w_n14840_n200# 0.07285f
C576 vdd.n476 w_n14840_n200# 0.0596f
C577 vdd.n477 w_n14840_n200# 0.0596f
C578 vdd.n478 w_n14840_n200# 0.04471f
C579 vdd.n479 w_n14840_n200# 0.07285f
C580 vdd.n480 w_n14840_n200# 0.07285f
C581 vdd.n481 w_n14840_n200# 0.07285f
C582 vdd.n482 w_n14840_n200# 0.0596f
C583 vdd.n483 w_n14840_n200# 0.0596f
C584 vdd.n484 w_n14840_n200# 0.05964f
C585 vdd.t90 w_n14840_n200# 0.36041f
C586 vdd.t92 w_n14840_n200# 0.36041f
C587 vdd.n485 w_n14840_n200# 0.42222f
C588 vdd.t94 w_n14840_n200# 0.36041f
C589 vdd.n486 w_n14840_n200# 0.06561f
C590 vdd.n487 w_n14840_n200# 0.07285f
C591 vdd.n488 w_n14840_n200# 0.0596f
C592 vdd.n489 w_n14840_n200# 0.0596f
C593 vdd.n490 w_n14840_n200# 0.0596f
C594 vdd.n491 w_n14840_n200# 0.07285f
C595 vdd.n492 w_n14840_n200# 0.19825f
C596 vdd.n493 w_n14840_n200# 0.06106f
C597 vdd.n494 w_n14840_n200# 0.05597f
C598 vdd.n495 w_n14840_n200# 0.0332f
C599 vdd.n496 w_n14840_n200# 0.0756f
C600 vdd.n497 w_n14840_n200# 0.05826f
C601 vdd.n498 w_n14840_n200# 0.06262f
C602 vdd.n499 w_n14840_n200# 0.07285f
C603 vdd.n500 w_n14840_n200# 0.0596f
C604 vdd.n501 w_n14840_n200# 0.05964f
C605 vdd.n502 w_n14840_n200# 0.07285f
C606 vdd.n503 w_n14840_n200# 0.0596f
C607 vdd.n504 w_n14840_n200# 0.07285f
C608 vdd.n505 w_n14840_n200# 0.07285f
C609 vdd.n506 w_n14840_n200# 0.0596f
C610 vdd.n507 w_n14840_n200# 0.0596f
C611 vdd.n508 w_n14840_n200# 0.0596f
C612 vdd.n509 w_n14840_n200# 0.07285f
C613 vdd.n510 w_n14840_n200# 0.07289f
C614 vdd.n511 w_n14840_n200# 0.0596f
C615 vdd.n512 w_n14840_n200# 0.0596f
C616 vdd.n513 w_n14840_n200# 0.06561f
C617 vdd.n514 w_n14840_n200# 0.07285f
C618 vdd.n515 w_n14840_n200# 0.07285f
C619 vdd.n516 w_n14840_n200# 0.0596f
C620 vdd.n517 w_n14840_n200# 0.0596f
C621 vdd.n518 w_n14840_n200# 0.0596f
C622 vdd.n519 w_n14840_n200# 0.19825f
C623 vdd.n520 w_n14840_n200# 0.24335f
C624 vdd.n521 w_n14840_n200# 0.3972f
C625 vdd.n522 w_n14840_n200# 1.03315f
C626 vdd.n523 w_n14840_n200# 0.05829f
C627 vdd.n524 w_n14840_n200# 0.0596f
C628 vdd.n525 w_n14840_n200# 0.05964f
C629 vdd.n526 w_n14840_n200# 0.0596f
C630 vdd.n527 w_n14840_n200# 0.07285f
C631 vdd.n528 w_n14840_n200# 0.07285f
C632 vdd.n529 w_n14840_n200# 0.07285f
C633 vdd.n530 w_n14840_n200# 0.04471f
C634 vdd.n531 w_n14840_n200# 0.04471f
C635 vdd.n532 w_n14840_n200# 0.0596f
C636 vdd.n533 w_n14840_n200# 0.07285f
C637 vdd.n534 w_n14840_n200# 0.07285f
C638 vdd.n535 w_n14840_n200# 0.05964f
C639 vdd.n536 w_n14840_n200# 0.0596f
C640 vdd.n537 w_n14840_n200# 0.05829f
C641 vdd.n538 w_n14840_n200# 0.07285f
C642 vdd.n539 w_n14840_n200# 0.07285f
C643 vdd.n540 w_n14840_n200# 0.0596f
C644 vdd.n541 w_n14840_n200# 0.0596f
C645 vdd.n542 w_n14840_n200# 0.0596f
C646 vdd.n543 w_n14840_n200# 0.07285f
C647 vdd.n544 w_n14840_n200# 0.07285f
C648 vdd.n545 w_n14840_n200# 0.07289f
C649 vdd.n546 w_n14840_n200# 0.05964f
C650 vdd.n547 w_n14840_n200# 0.0596f
C651 vdd.n548 w_n14840_n200# 0.0596f
C652 vdd.n549 w_n14840_n200# 0.0596f
C653 vdd.n550 w_n14840_n200# 0.07285f
C654 vdd.n551 w_n14840_n200# 0.07285f
C655 vdd.n552 w_n14840_n200# 0.0596f
C656 vdd.n553 w_n14840_n200# 0.0596f
C657 vdd.n554 w_n14840_n200# 0.0596f
C658 vdd.n555 w_n14840_n200# 0.3972f
C659 vdd.t44 w_n14840_n200# 0.36041f
C660 vdd.n556 w_n14840_n200# 0.05826f
C661 vdd.n557 w_n14840_n200# 0.03095f
C662 vdd.n558 w_n14840_n200# 0.71158f
C663 vdd.n559 w_n14840_n200# 9.6395f
C664 vdd.n560 w_n14840_n200# 0.12914f
C665 vdd.n561 w_n14840_n200# 0.03095f
C666 vdd.n562 w_n14840_n200# 0.05594f
C667 vdd.n563 w_n14840_n200# 0.05597f
C668 vdd.n564 w_n14840_n200# 0.06106f
C669 vdd.n565 w_n14840_n200# 0.0596f
C670 vdd.n566 w_n14840_n200# 0.19825f
C671 vdd.n567 w_n14840_n200# 0.07285f
C672 vdd.n568 w_n14840_n200# 0.07285f
C673 vdd.n569 w_n14840_n200# 0.0596f
C674 vdd.n570 w_n14840_n200# 0.0596f
C675 vdd.n571 w_n14840_n200# 0.0596f
C676 vdd.t49 w_n14840_n200# 0.36041f
C677 vdd.t52 w_n14840_n200# 0.36041f
C678 vdd.n572 w_n14840_n200# 0.42222f
C679 vdd.t55 w_n14840_n200# 0.36041f
C680 vg.n0 w_n14840_n200# 1.69314f
C681 vg.n1 w_n14840_n200# 1.69314f
C682 vg.n2 w_n14840_n200# 1.69314f
C683 vg.n3 w_n14840_n200# 1.69314f
C684 vg.n4 w_n14840_n200# 1.69314f
C685 vg.n5 w_n14840_n200# 1.69318f
C686 vg.n6 w_n14840_n200# 1.69314f
C687 vg.n7 w_n14840_n200# 1.69314f
C688 vg.n8 w_n14840_n200# 1.69314f
C689 vg.n9 w_n14840_n200# 1.69314f
C690 vg.n10 w_n14840_n200# 1.69314f
C691 vg.n11 w_n14840_n200# 1.69318f
C692 vg.n12 w_n14840_n200# 1.69314f
C693 vg.n13 w_n14840_n200# 1.69314f
C694 vg.n14 w_n14840_n200# 1.69314f
C695 vg.n15 w_n14840_n200# 1.69314f
C696 vg.n16 w_n14840_n200# 1.69314f
C697 vg.n17 w_n14840_n200# 1.69318f
C698 vg.n18 w_n14840_n200# 0.34464f
C699 vg.t43 w_n14840_n200# 6.66058f
C700 vg.t42 w_n14840_n200# 6.68076f
C701 vg.t41 w_n14840_n200# 6.68097f
C702 vg.n19 w_n14840_n200# 1.69285f
C703 vg.n20 w_n14840_n200# 1.69306f
C704 vg.n21 w_n14840_n200# 1.69285f
C705 vg.n22 w_n14840_n200# 1.69306f
C706 vg.n23 w_n14840_n200# 1.69285f
C707 vg.n24 w_n14840_n200# 1.69306f
C708 vg.n25 w_n14840_n200# 1.69285f
C709 vg.n26 w_n14840_n200# 1.69306f
C710 vg.n27 w_n14840_n200# 1.69285f
C711 vg.n28 w_n14840_n200# 1.69306f
C712 vg.n29 w_n14840_n200# 1.69306f
C713 vg.n30 w_n14840_n200# 1.69281f
C714 vg.n31 w_n14840_n200# 1.8236f
C715 vg.n32 w_n14840_n200# 1.69285f
C716 vg.n33 w_n14840_n200# 1.6596f
C717 vg.n34 w_n14840_n200# 1.69306f
C718 vg.n35 w_n14840_n200# 1.69285f
C719 vg.n36 w_n14840_n200# 1.69306f
C720 vg.n37 w_n14840_n200# 1.69285f
C721 vg.n38 w_n14840_n200# 1.69306f
C722 vg.n39 w_n14840_n200# 1.69285f
C723 vg.n40 w_n14840_n200# 1.69306f
C724 vg.n41 w_n14840_n200# 1.69285f
C725 vg.n42 w_n14840_n200# 1.69306f
C726 vg.n43 w_n14840_n200# 1.69285f
C727 vg.n44 w_n14840_n200# 1.69306f
C728 vg.n45 w_n14840_n200# 1.69306f
C729 vg.n46 w_n14840_n200# 1.69281f
C730 vg.n47 w_n14840_n200# 1.8236f
C731 vg.n48 w_n14840_n200# 1.69285f
C732 vg.n49 w_n14840_n200# 1.6596f
C733 vg.n50 w_n14840_n200# 1.69306f
C734 vg.n51 w_n14840_n200# 1.69285f
C735 vg.n52 w_n14840_n200# 1.69306f
C736 vg.n53 w_n14840_n200# 1.69285f
C737 vg.n54 w_n14840_n200# 1.69306f
C738 vg.n55 w_n14840_n200# 1.69285f
C739 vg.n56 w_n14840_n200# 1.69306f
C740 vg.n57 w_n14840_n200# 1.69285f
C741 vg.n58 w_n14840_n200# 1.69306f
C742 vg.n59 w_n14840_n200# 1.69285f
C743 vg.n60 w_n14840_n200# 1.69306f
C744 vg.n61 w_n14840_n200# 1.69306f
C745 vg.n62 w_n14840_n200# 1.69281f
C746 vg.n63 w_n14840_n200# 1.8236f
C747 vg.n64 w_n14840_n200# 0.50013f
C748 vg.t40 w_n14840_n200# 4.9879f
C749 vg.t36 w_n14840_n200# 4.9879f
C750 vg.t37 w_n14840_n200# 4.9879f
C751 vg.n65 w_n14840_n200# 0.50013f
C752 vg.t31 w_n14840_n200# 4.9879f
C753 vg.t32 w_n14840_n200# 4.9879f
C754 vg.t27 w_n14840_n200# 4.9879f
C755 vg.t28 w_n14840_n200# 4.9879f
C756 vg.t22 w_n14840_n200# 4.9879f
C757 vg.t23 w_n14840_n200# 4.9879f
C758 vg.t24 w_n14840_n200# 4.9879f
C759 vg.t25 w_n14840_n200# 4.9879f
C760 vg.t26 w_n14840_n200# 4.9879f
C761 vg.n66 w_n14840_n200# 0.60386f
C762 vg.n67 w_n14840_n200# 0.50013f
C763 vg.t29 w_n14840_n200# 4.9879f
C764 vg.t30 w_n14840_n200# 4.9879f
C765 vg.t33 w_n14840_n200# 4.9879f
C766 vg.t34 w_n14840_n200# 4.9879f
C767 vg.t35 w_n14840_n200# 4.9879f
C768 vg.n68 w_n14840_n200# 0.50013f
C769 vg.n69 w_n14840_n200# 0.50013f
C770 vg.t38 w_n14840_n200# 4.9879f
C771 vg.t39 w_n14840_n200# 4.9879f
C772 vg.n70 w_n14840_n200# 0.50013f
C773 vg.t62 w_n14840_n200# 4.9879f
C774 vg.t63 w_n14840_n200# 4.9879f
C775 vg.t58 w_n14840_n200# 4.9879f
C776 vg.t59 w_n14840_n200# 4.9879f
C777 vg.n71 w_n14840_n200# 0.50013f
C778 vg.t53 w_n14840_n200# 4.9879f
C779 vg.t54 w_n14840_n200# 4.9879f
C780 vg.t49 w_n14840_n200# 4.9879f
C781 vg.t50 w_n14840_n200# 4.9879f
C782 vg.t44 w_n14840_n200# 4.9879f
C783 vg.t45 w_n14840_n200# 4.9879f
C784 vg.t46 w_n14840_n200# 4.9879f
C785 vg.t47 w_n14840_n200# 4.9879f
C786 vg.t48 w_n14840_n200# 4.9879f
C787 vg.n72 w_n14840_n200# 0.60386f
C788 vg.n73 w_n14840_n200# 0.50013f
C789 vg.t51 w_n14840_n200# 4.9879f
C790 vg.t52 w_n14840_n200# 4.9879f
C791 vg.t55 w_n14840_n200# 4.9879f
C792 vg.t56 w_n14840_n200# 4.9879f
C793 vg.t57 w_n14840_n200# 4.9879f
C794 vg.n74 w_n14840_n200# 0.50013f
C795 vg.n75 w_n14840_n200# 0.50013f
C796 vg.t60 w_n14840_n200# 4.9879f
C797 vg.t61 w_n14840_n200# 4.9879f
C798 vg.t64 w_n14840_n200# 4.9879f
C799 vg.t65 w_n14840_n200# 5.00097f
C800 vg.n76 w_n14840_n200# 0.47699f
C801 vg.n77 w_n14840_n200# 0.50013f
C802 vg.t18 w_n14840_n200# 4.9879f
C803 vg.t19 w_n14840_n200# 4.9879f
C804 vg.t14 w_n14840_n200# 4.9879f
C805 vg.t15 w_n14840_n200# 4.9879f
C806 vg.n78 w_n14840_n200# 0.50013f
C807 vg.t9 w_n14840_n200# 4.9879f
C808 vg.t10 w_n14840_n200# 4.9879f
C809 vg.t5 w_n14840_n200# 4.9879f
C810 vg.t6 w_n14840_n200# 4.9879f
C811 vg.t0 w_n14840_n200# 4.9879f
C812 vg.t1 w_n14840_n200# 4.9879f
C813 vg.t2 w_n14840_n200# 4.9879f
C814 vg.t3 w_n14840_n200# 4.9879f
C815 vg.t4 w_n14840_n200# 4.9879f
C816 vg.n79 w_n14840_n200# 0.60386f
C817 vg.n80 w_n14840_n200# 0.50013f
C818 vg.t7 w_n14840_n200# 4.9879f
C819 vg.t8 w_n14840_n200# 4.9879f
C820 vg.t11 w_n14840_n200# 4.9879f
C821 vg.t12 w_n14840_n200# 4.9879f
C822 vg.t13 w_n14840_n200# 4.9879f
C823 vg.n81 w_n14840_n200# 0.50013f
C824 vg.n82 w_n14840_n200# 0.50013f
C825 vg.t16 w_n14840_n200# 4.9879f
C826 vg.t17 w_n14840_n200# 4.9879f
C827 vg.t20 w_n14840_n200# 4.9879f
C828 vg.t21 w_n14840_n200# 5.00097f
C829 vg.n83 w_n14840_n200# 0.47699f
C830 vg.n84 w_n14840_n200# 1.16682f
C831 vgi.t27 w_n14840_n200# 3.73223f
C832 vgi.t26 w_n14840_n200# 3.75118f
C833 vgi.t25 w_n14840_n200# 3.75118f
C834 vgi.t24 w_n14840_n200# 3.75059f
C835 vgi.n0 w_n14840_n200# 0.63381f
C836 vgi.n1 w_n14840_n200# 0.97027f
C837 vgi.n2 w_n14840_n200# 0.96968f
C838 vgi.n3 w_n14840_n200# 0.96967f
C839 vgi.n4 w_n14840_n200# 0.96909f
C840 vgi.n5 w_n14840_n200# 0.97027f
C841 vgi.n6 w_n14840_n200# 0.96968f
C842 vgi.n7 w_n14840_n200# 0.96967f
C843 vgi.n8 w_n14840_n200# 0.97027f
C844 vgi.n9 w_n14840_n200# 0.96909f
C845 vgi.n10 w_n14840_n200# 0.96968f
C846 vgi.n11 w_n14840_n200# 0.96967f
C847 vgi.n12 w_n14840_n200# 0.96909f
C848 vgi.n13 w_n14840_n200# 0.63381f
C849 vgi.n14 w_n14840_n200# 0.97027f
C850 vgi.n15 w_n14840_n200# 0.96968f
C851 vgi.n16 w_n14840_n200# 0.96967f
C852 vgi.n17 w_n14840_n200# 0.96909f
C853 vgi.n18 w_n14840_n200# 0.97027f
C854 vgi.n19 w_n14840_n200# 0.96968f
C855 vgi.n20 w_n14840_n200# 0.96967f
C856 vgi.n21 w_n14840_n200# 0.97027f
C857 vgi.n22 w_n14840_n200# 0.96909f
C858 vgi.n23 w_n14840_n200# 0.96967f
C859 vgi.n24 w_n14840_n200# 0.96909f
C860 vgi.n25 w_n14840_n200# 1.07207f
C861 vgi.t20 w_n14840_n200# 2.7815f
C862 vgi.t21 w_n14840_n200# 2.7815f
C863 vgi.t19 w_n14840_n200# 2.7815f
C864 vgi.t12 w_n14840_n200# 2.7815f
C865 vgi.t13 w_n14840_n200# 2.7815f
C866 vgi.t8 w_n14840_n200# 2.7815f
C867 vgi.t9 w_n14840_n200# 2.7815f
C868 vgi.t7 w_n14840_n200# 2.7815f
C869 vgi.t0 w_n14840_n200# 2.7815f
C870 vgi.t1 w_n14840_n200# 2.7815f
C871 vgi.t2 w_n14840_n200# 2.7815f
C872 vgi.t3 w_n14840_n200# 2.7815f
C873 vgi.t4 w_n14840_n200# 2.7815f
C874 vgi.t5 w_n14840_n200# 2.7815f
C875 vgi.t6 w_n14840_n200# 2.7815f
C876 vgi.n26 w_n14840_n200# 0.67717f
C877 vgi.n27 w_n14840_n200# 0.63381f
C878 vgi.t10 w_n14840_n200# 2.7815f
C879 vgi.t11 w_n14840_n200# 2.7815f
C880 vgi.t14 w_n14840_n200# 2.7815f
C881 vgi.t15 w_n14840_n200# 2.7815f
C882 vgi.t16 w_n14840_n200# 2.7815f
C883 vgi.t17 w_n14840_n200# 2.7815f
C884 vgi.t18 w_n14840_n200# 2.7815f
C885 vgi.n28 w_n14840_n200# 0.63381f
C886 vgi.n29 w_n14840_n200# 0.63381f
C887 vgi.t22 w_n14840_n200# 2.7815f
C888 vgi.t23 w_n14840_n200# 2.7815f
C889 vgi.n30 w_n14840_n200# 0.61414f
.ends
