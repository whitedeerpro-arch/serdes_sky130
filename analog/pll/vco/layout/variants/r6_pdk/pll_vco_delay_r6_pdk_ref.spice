.subckt pll_vco_delay_r6_pdk inp inn outp outn vbias vdd vss
Xp outp inp tail vss sky130_fd_pr__nfet_01v8_lvt w=40 l=.15
Xn outn inn tail vss sky130_fd_pr__nfet_01v8_lvt w=40 l=.15
Xt tail vbias vss vss sky130_fd_pr__nfet_01v8 w=25.2 l=.5
Xr0 vdd outp vss sky130_fd_pr__res_high_po_2p85 l=4.77
Xr1 vdd outn vss sky130_fd_pr__res_high_po_2p85 l=4.77
Xr2 vdd outn vss sky130_fd_pr__res_high_po_2p85 l=4.77
Xr3 vdd outp vss sky130_fd_pr__res_high_po_2p85 l=4.77
.ends pll_vco_delay_r6_pdk
