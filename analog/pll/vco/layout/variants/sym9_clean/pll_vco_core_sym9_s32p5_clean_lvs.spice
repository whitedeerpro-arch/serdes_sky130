* NGSPICE file created from pll_vco_core_sym9_s32p5_clean.ext - technology: sky130A

.subckt pll_vco_core_sym9_s32p5_clean ctrl cfg0 cfg1 cfg2 cfg3 cfg4 vbias_q b0p b0n
+ b1p b1n b2p b2n b3p b3n vdd_q vss
X0 a_1660_3469# a_827_3117# sky130_fd_pr__cap_mim_m3_1 l=2 w=2
X1 a_n6121_n4370# a_n5096_n3348# a_n6092_3282# vss sky130_fd_pr__nfet_01v8_lvt ad=0.825 pd=5.33 as=0.825 ps=5.33 w=5 l=0.15
X2 vss cfg2 a_827_5277# vss sky130_fd_pr__nfet_01v8 ad=0.31 pd=2.62 as=0.165 ps=1.33 w=1 l=0.15
X3 a_n5096_n3348# a_9193_n1683# sky130_fd_pr__cap_mim_m3_1 l=2.6 w=6.58
X4 a_n8760_n4271# ctrl vss sky130_fd_pr__cap_var_lvt w=5.2 l=0.5
X5 a_n6951_1610# a_n5033_3370# b0p vss sky130_fd_pr__nfet_01v8_lvt ad=0.495 pd=3.33 as=0.495 ps=3.33 w=3 l=0.15
X6 vss cfg3 a_827_n1683# vss sky130_fd_pr__nfet_01v8 ad=0.62 pd=4.62 as=0.33 ps=2.33 w=2 l=0.15
X7 a_n6092_n3348# ctrl vss sky130_fd_pr__cap_var_lvt w=5.2 l=0.5
X8 a_1660_3469# ctrl vss sky130_fd_pr__cap_var_lvt w=5.2 l=0.5
X9 vdd_q b0n vss sky130_fd_pr__res_high_po_2p85 l=4.22
X10 a_n8760_n4271# ctrl vss sky130_fd_pr__cap_var_lvt w=5.2 l=0.5
X11 a_n5096_n3348# a_9393_n2463# sky130_fd_pr__cap_mim_m3_1 l=2 w=4.15
X12 a_n977_n3903# cfg0 vss vss sky130_fd_pr__nfet_01v8 ad=0.12375 pd=1.08 as=0.2325 ps=2.12 w=0.75 l=0.15
X13 a_4299_3370# vbias_q vss vss sky130_fd_pr__nfet_01v8 ad=0.9135 pd=6.59 as=0.9135 ps=6.59 w=6.3 l=0.5
X14 a_n5033_3370# a_n1027_2397# sky130_fd_pr__cap_mim_m3_1 l=2 w=4.15
X15 a_1660_3469# a_827_2397# sky130_fd_pr__cap_mim_m3_1 l=2 w=4.15
X16 vss vbias_q a_n6121_3370# vss sky130_fd_pr__nfet_01v8 ad=0.9135 pd=6.59 as=0.9135 ps=6.59 w=6.3 l=0.5
X17 a_8793_577# cfg4 vss vss sky130_fd_pr__nfet_01v8 ad=0.66 pd=4.33 as=1.24 ps=8.62 w=4 l=0.15
X18 vss cfg4 a_n1627_n643# vss sky130_fd_pr__nfet_01v8 ad=1.24 pd=8.62 as=0.66 ps=4.33 w=4 l=0.15
X19 vss vbias_q a_3469_1610# vss sky130_fd_pr__nfet_01v8 ad=0.87 pd=6.58 as=0.435 ps=3.29 w=3 l=0.5
X20 a_n5033_3370# a_n8760_n4271# a_n6121_3370# vss sky130_fd_pr__nfet_01v8_lvt ad=0.825 pd=5.33 as=0.825 ps=5.33 w=5 l=0.15
X21 a_827_n3903# cfg0 vss vss sky130_fd_pr__nfet_01v8 ad=0.12375 pd=1.08 as=0.2325 ps=2.12 w=0.75 l=0.15
X22 a_n6951_1610# vbias_q vss vss sky130_fd_pr__nfet_01v8 ad=0.435 pd=3.29 as=0.87 ps=6.58 w=3 l=0.5
X23 a_n8760_3469# a_n9593_3117# sky130_fd_pr__cap_mim_m3_1 l=2 w=2
X24 a_n5096_n3348# a_9443_n4623# sky130_fd_pr__cap_mim_m3_1 l=2 w=2
X25 vdd_q b1n vss sky130_fd_pr__res_high_po_2p85 l=4.22
X26 a_n6121_3370# a_n6092_3282# a_n8760_3469# vss sky130_fd_pr__nfet_01v8_lvt ad=0.825 pd=5.33 as=0.825 ps=5.33 w=5 l=0.15
X27 b0n a_n8760_3469# a_n6951_1610# vss sky130_fd_pr__nfet_01v8_lvt ad=0.495 pd=3.33 as=0.93 ps=6.62 w=3 l=0.15
X28 vss vbias_q a_4299_3370# vss sky130_fd_pr__nfet_01v8 ad=0.9135 pd=6.59 as=0.9135 ps=6.59 w=6.3 l=0.5
X29 b3p vdd_q vss sky130_fd_pr__res_high_po_2p85 l=4.22
X30 a_n8760_n4271# a_n6092_n3348# a_n6121_n4370# vss sky130_fd_pr__nfet_01v8_lvt ad=0.825 pd=5.33 as=0.825 ps=5.33 w=5 l=0.15
X31 a_n6092_3282# ctrl vss sky130_fd_pr__cap_var_lvt w=5.2 l=0.5
X32 a_n6121_3370# vbias_q vss vss sky130_fd_pr__nfet_01v8 ad=0.9135 pd=6.59 as=0.9135 ps=6.59 w=6.3 l=0.5
X33 a_n6121_n4370# a_n5096_n3348# a_n6092_3282# vss sky130_fd_pr__nfet_01v8_lvt ad=1.55 pd=10.62 as=0.825 ps=5.33 w=5 l=0.15
X34 a_n8760_3469# ctrl vss sky130_fd_pr__cap_var_lvt w=5.2 l=0.5
X35 a_8793_n7303# cfg4 vss vss sky130_fd_pr__nfet_01v8 ad=0.66 pd=4.33 as=1.24 ps=8.62 w=4 l=0.15
X36 vdd_q b1p vss sky130_fd_pr__res_high_po_2p85 l=4.22
X37 a_n8760_3469# a_n9593_5277# sky130_fd_pr__cap_mim_m3_1 l=2 w=4.15
X38 a_n8760_3469# ctrl vss sky130_fd_pr__cap_var_lvt w=5.2 l=0.5
X39 a_n1627_7237# cfg4 vss vss sky130_fd_pr__nfet_01v8 ad=0.66 pd=4.33 as=1.24 ps=8.62 w=4 l=0.15
X40 b2p a_n5096_n3348# a_3469_n2210# vss sky130_fd_pr__nfet_01v8_lvt ad=0.495 pd=3.33 as=0.93 ps=6.62 w=3 l=0.15
X41 a_827_n643# cfg4 vss vss sky130_fd_pr__nfet_01v8 ad=0.66 pd=4.33 as=1.24 ps=8.62 w=4 l=0.15
X42 a_9193_1617# cfg3 vss vss sky130_fd_pr__nfet_01v8 ad=0.33 pd=2.33 as=0.62 ps=4.62 w=2 l=0.15
X43 a_n6092_3282# a_n5096_n3348# a_n6121_n4370# vss sky130_fd_pr__nfet_01v8_lvt ad=0.825 pd=5.33 as=0.825 ps=5.33 w=5 l=0.15
X44 vss vbias_q a_3469_1610# vss sky130_fd_pr__nfet_01v8 ad=0.87 pd=6.58 as=0.435 ps=3.29 w=3 l=0.5
X45 a_n9593_4557# cfg1 vss vss sky130_fd_pr__nfet_01v8 ad=0.12375 pd=1.08 as=0.2325 ps=2.12 w=0.75 l=0.15
X46 a_n1227_6057# cfg3 vss vss sky130_fd_pr__nfet_01v8 ad=0.33 pd=2.33 as=0.62 ps=4.62 w=2 l=0.15
X47 a_n6951_1610# vbias_q vss vss sky130_fd_pr__nfet_01v8 ad=0.435 pd=3.29 as=0.87 ps=6.58 w=3 l=0.5
X48 a_n6092_3282# vdd_q vss sky130_fd_pr__res_high_po_2p85 l=4.77
X49 a_827_3837# cfg0 vss vss sky130_fd_pr__nfet_01v8 ad=0.12375 pd=1.08 as=0.2325 ps=2.12 w=0.75 l=0.15
X50 a_9443_n4623# cfg1 vss vss sky130_fd_pr__nfet_01v8 ad=0.12375 pd=1.08 as=0.2325 ps=2.12 w=0.75 l=0.15
X51 a_n6092_n3348# a_827_n3903# sky130_fd_pr__cap_mim_m3_1 l=2 w=2
X52 vss cfg2 a_9393_n2463# vss sky130_fd_pr__nfet_01v8 ad=0.31 pd=2.62 as=0.165 ps=1.33 w=1 l=0.15
X53 a_n9593_577# cfg4 vss vss sky130_fd_pr__nfet_01v8 ad=0.66 pd=4.33 as=1.24 ps=8.62 w=4 l=0.15
X54 a_n6121_3370# a_n8760_n4271# a_n5033_3370# vss sky130_fd_pr__nfet_01v8_lvt ad=0.825 pd=5.33 as=0.825 ps=5.33 w=5 l=0.15
X55 a_n5033_3370# a_n1627_7237# sky130_fd_pr__cap_mim_m3_1 l=4.6 w=7.65
X56 a_827_3117# cfg1 vss vss sky130_fd_pr__nfet_01v8 ad=0.12375 pd=1.08 as=0.2325 ps=2.12 w=0.75 l=0.15
X57 a_n5033_3370# a_n1227_6057# sky130_fd_pr__cap_mim_m3_1 l=2.6 w=6.58
X58 b2n a_n6092_n3348# a_3469_n2210# vss sky130_fd_pr__nfet_01v8_lvt ad=0.495 pd=3.33 as=0.93 ps=6.62 w=3 l=0.15
X59 vss cfg2 a_9393_2397# vss sky130_fd_pr__nfet_01v8 ad=0.31 pd=2.62 as=0.165 ps=1.33 w=1 l=0.15
X60 a_n5096_n3348# vdd_q vss sky130_fd_pr__res_high_po_2p85 l=4.77
X61 a_n8760_n4271# ctrl vss sky130_fd_pr__cap_var_lvt w=5.2 l=0.5
X62 vss cfg1 a_n977_4557# vss sky130_fd_pr__nfet_01v8 ad=0.2325 pd=2.12 as=0.12375 ps=1.08 w=0.75 l=0.15
X63 a_4299_n4370# a_5324_n3348# a_n5096_n3348# vss sky130_fd_pr__nfet_01v8_lvt ad=1.55 pd=10.62 as=0.825 ps=5.33 w=5 l=0.15
X64 vss cfg4 a_827_7237# vss sky130_fd_pr__nfet_01v8 ad=1.24 pd=8.62 as=0.66 ps=4.33 w=4 l=0.15
X65 a_n6092_3282# vdd_q vss sky130_fd_pr__res_high_po_2p85 l=4.77
X66 a_n6951_n2210# a_n8760_n4271# b3n vss sky130_fd_pr__nfet_01v8_lvt ad=0.93 pd=6.62 as=0.495 ps=3.33 w=3 l=0.15
X67 a_n5033_3370# ctrl vss sky130_fd_pr__cap_var_lvt w=5.2 l=0.5
X68 a_4299_n4370# a_1660_3469# a_n6092_n3348# vss sky130_fd_pr__nfet_01v8_lvt ad=0.825 pd=5.33 as=0.825 ps=5.33 w=5 l=0.15
X69 vss cfg0 a_n9593_3837# vss sky130_fd_pr__nfet_01v8 ad=0.2325 pd=2.12 as=0.12375 ps=1.08 w=0.75 l=0.15
X70 a_n6092_3282# a_n977_n3183# sky130_fd_pr__cap_mim_m3_1 l=2 w=2
X71 a_n6121_n4370# a_n6092_n3348# a_n8760_n4271# vss sky130_fd_pr__nfet_01v8_lvt ad=0.825 pd=5.33 as=0.825 ps=5.33 w=5 l=0.15
X72 a_1660_3469# a_n8760_3469# a_4299_3370# vss sky130_fd_pr__nfet_01v8_lvt ad=0.825 pd=5.33 as=0.825 ps=5.33 w=5 l=0.15
X73 a_8793_n643# cfg4 vss vss sky130_fd_pr__nfet_01v8 ad=0.66 pd=4.33 as=1.24 ps=8.62 w=4 l=0.15
X74 vss cfg1 a_n9593_3117# vss sky130_fd_pr__nfet_01v8 ad=0.2325 pd=2.12 as=0.12375 ps=1.08 w=0.75 l=0.15
X75 a_n5096_n3348# ctrl vss sky130_fd_pr__cap_var_lvt w=5.2 l=0.5
X76 b3n a_n8760_n4271# a_n6951_n2210# vss sky130_fd_pr__nfet_01v8_lvt ad=0.495 pd=3.33 as=0.495 ps=3.33 w=3 l=0.15
X77 a_3469_1610# a_1660_3469# b1n vss sky130_fd_pr__nfet_01v8_lvt ad=0.93 pd=6.62 as=0.495 ps=3.33 w=3 l=0.15
X78 vss cfg2 a_827_2397# vss sky130_fd_pr__nfet_01v8 ad=0.31 pd=2.62 as=0.165 ps=1.33 w=1 l=0.15
X79 vss cfg4 a_827_577# vss sky130_fd_pr__nfet_01v8 ad=1.24 pd=8.62 as=0.66 ps=4.33 w=4 l=0.15
X80 a_n6092_3282# a_n1227_n6123# sky130_fd_pr__cap_mim_m3_1 l=2.6 w=6.58
X81 b1p a_5324_n3348# a_3469_1610# vss sky130_fd_pr__nfet_01v8_lvt ad=0.495 pd=3.33 as=0.495 ps=3.33 w=3 l=0.15
X82 a_n6121_3370# a_n6092_3282# a_n8760_3469# vss sky130_fd_pr__nfet_01v8_lvt ad=0.825 pd=5.33 as=0.825 ps=5.33 w=5 l=0.15
X83 vss cfg3 a_827_6057# vss sky130_fd_pr__nfet_01v8 ad=0.62 pd=4.62 as=0.33 ps=2.33 w=2 l=0.15
X84 a_9193_n1683# cfg3 vss vss sky130_fd_pr__nfet_01v8 ad=0.33 pd=2.33 as=0.62 ps=4.62 w=2 l=0.15
X85 a_n6092_n3348# a_827_n643# sky130_fd_pr__cap_mim_m3_1 l=4.6 w=7.65
X86 a_4299_n4370# vbias_q vss vss sky130_fd_pr__nfet_01v8 ad=0.9135 pd=6.59 as=0.9135 ps=6.59 w=6.3 l=0.5
X87 a_5324_n3348# ctrl vss sky130_fd_pr__cap_var_lvt w=5.2 l=0.5
X88 a_n8760_3469# ctrl vss sky130_fd_pr__cap_var_lvt w=5.2 l=0.5
X89 vss cfg2 a_n9593_n5343# vss sky130_fd_pr__nfet_01v8 ad=0.31 pd=2.62 as=0.165 ps=1.33 w=1 l=0.15
X90 a_5324_n3348# a_9193_6057# sky130_fd_pr__cap_mim_m3_1 l=2.6 w=6.58
X91 a_n5096_n3348# a_9393_n5343# sky130_fd_pr__cap_mim_m3_1 l=2 w=4.15
X92 a_n5033_3370# a_n1027_5277# sky130_fd_pr__cap_mim_m3_1 l=2 w=4.15
X93 a_1660_3469# a_827_5277# sky130_fd_pr__cap_mim_m3_1 l=2 w=4.15
X94 b3p a_n6092_3282# a_n6951_n2210# vss sky130_fd_pr__nfet_01v8_lvt ad=0.495 pd=3.33 as=0.495 ps=3.33 w=3 l=0.15
X95 a_n6121_3370# a_n8760_n4271# a_n5033_3370# vss sky130_fd_pr__nfet_01v8_lvt ad=1.55 pd=10.62 as=0.825 ps=5.33 w=5 l=0.15
X96 vss vbias_q a_n6951_n2210# vss sky130_fd_pr__nfet_01v8 ad=0.87 pd=6.58 as=0.435 ps=3.29 w=3 l=0.5
X97 b0p a_n5033_3370# a_n6951_1610# vss sky130_fd_pr__nfet_01v8_lvt ad=0.495 pd=3.33 as=0.495 ps=3.33 w=3 l=0.15
X98 vss cfg4 a_8793_7237# vss sky130_fd_pr__nfet_01v8 ad=1.24 pd=8.62 as=0.66 ps=4.33 w=4 l=0.15
X99 a_n5096_n3348# a_5324_n3348# a_4299_n4370# vss sky130_fd_pr__nfet_01v8_lvt ad=0.825 pd=5.33 as=0.825 ps=5.33 w=5 l=0.15
X100 vss cfg3 a_n1227_1617# vss sky130_fd_pr__nfet_01v8 ad=0.62 pd=4.62 as=0.33 ps=2.33 w=2 l=0.15
X101 a_n5033_3370# a_n977_4557# sky130_fd_pr__cap_mim_m3_1 l=2 w=2
X102 vss vbias_q a_3469_n2210# vss sky130_fd_pr__nfet_01v8 ad=0.87 pd=6.58 as=0.435 ps=3.29 w=3 l=0.5
X103 a_n5033_3370# a_n8760_n4271# a_n6121_3370# vss sky130_fd_pr__nfet_01v8_lvt ad=0.825 pd=5.33 as=1.55 ps=10.62 w=5 l=0.15
X104 a_n1227_n1683# cfg3 vss vss sky130_fd_pr__nfet_01v8 ad=0.33 pd=2.33 as=0.62 ps=4.62 w=2 l=0.15
X105 a_n5096_n3348# a_9443_n3183# sky130_fd_pr__cap_mim_m3_1 l=2 w=2
X106 b3n vdd_q vss sky130_fd_pr__res_high_po_2p85 l=4.22
X107 a_4299_3370# vbias_q vss vss sky130_fd_pr__nfet_01v8 ad=0.9135 pd=6.59 as=1.827 ps=13.18 w=6.3 l=0.5
X108 a_n6092_n3348# a_827_n4623# sky130_fd_pr__cap_mim_m3_1 l=2 w=2
X109 a_4299_3370# a_n8760_3469# a_1660_3469# vss sky130_fd_pr__nfet_01v8_lvt ad=0.825 pd=5.33 as=0.825 ps=5.33 w=5 l=0.15
X110 vss vbias_q a_4299_n4370# vss sky130_fd_pr__nfet_01v8 ad=1.827 pd=13.18 as=0.9135 ps=6.59 w=6.3 l=0.5
X111 a_n6092_n3348# a_827_n7303# sky130_fd_pr__cap_mim_m3_1 l=4.6 w=7.65
X112 vss cfg2 a_827_n5343# vss sky130_fd_pr__nfet_01v8 ad=0.31 pd=2.62 as=0.165 ps=1.33 w=1 l=0.15
X113 a_1660_3469# a_827_6057# sky130_fd_pr__cap_mim_m3_1 l=2.6 w=6.58
X114 a_9393_n5343# cfg2 vss vss sky130_fd_pr__nfet_01v8 ad=0.165 pd=1.33 as=0.31 ps=2.62 w=1 l=0.15
X115 a_n9593_n4623# cfg1 vss vss sky130_fd_pr__nfet_01v8 ad=0.12375 pd=1.08 as=0.2325 ps=2.12 w=0.75 l=0.15
X116 a_n6092_n3348# a_1660_3469# a_4299_n4370# vss sky130_fd_pr__nfet_01v8_lvt ad=0.825 pd=5.33 as=0.825 ps=5.33 w=5 l=0.15
X117 a_n1627_577# cfg4 vss vss sky130_fd_pr__nfet_01v8 ad=0.66 pd=4.33 as=1.24 ps=8.62 w=4 l=0.15
X118 a_n8760_3469# a_n6092_3282# a_n6121_3370# vss sky130_fd_pr__nfet_01v8_lvt ad=0.825 pd=5.33 as=0.825 ps=5.33 w=5 l=0.15
X119 vss cfg1 a_9443_n3183# vss sky130_fd_pr__nfet_01v8 ad=0.2325 pd=2.12 as=0.12375 ps=1.08 w=0.75 l=0.15
X120 a_n6951_n2210# a_n8760_n4271# b3n vss sky130_fd_pr__nfet_01v8_lvt ad=0.495 pd=3.33 as=0.495 ps=3.33 w=3 l=0.15
X121 a_n8760_3469# a_n9593_7237# sky130_fd_pr__cap_mim_m3_1 l=4.6 w=7.65
X122 a_n1627_n7303# cfg4 vss vss sky130_fd_pr__nfet_01v8 ad=0.66 pd=4.33 as=1.24 ps=8.62 w=4 l=0.15
X123 a_5324_n3348# a_9443_4557# sky130_fd_pr__cap_mim_m3_1 l=2 w=2
X124 a_n9593_n1683# cfg3 vss vss sky130_fd_pr__nfet_01v8 ad=0.33 pd=2.33 as=0.62 ps=4.62 w=2 l=0.15
X125 a_n5096_n3348# ctrl vss sky130_fd_pr__cap_var_lvt w=5.2 l=0.5
X126 a_n977_n4623# cfg1 vss vss sky130_fd_pr__nfet_01v8 ad=0.12375 pd=1.08 as=0.2325 ps=2.12 w=0.75 l=0.15
X127 a_9193_6057# cfg3 vss vss sky130_fd_pr__nfet_01v8 ad=0.33 pd=2.33 as=0.62 ps=4.62 w=2 l=0.15
X128 a_n5096_n3348# ctrl vss sky130_fd_pr__cap_var_lvt w=5.2 l=0.5
X129 a_n8760_3469# a_n9593_6057# sky130_fd_pr__cap_mim_m3_1 l=2.6 w=6.58
X130 vss cfg3 a_9193_n6123# vss sky130_fd_pr__nfet_01v8 ad=0.62 pd=4.62 as=0.33 ps=2.33 w=2 l=0.15
X131 a_827_n4623# cfg1 vss vss sky130_fd_pr__nfet_01v8 ad=0.12375 pd=1.08 as=0.2325 ps=2.12 w=0.75 l=0.15
X132 a_n6092_3282# a_n1227_n1683# sky130_fd_pr__cap_mim_m3_1 l=2.6 w=6.58
X133 a_4299_3370# a_n5033_3370# a_5324_n3348# vss sky130_fd_pr__nfet_01v8_lvt ad=0.825 pd=5.33 as=0.825 ps=5.33 w=5 l=0.15
X134 a_n6951_n2210# a_n6092_3282# b3p vss sky130_fd_pr__nfet_01v8_lvt ad=0.495 pd=3.33 as=0.495 ps=3.33 w=3 l=0.15
X135 a_9443_3837# cfg0 vss vss sky130_fd_pr__nfet_01v8 ad=0.12375 pd=1.08 as=0.2325 ps=2.12 w=0.75 l=0.15
X136 vdd_q b0p vss sky130_fd_pr__res_high_po_2p85 l=4.22
X137 a_n5033_3370# ctrl vss sky130_fd_pr__cap_var_lvt w=5.2 l=0.5
X138 a_1660_3469# a_827_4557# sky130_fd_pr__cap_mim_m3_1 l=2 w=2
X139 a_4299_n4370# a_5324_n3348# a_n5096_n3348# vss sky130_fd_pr__nfet_01v8_lvt ad=0.825 pd=5.33 as=0.825 ps=5.33 w=5 l=0.15
X140 a_9443_3117# cfg1 vss vss sky130_fd_pr__nfet_01v8 ad=0.12375 pd=1.08 as=0.2325 ps=2.12 w=0.75 l=0.15
X141 a_n5033_3370# ctrl vss sky130_fd_pr__cap_var_lvt w=5.2 l=0.5
X142 a_n6092_n3348# a_1660_3469# a_4299_n4370# vss sky130_fd_pr__nfet_01v8_lvt ad=0.825 pd=5.33 as=1.55 ps=10.62 w=5 l=0.15
X143 a_827_n1683# cfg3 vss vss sky130_fd_pr__nfet_01v8 ad=0.33 pd=2.33 as=0.62 ps=4.62 w=2 l=0.15
X144 vss cfg2 a_n1027_n5343# vss sky130_fd_pr__nfet_01v8 ad=0.31 pd=2.62 as=0.165 ps=1.33 w=1 l=0.15
X145 b1n a_1660_3469# a_3469_1610# vss sky130_fd_pr__nfet_01v8_lvt ad=0.495 pd=3.33 as=0.93 ps=6.62 w=3 l=0.15
X146 vss cfg3 a_n1227_n6123# vss sky130_fd_pr__nfet_01v8 ad=0.62 pd=4.62 as=0.33 ps=2.33 w=2 l=0.15
X147 vss cfg4 a_n9593_n7303# vss sky130_fd_pr__nfet_01v8 ad=1.24 pd=8.62 as=0.66 ps=4.33 w=4 l=0.15
X148 vss cfg4 a_8793_577# vss sky130_fd_pr__nfet_01v8 ad=1.24 pd=8.62 as=0.66 ps=4.33 w=4 l=0.15
X149 a_n8760_n4271# a_n9593_n643# sky130_fd_pr__cap_mim_m3_1 l=4.6 w=7.65
X150 a_n1627_n643# cfg4 vss vss sky130_fd_pr__nfet_01v8 ad=0.66 pd=4.33 as=1.24 ps=8.62 w=4 l=0.15
X151 a_n9593_1617# cfg3 vss vss sky130_fd_pr__nfet_01v8 ad=0.33 pd=2.33 as=0.62 ps=4.62 w=2 l=0.15
X152 a_4299_n4370# a_1660_3469# a_n6092_n3348# vss sky130_fd_pr__nfet_01v8_lvt ad=0.825 pd=5.33 as=0.825 ps=5.33 w=5 l=0.15
X153 a_5324_n3348# ctrl vss sky130_fd_pr__cap_var_lvt w=5.2 l=0.5
X154 a_n9593_5277# cfg2 vss vss sky130_fd_pr__nfet_01v8 ad=0.165 pd=1.33 as=0.31 ps=2.62 w=1 l=0.15
X155 a_5324_n3348# ctrl vss sky130_fd_pr__cap_var_lvt w=5.2 l=0.5
X156 a_n8760_3469# a_n9593_4557# sky130_fd_pr__cap_mim_m3_1 l=2 w=2
X157 a_827_4557# cfg1 vss vss sky130_fd_pr__nfet_01v8 ad=0.12375 pd=1.08 as=0.2325 ps=2.12 w=0.75 l=0.15
X158 a_4299_3370# a_n8760_3469# a_1660_3469# vss sky130_fd_pr__nfet_01v8_lvt ad=0.825 pd=5.33 as=0.825 ps=5.33 w=5 l=0.15
X159 vss cfg2 a_n9593_n2463# vss sky130_fd_pr__nfet_01v8 ad=0.31 pd=2.62 as=0.165 ps=1.33 w=1 l=0.15
X160 a_n1027_5277# cfg2 vss vss sky130_fd_pr__nfet_01v8 ad=0.165 pd=1.33 as=0.31 ps=2.62 w=1 l=0.15
X161 vss cfg3 a_n9593_n6123# vss sky130_fd_pr__nfet_01v8 ad=0.62 pd=4.62 as=0.33 ps=2.33 w=2 l=0.15
X162 a_5324_n3348# a_n5033_3370# a_4299_3370# vss sky130_fd_pr__nfet_01v8_lvt ad=0.825 pd=5.33 as=0.825 ps=5.33 w=5 l=0.15
X163 vdd_q a_1660_3469# vss sky130_fd_pr__res_high_po_2p85 l=4.77
X164 a_3469_1610# a_5324_n3348# b1p vss sky130_fd_pr__nfet_01v8_lvt ad=0.495 pd=3.33 as=0.495 ps=3.33 w=3 l=0.15
X165 vss cfg4 a_827_n7303# vss sky130_fd_pr__nfet_01v8 ad=1.24 pd=8.62 as=0.66 ps=4.33 w=4 l=0.15
X166 a_n8760_n4271# a_n9593_n7303# sky130_fd_pr__cap_mim_m3_1 l=4.6 w=7.65
X167 a_n6092_3282# a_n5096_n3348# a_n6121_n4370# vss sky130_fd_pr__nfet_01v8_lvt ad=0.825 pd=5.33 as=0.825 ps=5.33 w=5 l=0.15
X168 vss cfg4 a_n1627_7237# vss sky130_fd_pr__nfet_01v8 ad=1.24 pd=8.62 as=0.66 ps=4.33 w=4 l=0.15
X169 a_n5096_n3348# ctrl vss sky130_fd_pr__cap_var_lvt w=5.2 l=0.5
X170 vss cfg1 a_n9593_n3183# vss sky130_fd_pr__nfet_01v8 ad=0.2325 pd=2.12 as=0.12375 ps=1.08 w=0.75 l=0.15
X171 vss cfg3 a_9193_1617# vss sky130_fd_pr__nfet_01v8 ad=0.62 pd=4.62 as=0.33 ps=2.33 w=2 l=0.15
X172 vdd_q a_n5033_3370# vss sky130_fd_pr__res_high_po_2p85 l=4.77
X173 vss cfg3 a_n1227_6057# vss sky130_fd_pr__nfet_01v8 ad=0.62 pd=4.62 as=0.33 ps=2.33 w=2 l=0.15
X174 a_n8760_n4271# a_n9593_n3903# sky130_fd_pr__cap_mim_m3_1 l=2 w=2
X175 vss cfg1 a_n9593_4557# vss sky130_fd_pr__nfet_01v8 ad=0.2325 pd=2.12 as=0.12375 ps=1.08 w=0.75 l=0.15
X176 a_n5096_n3348# a_5324_n3348# a_4299_n4370# vss sky130_fd_pr__nfet_01v8_lvt ad=0.825 pd=5.33 as=0.825 ps=5.33 w=5 l=0.15
X177 vss cfg0 a_827_3837# vss sky130_fd_pr__nfet_01v8 ad=0.2325 pd=2.12 as=0.12375 ps=1.08 w=0.75 l=0.15
X178 vss cfg2 a_827_n2463# vss sky130_fd_pr__nfet_01v8 ad=0.31 pd=2.62 as=0.165 ps=1.33 w=1 l=0.15
X179 a_n6092_n3348# a_827_n3183# sky130_fd_pr__cap_mim_m3_1 l=2 w=2
X180 a_3469_n2210# a_n5096_n3348# b2p vss sky130_fd_pr__nfet_01v8_lvt ad=0.495 pd=3.33 as=0.495 ps=3.33 w=3 l=0.15
X181 a_n6092_3282# a_n5096_n3348# a_n6121_n4370# vss sky130_fd_pr__nfet_01v8_lvt ad=0.825 pd=5.33 as=1.55 ps=10.62 w=5 l=0.15
X182 a_9393_n2463# cfg2 vss vss sky130_fd_pr__nfet_01v8 ad=0.165 pd=1.33 as=0.31 ps=2.62 w=1 l=0.15
X183 vss cfg4 a_n9593_577# vss sky130_fd_pr__nfet_01v8 ad=1.24 pd=8.62 as=0.66 ps=4.33 w=4 l=0.15
X184 vss cfg3 a_827_n6123# vss sky130_fd_pr__nfet_01v8 ad=0.62 pd=4.62 as=0.33 ps=2.33 w=2 l=0.15
X185 a_n6121_n4370# a_n5096_n3348# a_n6092_3282# vss sky130_fd_pr__nfet_01v8_lvt ad=0.825 pd=5.33 as=0.825 ps=5.33 w=5 l=0.15
X186 vss cfg1 a_827_3117# vss sky130_fd_pr__nfet_01v8 ad=0.2325 pd=2.12 as=0.12375 ps=1.08 w=0.75 l=0.15
X187 a_n5033_3370# ctrl vss sky130_fd_pr__cap_var_lvt w=5.2 l=0.5
X188 vss cfg1 a_n977_n3183# vss sky130_fd_pr__nfet_01v8 ad=0.2325 pd=2.12 as=0.12375 ps=1.08 w=0.75 l=0.15
X189 a_n6092_n3348# a_827_n2463# sky130_fd_pr__cap_mim_m3_1 l=2 w=4.15
X190 a_1660_3469# a_n8760_3469# a_4299_3370# vss sky130_fd_pr__nfet_01v8_lvt ad=0.825 pd=5.33 as=0.825 ps=5.33 w=5 l=0.15
X191 a_3469_1610# vbias_q vss vss sky130_fd_pr__nfet_01v8 ad=0.435 pd=3.29 as=0.87 ps=6.58 w=3 l=0.5
X192 vss cfg1 a_827_n3183# vss sky130_fd_pr__nfet_01v8 ad=0.2325 pd=2.12 as=0.12375 ps=1.08 w=0.75 l=0.15
X193 vss cfg4 a_n9593_n643# vss sky130_fd_pr__nfet_01v8 ad=1.24 pd=8.62 as=0.66 ps=4.33 w=4 l=0.15
X194 a_3469_n2210# a_n6092_n3348# b2n vss sky130_fd_pr__nfet_01v8_lvt ad=0.495 pd=3.33 as=0.495 ps=3.33 w=3 l=0.15
X195 a_n6121_n4370# a_n6092_n3348# a_n8760_n4271# vss sky130_fd_pr__nfet_01v8_lvt ad=1.55 pd=10.62 as=0.825 ps=5.33 w=5 l=0.15
X196 vss vbias_q a_4299_3370# vss sky130_fd_pr__nfet_01v8 ad=1.827 pd=13.18 as=0.9135 ps=6.59 w=6.3 l=0.5
X197 a_n8760_n4271# a_n9593_n2463# sky130_fd_pr__cap_mim_m3_1 l=2 w=4.15
X198 vss cfg0 a_9443_n3903# vss sky130_fd_pr__nfet_01v8 ad=0.2325 pd=2.12 as=0.12375 ps=1.08 w=0.75 l=0.15
X199 a_n6121_3370# vbias_q vss vss sky130_fd_pr__nfet_01v8 ad=0.9135 pd=6.59 as=1.827 ps=13.18 w=6.3 l=0.5
X200 a_5324_n3348# ctrl vss sky130_fd_pr__cap_var_lvt w=5.2 l=0.5
X201 vdd_q a_1660_3469# vss sky130_fd_pr__res_high_po_2p85 l=4.77
X202 a_n6121_3370# a_n8760_n4271# a_n5033_3370# vss sky130_fd_pr__nfet_01v8_lvt ad=0.825 pd=5.33 as=0.825 ps=5.33 w=5 l=0.15
X203 a_n8760_n4271# a_n6092_n3348# a_n6121_n4370# vss sky130_fd_pr__nfet_01v8_lvt ad=0.825 pd=5.33 as=0.825 ps=5.33 w=5 l=0.15
X204 b0p a_n5033_3370# a_n6951_1610# vss sky130_fd_pr__nfet_01v8_lvt ad=0.495 pd=3.33 as=0.93 ps=6.62 w=3 l=0.15
X205 a_n5096_n3348# vdd_q vss sky130_fd_pr__res_high_po_2p85 l=4.77
X206 vss cfg2 a_n1027_n2463# vss sky130_fd_pr__nfet_01v8 ad=0.31 pd=2.62 as=0.165 ps=1.33 w=1 l=0.15
X207 a_n6121_n4370# a_n5096_n3348# a_n6092_3282# vss sky130_fd_pr__nfet_01v8_lvt ad=0.825 pd=5.33 as=0.825 ps=5.33 w=5 l=0.15
X208 a_n977_3837# cfg0 vss vss sky130_fd_pr__nfet_01v8 ad=0.12375 pd=1.08 as=0.2325 ps=2.12 w=0.75 l=0.15
X209 vdd_q a_n5033_3370# vss sky130_fd_pr__res_high_po_2p85 l=4.77
X210 a_5324_n3348# a_8793_577# sky130_fd_pr__cap_mim_m3_1 l=4.6 w=7.65
X211 a_n6951_1610# a_n8760_3469# b0n vss sky130_fd_pr__nfet_01v8_lvt ad=0.495 pd=3.33 as=0.495 ps=3.33 w=3 l=0.15
X212 a_n9593_7237# cfg4 vss vss sky130_fd_pr__nfet_01v8 ad=0.66 pd=4.33 as=1.24 ps=8.62 w=4 l=0.15
X213 a_n9593_n5343# cfg2 vss vss sky130_fd_pr__nfet_01v8 ad=0.165 pd=1.33 as=0.31 ps=2.62 w=1 l=0.15
X214 a_5324_n3348# a_n5033_3370# a_4299_3370# vss sky130_fd_pr__nfet_01v8_lvt ad=0.825 pd=5.33 as=1.55 ps=10.62 w=5 l=0.15
X215 a_n977_3117# cfg1 vss vss sky130_fd_pr__nfet_01v8 ad=0.12375 pd=1.08 as=0.2325 ps=2.12 w=0.75 l=0.15
X216 vdd_q a_n8760_3469# vss sky130_fd_pr__res_high_po_2p85 l=4.77
X217 b2p a_n5096_n3348# a_3469_n2210# vss sky130_fd_pr__nfet_01v8_lvt ad=0.495 pd=3.33 as=0.495 ps=3.33 w=3 l=0.15
X218 a_3469_n2210# vbias_q vss vss sky130_fd_pr__nfet_01v8 ad=0.435 pd=3.29 as=0.87 ps=6.58 w=3 l=0.5
X219 vss vbias_q a_4299_n4370# vss sky130_fd_pr__nfet_01v8 ad=0.9135 pd=6.59 as=0.9135 ps=6.59 w=6.3 l=0.5
X220 a_4299_3370# a_n5033_3370# a_5324_n3348# vss sky130_fd_pr__nfet_01v8_lvt ad=1.55 pd=10.62 as=0.825 ps=5.33 w=5 l=0.15
X221 a_n5033_3370# a_n977_3837# sky130_fd_pr__cap_mim_m3_1 l=2 w=2
X222 a_n9593_2397# cfg2 vss vss sky130_fd_pr__nfet_01v8 ad=0.165 pd=1.33 as=0.31 ps=2.62 w=1 l=0.15
X223 vss vbias_q a_n6121_n4370# vss sky130_fd_pr__nfet_01v8 ad=0.9135 pd=6.59 as=0.9135 ps=6.59 w=6.3 l=0.5
X224 a_n8760_n4271# a_n9593_n4623# sky130_fd_pr__cap_mim_m3_1 l=2 w=2
X225 a_n9593_6057# cfg3 vss vss sky130_fd_pr__nfet_01v8 ad=0.33 pd=2.33 as=0.62 ps=4.62 w=2 l=0.15
X226 a_n1027_2397# cfg2 vss vss sky130_fd_pr__nfet_01v8 ad=0.165 pd=1.33 as=0.31 ps=2.62 w=1 l=0.15
X227 a_n6092_n3348# vdd_q vss sky130_fd_pr__res_high_po_2p85 l=4.77
X228 a_827_n5343# cfg2 vss vss sky130_fd_pr__nfet_01v8 ad=0.165 pd=1.33 as=0.31 ps=2.62 w=1 l=0.15
X229 vss vbias_q a_n6121_3370# vss sky130_fd_pr__nfet_01v8 ad=1.827 pd=13.18 as=0.9135 ps=6.59 w=6.3 l=0.5
X230 b2n a_n6092_n3348# a_3469_n2210# vss sky130_fd_pr__nfet_01v8_lvt ad=0.495 pd=3.33 as=0.495 ps=3.33 w=3 l=0.15
X231 a_9443_4557# cfg1 vss vss sky130_fd_pr__nfet_01v8 ad=0.12375 pd=1.08 as=0.2325 ps=2.12 w=0.75 l=0.15
X232 a_n5033_3370# a_n8760_n4271# a_n6121_3370# vss sky130_fd_pr__nfet_01v8_lvt ad=0.825 pd=5.33 as=0.825 ps=5.33 w=5 l=0.15
X233 a_n8760_n4271# a_n6092_n3348# a_n6121_n4370# vss sky130_fd_pr__nfet_01v8_lvt ad=0.825 pd=5.33 as=0.825 ps=5.33 w=5 l=0.15
X234 vss cfg4 a_n1627_577# vss sky130_fd_pr__nfet_01v8 ad=1.24 pd=8.62 as=0.66 ps=4.33 w=4 l=0.15
X235 vss vbias_q a_3469_n2210# vss sky130_fd_pr__nfet_01v8 ad=0.87 pd=6.58 as=0.435 ps=3.29 w=3 l=0.5
X236 a_n6951_n2210# vbias_q vss vss sky130_fd_pr__nfet_01v8 ad=0.435 pd=3.29 as=0.87 ps=6.58 w=3 l=0.5
X237 a_9443_n3183# cfg1 vss vss sky130_fd_pr__nfet_01v8 ad=0.12375 pd=1.08 as=0.2325 ps=2.12 w=0.75 l=0.15
X238 vdd_q a_5324_n3348# vss sky130_fd_pr__res_high_po_2p85 l=4.77
X239 a_n6121_n4370# vbias_q vss vss sky130_fd_pr__nfet_01v8 ad=0.9135 pd=6.59 as=1.827 ps=13.18 w=6.3 l=0.5
X240 a_n5096_n3348# a_8793_n643# sky130_fd_pr__cap_mim_m3_1 l=4.6 w=7.65
X241 a_9393_5277# cfg2 vss vss sky130_fd_pr__nfet_01v8 ad=0.165 pd=1.33 as=0.31 ps=2.62 w=1 l=0.15
X242 a_5324_n3348# a_9443_3837# sky130_fd_pr__cap_mim_m3_1 l=2 w=2
X243 a_4299_3370# a_n5033_3370# a_5324_n3348# vss sky130_fd_pr__nfet_01v8_lvt ad=0.825 pd=5.33 as=0.825 ps=5.33 w=5 l=0.15
X244 a_4299_n4370# vbias_q vss vss sky130_fd_pr__nfet_01v8 ad=0.9135 pd=6.59 as=1.827 ps=13.18 w=6.3 l=0.5
X245 a_n6092_3282# a_n1027_n2463# sky130_fd_pr__cap_mim_m3_1 l=2 w=4.15
X246 a_3469_1610# vbias_q vss vss sky130_fd_pr__nfet_01v8 ad=0.435 pd=3.29 as=0.87 ps=6.58 w=3 l=0.5
X247 a_n6092_n3348# vdd_q vss sky130_fd_pr__res_high_po_2p85 l=4.77
X248 a_n6121_n4370# a_n6092_n3348# a_n8760_n4271# vss sky130_fd_pr__nfet_01v8_lvt ad=0.825 pd=5.33 as=0.825 ps=5.33 w=5 l=0.15
X249 vss vbias_q a_n6951_1610# vss sky130_fd_pr__nfet_01v8 ad=0.87 pd=6.58 as=0.435 ps=3.29 w=3 l=0.5
X250 a_n6092_3282# a_n1627_n643# sky130_fd_pr__cap_mim_m3_1 l=4.6 w=7.65
X251 vss cfg3 a_9193_6057# vss sky130_fd_pr__nfet_01v8 ad=0.62 pd=4.62 as=0.33 ps=2.33 w=2 l=0.15
X252 b3n a_n8760_n4271# a_n6951_n2210# vss sky130_fd_pr__nfet_01v8_lvt ad=0.495 pd=3.33 as=0.93 ps=6.62 w=3 l=0.15
X253 a_9193_n6123# cfg3 vss vss sky130_fd_pr__nfet_01v8 ad=0.33 pd=2.33 as=0.62 ps=4.62 w=2 l=0.15
X254 a_n6092_n3348# a_827_n6123# sky130_fd_pr__cap_mim_m3_1 l=2.6 w=6.58
X255 a_827_1617# cfg3 vss vss sky130_fd_pr__nfet_01v8 ad=0.33 pd=2.33 as=0.62 ps=4.62 w=2 l=0.15
X256 a_n6092_n3348# a_827_n5343# sky130_fd_pr__cap_mim_m3_1 l=2 w=4.15
X257 vss cfg0 a_n9593_n3903# vss sky130_fd_pr__nfet_01v8 ad=0.2325 pd=2.12 as=0.12375 ps=1.08 w=0.75 l=0.15
X258 vss cfg0 a_9443_3837# vss sky130_fd_pr__nfet_01v8 ad=0.2325 pd=2.12 as=0.12375 ps=1.08 w=0.75 l=0.15
X259 b1n a_1660_3469# a_3469_1610# vss sky130_fd_pr__nfet_01v8_lvt ad=0.495 pd=3.33 as=0.495 ps=3.33 w=3 l=0.15
X260 vdd_q a_n8760_3469# vss sky130_fd_pr__res_high_po_2p85 l=4.77
X261 a_1660_3469# a_827_3837# sky130_fd_pr__cap_mim_m3_1 l=2 w=2
X262 a_827_5277# cfg2 vss vss sky130_fd_pr__nfet_01v8 ad=0.165 pd=1.33 as=0.31 ps=2.62 w=1 l=0.15
X263 a_n8760_3469# a_n9593_577# sky130_fd_pr__cap_mim_m3_1 l=4.6 w=7.65
X264 vss cfg1 a_9443_3117# vss sky130_fd_pr__nfet_01v8 ad=0.2325 pd=2.12 as=0.12375 ps=1.08 w=0.75 l=0.15
X265 a_5324_n3348# a_9393_2397# sky130_fd_pr__cap_mim_m3_1 l=2 w=4.15
X266 a_n8760_3469# a_n6092_3282# a_n6121_3370# vss sky130_fd_pr__nfet_01v8_lvt ad=0.825 pd=5.33 as=0.825 ps=5.33 w=5 l=0.15
X267 a_n5096_n3348# a_8793_n7303# sky130_fd_pr__cap_mim_m3_1 l=4.6 w=7.65
X268 a_n1027_n5343# cfg2 vss vss sky130_fd_pr__nfet_01v8 ad=0.165 pd=1.33 as=0.31 ps=2.62 w=1 l=0.15
X269 b3p a_n6092_3282# a_n6951_n2210# vss sky130_fd_pr__nfet_01v8_lvt ad=0.495 pd=3.33 as=0.93 ps=6.62 w=3 l=0.15
X270 a_n8760_n4271# a_n9593_n5343# sky130_fd_pr__cap_mim_m3_1 l=2 w=4.15
X271 a_n6092_3282# a_n1627_n7303# sky130_fd_pr__cap_mim_m3_1 l=4.6 w=7.65
X272 a_4299_3370# a_n8760_3469# a_1660_3469# vss sky130_fd_pr__nfet_01v8_lvt ad=0.825 pd=5.33 as=0.825 ps=5.33 w=5 l=0.15
X273 vss cfg0 a_n977_n3903# vss sky130_fd_pr__nfet_01v8 ad=0.2325 pd=2.12 as=0.12375 ps=1.08 w=0.75 l=0.15
X274 a_n1227_n6123# cfg3 vss vss sky130_fd_pr__nfet_01v8 ad=0.33 pd=2.33 as=0.62 ps=4.62 w=2 l=0.15
X275 a_n9593_n7303# cfg4 vss vss sky130_fd_pr__nfet_01v8 ad=0.66 pd=4.33 as=1.24 ps=8.62 w=4 l=0.15
X276 a_4299_n4370# a_1660_3469# a_n6092_n3348# vss sky130_fd_pr__nfet_01v8_lvt ad=0.825 pd=5.33 as=0.825 ps=5.33 w=5 l=0.15
X277 a_n6951_1610# a_n5033_3370# b0p vss sky130_fd_pr__nfet_01v8_lvt ad=0.93 pd=6.62 as=0.495 ps=3.33 w=3 l=0.15
X278 vss cfg3 a_n9593_1617# vss sky130_fd_pr__nfet_01v8 ad=0.62 pd=4.62 as=0.33 ps=2.33 w=2 l=0.15
X279 a_5324_n3348# a_n5033_3370# a_4299_3370# vss sky130_fd_pr__nfet_01v8_lvt ad=0.825 pd=5.33 as=0.825 ps=5.33 w=5 l=0.15
X280 vss cfg0 a_827_n3903# vss sky130_fd_pr__nfet_01v8 ad=0.2325 pd=2.12 as=0.12375 ps=1.08 w=0.75 l=0.15
X281 a_3469_1610# a_5324_n3348# b1p vss sky130_fd_pr__nfet_01v8_lvt ad=0.93 pd=6.62 as=0.495 ps=3.33 w=3 l=0.15
X282 a_1660_3469# ctrl vss sky130_fd_pr__cap_var_lvt w=5.2 l=0.5
X283 vss cfg2 a_n9593_5277# vss sky130_fd_pr__nfet_01v8 ad=0.31 pd=2.62 as=0.165 ps=1.33 w=1 l=0.15
X284 a_n8760_3469# a_n9593_3837# sky130_fd_pr__cap_mim_m3_1 l=2 w=2
X285 vss cfg1 a_827_4557# vss sky130_fd_pr__nfet_01v8 ad=0.2325 pd=2.12 as=0.12375 ps=1.08 w=0.75 l=0.15
X286 a_4299_n4370# a_1660_3469# a_n6092_n3348# vss sky130_fd_pr__nfet_01v8_lvt ad=1.55 pd=10.62 as=0.825 ps=5.33 w=5 l=0.15
X287 a_n8760_n4271# a_n9593_n6123# sky130_fd_pr__cap_mim_m3_1 l=2.6 w=6.58
X288 a_n9593_n2463# cfg2 vss vss sky130_fd_pr__nfet_01v8 ad=0.165 pd=1.33 as=0.31 ps=2.62 w=1 l=0.15
X289 vss cfg2 a_n1027_5277# vss sky130_fd_pr__nfet_01v8 ad=0.31 pd=2.62 as=0.165 ps=1.33 w=1 l=0.15
X290 a_n6092_n3348# a_1660_3469# a_4299_n4370# vss sky130_fd_pr__nfet_01v8_lvt ad=0.825 pd=5.33 as=0.825 ps=5.33 w=5 l=0.15
X291 a_n9593_n6123# cfg3 vss vss sky130_fd_pr__nfet_01v8 ad=0.33 pd=2.33 as=0.62 ps=4.62 w=2 l=0.15
X292 a_n5033_3370# a_n8760_n4271# a_n6121_3370# vss sky130_fd_pr__nfet_01v8_lvt ad=0.825 pd=5.33 as=0.825 ps=5.33 w=5 l=0.15
X293 a_n5033_3370# a_n1227_1617# sky130_fd_pr__cap_mim_m3_1 l=2.6 w=6.58
X294 vss cfg4 a_8793_n7303# vss sky130_fd_pr__nfet_01v8 ad=1.24 pd=8.62 as=0.66 ps=4.33 w=4 l=0.15
X295 a_827_n7303# cfg4 vss vss sky130_fd_pr__nfet_01v8 ad=0.66 pd=4.33 as=1.24 ps=8.62 w=4 l=0.15
X296 a_n6121_3370# a_n6092_3282# a_n8760_3469# vss sky130_fd_pr__nfet_01v8_lvt ad=0.825 pd=5.33 as=0.825 ps=5.33 w=5 l=0.15
X297 b0n a_n8760_3469# a_n6951_1610# vss sky130_fd_pr__nfet_01v8_lvt ad=0.495 pd=3.33 as=0.495 ps=3.33 w=3 l=0.15
X298 a_n6092_n3348# ctrl vss sky130_fd_pr__cap_var_lvt w=5.2 l=0.5
X299 a_n9593_n3183# cfg1 vss vss sky130_fd_pr__nfet_01v8 ad=0.12375 pd=1.08 as=0.2325 ps=2.12 w=0.75 l=0.15
X300 vss cfg4 a_827_n643# vss sky130_fd_pr__nfet_01v8 ad=1.24 pd=8.62 as=0.66 ps=4.33 w=4 l=0.15
X301 a_n5096_n3348# a_5324_n3348# a_4299_n4370# vss sky130_fd_pr__nfet_01v8_lvt ad=0.825 pd=5.33 as=1.55 ps=10.62 w=5 l=0.15
X302 a_n8760_n4271# a_n9593_n3183# sky130_fd_pr__cap_mim_m3_1 l=2 w=2
X303 a_1660_3469# a_n8760_3469# a_4299_3370# vss sky130_fd_pr__nfet_01v8_lvt ad=0.825 pd=5.33 as=0.825 ps=5.33 w=5 l=0.15
X304 a_n6092_n3348# a_827_n1683# sky130_fd_pr__cap_mim_m3_1 l=2.6 w=6.58
X305 a_827_n2463# cfg2 vss vss sky130_fd_pr__nfet_01v8 ad=0.165 pd=1.33 as=0.31 ps=2.62 w=1 l=0.15
X306 a_n8760_n4271# vdd_q vss sky130_fd_pr__res_high_po_2p85 l=4.77
X307 vss cfg1 a_9443_n4623# vss sky130_fd_pr__nfet_01v8 ad=0.2325 pd=2.12 as=0.12375 ps=1.08 w=0.75 l=0.15
X308 a_827_n6123# cfg3 vss vss sky130_fd_pr__nfet_01v8 ad=0.33 pd=2.33 as=0.62 ps=4.62 w=2 l=0.15
X309 a_4299_n4370# a_5324_n3348# a_n5096_n3348# vss sky130_fd_pr__nfet_01v8_lvt ad=0.825 pd=5.33 as=0.825 ps=5.33 w=5 l=0.15
X310 a_n977_n3183# cfg1 vss vss sky130_fd_pr__nfet_01v8 ad=0.12375 pd=1.08 as=0.2325 ps=2.12 w=0.75 l=0.15
X311 a_n6092_n3348# a_1660_3469# a_4299_n4370# vss sky130_fd_pr__nfet_01v8_lvt ad=0.825 pd=5.33 as=0.825 ps=5.33 w=5 l=0.15
X312 a_9393_2397# cfg2 vss vss sky130_fd_pr__nfet_01v8 ad=0.165 pd=1.33 as=0.31 ps=2.62 w=1 l=0.15
X313 a_n977_4557# cfg1 vss vss sky130_fd_pr__nfet_01v8 ad=0.12375 pd=1.08 as=0.2325 ps=2.12 w=0.75 l=0.15
X314 a_5324_n3348# a_8793_7237# sky130_fd_pr__cap_mim_m3_1 l=4.6 w=7.65
X315 a_n6092_3282# ctrl vss sky130_fd_pr__cap_var_lvt w=5.2 l=0.5
X316 a_827_n3183# cfg1 vss vss sky130_fd_pr__nfet_01v8 ad=0.12375 pd=1.08 as=0.2325 ps=2.12 w=0.75 l=0.15
X317 a_n9593_n643# cfg4 vss vss sky130_fd_pr__nfet_01v8 ad=0.66 pd=4.33 as=1.24 ps=8.62 w=4 l=0.15
X318 a_827_7237# cfg4 vss vss sky130_fd_pr__nfet_01v8 ad=0.66 pd=4.33 as=1.24 ps=8.62 w=4 l=0.15
X319 a_n6092_3282# a_n1027_n5343# sky130_fd_pr__cap_mim_m3_1 l=2 w=4.15
X320 vss vbias_q a_n6951_1610# vss sky130_fd_pr__nfet_01v8 ad=0.87 pd=6.58 as=0.435 ps=3.29 w=3 l=0.5
X321 a_n6121_3370# a_n8760_n4271# a_n5033_3370# vss sky130_fd_pr__nfet_01v8_lvt ad=0.825 pd=5.33 as=0.825 ps=5.33 w=5 l=0.15
X322 a_5324_n3348# a_9193_1617# sky130_fd_pr__cap_mim_m3_1 l=2.6 w=6.58
X323 a_n9593_3837# cfg0 vss vss sky130_fd_pr__nfet_01v8 ad=0.12375 pd=1.08 as=0.2325 ps=2.12 w=0.75 l=0.15
X324 a_n8760_n4271# vdd_q vss sky130_fd_pr__res_high_po_2p85 l=4.77
X325 a_n6092_3282# a_n977_n3903# sky130_fd_pr__cap_mim_m3_1 l=2 w=2
X326 a_9443_n3903# cfg0 vss vss sky130_fd_pr__nfet_01v8 ad=0.12375 pd=1.08 as=0.2325 ps=2.12 w=0.75 l=0.15
X327 vss cfg4 a_8793_n643# vss sky130_fd_pr__nfet_01v8 ad=1.24 pd=8.62 as=0.66 ps=4.33 w=4 l=0.15
X328 a_5324_n3348# a_n5033_3370# a_4299_3370# vss sky130_fd_pr__nfet_01v8_lvt ad=0.825 pd=5.33 as=0.825 ps=5.33 w=5 l=0.15
X329 a_n9593_3117# cfg1 vss vss sky130_fd_pr__nfet_01v8 ad=0.12375 pd=1.08 as=0.2325 ps=2.12 w=0.75 l=0.15
X330 a_827_577# cfg4 vss vss sky130_fd_pr__nfet_01v8 ad=0.66 pd=4.33 as=1.24 ps=8.62 w=4 l=0.15
X331 a_827_2397# cfg2 vss vss sky130_fd_pr__nfet_01v8 ad=0.165 pd=1.33 as=0.31 ps=2.62 w=1 l=0.15
X332 a_n8760_n4271# a_n9593_n1683# sky130_fd_pr__cap_mim_m3_1 l=2.6 w=6.58
X333 a_5324_n3348# a_9393_5277# sky130_fd_pr__cap_mim_m3_1 l=2 w=4.15
X334 a_827_6057# cfg3 vss vss sky130_fd_pr__nfet_01v8 ad=0.33 pd=2.33 as=0.62 ps=4.62 w=2 l=0.15
X335 a_n6951_n2210# a_n6092_3282# b3p vss sky130_fd_pr__nfet_01v8_lvt ad=0.93 pd=6.62 as=0.495 ps=3.33 w=3 l=0.15
X336 vss cfg3 a_9193_n1683# vss sky130_fd_pr__nfet_01v8 ad=0.62 pd=4.62 as=0.33 ps=2.33 w=2 l=0.15
X337 a_n1027_n2463# cfg2 vss vss sky130_fd_pr__nfet_01v8 ad=0.165 pd=1.33 as=0.31 ps=2.62 w=1 l=0.15
X338 a_1660_3469# a_n8760_3469# a_4299_3370# vss sky130_fd_pr__nfet_01v8_lvt ad=0.825 pd=5.33 as=1.55 ps=10.62 w=5 l=0.15
X339 vss cfg0 a_n977_3837# vss sky130_fd_pr__nfet_01v8 ad=0.2325 pd=2.12 as=0.12375 ps=1.08 w=0.75 l=0.15
X340 vss cfg4 a_n9593_7237# vss sky130_fd_pr__nfet_01v8 ad=1.24 pd=8.62 as=0.66 ps=4.33 w=4 l=0.15
X341 a_n5096_n3348# a_9193_n6123# sky130_fd_pr__cap_mim_m3_1 l=2.6 w=6.58
X342 a_1660_3469# a_827_7237# sky130_fd_pr__cap_mim_m3_1 l=4.6 w=7.65
X343 a_1660_3469# a_827_1617# sky130_fd_pr__cap_mim_m3_1 l=2.6 w=6.58
X344 a_4299_n4370# a_5324_n3348# a_n5096_n3348# vss sky130_fd_pr__nfet_01v8_lvt ad=0.825 pd=5.33 as=0.825 ps=5.33 w=5 l=0.15
X345 b2n vdd_q vss sky130_fd_pr__res_high_po_2p85 l=4.22
X346 a_n8760_n4271# a_n6092_n3348# a_n6121_n4370# vss sky130_fd_pr__nfet_01v8_lvt ad=0.825 pd=5.33 as=1.55 ps=10.62 w=5 l=0.15
X347 a_3469_1610# a_1660_3469# b1n vss sky130_fd_pr__nfet_01v8_lvt ad=0.495 pd=3.33 as=0.495 ps=3.33 w=3 l=0.15
X348 a_1660_3469# ctrl vss sky130_fd_pr__cap_var_lvt w=5.2 l=0.5
X349 a_n6092_n3348# ctrl vss sky130_fd_pr__cap_var_lvt w=5.2 l=0.5
X350 vss vbias_q a_n6121_n4370# vss sky130_fd_pr__nfet_01v8 ad=1.827 pd=13.18 as=0.9135 ps=6.59 w=6.3 l=0.5
X351 vss cfg1 a_n977_3117# vss sky130_fd_pr__nfet_01v8 ad=0.2325 pd=2.12 as=0.12375 ps=1.08 w=0.75 l=0.15
X352 b1p a_5324_n3348# a_3469_1610# vss sky130_fd_pr__nfet_01v8_lvt ad=0.495 pd=3.33 as=0.93 ps=6.62 w=3 l=0.15
X353 a_n6092_3282# a_n5096_n3348# a_n6121_n4370# vss sky130_fd_pr__nfet_01v8_lvt ad=0.825 pd=5.33 as=0.825 ps=5.33 w=5 l=0.15
X354 a_n8760_n4271# ctrl vss sky130_fd_pr__cap_var_lvt w=5.2 l=0.5
X355 a_4299_3370# a_n8760_3469# a_1660_3469# vss sky130_fd_pr__nfet_01v8_lvt ad=1.55 pd=10.62 as=0.825 ps=5.33 w=5 l=0.15
X356 a_1660_3469# ctrl vss sky130_fd_pr__cap_var_lvt w=5.2 l=0.5
X357 a_n6121_3370# a_n6092_3282# a_n8760_3469# vss sky130_fd_pr__nfet_01v8_lvt ad=1.55 pd=10.62 as=0.825 ps=5.33 w=5 l=0.15
X358 a_n6092_n3348# ctrl vss sky130_fd_pr__cap_var_lvt w=5.2 l=0.5
X359 a_8793_7237# cfg4 vss vss sky130_fd_pr__nfet_01v8 ad=0.66 pd=4.33 as=1.24 ps=8.62 w=4 l=0.15
X360 a_n8760_3469# a_n9593_2397# sky130_fd_pr__cap_mim_m3_1 l=2 w=4.15
X361 a_n5033_3370# a_n977_3117# sky130_fd_pr__cap_mim_m3_1 l=2 w=2
X362 a_n1227_1617# cfg3 vss vss sky130_fd_pr__nfet_01v8 ad=0.33 pd=2.33 as=0.62 ps=4.62 w=2 l=0.15
X363 vss cfg2 a_n9593_2397# vss sky130_fd_pr__nfet_01v8 ad=0.31 pd=2.62 as=0.165 ps=1.33 w=1 l=0.15
X364 a_n5096_n3348# a_5324_n3348# a_4299_n4370# vss sky130_fd_pr__nfet_01v8_lvt ad=0.825 pd=5.33 as=0.825 ps=5.33 w=5 l=0.15
X365 a_n8760_3469# ctrl vss sky130_fd_pr__cap_var_lvt w=5.2 l=0.5
X366 vss cfg3 a_n9593_6057# vss sky130_fd_pr__nfet_01v8 ad=0.62 pd=4.62 as=0.33 ps=2.33 w=2 l=0.15
X367 a_3469_n2210# a_n5096_n3348# b2p vss sky130_fd_pr__nfet_01v8_lvt ad=0.93 pd=6.62 as=0.495 ps=3.33 w=3 l=0.15
X368 vss cfg3 a_n1227_n1683# vss sky130_fd_pr__nfet_01v8 ad=0.62 pd=4.62 as=0.33 ps=2.33 w=2 l=0.15
X369 vss cfg2 a_n1027_2397# vss sky130_fd_pr__nfet_01v8 ad=0.31 pd=2.62 as=0.165 ps=1.33 w=1 l=0.15
X370 a_n8760_3469# a_n6092_3282# a_n6121_3370# vss sky130_fd_pr__nfet_01v8_lvt ad=0.825 pd=5.33 as=1.55 ps=10.62 w=5 l=0.15
X371 a_n5096_n3348# a_9443_n3903# sky130_fd_pr__cap_mim_m3_1 l=2 w=2
X372 a_n8760_3469# a_n9593_1617# sky130_fd_pr__cap_mim_m3_1 l=2.6 w=6.58
X373 vss vbias_q a_n6951_n2210# vss sky130_fd_pr__nfet_01v8 ad=0.87 pd=6.58 as=0.435 ps=3.29 w=3 l=0.5
X374 a_4299_3370# a_n5033_3370# a_5324_n3348# vss sky130_fd_pr__nfet_01v8_lvt ad=0.825 pd=5.33 as=0.825 ps=5.33 w=5 l=0.15
X375 a_n6121_n4370# vbias_q vss vss sky130_fd_pr__nfet_01v8 ad=0.9135 pd=6.59 as=0.9135 ps=6.59 w=6.3 l=0.5
X376 vss cfg1 a_n9593_n4623# vss sky130_fd_pr__nfet_01v8 ad=0.2325 pd=2.12 as=0.12375 ps=1.08 w=0.75 l=0.15
X377 vss cfg1 a_9443_4557# vss sky130_fd_pr__nfet_01v8 ad=0.2325 pd=2.12 as=0.12375 ps=1.08 w=0.75 l=0.15
X378 vss cfg2 a_9393_n5343# vss sky130_fd_pr__nfet_01v8 ad=0.31 pd=2.62 as=0.165 ps=1.33 w=1 l=0.15
X379 a_n6092_3282# ctrl vss sky130_fd_pr__cap_var_lvt w=5.2 l=0.5
X380 a_1660_3469# a_827_577# sky130_fd_pr__cap_mim_m3_1 l=4.6 w=7.65
X381 a_n6092_3282# ctrl vss sky130_fd_pr__cap_var_lvt w=5.2 l=0.5
X382 b2p vdd_q vss sky130_fd_pr__res_high_po_2p85 l=4.22
X383 a_3469_n2210# a_n6092_n3348# b2n vss sky130_fd_pr__nfet_01v8_lvt ad=0.93 pd=6.62 as=0.495 ps=3.33 w=3 l=0.15
X384 a_5324_n3348# a_9443_3117# sky130_fd_pr__cap_mim_m3_1 l=2 w=2
X385 vss cfg2 a_9393_5277# vss sky130_fd_pr__nfet_01v8 ad=0.31 pd=2.62 as=0.165 ps=1.33 w=1 l=0.15
X386 vss cfg4 a_n1627_n7303# vss sky130_fd_pr__nfet_01v8 ad=1.24 pd=8.62 as=0.66 ps=4.33 w=4 l=0.15
X387 a_n6121_n4370# a_n6092_n3348# a_n8760_n4271# vss sky130_fd_pr__nfet_01v8_lvt ad=0.825 pd=5.33 as=0.825 ps=5.33 w=5 l=0.15
X388 vss cfg3 a_n9593_n1683# vss sky130_fd_pr__nfet_01v8 ad=0.62 pd=4.62 as=0.33 ps=2.33 w=2 l=0.15
X389 a_3469_n2210# vbias_q vss vss sky130_fd_pr__nfet_01v8 ad=0.435 pd=3.29 as=0.87 ps=6.58 w=3 l=0.5
X390 vss cfg1 a_n977_n4623# vss sky130_fd_pr__nfet_01v8 ad=0.2325 pd=2.12 as=0.12375 ps=1.08 w=0.75 l=0.15
X391 a_n6092_3282# a_n977_n4623# sky130_fd_pr__cap_mim_m3_1 l=2 w=2
X392 a_n6951_n2210# vbias_q vss vss sky130_fd_pr__nfet_01v8 ad=0.435 pd=3.29 as=0.87 ps=6.58 w=3 l=0.5
X393 a_n8760_3469# a_n6092_3282# a_n6121_3370# vss sky130_fd_pr__nfet_01v8_lvt ad=0.825 pd=5.33 as=0.825 ps=5.33 w=5 l=0.15
X394 vdd_q a_5324_n3348# vss sky130_fd_pr__res_high_po_2p85 l=4.77
X395 a_n5033_3370# a_n1627_577# sky130_fd_pr__cap_mim_m3_1 l=4.6 w=7.65
X396 vss cfg1 a_827_n4623# vss sky130_fd_pr__nfet_01v8 ad=0.2325 pd=2.12 as=0.12375 ps=1.08 w=0.75 l=0.15
X397 vss cfg3 a_827_1617# vss sky130_fd_pr__nfet_01v8 ad=0.62 pd=4.62 as=0.33 ps=2.33 w=2 l=0.15
X398 a_n6951_1610# a_n8760_3469# b0n vss sky130_fd_pr__nfet_01v8_lvt ad=0.93 pd=6.62 as=0.495 ps=3.33 w=3 l=0.15
X399 a_n9593_n3903# cfg0 vss vss sky130_fd_pr__nfet_01v8 ad=0.12375 pd=1.08 as=0.2325 ps=2.12 w=0.75 l=0.15
.ends
