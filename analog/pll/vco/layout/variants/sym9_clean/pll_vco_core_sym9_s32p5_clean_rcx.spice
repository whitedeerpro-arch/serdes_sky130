* NGSPICE file created from pll_vco_core_sym9_s32p5_clean.ext - technology: sky130A

.subckt pll_vco_core_sym9_s32p5_clean ctrl cfg0 cfg1 cfg2 cfg3 cfg4 vbias_q b0p b0n
+ b1p b1n b2p b2n b3p b3n vdd_q vss
X0 a_1660_3469.t10 a_827_3117# sky130_fd_pr__cap_mim_m3_1 l=2 w=2
X1 a_n6121_n4370# a_n5096_n3348.t19 a_n6092_3282.t5 vss.t211 sky130_fd_pr__nfet_01v8_lvt ad=0.825 pd=5.33 as=0.825 ps=5.33 w=5 l=0.15
X2 vss.t104 cfg2 a_827_5277# vss.t103 sky130_fd_pr__nfet_01v8 ad=0.31 pd=2.62 as=0.165 ps=1.33 w=1 l=0.15
X3 a_n5096_n3348.t10 a_9193_n1683# sky130_fd_pr__cap_mim_m3_1 l=2.6 w=6.58
X4 a_n8760_n4271.t11 ctrl.t30 vss sky130_fd_pr__cap_var_lvt w=5.2 l=0.5
X5 a_n6951_1610# a_n5033_3370.t13 b0p vss.t2 sky130_fd_pr__nfet_01v8_lvt ad=0.495 pd=3.33 as=0.495 ps=3.33 w=3 l=0.15
X6 vss.t171 cfg3 a_827_n1683# vss.t161 sky130_fd_pr__nfet_01v8 ad=0.62 pd=4.62 as=0.33 ps=2.33 w=2 l=0.15
X7 a_n6092_n3348.t14 ctrl.t50 vss sky130_fd_pr__cap_var_lvt w=5.2 l=0.5
X8 a_1660_3469.t23 ctrl.t28 vss sky130_fd_pr__cap_var_lvt w=5.2 l=0.5
X9 vdd_q b0n vss.t66 sky130_fd_pr__res_high_po_2p85 l=4.22
X10 a_n8760_n4271.t13 ctrl.t10 vss sky130_fd_pr__cap_var_lvt w=5.2 l=0.5
X11 a_n5096_n3348.t10 a_9393_n2463# sky130_fd_pr__cap_mim_m3_1 l=2 w=4.15
X12 a_n977_n3903# cfg0 vss.t201 vss.t189 sky130_fd_pr__nfet_01v8 ad=0.12375 pd=1.08 as=0.2325 ps=2.12 w=0.75 l=0.15
X13 a_4299_3370# vbias_q vss.t305 vss.t322 sky130_fd_pr__nfet_01v8 ad=0.9135 pd=6.59 as=0.9135 ps=6.59 w=6.3 l=0.5
X14 a_n5033_3370.t10 a_n1027_2397# sky130_fd_pr__cap_mim_m3_1 l=2 w=4.15
X15 a_1660_3469.t10 a_827_2397# sky130_fd_pr__cap_mim_m3_1 l=2 w=4.15
X16 vss.t310 vbias_q a_n6121_3370# vss.t311 sky130_fd_pr__nfet_01v8 ad=0.9135 pd=6.59 as=0.9135 ps=6.59 w=6.3 l=0.5
X17 a_8793_577# cfg4 vss.t244 vss.t242 sky130_fd_pr__nfet_01v8 ad=0.66 pd=4.33 as=1.24 ps=8.62 w=4 l=0.15
X18 vss.t246 cfg4 a_n1627_n643# vss.t238 sky130_fd_pr__nfet_01v8 ad=1.24 pd=8.62 as=0.66 ps=4.33 w=4 l=0.15
X19 vss.t325 vbias_q a_3469_1610# vss.t326 sky130_fd_pr__nfet_01v8 ad=0.87 pd=6.58 as=0.435 ps=3.29 w=3 l=0.5
X20 a_n5033_3370.t6 a_n8760_n4271.t22 a_n6121_3370# vss.t27 sky130_fd_pr__nfet_01v8_lvt ad=0.825 pd=5.33 as=0.825 ps=5.33 w=5 l=0.15
X21 a_827_n3903# cfg0 vss.t204 vss.t202 sky130_fd_pr__nfet_01v8 ad=0.12375 pd=1.08 as=0.2325 ps=2.12 w=0.75 l=0.15
X22 a_n6951_1610# vbias_q vss.t307 vss.t306 sky130_fd_pr__nfet_01v8 ad=0.435 pd=3.29 as=0.87 ps=6.58 w=3 l=0.5
X23 a_n8760_3469.t10 a_n9593_3117# sky130_fd_pr__cap_mim_m3_1 l=2 w=2
X24 a_n5096_n3348.t10 a_9443_n4623# sky130_fd_pr__cap_mim_m3_1 l=2 w=2
X25 vdd_q b1n vss.t69 sky130_fd_pr__res_high_po_2p85 l=4.22
X26 a_n6121_3370# a_n6092_3282.t25 a_n8760_3469.t3 vss.t55 sky130_fd_pr__nfet_01v8_lvt ad=0.825 pd=5.33 as=0.825 ps=5.33 w=5 l=0.15
X27 b0n a_n8760_3469.t14 a_n6951_1610# vss.t7 sky130_fd_pr__nfet_01v8_lvt ad=0.495 pd=3.33 as=0.93 ps=6.62 w=3 l=0.15
X28 vss.t305 vbias_q a_4299_3370# vss.t321 sky130_fd_pr__nfet_01v8 ad=0.9135 pd=6.59 as=0.9135 ps=6.59 w=6.3 l=0.5
X29 b3p vdd_q vss.t80 sky130_fd_pr__res_high_po_2p85 l=4.22
X30 a_n8760_n4271.t6 a_n6092_n3348.t18 a_n6121_n4370# vss.t52 sky130_fd_pr__nfet_01v8_lvt ad=0.825 pd=5.33 as=0.825 ps=5.33 w=5 l=0.15
X31 a_n6092_3282.t14 ctrl.t32 vss sky130_fd_pr__cap_var_lvt w=5.2 l=0.5
X32 a_n6121_3370# vbias_q vss.t310 vss.t312 sky130_fd_pr__nfet_01v8 ad=0.9135 pd=6.59 as=0.9135 ps=6.59 w=6.3 l=0.5
X33 a_n6121_n4370# a_n5096_n3348.t15 a_n6092_3282.t9 vss.t15 sky130_fd_pr__nfet_01v8_lvt ad=1.55 pd=10.62 as=0.825 ps=5.33 w=5 l=0.15
X34 a_n8760_3469.t26 ctrl.t46 vss sky130_fd_pr__cap_var_lvt w=5.2 l=0.5
X35 a_8793_n7303# cfg4 vss.t259 vss.t254 sky130_fd_pr__nfet_01v8 ad=0.66 pd=4.33 as=1.24 ps=8.62 w=4 l=0.15
X36 vdd_q b1p vss.t70 sky130_fd_pr__res_high_po_2p85 l=4.22
X37 a_n8760_3469.t10 a_n9593_5277# sky130_fd_pr__cap_mim_m3_1 l=2 w=4.15
X38 a_n8760_3469.t24 ctrl.t44 vss sky130_fd_pr__cap_var_lvt w=5.2 l=0.5
X39 a_n1627_7237# cfg4 vss.t221 vss.t219 sky130_fd_pr__nfet_01v8 ad=0.66 pd=4.33 as=1.24 ps=8.62 w=4 l=0.15
X40 b2p a_n5096_n3348.t26 a_3469_n2210# vss.t13 sky130_fd_pr__nfet_01v8_lvt ad=0.495 pd=3.33 as=0.93 ps=6.62 w=3 l=0.15
X41 a_827_n643# cfg4 vss.t249 vss.t228 sky130_fd_pr__nfet_01v8 ad=0.66 pd=4.33 as=1.24 ps=8.62 w=4 l=0.15
X42 a_9193_1617# cfg3 vss.t166 vss.t157 sky130_fd_pr__nfet_01v8 ad=0.33 pd=2.33 as=0.62 ps=4.62 w=2 l=0.15
X43 a_n6092_3282.t4 a_n5096_n3348.t20 a_n6121_n4370# vss.t38 sky130_fd_pr__nfet_01v8_lvt ad=0.825 pd=5.33 as=0.825 ps=5.33 w=5 l=0.15
X44 vss.t319 vbias_q a_3469_1610# vss.t320 sky130_fd_pr__nfet_01v8 ad=0.87 pd=6.58 as=0.435 ps=3.29 w=3 l=0.5
X45 a_n9593_4557# cfg1 vss.t262 vss.t260 sky130_fd_pr__nfet_01v8 ad=0.12375 pd=1.08 as=0.2325 ps=2.12 w=0.75 l=0.15
X46 a_n1227_6057# cfg3 vss.t149 vss.t147 sky130_fd_pr__nfet_01v8 ad=0.33 pd=2.33 as=0.62 ps=4.62 w=2 l=0.15
X47 a_n6951_1610# vbias_q vss.t315 vss.t314 sky130_fd_pr__nfet_01v8 ad=0.435 pd=3.29 as=0.87 ps=6.58 w=3 l=0.5
X48 a_n6092_3282.t1 vdd_q vss.t85 sky130_fd_pr__res_high_po_2p85 l=4.77
X49 a_827_3837# cfg0 vss.t195 vss.t193 sky130_fd_pr__nfet_01v8 ad=0.12375 pd=1.08 as=0.2325 ps=2.12 w=0.75 l=0.15
X50 a_9443_n4623# cfg1 vss.t303 vss.t298 sky130_fd_pr__nfet_01v8 ad=0.12375 pd=1.08 as=0.2325 ps=2.12 w=0.75 l=0.15
X51 a_n6092_n3348.t10 a_827_n3903# sky130_fd_pr__cap_mim_m3_1 l=2 w=2
X52 vss.t127 cfg2 a_9393_n2463# vss.t113 sky130_fd_pr__nfet_01v8 ad=0.31 pd=2.62 as=0.165 ps=1.33 w=1 l=0.15
X53 a_n9593_577# cfg4 vss.t236 vss.t234 sky130_fd_pr__nfet_01v8 ad=0.66 pd=4.33 as=1.24 ps=8.62 w=4 l=0.15
X54 a_n6121_3370# a_n8760_n4271.t25 a_n5033_3370.t3 vss.t3 sky130_fd_pr__nfet_01v8_lvt ad=0.825 pd=5.33 as=0.825 ps=5.33 w=5 l=0.15
X55 a_n5033_3370.t10 a_n1627_7237# sky130_fd_pr__cap_mim_m3_1 l=4.6 w=7.65
X56 a_827_3117# cfg1 vss.t279 vss.t277 sky130_fd_pr__nfet_01v8 ad=0.12375 pd=1.08 as=0.2325 ps=2.12 w=0.75 l=0.15
X57 a_n5033_3370.t10 a_n1227_6057# sky130_fd_pr__cap_mim_m3_1 l=2.6 w=6.58
X58 b2n a_n6092_n3348.t26 a_3469_n2210# vss.t16 sky130_fd_pr__nfet_01v8_lvt ad=0.495 pd=3.33 as=0.93 ps=6.62 w=3 l=0.15
X59 vss.t114 cfg2 a_9393_2397# vss.t113 sky130_fd_pr__nfet_01v8 ad=0.31 pd=2.62 as=0.165 ps=1.33 w=1 l=0.15
X60 a_n5096_n3348.t6 vdd_q vss.t93 sky130_fd_pr__res_high_po_2p85 l=4.77
X61 a_n8760_n4271.t14 ctrl.t52 vss sky130_fd_pr__cap_var_lvt w=5.2 l=0.5
X62 vss.t264 cfg1 a_n977_4557# vss.t263 sky130_fd_pr__nfet_01v8 ad=0.2325 pd=2.12 as=0.12375 ps=1.08 w=0.75 l=0.15
X63 a_4299_n4370# a_5324_n3348.t11 a_n5096_n3348.t8 vss.t214 sky130_fd_pr__nfet_01v8_lvt ad=1.55 pd=10.62 as=0.825 ps=5.33 w=5 l=0.15
X64 vss.t223 cfg4 a_827_7237# vss.t222 sky130_fd_pr__nfet_01v8 ad=1.24 pd=8.62 as=0.66 ps=4.33 w=4 l=0.15
X65 a_n6092_3282.t0 vdd_q vss.t84 sky130_fd_pr__res_high_po_2p85 l=4.77
X66 a_n6951_n2210# a_n8760_n4271.t15 b3n vss.t34 sky130_fd_pr__nfet_01v8_lvt ad=0.93 pd=6.62 as=0.495 ps=3.33 w=3 l=0.15
X67 a_n5033_3370.t25 ctrl.t18 vss sky130_fd_pr__cap_var_lvt w=5.2 l=0.5
X68 a_4299_n4370# a_1660_3469.t15 a_n6092_n3348.t8 vss.t77 sky130_fd_pr__nfet_01v8_lvt ad=0.825 pd=5.33 as=0.825 ps=5.33 w=5 l=0.15
X69 vss.t185 cfg0 a_n9593_3837# vss.t184 sky130_fd_pr__nfet_01v8 ad=0.2325 pd=2.12 as=0.12375 ps=1.08 w=0.75 l=0.15
X70 a_n6092_3282.t10 a_n977_n3183# sky130_fd_pr__cap_mim_m3_1 l=2 w=2
X71 a_n6121_n4370# a_n6092_n3348.t19 a_n8760_n4271.t5 vss.t36 sky130_fd_pr__nfet_01v8_lvt ad=0.825 pd=5.33 as=0.825 ps=5.33 w=5 l=0.15
X72 a_1660_3469.t9 a_n8760_3469.t20 a_4299_3370# vss.t89 sky130_fd_pr__nfet_01v8_lvt ad=0.825 pd=5.33 as=0.825 ps=5.33 w=5 l=0.15
X73 a_8793_n643# cfg4 vss.t251 vss.t242 sky130_fd_pr__nfet_01v8 ad=0.66 pd=4.33 as=1.24 ps=8.62 w=4 l=0.15
X74 vss.t275 cfg1 a_n9593_3117# vss.t273 sky130_fd_pr__nfet_01v8 ad=0.2325 pd=2.12 as=0.12375 ps=1.08 w=0.75 l=0.15
X75 a_n5096_n3348.t12 ctrl.t12 vss sky130_fd_pr__cap_var_lvt w=5.2 l=0.5
X76 b3n a_n8760_n4271.t16 a_n6951_n2210# vss.t20 sky130_fd_pr__nfet_01v8_lvt ad=0.495 pd=3.33 as=0.495 ps=3.33 w=3 l=0.15
X77 a_3469_1610# a_1660_3469.t19 b1n vss.t0 sky130_fd_pr__nfet_01v8_lvt ad=0.93 pd=6.62 as=0.495 ps=3.33 w=3 l=0.15
X78 vss.t116 cfg2 a_827_2397# vss.t115 sky130_fd_pr__nfet_01v8 ad=0.31 pd=2.62 as=0.165 ps=1.33 w=1 l=0.15
X79 vss.t229 cfg4 a_827_577# vss.t228 sky130_fd_pr__nfet_01v8 ad=1.24 pd=8.62 as=0.66 ps=4.33 w=4 l=0.15
X80 a_n6092_3282.t10 a_n1227_n6123# sky130_fd_pr__cap_mim_m3_1 l=2.6 w=6.58
X81 b1p a_5324_n3348.t20 a_3469_1610# vss.t6 sky130_fd_pr__nfet_01v8_lvt ad=0.495 pd=3.33 as=0.495 ps=3.33 w=3 l=0.15
X82 a_n6121_3370# a_n6092_3282.t21 a_n8760_3469.t7 vss.t57 sky130_fd_pr__nfet_01v8_lvt ad=0.825 pd=5.33 as=0.825 ps=5.33 w=5 l=0.15
X83 vss.t151 cfg3 a_827_6057# vss.t150 sky130_fd_pr__nfet_01v8 ad=0.62 pd=4.62 as=0.33 ps=2.33 w=2 l=0.15
X84 a_9193_n1683# cfg3 vss.t173 vss.t157 sky130_fd_pr__nfet_01v8 ad=0.33 pd=2.33 as=0.62 ps=4.62 w=2 l=0.15
X85 a_n6092_n3348.t10 a_827_n643# sky130_fd_pr__cap_mim_m3_1 l=4.6 w=7.65
X86 a_4299_n4370# vbias_q vss.t334 vss.t322 sky130_fd_pr__nfet_01v8 ad=0.9135 pd=6.59 as=0.9135 ps=6.59 w=6.3 l=0.5
X87 a_5324_n3348.t25 ctrl.t62 vss sky130_fd_pr__cap_var_lvt w=5.2 l=0.5
X88 a_n8760_3469.t23 ctrl.t36 vss sky130_fd_pr__cap_var_lvt w=5.2 l=0.5
X89 vss.t122 cfg2 a_n9593_n5343# vss.t121 sky130_fd_pr__nfet_01v8 ad=0.31 pd=2.62 as=0.165 ps=1.33 w=1 l=0.15
X90 a_5324_n3348.t10 a_9193_6057# sky130_fd_pr__cap_mim_m3_1 l=2.6 w=6.58
X91 a_n5096_n3348.t10 a_9393_n5343# sky130_fd_pr__cap_mim_m3_1 l=2 w=4.15
X92 a_n5033_3370.t10 a_n1027_5277# sky130_fd_pr__cap_mim_m3_1 l=2 w=4.15
X93 a_1660_3469.t10 a_827_5277# sky130_fd_pr__cap_mim_m3_1 l=2 w=4.15
X94 b3p a_n6092_3282.t16 a_n6951_n2210# vss.t11 sky130_fd_pr__nfet_01v8_lvt ad=0.495 pd=3.33 as=0.495 ps=3.33 w=3 l=0.15
X95 a_n6121_3370# a_n8760_n4271.t19 a_n5033_3370.t9 vss.t51 sky130_fd_pr__nfet_01v8_lvt ad=1.55 pd=10.62 as=0.825 ps=5.33 w=5 l=0.15
X96 vss.t317 vbias_q a_n6951_n2210# vss.t308 sky130_fd_pr__nfet_01v8 ad=0.87 pd=6.58 as=0.435 ps=3.29 w=3 l=0.5
X97 b0p a_n5033_3370.t12 a_n6951_1610# vss.t11 sky130_fd_pr__nfet_01v8_lvt ad=0.495 pd=3.33 as=0.495 ps=3.33 w=3 l=0.15
X98 vss.t226 cfg4 a_8793_7237# vss.t225 sky130_fd_pr__nfet_01v8 ad=1.24 pd=8.62 as=0.66 ps=4.33 w=4 l=0.15
X99 a_n5096_n3348.t4 a_5324_n3348.t16 a_4299_n4370# vss.t54 sky130_fd_pr__nfet_01v8_lvt ad=0.825 pd=5.33 as=0.825 ps=5.33 w=5 l=0.15
X100 vss.t163 cfg3 a_n1227_1617# vss.t142 sky130_fd_pr__nfet_01v8 ad=0.62 pd=4.62 as=0.33 ps=2.33 w=2 l=0.15
X101 a_n5033_3370.t10 a_n977_4557# sky130_fd_pr__cap_mim_m3_1 l=2 w=2
X102 vss.t340 vbias_q a_3469_n2210# vss.t326 sky130_fd_pr__nfet_01v8 ad=0.87 pd=6.58 as=0.435 ps=3.29 w=3 l=0.5
X103 a_n5033_3370.t2 a_n8760_n4271.t26 a_n6121_3370# vss.t43 sky130_fd_pr__nfet_01v8_lvt ad=0.825 pd=5.33 as=1.55 ps=10.62 w=5 l=0.15
X104 a_n1227_n1683# cfg3 vss.t169 vss.t142 sky130_fd_pr__nfet_01v8 ad=0.33 pd=2.33 as=0.62 ps=4.62 w=2 l=0.15
X105 a_n5096_n3348.t10 a_9443_n3183# sky130_fd_pr__cap_mim_m3_1 l=2 w=2
X106 b3n vdd_q vss.t94 sky130_fd_pr__res_high_po_2p85 l=4.22
X107 a_4299_3370# vbias_q vss.t305 vss.t304 sky130_fd_pr__nfet_01v8 ad=0.9135 pd=6.59 as=1.827 ps=13.18 w=6.3 l=0.5
X108 a_n6092_n3348.t10 a_827_n4623# sky130_fd_pr__cap_mim_m3_1 l=2 w=2
X109 a_4299_3370# a_n8760_3469.t17 a_1660_3469.t6 vss.t81 sky130_fd_pr__nfet_01v8_lvt ad=0.825 pd=5.33 as=0.825 ps=5.33 w=5 l=0.15
X110 vss.t334 vbias_q a_4299_n4370# vss.t323 sky130_fd_pr__nfet_01v8 ad=1.827 pd=13.18 as=0.9135 ps=6.59 w=6.3 l=0.5
X111 a_n6092_n3348.t10 a_827_n7303# sky130_fd_pr__cap_mim_m3_1 l=4.6 w=7.65
X112 vss.t134 cfg2 a_827_n5343# vss.t133 sky130_fd_pr__nfet_01v8 ad=0.31 pd=2.62 as=0.165 ps=1.33 w=1 l=0.15
X113 a_1660_3469.t10 a_827_6057# sky130_fd_pr__cap_mim_m3_1 l=2.6 w=6.58
X114 a_9393_n5343# cfg2 vss.t138 vss.t136 sky130_fd_pr__nfet_01v8 ad=0.165 pd=1.33 as=0.31 ps=2.62 w=1 l=0.15
X115 a_n9593_n4623# cfg1 vss.t272 vss.t270 sky130_fd_pr__nfet_01v8 ad=0.12375 pd=1.08 as=0.2325 ps=2.12 w=0.75 l=0.15
X116 a_n6092_n3348.t5 a_1660_3469.t14 a_4299_n4370# vss.t46 sky130_fd_pr__nfet_01v8_lvt ad=0.825 pd=5.33 as=0.825 ps=5.33 w=5 l=0.15
X117 a_n1627_577# cfg4 vss.t240 vss.t238 sky130_fd_pr__nfet_01v8 ad=0.66 pd=4.33 as=1.24 ps=8.62 w=4 l=0.15
X118 a_n8760_3469.t4 a_n6092_3282.t24 a_n6121_3370# vss.t56 sky130_fd_pr__nfet_01v8_lvt ad=0.825 pd=5.33 as=0.825 ps=5.33 w=5 l=0.15
X119 vss.t300 cfg1 a_9443_n3183# vss.t286 sky130_fd_pr__nfet_01v8 ad=0.2325 pd=2.12 as=0.12375 ps=1.08 w=0.75 l=0.15
X120 a_n6951_n2210# a_n8760_n4271.t17 b3n vss.t30 sky130_fd_pr__nfet_01v8_lvt ad=0.495 pd=3.33 as=0.495 ps=3.33 w=3 l=0.15
X121 a_n8760_3469.t10 a_n9593_7237# sky130_fd_pr__cap_mim_m3_1 l=4.6 w=7.65
X122 a_n1627_n7303# cfg4 vss.t253 vss.t230 sky130_fd_pr__nfet_01v8 ad=0.66 pd=4.33 as=1.24 ps=8.62 w=4 l=0.15
X123 a_5324_n3348.t10 a_9443_4557# sky130_fd_pr__cap_mim_m3_1 l=2 w=2
X124 a_n9593_n1683# cfg3 vss.t168 vss.t140 sky130_fd_pr__nfet_01v8 ad=0.33 pd=2.33 as=0.62 ps=4.62 w=2 l=0.15
X125 a_n5096_n3348.t11 ctrl.t58 vss sky130_fd_pr__cap_var_lvt w=5.2 l=0.5
X126 a_n977_n4623# cfg1 vss.t295 vss.t293 sky130_fd_pr__nfet_01v8 ad=0.12375 pd=1.08 as=0.2325 ps=2.12 w=0.75 l=0.15
X127 a_9193_6057# cfg3 vss.t155 vss.t153 sky130_fd_pr__nfet_01v8 ad=0.33 pd=2.33 as=0.62 ps=4.62 w=2 l=0.15
X128 a_n5096_n3348.t13 ctrl.t48 vss sky130_fd_pr__cap_var_lvt w=5.2 l=0.5
X129 a_n8760_3469.t10 a_n9593_6057# sky130_fd_pr__cap_mim_m3_1 l=2.6 w=6.58
X130 vss.t182 cfg3 a_9193_n6123# vss.t181 sky130_fd_pr__nfet_01v8 ad=0.62 pd=4.62 as=0.33 ps=2.33 w=2 l=0.15
X131 a_827_n4623# cfg1 vss.t301 vss.t296 sky130_fd_pr__nfet_01v8 ad=0.12375 pd=1.08 as=0.2325 ps=2.12 w=0.75 l=0.15
X132 a_n6092_3282.t10 a_n1227_n1683# sky130_fd_pr__cap_mim_m3_1 l=2.6 w=6.58
X133 a_4299_3370# a_n5033_3370.t21 a_5324_n3348.t4 vss.t44 sky130_fd_pr__nfet_01v8_lvt ad=0.825 pd=5.33 as=0.825 ps=5.33 w=5 l=0.15
X134 a_n6951_n2210# a_n6092_3282.t17 b3p vss.t2 sky130_fd_pr__nfet_01v8_lvt ad=0.495 pd=3.33 as=0.495 ps=3.33 w=3 l=0.15
X135 a_9443_3837# cfg0 vss.t199 vss.t187 sky130_fd_pr__nfet_01v8 ad=0.12375 pd=1.08 as=0.2325 ps=2.12 w=0.75 l=0.15
X136 vdd_q b0p vss.t67 sky130_fd_pr__res_high_po_2p85 l=4.22
X137 a_n5033_3370.t26 ctrl.t20 vss sky130_fd_pr__cap_var_lvt w=5.2 l=0.5
X138 a_1660_3469.t10 a_827_4557# sky130_fd_pr__cap_mim_m3_1 l=2 w=2
X139 a_4299_n4370# a_5324_n3348.t15 a_n5096_n3348.t3 vss.t35 sky130_fd_pr__nfet_01v8_lvt ad=0.825 pd=5.33 as=0.825 ps=5.33 w=5 l=0.15
X140 a_9443_3117# cfg1 vss.t288 vss.t286 sky130_fd_pr__nfet_01v8 ad=0.12375 pd=1.08 as=0.2325 ps=2.12 w=0.75 l=0.15
X141 a_n5033_3370.t24 ctrl.t22 vss sky130_fd_pr__cap_var_lvt w=5.2 l=0.5
X142 a_n6092_n3348.t0 a_1660_3469.t18 a_4299_n4370# vss.t1 sky130_fd_pr__nfet_01v8_lvt ad=0.825 pd=5.33 as=1.55 ps=10.62 w=5 l=0.15
X143 a_827_n1683# cfg3 vss.t172 vss.t161 sky130_fd_pr__nfet_01v8 ad=0.33 pd=2.33 as=0.62 ps=4.62 w=2 l=0.15
X144 vss.t131 cfg2 a_n1027_n5343# vss.t130 sky130_fd_pr__nfet_01v8 ad=0.31 pd=2.62 as=0.165 ps=1.33 w=1 l=0.15
X145 b1n a_1660_3469.t22 a_3469_1610# vss.t16 sky130_fd_pr__nfet_01v8_lvt ad=0.495 pd=3.33 as=0.93 ps=6.62 w=3 l=0.15
X146 vss.t176 cfg3 a_n1227_n6123# vss.t175 sky130_fd_pr__nfet_01v8 ad=0.62 pd=4.62 as=0.33 ps=2.33 w=2 l=0.15
X147 vss.t233 cfg4 a_n9593_n7303# vss.t232 sky130_fd_pr__nfet_01v8 ad=1.24 pd=8.62 as=0.66 ps=4.33 w=4 l=0.15
X148 vss.t243 cfg4 a_8793_577# vss.t242 sky130_fd_pr__nfet_01v8 ad=1.24 pd=8.62 as=0.66 ps=4.33 w=4 l=0.15
X149 a_n8760_n4271.t10 a_n9593_n643# sky130_fd_pr__cap_mim_m3_1 l=4.6 w=7.65
X150 a_n1627_n643# cfg4 vss.t247 vss.t238 sky130_fd_pr__nfet_01v8 ad=0.66 pd=4.33 as=1.24 ps=8.62 w=4 l=0.15
X151 a_n9593_1617# cfg3 vss.t156 vss.t140 sky130_fd_pr__nfet_01v8 ad=0.33 pd=2.33 as=0.62 ps=4.62 w=2 l=0.15
X152 a_4299_n4370# a_1660_3469.t13 a_n6092_n3348.t2 vss.t21 sky130_fd_pr__nfet_01v8_lvt ad=0.825 pd=5.33 as=0.825 ps=5.33 w=5 l=0.15
X153 a_5324_n3348.t26 ctrl.t26 vss sky130_fd_pr__cap_var_lvt w=5.2 l=0.5
X154 a_n9593_5277# cfg2 vss.t99 vss.t97 sky130_fd_pr__nfet_01v8 ad=0.165 pd=1.33 as=0.31 ps=2.62 w=1 l=0.15
X155 a_5324_n3348.t24 ctrl.t4 vss sky130_fd_pr__cap_var_lvt w=5.2 l=0.5
X156 a_n8760_3469.t10 a_n9593_4557# sky130_fd_pr__cap_mim_m3_1 l=2 w=2
X157 a_827_4557# cfg1 vss.t283 vss.t281 sky130_fd_pr__nfet_01v8 ad=0.12375 pd=1.08 as=0.2325 ps=2.12 w=0.75 l=0.15
X158 a_4299_3370# a_n8760_3469.t21 a_1660_3469.t8 vss.t88 sky130_fd_pr__nfet_01v8_lvt ad=0.825 pd=5.33 as=0.825 ps=5.33 w=5 l=0.15
X159 vss.t108 cfg2 a_n9593_n2463# vss.t107 sky130_fd_pr__nfet_01v8 ad=0.31 pd=2.62 as=0.165 ps=1.33 w=1 l=0.15
X160 a_n1027_5277# cfg2 vss.t102 vss.t100 sky130_fd_pr__nfet_01v8 ad=0.165 pd=1.33 as=0.31 ps=2.62 w=1 l=0.15
X161 vss.t160 cfg3 a_n9593_n6123# vss.t159 sky130_fd_pr__nfet_01v8 ad=0.62 pd=4.62 as=0.33 ps=2.33 w=2 l=0.15
X162 a_5324_n3348.t0 a_n5033_3370.t18 a_4299_3370# vss.t12 sky130_fd_pr__nfet_01v8_lvt ad=0.825 pd=5.33 as=0.825 ps=5.33 w=5 l=0.15
X163 vdd_q a_1660_3469.t3 vss.t74 sky130_fd_pr__res_high_po_2p85 l=4.77
X164 a_3469_1610# a_5324_n3348.t21 b1p vss.t14 sky130_fd_pr__nfet_01v8_lvt ad=0.495 pd=3.33 as=0.495 ps=3.33 w=3 l=0.15
X165 vss.t257 cfg4 a_827_n7303# vss.t256 sky130_fd_pr__nfet_01v8 ad=1.24 pd=8.62 as=0.66 ps=4.33 w=4 l=0.15
X166 a_n8760_n4271.t10 a_n9593_n7303# sky130_fd_pr__cap_mim_m3_1 l=4.6 w=7.65
X167 a_n6092_3282.t8 a_n5096_n3348.t16 a_n6121_n4370# vss.t9 sky130_fd_pr__nfet_01v8_lvt ad=0.825 pd=5.33 as=0.825 ps=5.33 w=5 l=0.15
X168 vss.t220 cfg4 a_n1627_7237# vss.t219 sky130_fd_pr__nfet_01v8 ad=1.24 pd=8.62 as=0.66 ps=4.33 w=4 l=0.15
X169 a_n5096_n3348.t14 ctrl.t16 vss sky130_fd_pr__cap_var_lvt w=5.2 l=0.5
X170 vss.t274 cfg1 a_n9593_n3183# vss.t273 sky130_fd_pr__nfet_01v8 ad=0.2325 pd=2.12 as=0.12375 ps=1.08 w=0.75 l=0.15
X171 vss.t158 cfg3 a_9193_1617# vss.t157 sky130_fd_pr__nfet_01v8 ad=0.62 pd=4.62 as=0.33 ps=2.33 w=2 l=0.15
X172 vdd_q a_n5033_3370.t1 vss.t68 sky130_fd_pr__res_high_po_2p85 l=4.77
X173 vss.t148 cfg3 a_n1227_6057# vss.t147 sky130_fd_pr__nfet_01v8 ad=0.62 pd=4.62 as=0.33 ps=2.33 w=2 l=0.15
X174 a_n8760_n4271.t10 a_n9593_n3903# sky130_fd_pr__cap_mim_m3_1 l=2 w=2
X175 vss.t261 cfg1 a_n9593_4557# vss.t260 sky130_fd_pr__nfet_01v8 ad=0.2325 pd=2.12 as=0.12375 ps=1.08 w=0.75 l=0.15
X176 a_n5096_n3348.t7 a_5324_n3348.t14 a_4299_n4370# vss.t209 sky130_fd_pr__nfet_01v8_lvt ad=0.825 pd=5.33 as=0.825 ps=5.33 w=5 l=0.15
X177 vss.t194 cfg0 a_827_3837# vss.t193 sky130_fd_pr__nfet_01v8 ad=0.2325 pd=2.12 as=0.12375 ps=1.08 w=0.75 l=0.15
X178 vss.t125 cfg2 a_827_n2463# vss.t115 sky130_fd_pr__nfet_01v8 ad=0.31 pd=2.62 as=0.165 ps=1.33 w=1 l=0.15
X179 a_n6092_n3348.t10 a_827_n3183# sky130_fd_pr__cap_mim_m3_1 l=2 w=2
X180 a_3469_n2210# a_n5096_n3348.t25 b2p vss.t14 sky130_fd_pr__nfet_01v8_lvt ad=0.495 pd=3.33 as=0.495 ps=3.33 w=3 l=0.15
X181 a_n6092_3282.t2 a_n5096_n3348.t22 a_n6121_n4370# vss.t8 sky130_fd_pr__nfet_01v8_lvt ad=0.825 pd=5.33 as=1.55 ps=10.62 w=5 l=0.15
X182 a_9393_n2463# cfg2 vss.t128 vss.t113 sky130_fd_pr__nfet_01v8 ad=0.165 pd=1.33 as=0.31 ps=2.62 w=1 l=0.15
X183 vss.t235 cfg4 a_n9593_577# vss.t234 sky130_fd_pr__nfet_01v8 ad=1.24 pd=8.62 as=0.66 ps=4.33 w=4 l=0.15
X184 vss.t179 cfg3 a_827_n6123# vss.t178 sky130_fd_pr__nfet_01v8 ad=0.62 pd=4.62 as=0.33 ps=2.33 w=2 l=0.15
X185 a_n6121_n4370# a_n5096_n3348.t21 a_n6092_3282.t3 vss.t210 sky130_fd_pr__nfet_01v8_lvt ad=0.825 pd=5.33 as=0.825 ps=5.33 w=5 l=0.15
X186 vss.t278 cfg1 a_827_3117# vss.t277 sky130_fd_pr__nfet_01v8 ad=0.2325 pd=2.12 as=0.12375 ps=1.08 w=0.75 l=0.15
X187 a_n5033_3370.t23 ctrl.t42 vss sky130_fd_pr__cap_var_lvt w=5.2 l=0.5
X188 vss.t269 cfg1 a_n977_n3183# vss.t268 sky130_fd_pr__nfet_01v8 ad=0.2325 pd=2.12 as=0.12375 ps=1.08 w=0.75 l=0.15
X189 a_n6092_n3348.t10 a_827_n2463# sky130_fd_pr__cap_mim_m3_1 l=2 w=4.15
X190 a_1660_3469.t1 a_n8760_3469.t18 a_4299_3370# vss.t40 sky130_fd_pr__nfet_01v8_lvt ad=0.825 pd=5.33 as=0.825 ps=5.33 w=5 l=0.15
X191 a_3469_1610# vbias_q vss.t325 vss.t324 sky130_fd_pr__nfet_01v8 ad=0.435 pd=3.29 as=0.87 ps=6.58 w=3 l=0.5
X192 vss.t291 cfg1 a_827_n3183# vss.t277 sky130_fd_pr__nfet_01v8 ad=0.2325 pd=2.12 as=0.12375 ps=1.08 w=0.75 l=0.15
X193 vss.t237 cfg4 a_n9593_n643# vss.t234 sky130_fd_pr__nfet_01v8 ad=1.24 pd=8.62 as=0.66 ps=4.33 w=4 l=0.15
X194 a_3469_n2210# a_n6092_n3348.t25 b2n vss.t42 sky130_fd_pr__nfet_01v8_lvt ad=0.495 pd=3.33 as=0.495 ps=3.33 w=3 l=0.15
X195 a_n6121_n4370# a_n6092_n3348.t15 a_n8760_n4271.t9 vss.t212 sky130_fd_pr__nfet_01v8_lvt ad=1.55 pd=10.62 as=0.825 ps=5.33 w=5 l=0.15
X196 vss.t305 vbias_q a_4299_3370# vss.t323 sky130_fd_pr__nfet_01v8 ad=1.827 pd=13.18 as=0.9135 ps=6.59 w=6.3 l=0.5
X197 a_n8760_n4271.t10 a_n9593_n2463# sky130_fd_pr__cap_mim_m3_1 l=2 w=4.15
X198 vss.t206 cfg0 a_9443_n3903# vss.t205 sky130_fd_pr__nfet_01v8 ad=0.2325 pd=2.12 as=0.12375 ps=1.08 w=0.75 l=0.15
X199 a_n6121_3370# vbias_q vss.t310 vss.t309 sky130_fd_pr__nfet_01v8 ad=0.9135 pd=6.59 as=1.827 ps=13.18 w=6.3 l=0.5
X200 a_5324_n3348.t23 ctrl.t54 vss sky130_fd_pr__cap_var_lvt w=5.2 l=0.5
X201 vdd_q a_1660_3469.t2 vss.t73 sky130_fd_pr__res_high_po_2p85 l=4.77
X202 a_n6121_3370# a_n8760_n4271.t21 a_n5033_3370.t7 vss.t53 sky130_fd_pr__nfet_01v8_lvt ad=0.825 pd=5.33 as=0.825 ps=5.33 w=5 l=0.15
X203 a_n8760_n4271.t4 a_n6092_n3348.t20 a_n6121_n4370# vss.t19 sky130_fd_pr__nfet_01v8_lvt ad=0.825 pd=5.33 as=0.825 ps=5.33 w=5 l=0.15
X204 b0p a_n5033_3370.t14 a_n6951_1610# vss.t48 sky130_fd_pr__nfet_01v8_lvt ad=0.495 pd=3.33 as=0.93 ps=6.62 w=3 l=0.15
X205 a_n5096_n3348.t5 vdd_q vss.t90 sky130_fd_pr__res_high_po_2p85 l=4.77
X206 vss.t123 cfg2 a_n1027_n2463# vss.t110 sky130_fd_pr__nfet_01v8 ad=0.31 pd=2.62 as=0.165 ps=1.33 w=1 l=0.15
X207 a_n6121_n4370# a_n5096_n3348.t17 a_n6092_3282.t7 vss.t208 sky130_fd_pr__nfet_01v8_lvt ad=0.825 pd=5.33 as=0.825 ps=5.33 w=5 l=0.15
X208 a_n977_3837# cfg0 vss.t198 vss.t196 sky130_fd_pr__nfet_01v8 ad=0.12375 pd=1.08 as=0.2325 ps=2.12 w=0.75 l=0.15
X209 vdd_q a_n5033_3370.t0 vss.t62 sky130_fd_pr__res_high_po_2p85 l=4.77
X210 a_5324_n3348.t10 a_8793_577# sky130_fd_pr__cap_mim_m3_1 l=4.6 w=7.65
X211 a_n6951_1610# a_n8760_3469.t13 b0n vss.t30 sky130_fd_pr__nfet_01v8_lvt ad=0.495 pd=3.33 as=0.495 ps=3.33 w=3 l=0.15
X212 a_n9593_7237# cfg4 vss.t218 vss.t216 sky130_fd_pr__nfet_01v8 ad=0.66 pd=4.33 as=1.24 ps=8.62 w=4 l=0.15
X213 a_n9593_n5343# cfg2 vss.t129 vss.t121 sky130_fd_pr__nfet_01v8 ad=0.165 pd=1.33 as=0.31 ps=2.62 w=1 l=0.15
X214 a_5324_n3348.t3 a_n5033_3370.t22 a_4299_3370# vss.t25 sky130_fd_pr__nfet_01v8_lvt ad=0.825 pd=5.33 as=1.55 ps=10.62 w=5 l=0.15
X215 a_n977_3117# cfg1 vss.t284 vss.t268 sky130_fd_pr__nfet_01v8 ad=0.12375 pd=1.08 as=0.2325 ps=2.12 w=0.75 l=0.15
X216 vdd_q a_n8760_3469.t0 vss.t63 sky130_fd_pr__res_high_po_2p85 l=4.77
X217 b2p a_n5096_n3348.t24 a_3469_n2210# vss.t6 sky130_fd_pr__nfet_01v8_lvt ad=0.495 pd=3.33 as=0.495 ps=3.33 w=3 l=0.15
X218 a_3469_n2210# vbias_q vss.t337 vss.t318 sky130_fd_pr__nfet_01v8 ad=0.435 pd=3.29 as=0.87 ps=6.58 w=3 l=0.5
X219 vss.t334 vbias_q a_4299_n4370# vss.t321 sky130_fd_pr__nfet_01v8 ad=0.9135 pd=6.59 as=0.9135 ps=6.59 w=6.3 l=0.5
X220 a_4299_3370# a_n5033_3370.t15 a_5324_n3348.t6 vss.t60 sky130_fd_pr__nfet_01v8_lvt ad=1.55 pd=10.62 as=0.825 ps=5.33 w=5 l=0.15
X221 a_n5033_3370.t10 a_n977_3837# sky130_fd_pr__cap_mim_m3_1 l=2 w=2
X222 a_n9593_2397# cfg2 vss.t112 vss.t107 sky130_fd_pr__nfet_01v8 ad=0.165 pd=1.33 as=0.31 ps=2.62 w=1 l=0.15
X223 vss.t328 vbias_q a_n6121_n4370# vss.t311 sky130_fd_pr__nfet_01v8 ad=0.9135 pd=6.59 as=0.9135 ps=6.59 w=6.3 l=0.5
X224 a_n8760_n4271.t10 a_n9593_n4623# sky130_fd_pr__cap_mim_m3_1 l=2 w=2
X225 a_n9593_6057# cfg3 vss.t146 vss.t144 sky130_fd_pr__nfet_01v8 ad=0.33 pd=2.33 as=0.62 ps=4.62 w=2 l=0.15
X226 a_n1027_2397# cfg2 vss.t117 vss.t110 sky130_fd_pr__nfet_01v8 ad=0.165 pd=1.33 as=0.31 ps=2.62 w=1 l=0.15
X227 a_n6092_n3348.t7 vdd_q vss.t75 sky130_fd_pr__res_high_po_2p85 l=4.77
X228 a_827_n5343# cfg2 vss.t135 vss.t133 sky130_fd_pr__nfet_01v8 ad=0.165 pd=1.33 as=0.31 ps=2.62 w=1 l=0.15
X229 vss.t310 vbias_q a_n6121_3370# vss.t313 sky130_fd_pr__nfet_01v8 ad=1.827 pd=13.18 as=0.9135 ps=6.59 w=6.3 l=0.5
X230 b2n a_n6092_n3348.t24 a_3469_n2210# vss.t26 sky130_fd_pr__nfet_01v8_lvt ad=0.495 pd=3.33 as=0.495 ps=3.33 w=3 l=0.15
X231 a_9443_4557# cfg1 vss.t285 vss.t266 sky130_fd_pr__nfet_01v8 ad=0.12375 pd=1.08 as=0.2325 ps=2.12 w=0.75 l=0.15
X232 a_n5033_3370.t4 a_n8760_n4271.t24 a_n6121_3370# vss.t29 sky130_fd_pr__nfet_01v8_lvt ad=0.825 pd=5.33 as=0.825 ps=5.33 w=5 l=0.15
X233 a_n8760_n4271.t8 a_n6092_n3348.t16 a_n6121_n4370# vss.t50 sky130_fd_pr__nfet_01v8_lvt ad=0.825 pd=5.33 as=0.825 ps=5.33 w=5 l=0.15
X234 vss.t239 cfg4 a_n1627_577# vss.t238 sky130_fd_pr__nfet_01v8 ad=1.24 pd=8.62 as=0.66 ps=4.33 w=4 l=0.15
X235 vss.t337 vbias_q a_3469_n2210# vss.t320 sky130_fd_pr__nfet_01v8 ad=0.87 pd=6.58 as=0.435 ps=3.29 w=3 l=0.5
X236 a_n6951_n2210# vbias_q vss.t317 vss.t306 sky130_fd_pr__nfet_01v8 ad=0.435 pd=3.29 as=0.87 ps=6.58 w=3 l=0.5
X237 a_9443_n3183# cfg1 vss.t302 vss.t286 sky130_fd_pr__nfet_01v8 ad=0.12375 pd=1.08 as=0.2325 ps=2.12 w=0.75 l=0.15
X238 vdd_q a_5324_n3348.t8 vss.t72 sky130_fd_pr__res_high_po_2p85 l=4.77
X239 a_n6121_n4370# vbias_q vss.t328 vss.t309 sky130_fd_pr__nfet_01v8 ad=0.9135 pd=6.59 as=1.827 ps=13.18 w=6.3 l=0.5
X240 a_n5096_n3348.t10 a_8793_n643# sky130_fd_pr__cap_mim_m3_1 l=4.6 w=7.65
X241 a_9393_5277# cfg2 vss.t106 vss.t95 sky130_fd_pr__nfet_01v8 ad=0.165 pd=1.33 as=0.31 ps=2.62 w=1 l=0.15
X242 a_5324_n3348.t10 a_9443_3837# sky130_fd_pr__cap_mim_m3_1 l=2 w=2
X243 a_4299_3370# a_n5033_3370.t19 a_5324_n3348.t1 vss.t23 sky130_fd_pr__nfet_01v8_lvt ad=0.825 pd=5.33 as=0.825 ps=5.33 w=5 l=0.15
X244 a_4299_n4370# vbias_q vss.t334 vss.t304 sky130_fd_pr__nfet_01v8 ad=0.9135 pd=6.59 as=1.827 ps=13.18 w=6.3 l=0.5
X245 a_n6092_3282.t10 a_n1027_n2463# sky130_fd_pr__cap_mim_m3_1 l=2 w=4.15
X246 a_3469_1610# vbias_q vss.t319 vss.t318 sky130_fd_pr__nfet_01v8 ad=0.435 pd=3.29 as=0.87 ps=6.58 w=3 l=0.5
X247 a_n6092_n3348.t9 vdd_q vss.t91 sky130_fd_pr__res_high_po_2p85 l=4.77
X248 a_n6121_n4370# a_n6092_n3348.t21 a_n8760_n4271.t3 vss.t213 sky130_fd_pr__nfet_01v8_lvt ad=0.825 pd=5.33 as=0.825 ps=5.33 w=5 l=0.15
X249 vss.t315 vbias_q a_n6951_1610# vss.t316 sky130_fd_pr__nfet_01v8 ad=0.87 pd=6.58 as=0.435 ps=3.29 w=3 l=0.5
X250 a_n6092_3282.t10 a_n1627_n643# sky130_fd_pr__cap_mim_m3_1 l=4.6 w=7.65
X251 vss.t154 cfg3 a_9193_6057# vss.t153 sky130_fd_pr__nfet_01v8 ad=0.62 pd=4.62 as=0.33 ps=2.33 w=2 l=0.15
X252 b3n a_n8760_n4271.t18 a_n6951_n2210# vss.t7 sky130_fd_pr__nfet_01v8_lvt ad=0.495 pd=3.33 as=0.93 ps=6.62 w=3 l=0.15
X253 a_9193_n6123# cfg3 vss.t183 vss.t181 sky130_fd_pr__nfet_01v8 ad=0.33 pd=2.33 as=0.62 ps=4.62 w=2 l=0.15
X254 a_n6092_n3348.t10 a_827_n6123# sky130_fd_pr__cap_mim_m3_1 l=2.6 w=6.58
X255 a_827_1617# cfg3 vss.t165 vss.t161 sky130_fd_pr__nfet_01v8 ad=0.33 pd=2.33 as=0.62 ps=4.62 w=2 l=0.15
X256 a_n6092_n3348.t10 a_827_n5343# sky130_fd_pr__cap_mim_m3_1 l=2 w=4.15
X257 vss.t192 cfg0 a_n9593_n3903# vss.t191 sky130_fd_pr__nfet_01v8 ad=0.2325 pd=2.12 as=0.12375 ps=1.08 w=0.75 l=0.15
X258 vss.t188 cfg0 a_9443_3837# vss.t187 sky130_fd_pr__nfet_01v8 ad=0.2325 pd=2.12 as=0.12375 ps=1.08 w=0.75 l=0.15
X259 b1n a_1660_3469.t20 a_3469_1610# vss.t26 sky130_fd_pr__nfet_01v8_lvt ad=0.495 pd=3.33 as=0.495 ps=3.33 w=3 l=0.15
X260 vdd_q a_n8760_3469.t1 vss.t65 sky130_fd_pr__res_high_po_2p85 l=4.77
X261 a_1660_3469.t10 a_827_3837# sky130_fd_pr__cap_mim_m3_1 l=2 w=2
X262 a_827_5277# cfg2 vss.t105 vss.t103 sky130_fd_pr__nfet_01v8 ad=0.165 pd=1.33 as=0.31 ps=2.62 w=1 l=0.15
X263 a_n8760_3469.t10 a_n9593_577# sky130_fd_pr__cap_mim_m3_1 l=4.6 w=7.65
X264 vss.t287 cfg1 a_9443_3117# vss.t286 sky130_fd_pr__nfet_01v8 ad=0.2325 pd=2.12 as=0.12375 ps=1.08 w=0.75 l=0.15
X265 a_5324_n3348.t10 a_9393_2397# sky130_fd_pr__cap_mim_m3_1 l=2 w=4.15
X266 a_n8760_3469.t8 a_n6092_3282.t20 a_n6121_3370# vss.t49 sky130_fd_pr__nfet_01v8_lvt ad=0.825 pd=5.33 as=0.825 ps=5.33 w=5 l=0.15
X267 a_n5096_n3348.t10 a_8793_n7303# sky130_fd_pr__cap_mim_m3_1 l=4.6 w=7.65
X268 a_n1027_n5343# cfg2 vss.t132 vss.t130 sky130_fd_pr__nfet_01v8 ad=0.165 pd=1.33 as=0.31 ps=2.62 w=1 l=0.15
X269 b3p a_n6092_3282.t18 a_n6951_n2210# vss.t48 sky130_fd_pr__nfet_01v8_lvt ad=0.495 pd=3.33 as=0.93 ps=6.62 w=3 l=0.15
X270 a_n8760_n4271.t10 a_n9593_n5343# sky130_fd_pr__cap_mim_m3_1 l=2 w=4.15
X271 a_n6092_3282.t10 a_n1627_n7303# sky130_fd_pr__cap_mim_m3_1 l=4.6 w=7.65
X272 a_4299_3370# a_n8760_3469.t19 a_1660_3469.t4 vss.t78 sky130_fd_pr__nfet_01v8_lvt ad=0.825 pd=5.33 as=0.825 ps=5.33 w=5 l=0.15
X273 vss.t190 cfg0 a_n977_n3903# vss.t189 sky130_fd_pr__nfet_01v8 ad=0.2325 pd=2.12 as=0.12375 ps=1.08 w=0.75 l=0.15
X274 a_n1227_n6123# cfg3 vss.t177 vss.t175 sky130_fd_pr__nfet_01v8 ad=0.33 pd=2.33 as=0.62 ps=4.62 w=2 l=0.15
X275 a_n9593_n7303# cfg4 vss.t252 vss.t232 sky130_fd_pr__nfet_01v8 ad=0.66 pd=4.33 as=1.24 ps=8.62 w=4 l=0.15
X276 a_4299_n4370# a_1660_3469.t17 a_n6092_n3348.t6 vss.t47 sky130_fd_pr__nfet_01v8_lvt ad=0.825 pd=5.33 as=0.825 ps=5.33 w=5 l=0.15
X277 a_n6951_1610# a_n5033_3370.t11 b0p vss.t41 sky130_fd_pr__nfet_01v8_lvt ad=0.93 pd=6.62 as=0.495 ps=3.33 w=3 l=0.15
X278 vss.t141 cfg3 a_n9593_1617# vss.t140 sky130_fd_pr__nfet_01v8 ad=0.62 pd=4.62 as=0.33 ps=2.33 w=2 l=0.15
X279 a_5324_n3348.t5 a_n5033_3370.t16 a_4299_3370# vss.t59 sky130_fd_pr__nfet_01v8_lvt ad=0.825 pd=5.33 as=0.825 ps=5.33 w=5 l=0.15
X280 vss.t203 cfg0 a_827_n3903# vss.t202 sky130_fd_pr__nfet_01v8 ad=0.2325 pd=2.12 as=0.12375 ps=1.08 w=0.75 l=0.15
X281 a_3469_1610# a_5324_n3348.t19 b1p vss.t45 sky130_fd_pr__nfet_01v8_lvt ad=0.93 pd=6.62 as=0.495 ps=3.33 w=3 l=0.15
X282 a_1660_3469.t25 ctrl.t40 vss sky130_fd_pr__cap_var_lvt w=5.2 l=0.5
X283 vss.t98 cfg2 a_n9593_5277# vss.t97 sky130_fd_pr__nfet_01v8 ad=0.31 pd=2.62 as=0.165 ps=1.33 w=1 l=0.15
X284 a_n8760_3469.t10 a_n9593_3837# sky130_fd_pr__cap_mim_m3_1 l=2 w=2
X285 vss.t282 cfg1 a_827_4557# vss.t281 sky130_fd_pr__nfet_01v8 ad=0.2325 pd=2.12 as=0.12375 ps=1.08 w=0.75 l=0.15
X286 a_4299_n4370# a_1660_3469.t11 a_n6092_n3348.t1 vss.t17 sky130_fd_pr__nfet_01v8_lvt ad=1.55 pd=10.62 as=0.825 ps=5.33 w=5 l=0.15
X287 a_n8760_n4271.t10 a_n9593_n6123# sky130_fd_pr__cap_mim_m3_1 l=2.6 w=6.58
X288 a_n9593_n2463# cfg2 vss.t120 vss.t107 sky130_fd_pr__nfet_01v8 ad=0.165 pd=1.33 as=0.31 ps=2.62 w=1 l=0.15
X289 vss.t101 cfg2 a_n1027_5277# vss.t100 sky130_fd_pr__nfet_01v8 ad=0.31 pd=2.62 as=0.165 ps=1.33 w=1 l=0.15
X290 a_n6092_n3348.t4 a_1660_3469.t12 a_4299_n4370# vss.t39 sky130_fd_pr__nfet_01v8_lvt ad=0.825 pd=5.33 as=0.825 ps=5.33 w=5 l=0.15
X291 a_n9593_n6123# cfg3 vss.t174 vss.t159 sky130_fd_pr__nfet_01v8 ad=0.33 pd=2.33 as=0.62 ps=4.62 w=2 l=0.15
X292 a_n5033_3370.t8 a_n8760_n4271.t20 a_n6121_3370# vss.t5 sky130_fd_pr__nfet_01v8_lvt ad=0.825 pd=5.33 as=0.825 ps=5.33 w=5 l=0.15
X293 a_n5033_3370.t10 a_n1227_1617# sky130_fd_pr__cap_mim_m3_1 l=2.6 w=6.58
X294 vss.t255 cfg4 a_8793_n7303# vss.t254 sky130_fd_pr__nfet_01v8 ad=1.24 pd=8.62 as=0.66 ps=4.33 w=4 l=0.15
X295 a_827_n7303# cfg4 vss.t258 vss.t256 sky130_fd_pr__nfet_01v8 ad=0.66 pd=4.33 as=1.24 ps=8.62 w=4 l=0.15
X296 a_n6121_3370# a_n6092_3282.t23 a_n8760_3469.t5 vss.t76 sky130_fd_pr__nfet_01v8_lvt ad=0.825 pd=5.33 as=0.825 ps=5.33 w=5 l=0.15
X297 b0n a_n8760_3469.t12 a_n6951_1610# vss.t20 sky130_fd_pr__nfet_01v8_lvt ad=0.495 pd=3.33 as=0.495 ps=3.33 w=3 l=0.15
X298 a_n6092_n3348.t12 ctrl.t6 vss sky130_fd_pr__cap_var_lvt w=5.2 l=0.5
X299 a_n9593_n3183# cfg1 vss.t289 vss.t273 sky130_fd_pr__nfet_01v8 ad=0.12375 pd=1.08 as=0.2325 ps=2.12 w=0.75 l=0.15
X300 vss.t248 cfg4 a_827_n643# vss.t228 sky130_fd_pr__nfet_01v8 ad=1.24 pd=8.62 as=0.66 ps=4.33 w=4 l=0.15
X301 a_n5096_n3348.t9 a_5324_n3348.t18 a_4299_n4370# vss.t215 sky130_fd_pr__nfet_01v8_lvt ad=0.825 pd=5.33 as=1.55 ps=10.62 w=5 l=0.15
X302 a_n8760_n4271.t10 a_n9593_n3183# sky130_fd_pr__cap_mim_m3_1 l=2 w=2
X303 a_1660_3469.t5 a_n8760_3469.t16 a_4299_3370# vss.t79 sky130_fd_pr__nfet_01v8_lvt ad=0.825 pd=5.33 as=0.825 ps=5.33 w=5 l=0.15
X304 a_n6092_n3348.t10 a_827_n1683# sky130_fd_pr__cap_mim_m3_1 l=2.6 w=6.58
X305 a_827_n2463# cfg2 vss.t126 vss.t115 sky130_fd_pr__nfet_01v8 ad=0.165 pd=1.33 as=0.31 ps=2.62 w=1 l=0.15
X306 a_n8760_n4271.t1 vdd_q vss.t87 sky130_fd_pr__res_high_po_2p85 l=4.77
X307 vss.t299 cfg1 a_9443_n4623# vss.t298 sky130_fd_pr__nfet_01v8 ad=0.2325 pd=2.12 as=0.12375 ps=1.08 w=0.75 l=0.15
X308 a_827_n6123# cfg3 vss.t180 vss.t178 sky130_fd_pr__nfet_01v8 ad=0.33 pd=2.33 as=0.62 ps=4.62 w=2 l=0.15
X309 a_4299_n4370# a_5324_n3348.t13 a_n5096_n3348.t0 vss.t4 sky130_fd_pr__nfet_01v8_lvt ad=0.825 pd=5.33 as=0.825 ps=5.33 w=5 l=0.15
X310 a_n977_n3183# cfg1 vss.t290 vss.t268 sky130_fd_pr__nfet_01v8 ad=0.12375 pd=1.08 as=0.2325 ps=2.12 w=0.75 l=0.15
X311 a_n6092_n3348.t3 a_1660_3469.t16 a_4299_n4370# vss.t22 sky130_fd_pr__nfet_01v8_lvt ad=0.825 pd=5.33 as=0.825 ps=5.33 w=5 l=0.15
X312 a_9393_2397# cfg2 vss.t119 vss.t113 sky130_fd_pr__nfet_01v8 ad=0.165 pd=1.33 as=0.31 ps=2.62 w=1 l=0.15
X313 a_n977_4557# cfg1 vss.t265 vss.t263 sky130_fd_pr__nfet_01v8 ad=0.12375 pd=1.08 as=0.2325 ps=2.12 w=0.75 l=0.15
X314 a_5324_n3348.t10 a_8793_7237# sky130_fd_pr__cap_mim_m3_1 l=4.6 w=7.65
X315 a_n6092_3282.t12 ctrl.t34 vss sky130_fd_pr__cap_var_lvt w=5.2 l=0.5
X316 a_827_n3183# cfg1 vss.t292 vss.t277 sky130_fd_pr__nfet_01v8 ad=0.12375 pd=1.08 as=0.2325 ps=2.12 w=0.75 l=0.15
X317 a_n9593_n643# cfg4 vss.t245 vss.t234 sky130_fd_pr__nfet_01v8 ad=0.66 pd=4.33 as=1.24 ps=8.62 w=4 l=0.15
X318 a_827_7237# cfg4 vss.t224 vss.t222 sky130_fd_pr__nfet_01v8 ad=0.66 pd=4.33 as=1.24 ps=8.62 w=4 l=0.15
X319 a_n6092_3282.t10 a_n1027_n5343# sky130_fd_pr__cap_mim_m3_1 l=2 w=4.15
X320 vss.t307 vbias_q a_n6951_1610# vss.t308 sky130_fd_pr__nfet_01v8 ad=0.87 pd=6.58 as=0.435 ps=3.29 w=3 l=0.5
X321 a_n6121_3370# a_n8760_n4271.t23 a_n5033_3370.t5 vss.t10 sky130_fd_pr__nfet_01v8_lvt ad=0.825 pd=5.33 as=0.825 ps=5.33 w=5 l=0.15
X322 a_5324_n3348.t10 a_9193_1617# sky130_fd_pr__cap_mim_m3_1 l=2.6 w=6.58
X323 a_n9593_3837# cfg0 vss.t186 vss.t184 sky130_fd_pr__nfet_01v8 ad=0.12375 pd=1.08 as=0.2325 ps=2.12 w=0.75 l=0.15
X324 a_n8760_n4271.t0 vdd_q vss.t86 sky130_fd_pr__res_high_po_2p85 l=4.77
X325 a_n6092_3282.t10 a_n977_n3903# sky130_fd_pr__cap_mim_m3_1 l=2 w=2
X326 a_9443_n3903# cfg0 vss.t207 vss.t205 sky130_fd_pr__nfet_01v8 ad=0.12375 pd=1.08 as=0.2325 ps=2.12 w=0.75 l=0.15
X327 vss.t250 cfg4 a_8793_n643# vss.t242 sky130_fd_pr__nfet_01v8 ad=1.24 pd=8.62 as=0.66 ps=4.33 w=4 l=0.15
X328 a_5324_n3348.t9 a_n5033_3370.t20 a_4299_3370# vss.t83 sky130_fd_pr__nfet_01v8_lvt ad=0.825 pd=5.33 as=0.825 ps=5.33 w=5 l=0.15
X329 a_n9593_3117# cfg1 vss.t276 vss.t273 sky130_fd_pr__nfet_01v8 ad=0.12375 pd=1.08 as=0.2325 ps=2.12 w=0.75 l=0.15
X330 a_827_577# cfg4 vss.t241 vss.t228 sky130_fd_pr__nfet_01v8 ad=0.66 pd=4.33 as=1.24 ps=8.62 w=4 l=0.15
X331 a_827_2397# cfg2 vss.t118 vss.t115 sky130_fd_pr__nfet_01v8 ad=0.165 pd=1.33 as=0.31 ps=2.62 w=1 l=0.15
X332 a_n8760_n4271.t10 a_n9593_n1683# sky130_fd_pr__cap_mim_m3_1 l=2.6 w=6.58
X333 a_5324_n3348.t10 a_9393_5277# sky130_fd_pr__cap_mim_m3_1 l=2 w=4.15
X334 a_827_6057# cfg3 vss.t152 vss.t150 sky130_fd_pr__nfet_01v8 ad=0.33 pd=2.33 as=0.62 ps=4.62 w=2 l=0.15
X335 a_n6951_n2210# a_n6092_3282.t15 b3p vss.t41 sky130_fd_pr__nfet_01v8_lvt ad=0.93 pd=6.62 as=0.495 ps=3.33 w=3 l=0.15
X336 vss.t170 cfg3 a_9193_n1683# vss.t157 sky130_fd_pr__nfet_01v8 ad=0.62 pd=4.62 as=0.33 ps=2.33 w=2 l=0.15
X337 a_n1027_n2463# cfg2 vss.t124 vss.t110 sky130_fd_pr__nfet_01v8 ad=0.165 pd=1.33 as=0.31 ps=2.62 w=1 l=0.15
X338 a_1660_3469.t0 a_n8760_3469.t22 a_4299_3370# vss.t28 sky130_fd_pr__nfet_01v8_lvt ad=0.825 pd=5.33 as=1.55 ps=10.62 w=5 l=0.15
X339 vss.t197 cfg0 a_n977_3837# vss.t196 sky130_fd_pr__nfet_01v8 ad=0.2325 pd=2.12 as=0.12375 ps=1.08 w=0.75 l=0.15
X340 vss.t217 cfg4 a_n9593_7237# vss.t216 sky130_fd_pr__nfet_01v8 ad=1.24 pd=8.62 as=0.66 ps=4.33 w=4 l=0.15
X341 a_n5096_n3348.t10 a_9193_n6123# sky130_fd_pr__cap_mim_m3_1 l=2.6 w=6.58
X342 a_1660_3469.t10 a_827_7237# sky130_fd_pr__cap_mim_m3_1 l=4.6 w=7.65
X343 a_1660_3469.t10 a_827_1617# sky130_fd_pr__cap_mim_m3_1 l=2.6 w=6.58
X344 a_4299_n4370# a_5324_n3348.t17 a_n5096_n3348.t2 vss.t32 sky130_fd_pr__nfet_01v8_lvt ad=0.825 pd=5.33 as=0.825 ps=5.33 w=5 l=0.15
X345 b2n vdd_q vss.t92 sky130_fd_pr__res_high_po_2p85 l=4.22
X346 a_n8760_n4271.t2 a_n6092_n3348.t22 a_n6121_n4370# vss.t18 sky130_fd_pr__nfet_01v8_lvt ad=0.825 pd=5.33 as=1.55 ps=10.62 w=5 l=0.15
X347 a_3469_1610# a_1660_3469.t21 b1n vss.t42 sky130_fd_pr__nfet_01v8_lvt ad=0.495 pd=3.33 as=0.495 ps=3.33 w=3 l=0.15
X348 a_1660_3469.t26 ctrl.t2 vss sky130_fd_pr__cap_var_lvt w=5.2 l=0.5
X349 a_n6092_n3348.t11 ctrl.t14 vss sky130_fd_pr__cap_var_lvt w=5.2 l=0.5
X350 vss.t328 vbias_q a_n6121_n4370# vss.t313 sky130_fd_pr__nfet_01v8 ad=1.827 pd=13.18 as=0.9135 ps=6.59 w=6.3 l=0.5
X351 vss.t280 cfg1 a_n977_3117# vss.t268 sky130_fd_pr__nfet_01v8 ad=0.2325 pd=2.12 as=0.12375 ps=1.08 w=0.75 l=0.15
X352 b1p a_5324_n3348.t22 a_3469_1610# vss.t13 sky130_fd_pr__nfet_01v8_lvt ad=0.495 pd=3.33 as=0.93 ps=6.62 w=3 l=0.15
X353 a_n6092_3282.t6 a_n5096_n3348.t18 a_n6121_n4370# vss.t64 sky130_fd_pr__nfet_01v8_lvt ad=0.825 pd=5.33 as=0.825 ps=5.33 w=5 l=0.15
X354 a_n8760_n4271.t12 ctrl.t60 vss sky130_fd_pr__cap_var_lvt w=5.2 l=0.5
X355 a_4299_3370# a_n8760_3469.t15 a_1660_3469.t7 vss.t82 sky130_fd_pr__nfet_01v8_lvt ad=1.55 pd=10.62 as=0.825 ps=5.33 w=5 l=0.15
X356 a_1660_3469.t24 ctrl.t56 vss sky130_fd_pr__cap_var_lvt w=5.2 l=0.5
X357 a_n6121_3370# a_n6092_3282.t19 a_n8760_3469.t9 vss.t58 sky130_fd_pr__nfet_01v8_lvt ad=1.55 pd=10.62 as=0.825 ps=5.33 w=5 l=0.15
X358 a_n6092_n3348.t13 ctrl.t0 vss sky130_fd_pr__cap_var_lvt w=5.2 l=0.5
X359 a_8793_7237# cfg4 vss.t227 vss.t225 sky130_fd_pr__nfet_01v8 ad=0.66 pd=4.33 as=1.24 ps=8.62 w=4 l=0.15
X360 a_n8760_3469.t10 a_n9593_2397# sky130_fd_pr__cap_mim_m3_1 l=2 w=4.15
X361 a_n5033_3370.t10 a_n977_3117# sky130_fd_pr__cap_mim_m3_1 l=2 w=2
X362 a_n1227_1617# cfg3 vss.t164 vss.t142 sky130_fd_pr__nfet_01v8 ad=0.33 pd=2.33 as=0.62 ps=4.62 w=2 l=0.15
X363 vss.t109 cfg2 a_n9593_2397# vss.t107 sky130_fd_pr__nfet_01v8 ad=0.31 pd=2.62 as=0.165 ps=1.33 w=1 l=0.15
X364 a_n5096_n3348.t1 a_5324_n3348.t12 a_4299_n4370# vss.t31 sky130_fd_pr__nfet_01v8_lvt ad=0.825 pd=5.33 as=0.825 ps=5.33 w=5 l=0.15
X365 a_n8760_3469.t25 ctrl.t38 vss sky130_fd_pr__cap_var_lvt w=5.2 l=0.5
X366 vss.t145 cfg3 a_n9593_6057# vss.t144 sky130_fd_pr__nfet_01v8 ad=0.62 pd=4.62 as=0.33 ps=2.33 w=2 l=0.15
X367 a_3469_n2210# a_n5096_n3348.t23 b2p vss.t45 sky130_fd_pr__nfet_01v8_lvt ad=0.93 pd=6.62 as=0.495 ps=3.33 w=3 l=0.15
X368 vss.t143 cfg3 a_n1227_n1683# vss.t142 sky130_fd_pr__nfet_01v8 ad=0.62 pd=4.62 as=0.33 ps=2.33 w=2 l=0.15
X369 vss.t111 cfg2 a_n1027_2397# vss.t110 sky130_fd_pr__nfet_01v8 ad=0.31 pd=2.62 as=0.165 ps=1.33 w=1 l=0.15
X370 a_n8760_3469.t2 a_n6092_3282.t26 a_n6121_3370# vss.t37 sky130_fd_pr__nfet_01v8_lvt ad=0.825 pd=5.33 as=1.55 ps=10.62 w=5 l=0.15
X371 a_n5096_n3348.t10 a_9443_n3903# sky130_fd_pr__cap_mim_m3_1 l=2 w=2
X372 a_n8760_3469.t10 a_n9593_1617# sky130_fd_pr__cap_mim_m3_1 l=2.6 w=6.58
X373 vss.t332 vbias_q a_n6951_n2210# vss.t316 sky130_fd_pr__nfet_01v8 ad=0.87 pd=6.58 as=0.435 ps=3.29 w=3 l=0.5
X374 a_4299_3370# a_n5033_3370.t17 a_5324_n3348.t2 vss.t24 sky130_fd_pr__nfet_01v8_lvt ad=0.825 pd=5.33 as=0.825 ps=5.33 w=5 l=0.15
X375 a_n6121_n4370# vbias_q vss.t328 vss.t312 sky130_fd_pr__nfet_01v8 ad=0.9135 pd=6.59 as=0.9135 ps=6.59 w=6.3 l=0.5
X376 vss.t271 cfg1 a_n9593_n4623# vss.t270 sky130_fd_pr__nfet_01v8 ad=0.2325 pd=2.12 as=0.12375 ps=1.08 w=0.75 l=0.15
X377 vss.t267 cfg1 a_9443_4557# vss.t266 sky130_fd_pr__nfet_01v8 ad=0.2325 pd=2.12 as=0.12375 ps=1.08 w=0.75 l=0.15
X378 vss.t137 cfg2 a_9393_n5343# vss.t136 sky130_fd_pr__nfet_01v8 ad=0.31 pd=2.62 as=0.165 ps=1.33 w=1 l=0.15
X379 a_n6092_3282.t11 ctrl.t24 vss sky130_fd_pr__cap_var_lvt w=5.2 l=0.5
X380 a_1660_3469.t10 a_827_577# sky130_fd_pr__cap_mim_m3_1 l=4.6 w=7.65
X381 a_n6092_3282.t13 ctrl.t8 vss sky130_fd_pr__cap_var_lvt w=5.2 l=0.5
X382 b2p vdd_q vss.t139 sky130_fd_pr__res_high_po_2p85 l=4.22
X383 a_3469_n2210# a_n6092_n3348.t23 b2n vss.t0 sky130_fd_pr__nfet_01v8_lvt ad=0.93 pd=6.62 as=0.495 ps=3.33 w=3 l=0.15
X384 a_5324_n3348.t10 a_9443_3117# sky130_fd_pr__cap_mim_m3_1 l=2 w=2
X385 vss.t96 cfg2 a_9393_5277# vss.t95 sky130_fd_pr__nfet_01v8 ad=0.31 pd=2.62 as=0.165 ps=1.33 w=1 l=0.15
X386 vss.t231 cfg4 a_n1627_n7303# vss.t230 sky130_fd_pr__nfet_01v8 ad=1.24 pd=8.62 as=0.66 ps=4.33 w=4 l=0.15
X387 a_n6121_n4370# a_n6092_n3348.t17 a_n8760_n4271.t7 vss.t33 sky130_fd_pr__nfet_01v8_lvt ad=0.825 pd=5.33 as=0.825 ps=5.33 w=5 l=0.15
X388 vss.t167 cfg3 a_n9593_n1683# vss.t140 sky130_fd_pr__nfet_01v8 ad=0.62 pd=4.62 as=0.33 ps=2.33 w=2 l=0.15
X389 a_3469_n2210# vbias_q vss.t340 vss.t324 sky130_fd_pr__nfet_01v8 ad=0.435 pd=3.29 as=0.87 ps=6.58 w=3 l=0.5
X390 vss.t294 cfg1 a_n977_n4623# vss.t293 sky130_fd_pr__nfet_01v8 ad=0.2325 pd=2.12 as=0.12375 ps=1.08 w=0.75 l=0.15
X391 a_n6092_3282.t10 a_n977_n4623# sky130_fd_pr__cap_mim_m3_1 l=2 w=2
X392 a_n6951_n2210# vbias_q vss.t332 vss.t314 sky130_fd_pr__nfet_01v8 ad=0.435 pd=3.29 as=0.87 ps=6.58 w=3 l=0.5
X393 a_n8760_3469.t6 a_n6092_3282.t22 a_n6121_3370# vss.t61 sky130_fd_pr__nfet_01v8_lvt ad=0.825 pd=5.33 as=0.825 ps=5.33 w=5 l=0.15
X394 vdd_q a_5324_n3348.t7 vss.t71 sky130_fd_pr__res_high_po_2p85 l=4.77
X395 a_n5033_3370.t10 a_n1627_577# sky130_fd_pr__cap_mim_m3_1 l=4.6 w=7.65
X396 vss.t297 cfg1 a_827_n4623# vss.t296 sky130_fd_pr__nfet_01v8 ad=0.2325 pd=2.12 as=0.12375 ps=1.08 w=0.75 l=0.15
X397 vss.t162 cfg3 a_827_1617# vss.t161 sky130_fd_pr__nfet_01v8 ad=0.62 pd=4.62 as=0.33 ps=2.33 w=2 l=0.15
X398 a_n6951_1610# a_n8760_3469.t11 b0n vss.t34 sky130_fd_pr__nfet_01v8_lvt ad=0.93 pd=6.62 as=0.495 ps=3.33 w=3 l=0.15
X399 a_n9593_n3903# cfg0 vss.t200 vss.t191 sky130_fd_pr__nfet_01v8 ad=0.12375 pd=1.08 as=0.2325 ps=2.12 w=0.75 l=0.15
R0 ctrl.n99 ctrl.n7 17.3589
R1 ctrl.n100 ctrl.n98 180.126
R2 ctrl.n102 ctrl.n4 180.126
R3 ctrl.n72 ctrl.n104 180.126
R4 ctrl.n107 ctrl.n103 180.126
R5 ctrl.n89 ctrl.n88 180.126
R6 ctrl.n85 ctrl.n84 180.126
R7 ctrl.n96 ctrl.n95 180.126
R8 ctrl.n92 ctrl.n91 180.126
R9 ctrl.n126 ctrl.n124 180.126
R10 ctrl.n129 ctrl.n123 180.126
R11 ctrl.n75 ctrl.n132 180.126
R12 ctrl.n134 ctrl.n131 180.126
R13 ctrl.n78 ctrl.n115 180.126
R14 ctrl.n113 ctrl.n112 180.126
R15 ctrl.n121 ctrl.n120 180.126
R16 ctrl.n117 ctrl.n81 180.126
R17 ctrl.n101 ctrl.n98 165.897
R18 ctrl.n102 ctrl.n101 165.897
R19 ctrl.n106 ctrl.n104 165.897
R20 ctrl.n107 ctrl.n106 165.897
R21 ctrl.n88 ctrl.n83 165.897
R22 ctrl.n85 ctrl.n83 165.897
R23 ctrl.n95 ctrl.n90 165.897
R24 ctrl.n92 ctrl.n90 165.897
R25 ctrl.n128 ctrl.n124 165.897
R26 ctrl.n129 ctrl.n128 165.897
R27 ctrl.n133 ctrl.n132 165.897
R28 ctrl.n134 ctrl.n133 165.897
R29 ctrl.n115 ctrl.n111 165.897
R30 ctrl.n113 ctrl.n111 165.897
R31 ctrl.n120 ctrl.n116 165.897
R32 ctrl.n117 ctrl.n116 165.897
R33 ctrl.n74 ctrl.n19 16.84
R34 ctrl.n127 ctrl.n23 14.542
R35 ctrl.n77 ctrl.n29 17.3594
R36 ctrl.n80 ctrl.n35 16.84
R37 ctrl ctrl.n137 32.6256
R38 ctrl.n71 ctrl.n102 14.2313
R39 ctrl.n101 ctrl.n70 14.2313
R40 ctrl.n99 ctrl.n98 14.2313
R41 ctrl.n108 ctrl.n107 14.2313
R42 ctrl.n106 ctrl.n105 14.2313
R43 ctrl.n2 ctrl.n104 14.2313
R44 ctrl.n86 ctrl.n85 14.2313
R45 ctrl.n87 ctrl.n83 14.2313
R46 ctrl.n88 ctrl.n73 14.2313
R47 ctrl.n93 ctrl.n92 14.2313
R48 ctrl.n74 ctrl.n90 14.2313
R49 ctrl.n95 ctrl.n94 14.2313
R50 ctrl.n130 ctrl.n129 14.2313
R51 ctrl.n128 ctrl.n127 14.2313
R52 ctrl.n125 ctrl.n124 14.2313
R53 ctrl.n135 ctrl.n134 14.2313
R54 ctrl.n133 ctrl.n76 14.2313
R55 ctrl.n77 ctrl.n132 14.2313
R56 ctrl.n80 ctrl.n113 14.2313
R57 ctrl.n114 ctrl.n111 14.2313
R58 ctrl.n115 ctrl.n79 14.2313
R59 ctrl.n82 ctrl.n117 14.2313
R60 ctrl.n118 ctrl.n116 14.2313
R61 ctrl.n120 ctrl.n119 14.2313
R62 ctrl.n6 ctrl.n70 14.5423
R63 ctrl.n0 ctrl.n105 17.0146
R64 ctrl.n86 ctrl.n15 16.84
R65 ctrl.n126 ctrl.n22 16.8401
R66 ctrl.n75 ctrl.n27 16.84
R67 ctrl.n28 ctrl.n76 14.5424
R68 ctrl.n30 ctrl.n135 16.84
R69 ctrl.n78 ctrl.n32 16.84
R70 ctrl.n109 ctrl.n45 8.41145
R71 ctrl.n97 ctrl.n50 8.41145
R72 ctrl.n136 ctrl.n59 8.41145
R73 ctrl.n122 ctrl.n66 8.41145
R74 ctrl.n109 ctrl.n42 7.84745
R75 ctrl.n97 ctrl.n46 7.84745
R76 ctrl.n136 ctrl.n55 7.84745
R77 ctrl.n122 ctrl.n62 7.84745
R78 ctrl.n4 ctrl.t16 7.73127
R79 ctrl.n100 ctrl.t58 7.73127
R80 ctrl.t58 ctrl.n99 7.73127
R81 ctrl.n99 ctrl.t12 7.73127
R82 ctrl.n70 ctrl.t12 7.73127
R83 ctrl.n70 ctrl.t48 7.73127
R84 ctrl.n71 ctrl.t48 7.73127
R85 ctrl.n71 ctrl.t16 7.73127
R86 ctrl.n103 ctrl.t50 7.73127
R87 ctrl.t14 ctrl.n72 7.73127
R88 ctrl.n2 ctrl.t14 7.73127
R89 ctrl.n2 ctrl.t6 7.73127
R90 ctrl.n105 ctrl.t6 7.73127
R91 ctrl.n105 ctrl.t0 7.73127
R92 ctrl.n108 ctrl.t0 7.73127
R93 ctrl.n108 ctrl.t50 7.73127
R94 ctrl.n84 ctrl.t26 7.73127
R95 ctrl.n89 ctrl.t54 7.73127
R96 ctrl.n73 ctrl.t54 7.73127
R97 ctrl.n73 ctrl.t4 7.73127
R98 ctrl.n87 ctrl.t4 7.73127
R99 ctrl.n87 ctrl.t62 7.73127
R100 ctrl.t62 ctrl.n86 7.73127
R101 ctrl.n86 ctrl.t26 7.73127
R102 ctrl.n91 ctrl.t2 7.73127
R103 ctrl.n96 ctrl.t28 7.73127
R104 ctrl.n94 ctrl.t28 7.73127
R105 ctrl.n94 ctrl.t56 7.73127
R106 ctrl.n74 ctrl.t56 7.73127
R107 ctrl.n74 ctrl.t40 7.73127
R108 ctrl.t40 ctrl.n93 7.73127
R109 ctrl.n93 ctrl.t2 7.73127
R110 ctrl.n123 ctrl.t32 7.73127
R111 ctrl.n126 ctrl.t24 7.73127
R112 ctrl.t24 ctrl.n125 7.73127
R113 ctrl.n125 ctrl.t34 7.73127
R114 ctrl.n127 ctrl.t34 7.73127
R115 ctrl.n127 ctrl.t8 7.73127
R116 ctrl.n130 ctrl.t8 7.73127
R117 ctrl.n130 ctrl.t32 7.73127
R118 ctrl.n131 ctrl.t52 7.73127
R119 ctrl.t30 ctrl.n75 7.73127
R120 ctrl.n77 ctrl.t30 7.73127
R121 ctrl.n77 ctrl.t60 7.73127
R122 ctrl.n76 ctrl.t60 7.73127
R123 ctrl.n76 ctrl.t10 7.73127
R124 ctrl.n135 ctrl.t10 7.73127
R125 ctrl.n135 ctrl.t52 7.73127
R126 ctrl.n112 ctrl.t20 7.73127
R127 ctrl.n78 ctrl.t42 7.73127
R128 ctrl.n79 ctrl.t42 7.73127
R129 ctrl.n79 ctrl.t22 7.73127
R130 ctrl.n114 ctrl.t22 7.73127
R131 ctrl.n114 ctrl.t18 7.73127
R132 ctrl.t18 ctrl.n80 7.73127
R133 ctrl.n80 ctrl.t20 7.73127
R134 ctrl.n81 ctrl.t46 7.73127
R135 ctrl.n121 ctrl.t36 7.73127
R136 ctrl.n119 ctrl.t36 7.73127
R137 ctrl.n119 ctrl.t44 7.73127
R138 ctrl.n118 ctrl.t44 7.73127
R139 ctrl.n118 ctrl.t38 7.73127
R140 ctrl.t38 ctrl.n82 7.73127
R141 ctrl.n82 ctrl.t46 7.73127
R142 ctrl.n110 ctrl.n97 6.44722
R143 ctrl.n137 ctrl.n122 6.44722
R144 ctrl.n110 ctrl.n109 4.8675
R145 ctrl.n137 ctrl.n136 4.8675
R146 ctrl.n42 ctrl.n8 0.717753
R147 ctrl.n71 ctrl.n8 16.84
R148 ctrl.n4 ctrl.n3 16.8399
R149 ctrl.n6 ctrl.n41 5.25785
R150 ctrl.n44 ctrl.n6 5.38396
R151 ctrl.n100 ctrl.n5 16.8399
R152 ctrl.n10 ctrl.n108 16.8401
R153 ctrl.n10 ctrl.n1 0.717755
R154 ctrl.n103 ctrl.n9 16.8401
R155 ctrl.n72 ctrl.n0 17.3997
R156 ctrl.n73 ctrl.n13 16.8401
R157 ctrl.n48 ctrl.n13 0.734941
R158 ctrl.n14 ctrl.n87 16.8401
R159 ctrl.n14 ctrl.n49 0.71775
R160 ctrl.n15 ctrl.n47 0.734942
R161 ctrl.n11 ctrl.n84 16.8399
R162 ctrl.n12 ctrl.n89 16.8401
R163 ctrl.n94 ctrl.n18 16.8399
R164 ctrl.n52 ctrl.n18 0.717754
R165 ctrl.n19 ctrl.n53 0.734942
R166 ctrl.n20 ctrl.n93 16.8398
R167 ctrl.n20 ctrl.n51 0.717753
R168 ctrl.n91 ctrl.n16 16.8397
R169 ctrl.n96 ctrl.n17 16.8397
R170 ctrl.n55 ctrl.n25 0.717755
R171 ctrl.n130 ctrl.n25 16.8401
R172 ctrl.n123 ctrl.n21 16.84
R173 ctrl.n54 ctrl.n23 5.25788
R174 ctrl.n23 ctrl.n57 5.38394
R175 ctrl.n59 ctrl.n30 0.73494
R176 ctrl.n131 ctrl.n26 16.8401
R177 ctrl.n61 ctrl.n28 5.25786
R178 ctrl.n28 ctrl.n58 5.38395
R179 ctrl.n62 ctrl.n33 0.717753
R180 ctrl.n79 ctrl.n33 16.84
R181 ctrl.n34 ctrl.n114 16.8398
R182 ctrl.n34 ctrl.n65 0.717753
R183 ctrl.n35 ctrl.n63 0.73494
R184 ctrl.n112 ctrl.n31 16.8399
R185 ctrl.n119 ctrl.n38 16.8397
R186 ctrl.n68 ctrl.n38 0.717753
R187 ctrl.n39 ctrl.n118 16.8398
R188 ctrl.n39 ctrl.n69 0.734938
R189 ctrl.n40 ctrl.n82 16.8401
R190 ctrl.n40 ctrl.n67 0.71775
R191 ctrl.n36 ctrl.n81 16.84
R192 ctrl.n121 ctrl.n37 16.8397
R193 ctrl ctrl.n110 3.71469
R194 ctrl.n8 ctrl.n43 0.734938
R195 ctrl.n3 ctrl.n42 1.68736
R196 ctrl.n41 ctrl.n7 0.524524
R197 ctrl.n5 ctrl.n41 1.51463
R198 ctrl.n45 ctrl.n10 0.734936
R199 ctrl.n46 ctrl.n13 0.71775
R200 ctrl.n49 ctrl.n15 1.51462
R201 ctrl.n11 ctrl.n49 1.51462
R202 ctrl.n46 ctrl.n12 1.68737
R203 ctrl.n50 ctrl.n18 0.734937
R204 ctrl.n51 ctrl.n19 1.64744
R205 ctrl.n51 ctrl.n16 1.51463
R206 ctrl.n17 ctrl.n52 1.51463
R207 ctrl.n25 ctrl.n56 0.734936
R208 ctrl.n21 ctrl.n55 1.68737
R209 ctrl.n24 ctrl.n54 0.524525
R210 ctrl.n30 ctrl.n60 0.717751
R211 ctrl.n29 ctrl.n61 0.570446
R212 ctrl.n64 ctrl.n33 0.734938
R213 ctrl.n65 ctrl.n35 1.51463
R214 ctrl.n65 ctrl.n31 1.51462
R215 ctrl.n66 ctrl.n38 0.734938
R216 ctrl.n67 ctrl.n39 1.64744
R217 ctrl.n37 ctrl.n68 1.51463
R218 ctrl.n68 ctrl.n67 1.12941
R219 ctrl.n64 ctrl.n63 1.12941
R220 ctrl.n61 ctrl.n60 1.12941
R221 ctrl.n57 ctrl.n56 1.12941
R222 ctrl.n52 ctrl.n51 1.12941
R223 ctrl.n48 ctrl.n47 1.12941
R224 ctrl.n0 ctrl.n1 1.12941
R225 ctrl.n44 ctrl.n43 1.12941
R226 ctrl.n69 ctrl.n66 1.05041
R227 ctrl.n65 ctrl.n62 1.05041
R228 ctrl.n59 ctrl.n58 1.05041
R229 ctrl.n55 ctrl.n54 1.05041
R230 ctrl.n53 ctrl.n50 1.05041
R231 ctrl.n49 ctrl.n46 1.05041
R232 ctrl.n42 ctrl.n41 1.05041
R233 ctrl.n66 ctrl.n37 1.70456
R234 ctrl.n62 ctrl.n32 1.68737
R235 ctrl.n59 ctrl.n26 1.70456
R236 ctrl.n50 ctrl.n17 1.70456
R237 ctrl.n45 ctrl.n9 1.70456
R238 ctrl.n63 ctrl.n34 1.66463
R239 ctrl.n57 ctrl.n24 0.576392
R240 ctrl.n47 ctrl.n14 1.66463
R241 ctrl.n0 ctrl.n2 17.3595
R242 ctrl.n44 ctrl.n7 0.576392
R243 ctrl.n43 ctrl.n3 1.53182
R244 ctrl.n44 ctrl.n5 1.53181
R245 ctrl.n1 ctrl.n9 1.51462
R246 ctrl.n11 ctrl.n47 1.53182
R247 ctrl.n48 ctrl.n12 1.53181
R248 ctrl.n16 ctrl.n53 1.53181
R249 ctrl.n56 ctrl.n21 1.53182
R250 ctrl.n57 ctrl.n22 1.53182
R251 ctrl.n54 ctrl.n22 1.51462
R252 ctrl.n60 ctrl.n26 1.51462
R253 ctrl.n27 ctrl.n58 1.53182
R254 ctrl.n61 ctrl.n27 1.51462
R255 ctrl.n31 ctrl.n63 1.53182
R256 ctrl.n64 ctrl.n32 1.53182
R257 ctrl.n36 ctrl.n67 1.51462
R258 ctrl.n36 ctrl.n69 1.53182
R259 ctrl.n69 ctrl.n40 1.53182
R260 ctrl.n58 ctrl.n29 0.530471
R261 ctrl.n125 ctrl.n24 17.359
R262 ctrl.n45 ctrl.n0 1.80331
R263 ctrl.n53 ctrl.n20 1.53181
R264 vss.n1660 vss.n1659 8036.44
R265 vss.n1659 vss.n622 8036.44
R266 vss.n1660 vss.n620 8036.44
R267 vss.n622 vss.n620 8036.44
R268 vss.n1289 vss.n1135 8036.44
R269 vss.n1285 vss.n1135 8036.44
R270 vss.n1290 vss.n1289 8036.44
R271 vss.n1290 vss.n1285 8036.44
R272 vss.n1328 vss.n1070 8036.44
R273 vss.n1332 vss.n1070 8036.44
R274 vss.n1328 vss.n1069 8036.44
R275 vss.n1332 vss.n1069 8036.44
R276 vss.n1074 vss.n1072 8036.44
R277 vss.n1073 vss.n1072 8036.44
R278 vss.n1078 vss.n1074 8036.44
R279 vss.n1078 vss.n1073 8036.44
R280 vss.n1403 vss.n973 8036.44
R281 vss.n975 vss.n973 8036.44
R282 vss.n1403 vss.n969 8036.44
R283 vss.n975 vss.n969 8036.44
R284 vss.n1410 vss.n968 8036.44
R285 vss.n1410 vss.n967 8036.44
R286 vss.n1409 vss.n968 8036.44
R287 vss.n1409 vss.n967 8036.44
R288 vss.n1718 vss.n1717 8036.44
R289 vss.n1722 vss.n1717 8036.44
R290 vss.n1718 vss.n1716 8036.44
R291 vss.n1722 vss.n1716 8036.44
R292 vss.n1890 vss.n582 8036.44
R293 vss.n1894 vss.n582 8036.44
R294 vss.n1890 vss.n580 8036.44
R295 vss.n1894 vss.n580 8036.44
R296 vss.n1784 vss.n1779 8036.44
R297 vss.n1780 vss.n1779 8036.44
R298 vss.n1784 vss.n1776 8036.44
R299 vss.n1780 vss.n1776 8036.44
R300 vss.n1791 vss.n1775 8036.44
R301 vss.n1791 vss.n1774 8036.44
R302 vss.n1790 vss.n1775 8036.44
R303 vss.n1790 vss.n1774 8036.44
R304 vss.n1281 vss.n1137 8036.44
R305 vss.n1277 vss.n1137 8036.44
R306 vss.n1281 vss.n1136 8036.44
R307 vss.n1277 vss.n1136 8036.44
R308 vss.n1302 vss.n1297 8036.44
R309 vss.n1298 vss.n1297 8036.44
R310 vss.n1302 vss.n1295 8036.44
R311 vss.n1298 vss.n1295 8036.44
R312 vss.n1307 vss.n1305 8036.44
R313 vss.n1311 vss.n1305 8036.44
R314 vss.n1307 vss.n1304 8036.44
R315 vss.n1311 vss.n1304 8036.44
R316 vss.n1651 vss.n628 8036.44
R317 vss.n1647 vss.n628 8036.44
R318 vss.n1651 vss.n627 8036.44
R319 vss.n1647 vss.n627 8036.44
R320 vss.n560 vss.n557 8036.44
R321 vss.n560 vss.n556 8036.44
R322 vss.n561 vss.n557 8036.44
R323 vss.n561 vss.n556 8036.44
R324 vss.n1925 vss.n549 8036.44
R325 vss.n1921 vss.n549 8036.44
R326 vss.n1925 vss.n548 8036.44
R327 vss.n1921 vss.n548 8036.44
R328 vss.n1342 vss.n1030 7717.77
R329 vss.n1346 vss.n1030 7717.77
R330 vss.n1342 vss.n1029 7717.77
R331 vss.n1346 vss.n1029 7717.77
R332 vss.n1335 vss.n1037 7717.77
R333 vss.n1335 vss.n1036 7717.77
R334 vss.n1339 vss.n1037 7717.77
R335 vss.n1339 vss.n1036 7717.77
R336 vss.n1467 vss.n1414 7717.77
R337 vss.n1467 vss.n1466 7717.77
R338 vss.n1466 vss.n1416 7717.77
R339 vss.n1416 vss.n1414 7717.77
R340 vss.n1888 vss.n1887 7717.77
R341 vss.n1888 vss.n1795 7717.77
R342 vss.n1887 vss.n1797 7717.77
R343 vss.n1797 vss.n1795 7717.77
R344 vss.n1880 vss.n1800 7717.77
R345 vss.n1884 vss.n1800 7717.77
R346 vss.n1880 vss.n1799 7717.77
R347 vss.n1884 vss.n1799 7717.77
R348 vss.n1725 vss.n599 7717.77
R349 vss.n1729 vss.n599 7717.77
R350 vss.n1725 vss.n598 7717.77
R351 vss.n1729 vss.n598 7717.77
R352 vss.n1459 vss.n1419 7717.77
R353 vss.n1463 vss.n1419 7717.77
R354 vss.n1459 vss.n1418 7717.77
R355 vss.n1463 vss.n1418 7717.77
R356 vss.n1734 vss.n596 7717.77
R357 vss.n1733 vss.n596 7717.77
R358 vss.n1738 vss.n1734 7717.77
R359 vss.n1738 vss.n1733 7717.77
R360 vss.n1974 vss.n546 7717.77
R361 vss.n1970 vss.n546 7717.77
R362 vss.n1974 vss.n545 7717.77
R363 vss.n1970 vss.n545 7717.77
R364 vss.n1982 vss.n544 7717.77
R365 vss.n1978 vss.n544 7717.77
R366 vss.n1982 vss.n543 7717.77
R367 vss.n1978 vss.n543 7717.77
R368 vss.n1266 vss.n1174 7717.77
R369 vss.n1262 vss.n1174 7717.77
R370 vss.n1266 vss.n1173 7717.77
R371 vss.n1262 vss.n1173 7717.77
R372 vss.n1274 vss.n1171 7717.77
R373 vss.n1274 vss.n1170 7717.77
R374 vss.n1270 vss.n1171 7717.77
R375 vss.n1270 vss.n1170 7717.77
R376 vss.n1569 vss.n890 7717.77
R377 vss.n1573 vss.n890 7717.77
R378 vss.n1573 vss.n889 7717.77
R379 vss.n1569 vss.n889 7717.77
R380 vss.n1582 vss.n888 7717.77
R381 vss.n1578 vss.n888 7717.77
R382 vss.n1582 vss.n887 7717.77
R383 vss.n1578 vss.n887 7717.77
R384 vss.n1636 vss.n636 7717.77
R385 vss.n1632 vss.n636 7717.77
R386 vss.n1636 vss.n635 7717.77
R387 vss.n1632 vss.n635 7717.77
R388 vss.n1644 vss.n632 7717.77
R389 vss.n1644 vss.n631 7717.77
R390 vss.n1640 vss.n632 7717.77
R391 vss.n1640 vss.n631 7717.77
R392 vss.n1507 vss.n948 6593.71
R393 vss.n971 vss.n948 6593.71
R394 vss.n1325 vss.n1323 6593.71
R395 vss.n1325 vss.n1080 6593.71
R396 vss.n2122 vss.n419 6593.71
R397 vss.n1777 vss.n419 6593.71
R398 vss.n1898 vss.n1897 6593.71
R399 vss.n1897 vss.n577 6593.71
R400 vss.n1314 vss.n1294 6593.71
R401 vss.n1314 vss.n949 6593.71
R402 vss.n1292 vss.n1132 6593.71
R403 vss.n1321 vss.n1132 6593.71
R404 vss.n1918 vss.n551 6593.71
R405 vss.n1918 vss.n420 6593.71
R406 vss.n1657 vss.n1655 6593.71
R407 vss.n1655 vss.n576 6593.71
R408 vss.n960 vss.n937 4670.06
R409 vss.n1088 vss.n937 4670.06
R410 vss.n1513 vss.n933 4670.06
R411 vss.n1513 vss.n934 4670.06
R412 vss.n427 vss.n407 4670.06
R413 vss.n567 vss.n407 4670.06
R414 vss.n573 vss.n408 4670.06
R415 vss.n429 vss.n408 4670.06
R416 vss.n952 vss.n936 4670.06
R417 vss.n1083 vss.n936 4670.06
R418 vss.n1082 vss.n938 4670.06
R419 vss.n951 vss.n938 4670.06
R420 vss.n2128 vss.n405 4670.06
R421 vss.n2128 vss.n404 4670.06
R422 vss.n422 vss.n409 4670.06
R423 vss.n571 vss.n409 4670.06
R424 vss.n1032 vss.n1012 4345.59
R425 vss.n1360 vss.n1012 4345.59
R426 vss.n1032 vss.n1011 4345.59
R427 vss.n1360 vss.n1011 4345.59
R428 vss.n1871 vss.n1864 4345.59
R429 vss.n1867 vss.n1864 4345.59
R430 vss.n1871 vss.n1863 4345.59
R431 vss.n1867 vss.n1863 4345.59
R432 vss.n1449 vss.n1448 4345.59
R433 vss.n1448 vss.n1447 4345.59
R434 vss.n1449 vss.n1444 4345.59
R435 vss.n1447 vss.n1444 4345.59
R436 vss.n1741 vss.n592 4345.59
R437 vss.n594 vss.n592 4345.59
R438 vss.n1755 vss.n1741 4345.59
R439 vss.n1755 vss.n594 4345.59
R440 vss.n2076 vss.n515 4345.59
R441 vss.n2077 vss.n515 4345.59
R442 vss.n2077 vss.n513 4345.59
R443 vss.n2076 vss.n513 4345.59
R444 vss.n1252 vss.n1251 4345.59
R445 vss.n1252 vss.n1247 4345.59
R446 vss.n1251 vss.n1248 4345.59
R447 vss.n1248 vss.n1247 4345.59
R448 vss.n1595 vss.n883 4345.59
R449 vss.n1595 vss.n885 4345.59
R450 vss.n1594 vss.n883 4345.59
R451 vss.n1594 vss.n885 4345.59
R452 vss.n733 vss.n731 4345.59
R453 vss.n732 vss.n731 4345.59
R454 vss.n747 vss.n733 4345.59
R455 vss.n747 vss.n732 4345.59
R456 vss.n1002 vss.n1000 4345.59
R457 vss.n1006 vss.n1000 4345.59
R458 vss.n1002 vss.n999 4345.59
R459 vss.n1006 vss.n999 4345.59
R460 vss.n842 vss.n831 4345.59
R461 vss.n842 vss.n833 4345.59
R462 vss.n835 vss.n831 4345.59
R463 vss.n835 vss.n833 4345.59
R464 vss.n707 vss.n393 4345.59
R465 vss.n708 vss.n707 4345.59
R466 vss.n713 vss.n393 4345.59
R467 vss.n713 vss.n708 4345.59
R468 vss.n2036 vss.n498 4345.59
R469 vss.n2041 vss.n2036 4345.59
R470 vss.n2037 vss.n498 4345.59
R471 vss.n2041 vss.n2037 4345.59
R472 vss.n997 vss.n993 4345.59
R473 vss.n998 vss.n997 4345.59
R474 vss.n993 vss.n992 4345.59
R475 vss.n998 vss.n992 4345.59
R476 vss.n837 vss.n834 4345.59
R477 vss.n836 vss.n834 4345.59
R478 vss.n841 vss.n837 4345.59
R479 vss.n841 vss.n836 4345.59
R480 vss.n2139 vss.n396 4345.59
R481 vss.n398 vss.n396 4345.59
R482 vss.n2139 vss.n395 4345.59
R483 vss.n398 vss.n395 4345.59
R484 vss.n2035 vss.n493 4345.59
R485 vss.n2043 vss.n2035 4345.59
R486 vss.n2047 vss.n493 4345.59
R487 vss.n2047 vss.n2043 4345.59
R488 vss.n612 vss.n611 4322.41
R489 vss.n1681 vss.n611 4322.41
R490 vss.n1489 vss.n1476 4322.41
R491 vss.n1490 vss.n1489 4322.41
R492 vss.n1103 vss.n1093 4322.41
R493 vss.n1120 vss.n1093 4322.41
R494 vss.n436 vss.n434 4322.41
R495 vss.n2109 vss.n434 4322.41
R496 vss.n615 vss.n613 4322.41
R497 vss.n1679 vss.n615 4322.41
R498 vss.n1475 vss.n1471 4322.41
R499 vss.n1492 vss.n1471 4322.41
R500 vss.n1104 vss.n1094 4322.41
R501 vss.n1118 vss.n1104 4322.41
R502 vss.n437 vss.n435 4322.41
R503 vss.n2107 vss.n437 4322.41
R504 vss.n1511 vss.n944 3708.24
R505 vss.n1511 vss.n943 3708.24
R506 vss.n2126 vss.n415 3708.24
R507 vss.n2126 vss.n414 3708.24
R508 vss.n1293 vss.n940 3708.24
R509 vss.n1133 vss.n940 3708.24
R510 vss.n1656 vss.n411 3708.24
R511 vss.n575 vss.n411 3708.24
R512 vss.n1526 vss.n919 3602.29
R513 vss.n1399 vss.n985 3602.29
R514 vss.n2181 vss.n311 3602.29
R515 vss.n2189 vss.n270 3602.29
R516 vss.n2089 vss.n466 3602.29
R517 vss.n2099 vss.n2098 3602.29
R518 vss.n1713 vss.n387 3602.29
R519 vss.n1687 vss.n390 3602.29
R520 vss.n1985 vss.n541 3602.29
R521 vss.n1939 vss.n1937 3602.29
R522 vss.n1565 vss.n1564 3602.29
R523 vss.n1536 vss.n914 3602.29
R524 vss.n2217 vss.n287 3602.29
R525 vss.n2245 vss.n274 3602.29
R526 vss.n1629 vss.n639 3602.29
R527 vss.n662 vss.n659 3602.29
R528 vss.n1349 vss.n1019 3186.76
R529 vss.n1019 vss.n1008 3186.76
R530 vss.n1353 vss.n1349 3186.76
R531 vss.n1353 vss.n1008 3186.76
R532 vss.n1873 vss.n1804 3186.76
R533 vss.n1877 vss.n1804 3186.76
R534 vss.n1873 vss.n1803 3186.76
R535 vss.n1877 vss.n1803 3186.76
R536 vss.n1452 vss.n1440 3186.76
R537 vss.n1456 vss.n1440 3186.76
R538 vss.n1452 vss.n1422 3186.76
R539 vss.n1456 vss.n1422 3186.76
R540 vss.n1747 vss.n1746 3186.76
R541 vss.n1747 vss.n1743 3186.76
R542 vss.n1746 vss.n1744 3186.76
R543 vss.n1744 vss.n1743 3186.76
R544 vss.n526 vss.n525 3186.76
R545 vss.n525 vss.n521 3186.76
R546 vss.n526 vss.n520 3186.76
R547 vss.n521 vss.n520 3186.76
R548 vss.n1259 vss.n1176 3186.76
R549 vss.n1178 vss.n1176 3186.76
R550 vss.n1259 vss.n1175 3186.76
R551 vss.n1178 vss.n1175 3186.76
R552 vss.n1586 vss.n1585 3186.76
R553 vss.n1590 vss.n1586 3186.76
R554 vss.n1585 vss.n1584 3186.76
R555 vss.n1590 vss.n1584 3186.76
R556 vss.n739 vss.n738 3186.76
R557 vss.n739 vss.n735 3186.76
R558 vss.n738 vss.n736 3186.76
R559 vss.n736 vss.n735 3186.76
R560 vss.n1233 vss.n924 3186.76
R561 vss.n1233 vss.n1191 3186.76
R562 vss.n1232 vss.n924 3186.76
R563 vss.n1232 vss.n1191 3186.76
R564 vss.n846 vss.n823 3186.76
R565 vss.n847 vss.n823 3186.76
R566 vss.n846 vss.n824 3186.76
R567 vss.n847 vss.n824 3186.76
R568 vss.n787 vss.n697 3186.76
R569 vss.n787 vss.n695 3186.76
R570 vss.n779 vss.n697 3186.76
R571 vss.n779 vss.n695 3186.76
R572 vss.n2021 vss.n494 3186.76
R573 vss.n2051 vss.n2021 3186.76
R574 vss.n2055 vss.n494 3186.76
R575 vss.n2055 vss.n2051 3186.76
R576 vss.n1522 vss.n926 3186.76
R577 vss.n928 vss.n926 3186.76
R578 vss.n1522 vss.n925 3186.76
R579 vss.n928 vss.n925 3186.76
R580 vss.n826 vss.n822 3186.76
R581 vss.n825 vss.n822 3186.76
R582 vss.n858 vss.n826 3186.76
R583 vss.n858 vss.n825 3186.76
R584 vss.n781 vss.n698 3186.76
R585 vss.n780 vss.n698 3186.76
R586 vss.n786 vss.n781 3186.76
R587 vss.n786 vss.n780 3186.76
R588 vss.n2083 vss.n500 3186.76
R589 vss.n2049 vss.n500 3186.76
R590 vss.n2083 vss.n499 3186.76
R591 vss.n2049 vss.n499 3186.76
R592 vss.n1507 vss.n944 2885.47
R593 vss.n1323 vss.n944 2885.47
R594 vss.n971 vss.n943 2885.47
R595 vss.n1080 vss.n943 2885.47
R596 vss.n2122 vss.n415 2885.47
R597 vss.n1898 vss.n415 2885.47
R598 vss.n1777 vss.n414 2885.47
R599 vss.n577 vss.n414 2885.47
R600 vss.n1294 vss.n1293 2885.47
R601 vss.n1293 vss.n1292 2885.47
R602 vss.n1133 vss.n949 2885.47
R603 vss.n1321 vss.n1133 2885.47
R604 vss.n1656 vss.n551 2885.47
R605 vss.n1657 vss.n1656 2885.47
R606 vss.n575 vss.n420 2885.47
R607 vss.n576 vss.n575 2885.47
R608 vss.n1355 vss.n1018 2607.35
R609 vss.n1355 vss.n1010 2607.35
R610 vss.n1354 vss.n1018 2607.35
R611 vss.n1354 vss.n1010 2607.35
R612 vss.n1862 vss.n1809 2607.35
R613 vss.n1858 vss.n1809 2607.35
R614 vss.n1862 vss.n1808 2607.35
R615 vss.n1858 vss.n1808 2607.35
R616 vss.n1434 vss.n1424 2607.35
R617 vss.n1433 vss.n1424 2607.35
R618 vss.n1439 vss.n1434 2607.35
R619 vss.n1439 vss.n1433 2607.35
R620 vss.n1763 vss.n1757 2607.35
R621 vss.n1759 vss.n1757 2607.35
R622 vss.n1763 vss.n1756 2607.35
R623 vss.n1759 vss.n1756 2607.35
R624 vss.n2070 vss.n519 2607.35
R625 vss.n2074 vss.n2070 2607.35
R626 vss.n519 vss.n518 2607.35
R627 vss.n2074 vss.n518 2607.35
R628 vss.n1243 vss.n1182 2607.35
R629 vss.n1243 vss.n1180 2607.35
R630 vss.n1242 vss.n1182 2607.35
R631 vss.n1242 vss.n1180 2607.35
R632 vss.n878 vss.n876 2607.35
R633 vss.n877 vss.n876 2607.35
R634 vss.n1600 vss.n878 2607.35
R635 vss.n1600 vss.n877 2607.35
R636 vss.n749 vss.n728 2607.35
R637 vss.n729 vss.n728 2607.35
R638 vss.n754 vss.n749 2607.35
R639 vss.n754 vss.n729 2607.35
R640 vss.n1200 vss.n1196 2607.35
R641 vss.n1196 vss.n1195 2607.35
R642 vss.n1200 vss.n1194 2607.35
R643 vss.n1195 vss.n1194 2607.35
R644 vss.n808 vss.n806 2607.35
R645 vss.n812 vss.n806 2607.35
R646 vss.n808 vss.n805 2607.35
R647 vss.n812 vss.n805 2607.35
R648 vss.n706 vss.n702 2607.35
R649 vss.n702 vss.n701 2607.35
R650 vss.n706 vss.n700 2607.35
R651 vss.n701 vss.n700 2607.35
R652 vss.n2023 vss.n497 2607.35
R653 vss.n2024 vss.n2023 2607.35
R654 vss.n2028 vss.n497 2607.35
R655 vss.n2028 vss.n2024 2607.35
R656 vss.n1208 vss.n1202 2607.35
R657 vss.n1204 vss.n1202 2607.35
R658 vss.n1208 vss.n1201 2607.35
R659 vss.n1204 vss.n1201 2607.35
R660 vss.n816 vss.n814 2607.35
R661 vss.n820 vss.n814 2607.35
R662 vss.n816 vss.n813 2607.35
R663 vss.n820 vss.n813 2607.35
R664 vss.n721 vss.n715 2607.35
R665 vss.n717 vss.n715 2607.35
R666 vss.n721 vss.n714 2607.35
R667 vss.n717 vss.n714 2607.35
R668 vss.n2022 vss.n492 2607.35
R669 vss.n2029 vss.n2022 2607.35
R670 vss.n2034 vss.n492 2607.35
R671 vss.n2034 vss.n2029 2607.35
R672 vss.n1901 vss.n404 2549.41
R673 vss.n1901 vss.n571 2549.41
R674 vss.n1671 vss.n1666 2549.41
R675 vss.n1671 vss.n570 2549.41
R676 vss.n1483 vss.n961 2549.41
R677 vss.n1484 vss.n1483 2549.41
R678 vss.n960 vss.n950 2549.41
R679 vss.n950 vss.n934 2549.41
R680 vss.n1107 vss.n1106 2549.41
R681 vss.n1107 vss.n1090 2549.41
R682 vss.n1088 vss.n1081 2549.41
R683 vss.n1081 vss.n933 2549.41
R684 vss.n441 vss.n440 2549.41
R685 vss.n441 vss.n430 2549.41
R686 vss.n427 vss.n421 2549.41
R687 vss.n429 vss.n421 2549.41
R688 vss.n1673 vss.n566 2549.41
R689 vss.n1673 vss.n616 2549.41
R690 vss.n574 vss.n567 2549.41
R691 vss.n574 vss.n573 2549.41
R692 vss.n1481 vss.n1480 2549.41
R693 vss.n1481 vss.n964 2549.41
R694 vss.n1504 vss.n952 2549.41
R695 vss.n1504 vss.n951 2549.41
R696 vss.n1109 vss.n1105 2549.41
R697 vss.n1109 vss.n1086 2549.41
R698 vss.n1130 vss.n1083 2549.41
R699 vss.n1130 vss.n1082 2549.41
R700 vss.n443 vss.n439 2549.41
R701 vss.n443 vss.n425 2549.41
R702 vss.n2119 vss.n405 2549.41
R703 vss.n2119 vss.n422 2549.41
R704 vss.n863 vss.n860 2462.5
R705 vss.n867 vss.n860 2462.5
R706 vss.n867 vss.n861 2462.5
R707 vss.n863 vss.n861 2462.5
R708 vss.n1226 vss.n1210 2462.5
R709 vss.n1226 vss.n1224 2462.5
R710 vss.n1230 vss.n1224 2462.5
R711 vss.n1230 vss.n1210 2462.5
R712 vss.n1368 vss.n988 2462.5
R713 vss.n1364 vss.n988 2462.5
R714 vss.n1368 vss.n987 2462.5
R715 vss.n1364 vss.n987 2462.5
R716 vss.n1026 vss.n1021 2462.5
R717 vss.n1026 vss.n1020 2462.5
R718 vss.n1021 vss.n1009 2462.5
R719 vss.n1020 vss.n1009 2462.5
R720 vss.n1851 vss.n1807 2462.5
R721 vss.n1855 vss.n1851 2462.5
R722 vss.n1811 vss.n1807 2462.5
R723 vss.n1855 vss.n1811 2462.5
R724 vss.n1427 vss.n1426 2462.5
R725 vss.n1427 vss.n1425 2462.5
R726 vss.n1431 vss.n1426 2462.5
R727 vss.n1431 vss.n1425 2462.5
R728 vss.n1767 vss.n1766 2462.5
R729 vss.n1768 vss.n1767 2462.5
R730 vss.n1766 vss.n590 2462.5
R731 vss.n1768 vss.n590 2462.5
R732 vss.n773 vss.n723 2462.5
R733 vss.n773 vss.n771 2462.5
R734 vss.n777 vss.n771 2462.5
R735 vss.n777 vss.n723 2462.5
R736 vss.n2177 vss.n334 2462.5
R737 vss.n366 vss.n334 2462.5
R738 vss.n2177 vss.n333 2462.5
R739 vss.n366 vss.n333 2462.5
R740 vss.n2169 vss.n377 2462.5
R741 vss.n2173 vss.n377 2462.5
R742 vss.n2169 vss.n376 2462.5
R743 vss.n2173 vss.n376 2462.5
R744 vss.n2069 vss.n529 2462.5
R745 vss.n2069 vss.n528 2462.5
R746 vss.n2065 vss.n529 2462.5
R747 vss.n2065 vss.n528 2462.5
R748 vss.n1236 vss.n1184 2462.5
R749 vss.n1236 vss.n1185 2462.5
R750 vss.n1240 vss.n1185 2462.5
R751 vss.n1240 vss.n1184 2462.5
R752 vss.n1218 vss.n1214 2462.5
R753 vss.n1218 vss.n1213 2462.5
R754 vss.n1214 vss.n1212 2462.5
R755 vss.n1213 vss.n1212 2462.5
R756 vss.n1219 vss.n1193 2462.5
R757 vss.n1223 vss.n1193 2462.5
R758 vss.n1219 vss.n1211 2462.5
R759 vss.n1223 vss.n1211 2462.5
R760 vss.n875 vss.n873 2462.5
R761 vss.n1601 vss.n875 2462.5
R762 vss.n1602 vss.n1601 2462.5
R763 vss.n1602 vss.n873 2462.5
R764 vss.n759 vss.n726 2462.5
R765 vss.n755 vss.n726 2462.5
R766 vss.n755 vss.n727 2462.5
R767 vss.n759 vss.n727 2462.5
R768 vss.n802 vss.n798 2462.5
R769 vss.n802 vss.n797 2462.5
R770 vss.n798 vss.n796 2462.5
R771 vss.n797 vss.n796 2462.5
R772 vss.n765 vss.n761 2462.5
R773 vss.n765 vss.n760 2462.5
R774 vss.n761 vss.n725 2462.5
R775 vss.n760 vss.n725 2462.5
R776 vss.n872 vss.n804 2462.5
R777 vss.n868 vss.n804 2462.5
R778 vss.n872 vss.n803 2462.5
R779 vss.n868 vss.n803 2462.5
R780 vss.n766 vss.n699 2462.5
R781 vss.n770 vss.n699 2462.5
R782 vss.n766 vss.n724 2462.5
R783 vss.n770 vss.n724 2462.5
R784 vss.n2057 vss.n490 2462.5
R785 vss.n2057 vss.n491 2462.5
R786 vss.n2085 vss.n491 2462.5
R787 vss.n2085 vss.n490 2462.5
R788 vss.n1850 vss.n1846 2462.5
R789 vss.n1850 vss.n1845 2462.5
R790 vss.n1846 vss.n1843 2462.5
R791 vss.n1845 vss.n1843 2462.5
R792 vss.n2019 vss.n2015 2462.5
R793 vss.n2019 vss.n2014 2462.5
R794 vss.n2015 vss.n2012 2462.5
R795 vss.n2014 vss.n2012 2462.5
R796 vss.n2064 vss.n495 2462.5
R797 vss.n2060 vss.n495 2462.5
R798 vss.n2064 vss.n2059 2462.5
R799 vss.n2060 vss.n2059 2462.5
R800 vss.n2175 vss.n372 2456.67
R801 vss.n2175 vss.n375 2456.67
R802 vss.n2175 vss.n2174 2456.67
R803 vss.n2176 vss.n2175 2456.67
R804 vss.n568 vss.n404 2039.53
R805 vss.n1666 vss.n568 2039.53
R806 vss.n1905 vss.n571 2039.53
R807 vss.n1905 vss.n570 2039.53
R808 vss.n1484 vss.n963 2039.53
R809 vss.n963 vss.n934 2039.53
R810 vss.n1498 vss.n961 2039.53
R811 vss.n1498 vss.n960 2039.53
R812 vss.n1089 vss.n1088 2039.53
R813 vss.n1106 vss.n1089 2039.53
R814 vss.n1124 vss.n933 2039.53
R815 vss.n1124 vss.n1090 2039.53
R816 vss.n2113 vss.n430 2039.53
R817 vss.n2113 vss.n429 2039.53
R818 vss.n440 vss.n428 2039.53
R819 vss.n428 vss.n427 2039.53
R820 vss.n1907 vss.n567 2039.53
R821 vss.n1907 vss.n566 2039.53
R822 vss.n573 vss.n569 2039.53
R823 vss.n616 vss.n569 2039.53
R824 vss.n1496 vss.n964 2039.53
R825 vss.n1496 vss.n951 2039.53
R826 vss.n1480 vss.n962 2039.53
R827 vss.n962 vss.n952 2039.53
R828 vss.n1087 vss.n1083 2039.53
R829 vss.n1105 vss.n1087 2039.53
R830 vss.n1126 vss.n1082 2039.53
R831 vss.n1126 vss.n1086 2039.53
R832 vss.n2115 vss.n425 2039.53
R833 vss.n2115 vss.n422 2039.53
R834 vss.n439 vss.n426 2039.53
R835 vss.n426 vss.n405 2039.53
R836 vss.n1666 vss.n612 1773
R837 vss.n1681 vss.n570 1773
R838 vss.n1490 vss.n1484 1773
R839 vss.n1476 vss.n961 1773
R840 vss.n1106 vss.n1103 1773
R841 vss.n1120 vss.n1090 1773
R842 vss.n2109 vss.n430 1773
R843 vss.n440 vss.n436 1773
R844 vss.n613 vss.n566 1773
R845 vss.n1679 vss.n616 1773
R846 vss.n1492 vss.n964 1773
R847 vss.n1480 vss.n1475 1773
R848 vss.n1105 vss.n1094 1773
R849 vss.n1118 vss.n1086 1773
R850 vss.n2107 vss.n425 1773
R851 vss.n439 vss.n435 1773
R852 vss.n2011 vss.n2010 1422.67
R853 vss.n1842 vss.n1841 1422.67
R854 vss.n1627 vss.n641 1422.67
R855 vss.n795 vss.n280 1422.67
R856 vss.n1561 vss.n905 1422.67
R857 vss.n2168 vss.n2167 1422.67
R858 vss.n367 vss.n364 1422.67
R859 vss.n1396 vss.n1369 1422.67
R860 vss.n2042 vss.n454 857.125
R861 vss.n2140 vss.n394 857.125
R862 vss.n2191 vss.n271 857.125
R863 vss.n1534 vss.n917 857.125
R864 vss.t191 vss.n2013 850.668
R865 vss.t191 vss.n2011 850.668
R866 vss.t184 vss.n1844 850.668
R867 vss.t184 vss.n1842 850.668
R868 vss.t189 vss.n641 850.668
R869 vss.t189 vss.n372 850.668
R870 vss.t202 vss.n375 850.668
R871 vss.t202 vss.n795 850.668
R872 vss.t205 vss.n905 850.668
R873 vss.t205 vss.n991 850.668
R874 vss.n2168 vss.t196 850.668
R875 vss.n2174 vss.t196 850.668
R876 vss.n2176 vss.t193 850.668
R877 vss.t193 vss.n367 850.668
R878 vss.n1369 vss.t187 850.668
R879 vss.n1363 vss.t187 850.668
R880 vss.n2175 vss.n370 839.886
R881 vss.n2175 vss.n371 839.886
R882 vss.n2175 vss.n369 839.886
R883 vss.n2175 vss.n368 839.886
R884 vss.n2098 vss.n452 585
R885 vss.n2099 vss.n448 585
R886 vss.n2102 vss.n2101 585
R887 vss.n2096 vss.n2095 585
R888 vss.n390 vss.n389 585
R889 vss.n1687 vss.n1686 585
R890 vss.n1689 vss.n609 585
R891 vss.n2144 vss.n2143 585
R892 vss.n2189 vss.n2188 585
R893 vss.n270 vss.n267 585
R894 vss.n2250 vss.n2249 585
R895 vss.n2187 vss.n298 585
R896 vss.n1526 vss.n248 585
R897 vss.n1530 vss.n919 585
R898 vss.n1532 vss.n1531 585
R899 vss.n1529 vss.n1528 585
R900 vss.n538 vss.n536 585
R901 vss.n1935 vss.n1934 585
R902 vss.n1941 vss.n1937 585
R903 vss.n1940 vss.n1939 585
R904 vss.n664 vss.n658 585
R905 vss.n260 vss.n648 585
R906 vss.n660 vss.n659 585
R907 vss.n662 vss.n661 585
R908 vss.n2243 vss.n273 585
R909 vss.n244 vss.n2193 585
R910 vss.n243 vss.n274 585
R911 vss.n2245 vss.n2244 585
R912 vss.n916 vss.n915 585
R913 vss.n913 vss.n912 585
R914 vss.n1538 vss.n914 585
R915 vss.n1537 vss.n1536 585
R916 vss.n2010 vss.n2009 585
R917 vss.n2009 vss.n2008 585
R918 vss.n539 vss.n537 585
R919 vss.n2007 vss.n2006 585
R920 vss.n2005 vss.n2004 585
R921 vss.n2003 vss.n2002 585
R922 vss.n2001 vss.n2000 585
R923 vss.n1999 vss.n1998 585
R924 vss.n1997 vss.n1996 585
R925 vss.n1995 vss.n1994 585
R926 vss.n1993 vss.n1992 585
R927 vss.n1991 vss.n1990 585
R928 vss.n1989 vss.n1988 585
R929 vss.n1987 vss.n1986 585
R930 vss.n1841 vss.n1840 585
R931 vss.n1840 vss.n485 585
R932 vss.n1839 vss.n1838 585
R933 vss.n1837 vss.n1836 585
R934 vss.n1835 vss.n1834 585
R935 vss.n1833 vss.n1832 585
R936 vss.n1831 vss.n1830 585
R937 vss.n1829 vss.n1828 585
R938 vss.n1827 vss.n1826 585
R939 vss.n1825 vss.n1824 585
R940 vss.n1823 vss.n1822 585
R941 vss.n1821 vss.n1820 585
R942 vss.n1819 vss.n1818 585
R943 vss.n450 vss.n449 585
R944 vss.n1968 vss.n541 585
R945 vss.n1943 vss.n541 585
R946 vss.n1944 vss.n1942 585
R947 vss.n1946 vss.n1945 585
R948 vss.n1948 vss.n1947 585
R949 vss.n1950 vss.n1949 585
R950 vss.n1952 vss.n1951 585
R951 vss.n1954 vss.n1953 585
R952 vss.n1956 vss.n1955 585
R953 vss.n1958 vss.n1957 585
R954 vss.n1960 vss.n1959 585
R955 vss.n1962 vss.n1961 585
R956 vss.n1968 vss.n1932 585
R957 vss.n1963 vss.n1932 585
R958 vss.n1964 vss.n1933 585
R959 vss.n1966 vss.n1965 585
R960 vss.n667 vss.n666 585
R961 vss.n657 vss.n656 585
R962 vss.n669 vss.n668 585
R963 vss.n671 vss.n655 585
R964 vss.n674 vss.n673 585
R965 vss.n654 vss.n653 585
R966 vss.n676 vss.n675 585
R967 vss.n678 vss.n652 585
R968 vss.n681 vss.n680 585
R969 vss.n651 vss.n650 585
R970 vss.n683 vss.n682 585
R971 vss.n685 vss.n649 585
R972 vss.n688 vss.n687 585
R973 vss.n689 vss.n639 585
R974 vss.n1630 vss.n1629 585
R975 vss.n1629 vss.n238 585
R976 vss.n886 vss.n287 585
R977 vss.n2221 vss.n287 585
R978 vss.n1628 vss.n1627 585
R979 vss.n1628 vss.n239 585
R980 vss.n1604 vss.n640 585
R981 vss.n1606 vss.n1605 585
R982 vss.n1608 vss.n1607 585
R983 vss.n1610 vss.n1609 585
R984 vss.n1612 vss.n1611 585
R985 vss.n1614 vss.n1613 585
R986 vss.n1616 vss.n1615 585
R987 vss.n1618 vss.n1617 585
R988 vss.n1620 vss.n1619 585
R989 vss.n1622 vss.n1621 585
R990 vss.n1623 vss.n647 585
R991 vss.n1625 vss.n1624 585
R992 vss.n280 vss.n275 585
R993 vss.n2242 vss.n275 585
R994 vss.n278 vss.n276 585
R995 vss.n2241 vss.n2240 585
R996 vss.n2239 vss.n277 585
R997 vss.n2237 vss.n2236 585
R998 vss.n2235 vss.n281 585
R999 vss.n2234 vss.n2233 585
R1000 vss.n2232 vss.n282 585
R1001 vss.n2230 vss.n2229 585
R1002 vss.n2228 vss.n284 585
R1003 vss.n2227 vss.n2226 585
R1004 vss.n2225 vss.n285 585
R1005 vss.n2223 vss.n2222 585
R1006 vss.n2217 vss.n224 585
R1007 vss.n2220 vss.n2219 585
R1008 vss.n289 vss.n288 585
R1009 vss.n2195 vss.n2194 585
R1010 vss.n2197 vss.n2196 585
R1011 vss.n2199 vss.n2198 585
R1012 vss.n2201 vss.n2200 585
R1013 vss.n2203 vss.n2202 585
R1014 vss.n2205 vss.n2204 585
R1015 vss.n2207 vss.n2206 585
R1016 vss.n2209 vss.n2208 585
R1017 vss.n2211 vss.n2210 585
R1018 vss.n2212 vss.n296 585
R1019 vss.n2214 vss.n2213 585
R1020 vss.n1149 vss.n1148 585
R1021 vss.n1152 vss.n1151 585
R1022 vss.n1150 vss.n1147 585
R1023 vss.n1154 vss.n1153 585
R1024 vss.n1156 vss.n1155 585
R1025 vss.n1159 vss.n1158 585
R1026 vss.n1157 vss.n1146 585
R1027 vss.n1161 vss.n1160 585
R1028 vss.n1163 vss.n1162 585
R1029 vss.n1165 vss.n1164 585
R1030 vss.n1145 vss.n1143 585
R1031 vss.n1167 vss.n1166 585
R1032 vss.n1144 vss.n900 585
R1033 vss.n1566 vss.n1565 585
R1034 vss.n1564 vss.n902 585
R1035 vss.n1564 vss.n899 585
R1036 vss.n1563 vss.n903 585
R1037 vss.n1539 vss.n904 585
R1038 vss.n1541 vss.n1540 585
R1039 vss.n1543 vss.n1542 585
R1040 vss.n1545 vss.n1544 585
R1041 vss.n1547 vss.n1546 585
R1042 vss.n1549 vss.n1548 585
R1043 vss.n1551 vss.n1550 585
R1044 vss.n1561 vss.n910 585
R1045 vss.n1552 vss.n910 585
R1046 vss.n1554 vss.n1553 585
R1047 vss.n1556 vss.n1555 585
R1048 vss.n1557 vss.n911 585
R1049 vss.n1559 vss.n1558 585
R1050 vss.n2167 vss.n383 585
R1051 vss.n2145 vss.n383 585
R1052 vss.n2147 vss.n2146 585
R1053 vss.n2149 vss.n2148 585
R1054 vss.n2167 vss.n381 585
R1055 vss.n2150 vss.n381 585
R1056 vss.n2152 vss.n2151 585
R1057 vss.n2154 vss.n2153 585
R1058 vss.n2167 vss.n385 585
R1059 vss.n2155 vss.n385 585
R1060 vss.n2157 vss.n2156 585
R1061 vss.n2159 vss.n2158 585
R1062 vss.n2161 vss.n2160 585
R1063 vss.n2163 vss.n2162 585
R1064 vss.n196 vss.n386 585
R1065 vss.n2165 vss.n2164 585
R1066 vss.n364 vss.n363 585
R1067 vss.n363 vss.n329 585
R1068 vss.n362 vss.n361 585
R1069 vss.n360 vss.n359 585
R1070 vss.n358 vss.n357 585
R1071 vss.n356 vss.n355 585
R1072 vss.n354 vss.n353 585
R1073 vss.n352 vss.n351 585
R1074 vss.n350 vss.n349 585
R1075 vss.n348 vss.n347 585
R1076 vss.n346 vss.n345 585
R1077 vss.n344 vss.n343 585
R1078 vss.n342 vss.n341 585
R1079 vss.n269 vss.n268 585
R1080 vss.n595 vss.n387 585
R1081 vss.n388 vss.n387 585
R1082 vss.n1421 vss.n311 585
R1083 vss.n2179 vss.n311 585
R1084 vss.n302 vss.n299 585
R1085 vss.n2186 vss.n2185 585
R1086 vss.n301 vss.n300 585
R1087 vss.n314 vss.n313 585
R1088 vss.n316 vss.n315 585
R1089 vss.n318 vss.n317 585
R1090 vss.n2183 vss.n305 585
R1091 vss.n319 vss.n305 585
R1092 vss.n321 vss.n320 585
R1093 vss.n323 vss.n322 585
R1094 vss.n325 vss.n324 585
R1095 vss.n327 vss.n326 585
R1096 vss.n2183 vss.n309 585
R1097 vss.n328 vss.n309 585
R1098 vss.n312 vss.n310 585
R1099 vss.n2181 vss.n2180 585
R1100 vss.n1066 vss.n1065 585
R1101 vss.n1064 vss.n1044 585
R1102 vss.n1063 vss.n1062 585
R1103 vss.n1068 vss.n1042 585
R1104 vss.n1061 vss.n1042 585
R1105 vss.n1060 vss.n1059 585
R1106 vss.n1058 vss.n1057 585
R1107 vss.n1056 vss.n1055 585
R1108 vss.n1054 vss.n1053 585
R1109 vss.n1052 vss.n1051 585
R1110 vss.n1050 vss.n1049 585
R1111 vss.n1048 vss.n1047 585
R1112 vss.n1046 vss.n1045 585
R1113 vss.n1068 vss.n920 585
R1114 vss.n921 vss.n920 585
R1115 vss.n985 vss.n983 585
R1116 vss.n1399 vss.n984 585
R1117 vss.n1400 vss.n1399 585
R1118 vss.n923 vss.n922 585
R1119 vss.n1386 vss.n1385 585
R1120 vss.n1388 vss.n1387 585
R1121 vss.n1390 vss.n1389 585
R1122 vss.n1392 vss.n1391 585
R1123 vss.n1393 vss.n1376 585
R1124 vss.n1396 vss.n1395 585
R1125 vss.n1395 vss.n1394 585
R1126 vss.n1377 vss.n1375 585
R1127 vss.n1384 vss.n1383 585
R1128 vss.n1382 vss.n1381 585
R1129 vss.n1380 vss.n1379 585
R1130 vss.n1378 vss.n986 585
R1131 vss.n1398 vss.n982 585
R1132 vss.n2091 vss.n455 585
R1133 vss.n456 vss.n455 585
R1134 vss.n2094 vss.n2093 585
R1135 vss.n458 vss.n457 585
R1136 vss.n469 vss.n468 585
R1137 vss.n471 vss.n470 585
R1138 vss.n473 vss.n472 585
R1139 vss.n475 vss.n474 585
R1140 vss.n477 vss.n476 585
R1141 vss.n479 vss.n478 585
R1142 vss.n2091 vss.n464 585
R1143 vss.n480 vss.n464 585
R1144 vss.n482 vss.n481 585
R1145 vss.n484 vss.n483 585
R1146 vss.n467 vss.n465 585
R1147 vss.n2089 vss.n2088 585
R1148 vss.n608 vss.n607 585
R1149 vss.n1711 vss.n1710 585
R1150 vss.n1709 vss.n1708 585
R1151 vss.n1715 vss.n606 585
R1152 vss.n1707 vss.n606 585
R1153 vss.n1706 vss.n1705 585
R1154 vss.n1704 vss.n1703 585
R1155 vss.n1715 vss.n601 585
R1156 vss.n1702 vss.n601 585
R1157 vss.n1701 vss.n1700 585
R1158 vss.n1699 vss.n1698 585
R1159 vss.n1697 vss.n1696 585
R1160 vss.n1695 vss.n1694 585
R1161 vss.n1693 vss.n1692 585
R1162 vss.n1691 vss.n1690 585
R1163 vss.n1713 vss.n1712 585
R1164 vss.n1802 vss.n466 585
R1165 vss.n2087 vss.n466 585
R1166 vss.n1985 vss.n1984 585
R1167 vss.n1985 vss.n540 585
R1168 vss.n1662 vss.n619 522.165
R1169 vss.n621 vss.n619 522.165
R1170 vss.n1661 vss.n621 522.165
R1171 vss.n1662 vss.n1661 522.165
R1172 vss.n1286 vss.n894 522.165
R1173 vss.n1287 vss.n1286 522.165
R1174 vss.n1288 vss.n1287 522.165
R1175 vss.n1288 vss.n894 522.165
R1176 vss.n1278 vss.n896 522.165
R1177 vss.n1279 vss.n1278 522.165
R1178 vss.n1280 vss.n1279 522.165
R1179 vss.n1280 vss.n896 522.165
R1180 vss.n1329 vss.n979 522.165
R1181 vss.n1331 vss.n979 522.165
R1182 vss.n1330 vss.n1329 522.165
R1183 vss.n1331 vss.n1330 522.165
R1184 vss.n1076 vss.n977 522.165
R1185 vss.n1075 vss.n977 522.165
R1186 vss.n1077 vss.n1076 522.165
R1187 vss.n1077 vss.n1075 522.165
R1188 vss.n1402 vss.n1401 522.165
R1189 vss.n1401 vss.n976 522.165
R1190 vss.n1402 vss.n974 522.165
R1191 vss.n976 vss.n974 522.165
R1192 vss.n1411 vss.n966 522.165
R1193 vss.n1411 vss.n965 522.165
R1194 vss.n1408 vss.n966 522.165
R1195 vss.n1408 vss.n965 522.165
R1196 vss.n1719 vss.n585 522.165
R1197 vss.n1721 vss.n585 522.165
R1198 vss.n1720 vss.n1719 522.165
R1199 vss.n1721 vss.n1720 522.165
R1200 vss.n1892 vss.n1891 522.165
R1201 vss.n1893 vss.n1892 522.165
R1202 vss.n1891 vss.n583 522.165
R1203 vss.n1893 vss.n583 522.165
R1204 vss.n1783 vss.n1770 522.165
R1205 vss.n1781 vss.n1770 522.165
R1206 vss.n1783 vss.n1782 522.165
R1207 vss.n1782 vss.n1781 522.165
R1208 vss.n1792 vss.n1773 522.165
R1209 vss.n1792 vss.n1772 522.165
R1210 vss.n1789 vss.n1773 522.165
R1211 vss.n1789 vss.n1772 522.165
R1212 vss.n1648 vss.n629 522.165
R1213 vss.n1649 vss.n1648 522.165
R1214 vss.n1650 vss.n1649 522.165
R1215 vss.n1650 vss.n629 522.165
R1216 vss.n1301 vss.n1300 522.165
R1217 vss.n1300 vss.n1299 522.165
R1218 vss.n1301 vss.n893 522.165
R1219 vss.n1299 vss.n893 522.165
R1220 vss.n1309 vss.n1308 522.165
R1221 vss.n1310 vss.n1309 522.165
R1222 vss.n1308 vss.n891 522.165
R1223 vss.n1310 vss.n891 522.165
R1224 vss.n559 vss.n555 522.165
R1225 vss.n559 vss.n554 522.165
R1226 vss.n562 vss.n555 522.165
R1227 vss.n562 vss.n554 522.165
R1228 vss.n1924 vss.n1923 522.165
R1229 vss.n1923 vss.n1922 522.165
R1230 vss.n1924 vss.n109 522.165
R1231 vss.n1922 vss.n109 522.165
R1232 vss.n1264 vss.n1263 501.459
R1233 vss.n1265 vss.n1264 501.459
R1234 vss.n1271 vss.n897 501.459
R1235 vss.n1272 vss.n1271 501.459
R1236 vss.n1273 vss.n1272 501.459
R1237 vss.n1273 vss.n897 501.459
R1238 vss.n1344 vss.n1343 501.459
R1239 vss.n1345 vss.n1344 501.459
R1240 vss.n1336 vss.n980 501.459
R1241 vss.n1337 vss.n1336 501.459
R1242 vss.n1338 vss.n980 501.459
R1243 vss.n1338 vss.n1337 501.459
R1244 vss.n1468 vss.n1412 501.459
R1245 vss.n1468 vss.n1413 501.459
R1246 vss.n1415 vss.n1413 501.459
R1247 vss.n1415 vss.n1412 501.459
R1248 vss.n1889 vss.n1794 501.459
R1249 vss.n1889 vss.n1793 501.459
R1250 vss.n1796 vss.n1794 501.459
R1251 vss.n1796 vss.n1793 501.459
R1252 vss.n1881 vss.n1801 501.459
R1253 vss.n1883 vss.n1801 501.459
R1254 vss.n1726 vss.n586 501.459
R1255 vss.n1728 vss.n586 501.459
R1256 vss.n1727 vss.n1726 501.459
R1257 vss.n1728 vss.n1727 501.459
R1258 vss.n1460 vss.n1420 501.459
R1259 vss.n1462 vss.n1420 501.459
R1260 vss.n1737 vss.n1736 501.459
R1261 vss.n1737 vss.n1735 501.459
R1262 vss.n1973 vss.n1972 501.459
R1263 vss.n1972 vss.n1971 501.459
R1264 vss.n1973 vss.n547 501.459
R1265 vss.n1971 vss.n547 501.459
R1266 vss.n1981 vss.n1980 501.459
R1267 vss.n1980 vss.n1979 501.459
R1268 vss.n1634 vss.n1633 501.459
R1269 vss.n1635 vss.n1634 501.459
R1270 vss.n1641 vss.n633 501.459
R1271 vss.n1642 vss.n1641 501.459
R1272 vss.n1643 vss.n1642 501.459
R1273 vss.n1643 vss.n633 501.459
R1274 vss.n1571 vss.n1570 501.459
R1275 vss.n1572 vss.n1571 501.459
R1276 vss.n1572 vss.n1568 501.459
R1277 vss.n1570 vss.n1568 501.459
R1278 vss.n1580 vss.n1579 501.459
R1279 vss.n1581 vss.n1580 501.459
R1280 vss.n1639 vss.n1638 498.918
R1281 vss.n1637 vss.n634 498.918
R1282 vss.n1577 vss.n1576 498.918
R1283 vss.n1574 vss.t92 498.918
R1284 vss.n1269 vss.n1268 498.918
R1285 vss.n1267 vss.n1172 498.918
R1286 vss.n1730 vss.n597 498.918
R1287 vss.n1739 vss.n1731 498.918
R1288 vss.n1464 vss.n1417 498.918
R1289 vss.n1465 vss.t69 498.918
R1290 vss.n1340 vss.n1035 498.918
R1291 vss.n1341 vss.n1034 498.918
R1292 vss.n1885 vss.n1798 498.918
R1293 vss.n1886 vss.t66 498.918
R1294 vss.n1977 vss.n1976 498.918
R1295 vss.n1975 vss.t94 498.918
R1296 vss.n1263 vss.n898 486.401
R1297 vss.n1265 vss.n898 486.401
R1298 vss.n1343 vss.n981 486.401
R1299 vss.n1345 vss.n981 486.401
R1300 vss.n1882 vss.n1881 486.401
R1301 vss.n1883 vss.n1882 486.401
R1302 vss.n1461 vss.n1460 486.401
R1303 vss.n1462 vss.n1461 486.401
R1304 vss.n1736 vss.n587 486.401
R1305 vss.n1735 vss.n587 486.401
R1306 vss.n1979 vss.n99 486.401
R1307 vss.n1981 vss.n99 486.401
R1308 vss.n1633 vss.n101 486.401
R1309 vss.n1635 vss.n101 486.401
R1310 vss.n1579 vss.n94 486.401
R1311 vss.n1581 vss.n94 486.401
R1312 vss.n2175 vss.n374 450.765
R1313 vss.n2175 vss.n373 450.765
R1314 vss.n1508 vss.n947 428.425
R1315 vss.n970 vss.n947 428.425
R1316 vss.n1324 vss.n946 428.425
R1317 vss.n1324 vss.n978 428.425
R1318 vss.n2123 vss.n418 428.425
R1319 vss.n1771 vss.n418 428.425
R1320 vss.n578 vss.n417 428.425
R1321 vss.n584 vss.n578 428.425
R1322 vss.n1315 vss.n892 428.425
R1323 vss.n1316 vss.n1315 428.425
R1324 vss.n1134 vss.n895 428.425
R1325 vss.n1320 vss.n1134 428.425
R1326 vss.n1917 vss.n1916 428.425
R1327 vss.n1917 vss.n552 428.425
R1328 vss.n626 vss.n618 428.425
R1329 vss.n626 vss.n625 428.425
R1330 vss.n1926 vss.t87 371.805
R1331 vss.n1920 vss.t87 371.805
R1332 vss.n1652 vss.t84 371.805
R1333 vss.n1646 vss.t84 371.805
R1334 vss.n1306 vss.t91 371.805
R1335 vss.n1312 vss.t91 371.805
R1336 vss.n1282 vss.t93 371.805
R1337 vss.n1276 vss.t93 371.805
R1338 vss.t74 vss.n1407 371.805
R1339 vss.t74 vss.n1406 371.805
R1340 vss.n1327 vss.t71 371.805
R1341 vss.n1333 vss.t71 371.805
R1342 vss.t65 vss.n1788 371.805
R1343 vss.t65 vss.n1787 371.805
R1344 vss.t68 vss.n579 371.805
R1345 vss.n1723 vss.t68 371.805
R1346 vss.n1630 vss.n638 328.433
R1347 vss.n1575 vss.n886 328.433
R1348 vss.n1250 vss.n902 328.433
R1349 vss.n1740 vss.n595 328.433
R1350 vss.n1446 vss.n1421 328.433
R1351 vss.n1033 vss.n984 328.433
R1352 vss.n1866 vss.n1802 328.433
R1353 vss.n1984 vss.n542 328.433
R1354 vss.n2129 vss.n403 303.435
R1355 vss.n2129 vss.n402 303.435
R1356 vss.n1910 vss.n1909 303.435
R1357 vss.n1911 vss.n1910 303.435
R1358 vss.n431 vss.n401 303.435
R1359 vss.n1675 vss.n401 303.435
R1360 vss.n1098 vss.n958 303.435
R1361 vss.n1099 vss.n1098 303.435
R1362 vss.n1514 vss.n932 303.435
R1363 vss.n1514 vss.n931 303.435
R1364 vss.n1501 vss.n955 303.435
R1365 vss.n1502 vss.n1501 303.435
R1366 vss.n1084 vss.n953 303.435
R1367 vss.n1128 vss.n1084 303.435
R1368 vss.n2117 vss.n423 303.435
R1369 vss.n1903 vss.n423 303.435
R1370 vss.n2013 vss.n496 293.334
R1371 vss.n1844 vss.n496 293.334
R1372 vss.n1362 vss.n991 293.334
R1373 vss.n1363 vss.n1362 293.334
R1374 vss.t293 vss.n370 290.827
R1375 vss.t296 vss.n371 290.827
R1376 vss.t298 vss.n990 290.827
R1377 vss.t263 vss.n369 290.827
R1378 vss.t281 vss.n368 290.827
R1379 vss.n1361 vss.t266 290.827
R1380 vss.n1872 vss.t260 290.827
R1381 vss.t270 vss.n527 290.827
R1382 vss.n1566 vss.n899 289.13
R1383 vss.n1538 vss.n1537 289.13
R1384 vss.n2221 vss.n224 289.13
R1385 vss.n2244 vss.n243 289.13
R1386 vss.n1530 vss.n248 289.13
R1387 vss.n1400 vss.n983 289.13
R1388 vss.n2180 vss.n2179 289.13
R1389 vss.n2188 vss.n267 289.13
R1390 vss.n2088 vss.n2087 289.13
R1391 vss.n452 vss.n448 289.13
R1392 vss.n1712 vss.n388 289.13
R1393 vss.n1686 vss.n389 289.13
R1394 vss.n1943 vss.n540 289.13
R1395 vss.n1941 vss.n1940 289.13
R1396 vss.n689 vss.n238 289.13
R1397 vss.n661 vss.n660 289.13
R1398 vss.n1597 vss.n1596 282.353
R1399 vss.n1597 vss.n882 282.353
R1400 vss.n1005 vss.n1004 282.353
R1401 vss.n1005 vss.n1001 282.353
R1402 vss.n996 vss.n929 282.353
R1403 vss.n994 vss.n929 282.353
R1404 vss.n1359 vss.n1014 282.353
R1405 vss.n1359 vss.n1013 282.353
R1406 vss.n1870 vss.n1869 282.353
R1407 vss.n1870 vss.n1865 282.353
R1408 vss.n1752 vss.n1751 282.353
R1409 vss.n1754 vss.n1751 282.353
R1410 vss.n1450 vss.n1443 282.353
R1411 vss.n1450 vss.n1442 282.353
R1412 vss.n844 vss.n843 282.353
R1413 vss.n844 vss.n830 282.353
R1414 vss.n2039 vss.n504 282.353
R1415 vss.n2038 vss.n504 282.353
R1416 vss.n2079 vss.n2078 282.353
R1417 vss.n2079 vss.n512 282.353
R1418 vss.n2044 vss.n503 282.353
R1419 vss.n2046 vss.n503 282.353
R1420 vss.n710 vss.n709 282.353
R1421 vss.n712 vss.n709 282.353
R1422 vss.n744 vss.n743 282.353
R1423 vss.n746 vss.n743 282.353
R1424 vss.n2137 vss.n2136 282.353
R1425 vss.n2136 vss.n397 282.353
R1426 vss.n838 vss.n829 282.353
R1427 vss.n840 vss.n829 282.353
R1428 vss.n1254 vss.n1253 282.353
R1429 vss.n1254 vss.n1246 282.353
R1430 vss.n1667 vss.n610 280.848
R1431 vss.n447 vss.n446 280.848
R1432 vss.n1678 vss.n1665 280.848
R1433 vss.n2110 vss.n433 280.848
R1434 vss.n1121 vss.n1092 280.848
R1435 vss.n1488 vss.n956 280.848
R1436 vss.n1114 vss.n1113 280.848
R1437 vss.n1474 vss.n1473 280.848
R1438 vss.n2216 vss.t92 279.584
R1439 vss.n2183 vss.t69 279.584
R1440 vss.n2091 vss.t66 279.584
R1441 vss.n1968 vss.t94 279.584
R1442 vss.n2100 vss.n451 260.168
R1443 vss.n2097 vss.n454 260.168
R1444 vss.n1688 vss.n394 260.168
R1445 vss.n2142 vss.n2141 260.168
R1446 vss.n2248 vss.n2247 260.168
R1447 vss.n2191 vss.n2190 260.168
R1448 vss.n1534 vss.n1533 260.168
R1449 vss.n1527 vss.n1525 260.168
R1450 vss.n1938 vss.n451 260.168
R1451 vss.n1936 vss.n454 260.168
R1452 vss.n2141 vss.n392 260.168
R1453 vss.n663 vss.n394 260.168
R1454 vss.n2192 vss.n2191 260.168
R1455 vss.n2247 vss.n2246 260.168
R1456 vss.n1525 vss.n1524 260.168
R1457 vss.n1535 vss.n1534 260.168
R1458 vss.n686 vss.n630 252.952
R1459 vss.n2218 vss.n2216 252.952
R1460 vss.n1169 vss.n901 252.952
R1461 vss.n2183 vss.n2182 252.952
R1462 vss.n1068 vss.n1067 252.952
R1463 vss.n2091 vss.n2090 252.952
R1464 vss.n1715 vss.n1714 252.952
R1465 vss.n2010 vss.n535 246.959
R1466 vss.n2010 vss.n534 246.959
R1467 vss.n2010 vss.n533 246.959
R1468 vss.n2010 vss.n532 246.959
R1469 vss.n2010 vss.n531 246.959
R1470 vss.n2010 vss.n530 246.959
R1471 vss.n1841 vss.n1817 246.959
R1472 vss.n1841 vss.n1816 246.959
R1473 vss.n1841 vss.n1815 246.959
R1474 vss.n1841 vss.n1814 246.959
R1475 vss.n1841 vss.n1813 246.959
R1476 vss.n1841 vss.n1812 246.959
R1477 vss.n1968 vss.n1929 246.959
R1478 vss.n1968 vss.n1928 246.959
R1479 vss.n1968 vss.n1930 246.959
R1480 vss.n1968 vss.n1927 246.959
R1481 vss.n1968 vss.n1931 246.959
R1482 vss.n1968 vss.n1967 246.959
R1483 vss.n665 vss.n630 246.959
R1484 vss.n670 vss.n630 246.959
R1485 vss.n672 vss.n630 246.959
R1486 vss.n677 vss.n630 246.959
R1487 vss.n679 vss.n630 246.959
R1488 vss.n684 vss.n630 246.959
R1489 vss.n1627 vss.n645 246.959
R1490 vss.n1627 vss.n644 246.959
R1491 vss.n1627 vss.n643 246.959
R1492 vss.n1627 vss.n642 246.959
R1493 vss.n1627 vss.n646 246.959
R1494 vss.n1627 vss.n1626 246.959
R1495 vss.n280 vss.n279 246.959
R1496 vss.n2238 vss.n280 246.959
R1497 vss.n283 vss.n280 246.959
R1498 vss.n2231 vss.n280 246.959
R1499 vss.n286 vss.n280 246.959
R1500 vss.n2224 vss.n280 246.959
R1501 vss.n2216 vss.n294 246.959
R1502 vss.n2216 vss.n293 246.959
R1503 vss.n2216 vss.n292 246.959
R1504 vss.n2216 vss.n295 246.959
R1505 vss.n2216 vss.n291 246.959
R1506 vss.n2216 vss.n2215 246.959
R1507 vss.n1169 vss.n1138 246.959
R1508 vss.n1169 vss.n1139 246.959
R1509 vss.n1169 vss.n1140 246.959
R1510 vss.n1169 vss.n1141 246.959
R1511 vss.n1169 vss.n1142 246.959
R1512 vss.n1169 vss.n1168 246.959
R1513 vss.n1562 vss.n1561 246.959
R1514 vss.n1561 vss.n908 246.959
R1515 vss.n1561 vss.n907 246.959
R1516 vss.n1561 vss.n909 246.959
R1517 vss.n1561 vss.n906 246.959
R1518 vss.n1561 vss.n1560 246.959
R1519 vss.n2167 vss.n382 246.959
R1520 vss.n2167 vss.n384 246.959
R1521 vss.n2167 vss.n380 246.959
R1522 vss.n2167 vss.n379 246.959
R1523 vss.n2167 vss.n2166 246.959
R1524 vss.n364 vss.n340 246.959
R1525 vss.n364 vss.n339 246.959
R1526 vss.n364 vss.n338 246.959
R1527 vss.n364 vss.n337 246.959
R1528 vss.n364 vss.n336 246.959
R1529 vss.n364 vss.n335 246.959
R1530 vss.n2184 vss.n2183 246.959
R1531 vss.n2183 vss.n307 246.959
R1532 vss.n2183 vss.n306 246.959
R1533 vss.n2183 vss.n304 246.959
R1534 vss.n2183 vss.n308 246.959
R1535 vss.n1068 vss.n1043 246.959
R1536 vss.n1068 vss.n1041 246.959
R1537 vss.n1068 vss.n1040 246.959
R1538 vss.n1068 vss.n1038 246.959
R1539 vss.n1068 vss.n1039 246.959
R1540 vss.n1396 vss.n1373 246.959
R1541 vss.n1396 vss.n1372 246.959
R1542 vss.n1396 vss.n1374 246.959
R1543 vss.n1396 vss.n1371 246.959
R1544 vss.n1396 vss.n1370 246.959
R1545 vss.n1397 vss.n1396 246.959
R1546 vss.n2092 vss.n2091 246.959
R1547 vss.n2091 vss.n461 246.959
R1548 vss.n2091 vss.n462 246.959
R1549 vss.n2091 vss.n463 246.959
R1550 vss.n2091 vss.n460 246.959
R1551 vss.n1715 vss.n600 246.959
R1552 vss.n1715 vss.n605 246.959
R1553 vss.n1715 vss.n602 246.959
R1554 vss.n1715 vss.n604 246.959
R1555 vss.n1715 vss.n603 246.959
R1556 vss.n1510 vss.n1509 240.941
R1557 vss.n1510 vss.n945 240.941
R1558 vss.n2125 vss.n2124 240.941
R1559 vss.n2125 vss.n416 240.941
R1560 vss.n1318 vss.n1317 240.941
R1561 vss.n1319 vss.n1318 240.941
R1562 vss.n623 vss.n553 240.941
R1563 vss.n624 vss.n623 240.941
R1564 vss.n1596 vss.t258 239.812
R1565 vss.t257 vss.n882 239.812
R1566 vss.n1004 vss.t251 239.812
R1567 vss.t250 vss.n1001 239.812
R1568 vss.n996 vss.t244 239.812
R1569 vss.t243 vss.n994 239.812
R1570 vss.t227 vss.n1014 239.812
R1571 vss.t226 vss.n1013 239.812
R1572 vss.n1869 vss.t218 239.812
R1573 vss.t217 vss.n1865 239.812
R1574 vss.t221 vss.n1752 239.812
R1575 vss.n1754 vss.t220 239.812
R1576 vss.t224 vss.n1443 239.812
R1577 vss.t223 vss.n1442 239.812
R1578 vss.n843 vss.t249 239.812
R1579 vss.t248 vss.n830 239.812
R1580 vss.t245 vss.n2039 239.812
R1581 vss.t237 vss.n2038 239.812
R1582 vss.n2078 vss.t252 239.812
R1583 vss.t233 vss.n512 239.812
R1584 vss.t236 vss.n2044 239.812
R1585 vss.n2046 vss.t235 239.812
R1586 vss.t247 vss.n710 239.812
R1587 vss.n712 vss.t246 239.812
R1588 vss.t253 vss.n744 239.812
R1589 vss.n746 vss.t231 239.812
R1590 vss.t240 vss.n2137 239.812
R1591 vss.n397 vss.t239 239.812
R1592 vss.t241 vss.n838 239.812
R1593 vss.n840 vss.t229 239.812
R1594 vss.n1253 vss.t259 239.812
R1595 vss.t255 vss.n1246 239.812
R1596 vss.n1683 vss.n610 235.672
R1597 vss.n2105 vss.n447 235.672
R1598 vss.n1665 vss.n1664 235.672
R1599 vss.n1912 vss.n433 235.672
R1600 vss.n1096 vss.n1092 235.672
R1601 vss.n1488 vss.n1487 235.672
R1602 vss.n1116 vss.n1114 235.672
R1603 vss.n1473 vss.n1470 235.672
R1604 vss.n454 vss.n453 219.327
R1605 vss.n614 vss.n394 219.327
R1606 vss.n2191 vss.n297 219.327
R1607 vss.n1534 vss.n918 219.327
R1608 vss.n1528 vss.n923 215.762
R1609 vss.n1387 vss.n1386 215.762
R1610 vss.n1391 vss.n1390 215.762
R1611 vss.n1395 vss.n1376 215.762
R1612 vss.n1395 vss.n1375 215.762
R1613 vss.n1383 vss.n1382 215.762
R1614 vss.n1379 vss.n986 215.762
R1615 vss.n1532 vss.n920 215.762
R1616 vss.n1045 vss.n920 215.762
R1617 vss.n1049 vss.n1048 215.762
R1618 vss.n1053 vss.n1052 215.762
R1619 vss.n1057 vss.n1056 215.762
R1620 vss.n1059 vss.n1042 215.762
R1621 vss.n1062 vss.n1042 215.762
R1622 vss.n1066 vss.n1044 215.762
R1623 vss.n302 vss.n298 215.762
R1624 vss.n2185 vss.n301 215.762
R1625 vss.n315 vss.n314 215.762
R1626 vss.n317 vss.n305 215.762
R1627 vss.n320 vss.n305 215.762
R1628 vss.n324 vss.n323 215.762
R1629 vss.n326 vss.n309 215.762
R1630 vss.n310 vss.n309 215.762
R1631 vss.n2101 vss.n450 215.762
R1632 vss.n1820 vss.n1819 215.762
R1633 vss.n1824 vss.n1823 215.762
R1634 vss.n1828 vss.n1827 215.762
R1635 vss.n1832 vss.n1831 215.762
R1636 vss.n1836 vss.n1835 215.762
R1637 vss.n1840 vss.n1839 215.762
R1638 vss.n1690 vss.n1689 215.762
R1639 vss.n1694 vss.n1693 215.762
R1640 vss.n1698 vss.n1697 215.762
R1641 vss.n1700 vss.n601 215.762
R1642 vss.n1703 vss.n601 215.762
R1643 vss.n1705 vss.n606 215.762
R1644 vss.n1708 vss.n606 215.762
R1645 vss.n1710 vss.n607 215.762
R1646 vss.n2096 vss.n455 215.762
R1647 vss.n2093 vss.n455 215.762
R1648 vss.n468 vss.n458 215.762
R1649 vss.n472 vss.n471 215.762
R1650 vss.n476 vss.n475 215.762
R1651 vss.n478 vss.n464 215.762
R1652 vss.n481 vss.n464 215.762
R1653 vss.n483 vss.n465 215.762
R1654 vss.n2249 vss.n269 215.762
R1655 vss.n343 vss.n342 215.762
R1656 vss.n347 vss.n346 215.762
R1657 vss.n351 vss.n350 215.762
R1658 vss.n355 vss.n354 215.762
R1659 vss.n359 vss.n358 215.762
R1660 vss.n363 vss.n362 215.762
R1661 vss.n2143 vss.n383 215.762
R1662 vss.n2146 vss.n383 215.762
R1663 vss.n2148 vss.n381 215.762
R1664 vss.n2151 vss.n381 215.762
R1665 vss.n2153 vss.n385 215.762
R1666 vss.n2156 vss.n385 215.762
R1667 vss.n2160 vss.n2159 215.762
R1668 vss.n2162 vss.n386 215.762
R1669 vss.n1990 vss.n1989 215.762
R1670 vss.n1994 vss.n1993 215.762
R1671 vss.n1998 vss.n1997 215.762
R1672 vss.n2002 vss.n2001 215.762
R1673 vss.n2006 vss.n2005 215.762
R1674 vss.n2009 vss.n537 215.762
R1675 vss.n2009 vss.n536 215.762
R1676 vss.n1540 vss.n904 215.762
R1677 vss.n1544 vss.n1543 215.762
R1678 vss.n1548 vss.n1547 215.762
R1679 vss.n1550 vss.n910 215.762
R1680 vss.n1553 vss.n910 215.762
R1681 vss.n1555 vss.n911 215.762
R1682 vss.n1559 vss.n912 215.762
R1683 vss.n1167 vss.n1144 215.762
R1684 vss.n1164 vss.n1143 215.762
R1685 vss.n1162 vss.n1161 215.762
R1686 vss.n1158 vss.n1157 215.762
R1687 vss.n1155 vss.n1154 215.762
R1688 vss.n1151 vss.n1150 215.762
R1689 vss.n1148 vss.n916 215.762
R1690 vss.n2219 vss.n289 215.762
R1691 vss.n2196 vss.n2195 215.762
R1692 vss.n2200 vss.n2199 215.762
R1693 vss.n2204 vss.n2203 215.762
R1694 vss.n2208 vss.n2207 215.762
R1695 vss.n2210 vss.n296 215.762
R1696 vss.n2214 vss.n2193 215.762
R1697 vss.n2226 vss.n2225 215.762
R1698 vss.n2230 vss.n284 215.762
R1699 vss.n2233 vss.n2232 215.762
R1700 vss.n2237 vss.n281 215.762
R1701 vss.n2240 vss.n2239 215.762
R1702 vss.n278 vss.n275 215.762
R1703 vss.n275 vss.n273 215.762
R1704 vss.n1628 vss.n640 215.762
R1705 vss.n1607 vss.n1606 215.762
R1706 vss.n1611 vss.n1610 215.762
R1707 vss.n1615 vss.n1614 215.762
R1708 vss.n1619 vss.n1618 215.762
R1709 vss.n1621 vss.n647 215.762
R1710 vss.n1625 vss.n648 215.762
R1711 vss.n687 vss.n685 215.762
R1712 vss.n683 vss.n650 215.762
R1713 vss.n680 vss.n678 215.762
R1714 vss.n676 vss.n653 215.762
R1715 vss.n673 vss.n671 215.762
R1716 vss.n669 vss.n656 215.762
R1717 vss.n666 vss.n664 215.762
R1718 vss.n1947 vss.n1946 215.762
R1719 vss.n1951 vss.n1950 215.762
R1720 vss.n1955 vss.n1954 215.762
R1721 vss.n1959 vss.n1958 215.762
R1722 vss.n1961 vss.n1932 215.762
R1723 vss.n1933 vss.n1932 215.762
R1724 vss.n1966 vss.n1934 215.762
R1725 vss.n2082 vss.n502 207.06
R1726 vss.n2082 vss.n501 207.06
R1727 vss.n1588 vss.n881 207.06
R1728 vss.n1587 vss.n881 207.06
R1729 vss.n856 vss.n828 207.06
R1730 vss.n857 vss.n856 207.06
R1731 vss.n1350 vss.n1015 207.06
R1732 vss.n1352 vss.n1015 207.06
R1733 vss.n1875 vss.n1874 207.06
R1734 vss.n1874 vss.n1805 207.06
R1735 vss.n1749 vss.n1748 207.06
R1736 vss.n1749 vss.n1742 207.06
R1737 vss.n1454 vss.n1453 207.06
R1738 vss.n1453 vss.n1441 207.06
R1739 vss.n524 vss.n511 207.06
R1740 vss.n522 vss.n511 207.06
R1741 vss.n2052 vss.n505 207.06
R1742 vss.n2054 vss.n505 207.06
R1743 vss.n741 vss.n740 207.06
R1744 vss.n741 vss.n734 207.06
R1745 vss.n789 vss.n788 207.06
R1746 vss.n789 vss.n694 207.06
R1747 vss.n1520 vss.n1519 207.06
R1748 vss.n1519 vss.n927 207.06
R1749 vss.n1257 vss.n1256 207.06
R1750 vss.n1256 vss.n1177 207.06
R1751 vss.n1235 vss.n1234 207.06
R1752 vss.n1235 vss.n1190 207.06
R1753 vss.n850 vss.n849 207.06
R1754 vss.n850 vss.n845 207.06
R1755 vss.n783 vss.n782 207.06
R1756 vss.n785 vss.n782 207.06
R1757 vss.t230 vss.n637 196.81
R1758 vss.t256 vss.n1591 196.81
R1759 vss.n1260 vss.t254 196.81
R1760 vss.t219 vss.n593 196.81
R1761 vss.n1457 vss.t222 196.81
R1762 vss.n1348 vss.t225 196.81
R1763 vss.n1878 vss.t216 196.81
R1764 vss.t232 vss.n516 196.81
R1765 vss.n1638 vss.t80 188.035
R1766 vss.n1268 vss.t139 188.035
R1767 vss.t67 vss.n597 188.035
R1768 vss.t70 vss.n1035 188.035
R1769 vss.n1509 vss.n1508 187.482
R1770 vss.n1509 vss.n946 187.482
R1771 vss.n970 vss.n945 187.482
R1772 vss.n978 vss.n945 187.482
R1773 vss.n2124 vss.n2123 187.482
R1774 vss.n2124 vss.n417 187.482
R1775 vss.n1771 vss.n416 187.482
R1776 vss.n584 vss.n416 187.482
R1777 vss.n1317 vss.n892 187.482
R1778 vss.n1317 vss.n895 187.482
R1779 vss.n1319 vss.n1316 187.482
R1780 vss.n1320 vss.n1319 187.482
R1781 vss.n1916 vss.n553 187.482
R1782 vss.n618 vss.n553 187.482
R1783 vss.n624 vss.n552 187.482
R1784 vss.n625 vss.n624 187.482
R1785 vss.n442 vss.t306 183.671
R1786 vss.n2120 vss.t308 183.671
R1787 vss.n1900 vss.t314 183.671
R1788 vss.n1672 vss.t316 183.671
R1789 vss.n1482 vss.t318 183.671
R1790 vss.n1505 vss.t320 183.671
R1791 vss.n1131 vss.t324 183.671
R1792 vss.n1108 vss.t326 183.671
R1793 vss.n1399 vss.n1398 182.929
R1794 vss.n1840 vss.n466 182.929
R1795 vss.n363 vss.n311 182.929
R1796 vss.n2165 vss.n387 182.929
R1797 vss.n1986 vss.n1985 182.929
R1798 vss.n1564 vss.n1563 182.929
R1799 vss.n2223 vss.n287 182.929
R1800 vss.n1629 vss.n1628 182.929
R1801 vss.n1942 vss.n541 182.929
R1802 vss.n2042 vss.n451 176.269
R1803 vss.n2141 vss.n2140 176.269
R1804 vss.n2247 vss.n271 176.269
R1805 vss.n1525 vss.n917 176.269
R1806 vss.n2121 vss.t309 175.596
R1807 vss.n1899 vss.t313 175.596
R1808 vss.n1506 vss.t304 175.596
R1809 vss.n1322 vss.t323 175.596
R1810 vss.n2032 vss.n2031 169.412
R1811 vss.n2033 vss.n2032 169.412
R1812 vss.n1598 vss.n880 169.412
R1813 vss.n1599 vss.n1598 169.412
R1814 vss.n818 vss.n817 169.412
R1815 vss.n817 vss.n815 169.412
R1816 vss.n1357 vss.n1356 169.412
R1817 vss.n1357 vss.n1016 169.412
R1818 vss.n1861 vss.n1860 169.412
R1819 vss.n1861 vss.n1810 169.412
R1820 vss.n1437 vss.n1436 169.412
R1821 vss.n1438 vss.n1437 169.412
R1822 vss.n1761 vss.n1760 169.412
R1823 vss.n1760 vss.n1758 169.412
R1824 vss.n2072 vss.n510 169.412
R1825 vss.n2071 vss.n510 169.412
R1826 vss.n2025 vss.n506 169.412
R1827 vss.n2027 vss.n506 169.412
R1828 vss.n751 vss.n750 169.412
R1829 vss.n753 vss.n750 169.412
R1830 vss.n704 vss.n693 169.412
R1831 vss.n703 vss.n693 169.412
R1832 vss.n1206 vss.n1205 169.412
R1833 vss.n1205 vss.n1203 169.412
R1834 vss.n1245 vss.n1244 169.412
R1835 vss.n1245 vss.n1179 169.412
R1836 vss.n1198 vss.n1189 169.412
R1837 vss.n1197 vss.n1189 169.412
R1838 vss.n810 vss.n809 169.412
R1839 vss.n809 vss.n807 169.412
R1840 vss.n719 vss.n718 169.412
R1841 vss.n718 vss.n716 169.412
R1842 vss.n1639 vss.n1637 167.977
R1843 vss.n1577 vss.n1574 167.977
R1844 vss.n1269 vss.n1267 167.977
R1845 vss.n1731 vss.n1730 167.977
R1846 vss.n1465 vss.n1464 167.977
R1847 vss.n1341 vss.n1340 167.977
R1848 vss.n1886 vss.n1885 167.977
R1849 vss.n1977 vss.n1975 167.977
R1850 vss.n1902 vss.n402 165.648
R1851 vss.n1903 vss.n1902 165.648
R1852 vss.n1670 vss.n1669 165.648
R1853 vss.n1670 vss.n572 165.648
R1854 vss.n445 vss.n444 165.648
R1855 vss.n444 vss.n424 165.648
R1856 vss.n2118 vss.n403 165.648
R1857 vss.n2118 vss.n2117 165.648
R1858 vss.n1909 vss.n564 165.648
R1859 vss.n1675 vss.n564 165.648
R1860 vss.n1914 vss.n432 165.648
R1861 vss.n2111 vss.n432 165.648
R1862 vss.n1911 vss.n563 165.648
R1863 vss.n563 vss.n431 165.648
R1864 vss.n1099 vss.n1097 165.648
R1865 vss.n1097 vss.n931 165.648
R1866 vss.n1101 vss.n1091 165.648
R1867 vss.n1122 vss.n1091 165.648
R1868 vss.n1479 vss.n959 165.648
R1869 vss.n1479 vss.n1478 165.648
R1870 vss.n958 vss.n957 165.648
R1871 vss.n957 vss.n932 165.648
R1872 vss.n1129 vss.n955 165.648
R1873 vss.n1129 vss.n1128 165.648
R1874 vss.n1472 vss.n1469 165.648
R1875 vss.n1494 vss.n1469 165.648
R1876 vss.n1503 vss.n1502 165.648
R1877 vss.n1503 vss.n953 165.648
R1878 vss.n1112 vss.n1110 165.648
R1879 vss.n1110 vss.n1085 165.648
R1880 vss.n1674 vss.n565 165.648
R1881 vss.n1677 vss.n1674 165.648
R1882 vss.t156 vss.n502 164.518
R1883 vss.t141 vss.n501 164.518
R1884 vss.t180 vss.n1588 164.518
R1885 vss.t179 vss.n1587 164.518
R1886 vss.n828 vss.t165 164.518
R1887 vss.n857 vss.t162 164.518
R1888 vss.t155 vss.n1350 164.518
R1889 vss.n1352 vss.t154 164.518
R1890 vss.t146 vss.n1875 164.518
R1891 vss.n1805 vss.t145 164.518
R1892 vss.n1748 vss.t149 164.518
R1893 vss.t148 vss.n1742 164.518
R1894 vss.t152 vss.n1454 164.518
R1895 vss.n1441 vss.t151 164.518
R1896 vss.n524 vss.t174 164.518
R1897 vss.t160 vss.n522 164.518
R1898 vss.t168 vss.n2052 164.518
R1899 vss.n2054 vss.t167 164.518
R1900 vss.n740 vss.t177 164.518
R1901 vss.t176 vss.n734 164.518
R1902 vss.n788 vss.t169 164.518
R1903 vss.t143 vss.n694 164.518
R1904 vss.t166 vss.n1520 164.518
R1905 vss.n927 vss.t158 164.518
R1906 vss.t183 vss.n1257 164.518
R1907 vss.n1177 vss.t182 164.518
R1908 vss.n1234 vss.t173 164.518
R1909 vss.t170 vss.n1190 164.518
R1910 vss.n849 vss.t172 164.518
R1911 vss.t171 vss.n845 164.518
R1912 vss.t164 vss.n783 164.518
R1913 vss.n785 vss.t163 164.518
R1914 vss.n2086 vss.n489 160
R1915 vss.n2086 vss.n488 160
R1916 vss.n1603 vss.n794 160
R1917 vss.n1603 vss.n793 160
R1918 vss.n1237 vss.n1186 160
R1919 vss.n1238 vss.n1237 160
R1920 vss.n866 vss.n865 160
R1921 vss.n865 vss.n864 160
R1922 vss.n1227 vss.n1225 160
R1923 vss.n1228 vss.n1227 160
R1924 vss.n1366 vss.n1365 160
R1925 vss.n1365 vss.n989 160
R1926 vss.n1024 vss.n1023 160
R1927 vss.n1023 vss.n1022 160
R1928 vss.n1853 vss.n486 160
R1929 vss.n1852 vss.n486 160
R1930 vss.n1428 vss.n330 160
R1931 vss.n1430 vss.n330 160
R1932 vss.n1769 vss.n589 160
R1933 vss.n1769 vss.n588 160
R1934 vss.n774 vss.n772 160
R1935 vss.n775 vss.n774 160
R1936 vss.n2178 vss.n332 160
R1937 vss.n2178 vss.n331 160
R1938 vss.n2172 vss.n2171 160
R1939 vss.n2172 vss.n378 160
R1940 vss.n2068 vss.n509 160
R1941 vss.n2066 vss.n509 160
R1942 vss.n2018 vss.n508 160
R1943 vss.n2016 vss.n508 160
R1944 vss.n2063 vss.n507 160
R1945 vss.n2061 vss.n507 160
R1946 vss.n767 vss.n692 160
R1947 vss.n769 vss.n692 160
R1948 vss.n764 vss.n691 160
R1949 vss.n762 vss.n691 160
R1950 vss.n756 vss.n690 160
R1951 vss.n758 vss.n690 160
R1952 vss.n1220 vss.n1188 160
R1953 vss.n1222 vss.n1188 160
R1954 vss.n1217 vss.n1187 160
R1955 vss.n1215 vss.n1187 160
R1956 vss.n801 vss.n792 160
R1957 vss.n799 vss.n792 160
R1958 vss.n871 vss.n791 160
R1959 vss.n869 vss.n791 160
R1960 vss.n1849 vss.n487 160
R1961 vss.n1847 vss.n487 160
R1962 vss.n2084 vss.t273 156.087
R1963 vss.t268 vss.n374 156.087
R1964 vss.t277 vss.n373 156.087
R1965 vss.t286 vss.n1007 156.087
R1966 vss.n1969 vss.n1926 153.207
R1967 vss.n1646 vss.n1645 153.207
R1968 vss.n1306 vss.n290 153.207
R1969 vss.n1276 vss.n1275 153.207
R1970 vss.n1407 vss.n303 153.207
R1971 vss.n1334 vss.n1333 153.207
R1972 vss.n1788 vss.n459 153.207
R1973 vss.n1724 vss.n1723 153.207
R1974 vss.n2058 vss.n2057 146.25
R1975 vss.n2057 vss.n2056 146.25
R1976 vss.n2085 vss.n2084 146.25
R1977 vss.n2086 vss.n2085 146.25
R1978 vss.n773 vss.n374 146.25
R1979 vss.n774 vss.n773 146.25
R1980 vss.n778 vss.n777 146.25
R1981 vss.n777 vss.n776 146.25
R1982 vss.n860 vss.n859 146.25
R1983 vss.n862 vss.n860 146.25
R1984 vss.n861 vss.n373 146.25
R1985 vss.n865 vss.n861 146.25
R1986 vss.n1226 vss.n1007 146.25
R1987 vss.n1227 vss.n1226 146.25
R1988 vss.n1231 vss.n1230 146.25
R1989 vss.n1230 vss.n1229 146.25
R1990 vss.n2029 vss.n2020 146.25
R1991 vss.n2030 vss.n2029 146.25
R1992 vss.n2084 vss.n492 146.25
R1993 vss.n2032 vss.n492 146.25
R1994 vss.n2050 vss.n2049 146.25
R1995 vss.n2049 vss.n2048 146.25
R1996 vss.n2084 vss.n2083 146.25
R1997 vss.n2083 vss.n2082 146.25
R1998 vss.n717 vss.n374 146.25
R1999 vss.n718 vss.n717 146.25
R2000 vss.n722 vss.n721 146.25
R2001 vss.n721 vss.n720 146.25
R2002 vss.n821 vss.n820 146.25
R2003 vss.n820 vss.n819 146.25
R2004 vss.n816 vss.n373 146.25
R2005 vss.n817 vss.n816 146.25
R2006 vss.n780 vss.n374 146.25
R2007 vss.n782 vss.n780 146.25
R2008 vss.n781 vss.n391 146.25
R2009 vss.n784 vss.n781 146.25
R2010 vss.n825 vss.n272 146.25
R2011 vss.n827 vss.n825 146.25
R2012 vss.n826 vss.n373 146.25
R2013 vss.n856 vss.n826 146.25
R2014 vss.n1204 vss.n1007 146.25
R2015 vss.n1205 vss.n1204 146.25
R2016 vss.n1209 vss.n1208 146.25
R2017 vss.n1208 vss.n1207 146.25
R2018 vss.n1007 vss.n928 146.25
R2019 vss.n1519 vss.n928 146.25
R2020 vss.n1523 vss.n1522 146.25
R2021 vss.n1522 vss.n1521 146.25
R2022 vss.n2043 vss.n2042 146.25
R2023 vss.n2045 vss.n2043 146.25
R2024 vss.n2084 vss.n493 146.25
R2025 vss.n503 vss.n493 146.25
R2026 vss.n398 vss.n374 146.25
R2027 vss.n2136 vss.n398 146.25
R2028 vss.n2140 vss.n2139 146.25
R2029 vss.n2139 vss.n2138 146.25
R2030 vss.n836 vss.n271 146.25
R2031 vss.n839 vss.n836 146.25
R2032 vss.n837 vss.n373 146.25
R2033 vss.n837 vss.n829 146.25
R2034 vss.n1007 vss.n998 146.25
R2035 vss.n998 vss.n929 146.25
R2036 vss.n993 vss.n917 146.25
R2037 vss.n995 vss.n993 146.25
R2038 vss.n2042 vss.n2041 146.25
R2039 vss.n2041 vss.n2040 146.25
R2040 vss.n2084 vss.n498 146.25
R2041 vss.n504 vss.n498 146.25
R2042 vss.n708 vss.n374 146.25
R2043 vss.n709 vss.n708 146.25
R2044 vss.n2140 vss.n393 146.25
R2045 vss.n711 vss.n393 146.25
R2046 vss.n833 vss.n271 146.25
R2047 vss.n833 vss.n832 146.25
R2048 vss.n831 vss.n373 146.25
R2049 vss.n844 vss.n831 146.25
R2050 vss.n1007 vss.n1006 146.25
R2051 vss.n1006 vss.n1005 146.25
R2052 vss.n1002 vss.n917 146.25
R2053 vss.n1003 vss.n1002 146.25
R2054 vss.n2051 vss.n2050 146.25
R2055 vss.n2053 vss.n2051 146.25
R2056 vss.n2084 vss.n494 146.25
R2057 vss.n505 vss.n494 146.25
R2058 vss.n2024 vss.n2020 146.25
R2059 vss.n2026 vss.n2024 146.25
R2060 vss.n2084 vss.n497 146.25
R2061 vss.n506 vss.n497 146.25
R2062 vss.n695 vss.n374 146.25
R2063 vss.n789 vss.n695 146.25
R2064 vss.n697 vss.n391 146.25
R2065 vss.n697 vss.n696 146.25
R2066 vss.n847 vss.n272 146.25
R2067 vss.n848 vss.n847 146.25
R2068 vss.n846 vss.n373 146.25
R2069 vss.n850 vss.n846 146.25
R2070 vss.n701 vss.n374 146.25
R2071 vss.n701 vss.n693 146.25
R2072 vss.n722 vss.n706 146.25
R2073 vss.n706 vss.n705 146.25
R2074 vss.n821 vss.n812 146.25
R2075 vss.n812 vss.n811 146.25
R2076 vss.n808 vss.n373 146.25
R2077 vss.n809 vss.n808 146.25
R2078 vss.n1191 vss.n1007 146.25
R2079 vss.n1235 vss.n1191 146.25
R2080 vss.n1523 vss.n924 146.25
R2081 vss.n1192 vss.n924 146.25
R2082 vss.n1195 vss.n1007 146.25
R2083 vss.n1195 vss.n1189 146.25
R2084 vss.n1209 vss.n1200 146.25
R2085 vss.n1200 vss.n1199 146.25
R2086 vss.n2059 vss.n2058 146.25
R2087 vss.n2062 vss.n2059 146.25
R2088 vss.n2084 vss.n495 146.25
R2089 vss.n507 vss.n495 146.25
R2090 vss.n724 vss.n374 146.25
R2091 vss.n724 vss.n692 146.25
R2092 vss.n778 vss.n699 146.25
R2093 vss.n768 vss.n699 146.25
R2094 vss.n859 vss.n803 146.25
R2095 vss.n870 vss.n803 146.25
R2096 vss.n804 vss.n373 146.25
R2097 vss.n804 vss.n791 146.25
R2098 vss.n1211 vss.n1007 146.25
R2099 vss.n1211 vss.n1188 146.25
R2100 vss.n1231 vss.n1193 146.25
R2101 vss.n1221 vss.n1193 146.25
R2102 vss.n2014 vss.n2011 146.25
R2103 vss.n2017 vss.n2014 146.25
R2104 vss.n2015 vss.n2013 146.25
R2105 vss.n2015 vss.n508 146.25
R2106 vss.n1845 vss.n1842 146.25
R2107 vss.n1848 vss.n1845 146.25
R2108 vss.n1846 vss.n1844 146.25
R2109 vss.n1846 vss.n487 146.25
R2110 vss.n726 vss.n370 146.25
R2111 vss.n726 vss.n690 146.25
R2112 vss.n730 vss.n727 146.25
R2113 vss.n757 vss.n727 146.25
R2114 vss.n1592 vss.n875 146.25
R2115 vss.n875 vss.n874 146.25
R2116 vss.n1602 vss.n371 146.25
R2117 vss.n1603 vss.n1602 146.25
R2118 vss.n729 vss.n370 146.25
R2119 vss.n750 vss.n729 146.25
R2120 vss.n749 vss.n748 146.25
R2121 vss.n752 vss.n749 146.25
R2122 vss.n1593 vss.n877 146.25
R2123 vss.n879 vss.n877 146.25
R2124 vss.n878 vss.n371 146.25
R2125 vss.n1598 vss.n878 146.25
R2126 vss.n735 vss.n370 146.25
R2127 vss.n741 vss.n735 146.25
R2128 vss.n738 vss.n637 146.25
R2129 vss.n738 vss.n737 146.25
R2130 vss.n1591 vss.n1590 146.25
R2131 vss.n1590 vss.n1589 146.25
R2132 vss.n1585 vss.n371 146.25
R2133 vss.n1585 vss.n881 146.25
R2134 vss.n732 vss.n370 146.25
R2135 vss.n743 vss.n732 146.25
R2136 vss.n733 vss.n638 146.25
R2137 vss.n745 vss.n733 146.25
R2138 vss.n1575 vss.n885 146.25
R2139 vss.n885 vss.n884 146.25
R2140 vss.n883 vss.n371 146.25
R2141 vss.n1597 vss.n883 146.25
R2142 vss.n760 vss.n372 146.25
R2143 vss.n760 vss.n691 146.25
R2144 vss.n761 vss.n641 146.25
R2145 vss.n763 vss.n761 146.25
R2146 vss.n797 vss.n795 146.25
R2147 vss.n800 vss.n797 146.25
R2148 vss.n798 vss.n375 146.25
R2149 vss.n798 vss.n792 146.25
R2150 vss.n1236 vss.n990 146.25
R2151 vss.n1237 vss.n1236 146.25
R2152 vss.n1241 vss.n1240 146.25
R2153 vss.n1240 vss.n1239 146.25
R2154 vss.n1180 vss.n990 146.25
R2155 vss.n1245 vss.n1180 146.25
R2156 vss.n1183 vss.n1182 146.25
R2157 vss.n1182 vss.n1181 146.25
R2158 vss.n1178 vss.n990 146.25
R2159 vss.n1256 vss.n1178 146.25
R2160 vss.n1260 vss.n1259 146.25
R2161 vss.n1259 vss.n1258 146.25
R2162 vss.n1247 vss.n990 146.25
R2163 vss.n1254 vss.n1247 146.25
R2164 vss.n1251 vss.n1250 146.25
R2165 vss.n1251 vss.n1249 146.25
R2166 vss.n1213 vss.n991 146.25
R2167 vss.n1213 vss.n1187 146.25
R2168 vss.n1214 vss.n905 146.25
R2169 vss.n1216 vss.n1214 146.25
R2170 vss.n2174 vss.n2173 146.25
R2171 vss.n2173 vss.n2172 146.25
R2172 vss.n2169 vss.n2168 146.25
R2173 vss.n2170 vss.n2169 146.25
R2174 vss.n367 vss.n366 146.25
R2175 vss.n366 vss.n365 146.25
R2176 vss.n2177 vss.n2176 146.25
R2177 vss.n2178 vss.n2177 146.25
R2178 vss.n594 vss.n369 146.25
R2179 vss.n1751 vss.n594 146.25
R2180 vss.n1741 vss.n1740 146.25
R2181 vss.n1753 vss.n1741 146.25
R2182 vss.n1447 vss.n1446 146.25
R2183 vss.n1447 vss.n1445 146.25
R2184 vss.n1449 vss.n368 146.25
R2185 vss.n1450 vss.n1449 146.25
R2186 vss.n1743 vss.n369 146.25
R2187 vss.n1749 vss.n1743 146.25
R2188 vss.n1746 vss.n593 146.25
R2189 vss.n1746 vss.n1745 146.25
R2190 vss.n1457 vss.n1456 146.25
R2191 vss.n1456 vss.n1455 146.25
R2192 vss.n1452 vss.n368 146.25
R2193 vss.n1453 vss.n1452 146.25
R2194 vss.n1759 vss.n369 146.25
R2195 vss.n1760 vss.n1759 146.25
R2196 vss.n1764 vss.n1763 146.25
R2197 vss.n1763 vss.n1762 146.25
R2198 vss.n1433 vss.n1432 146.25
R2199 vss.n1435 vss.n1433 146.25
R2200 vss.n1434 vss.n368 146.25
R2201 vss.n1437 vss.n1434 146.25
R2202 vss.n1768 vss.n369 146.25
R2203 vss.n1769 vss.n1768 146.25
R2204 vss.n1766 vss.n1765 146.25
R2205 vss.n1766 vss.n591 146.25
R2206 vss.n1425 vss.n1423 146.25
R2207 vss.n1429 vss.n1425 146.25
R2208 vss.n1426 vss.n368 146.25
R2209 vss.n1426 vss.n330 146.25
R2210 vss.n1361 vss.n1360 146.25
R2211 vss.n1360 vss.n1359 146.25
R2212 vss.n1033 vss.n1032 146.25
R2213 vss.n1032 vss.n1031 146.25
R2214 vss.n1361 vss.n1008 146.25
R2215 vss.n1015 vss.n1008 146.25
R2216 vss.n1349 vss.n1348 146.25
R2217 vss.n1351 vss.n1349 146.25
R2218 vss.n1361 vss.n1010 146.25
R2219 vss.n1357 vss.n1010 146.25
R2220 vss.n1028 vss.n1018 146.25
R2221 vss.n1018 vss.n1017 146.25
R2222 vss.n1361 vss.n1009 146.25
R2223 vss.n1023 vss.n1009 146.25
R2224 vss.n1027 vss.n1026 146.25
R2225 vss.n1026 vss.n1025 146.25
R2226 vss.n1364 vss.n1363 146.25
R2227 vss.n1365 vss.n1364 146.25
R2228 vss.n1369 vss.n1368 146.25
R2229 vss.n1368 vss.n1367 146.25
R2230 vss.n1867 vss.n1866 146.25
R2231 vss.n1868 vss.n1867 146.25
R2232 vss.n1872 vss.n1871 146.25
R2233 vss.n1871 vss.n1870 146.25
R2234 vss.n1878 vss.n1877 146.25
R2235 vss.n1877 vss.n1876 146.25
R2236 vss.n1873 vss.n1872 146.25
R2237 vss.n1874 vss.n1873 146.25
R2238 vss.n1858 vss.n1857 146.25
R2239 vss.n1859 vss.n1858 146.25
R2240 vss.n1872 vss.n1862 146.25
R2241 vss.n1862 vss.n1861 146.25
R2242 vss.n1856 vss.n1855 146.25
R2243 vss.n1855 vss.n1854 146.25
R2244 vss.n1872 vss.n1807 146.25
R2245 vss.n1807 vss.n486 146.25
R2246 vss.n527 vss.n513 146.25
R2247 vss.n2079 vss.n513 146.25
R2248 vss.n542 vss.n515 146.25
R2249 vss.n515 vss.n514 146.25
R2250 vss.n528 vss.n517 146.25
R2251 vss.n2067 vss.n528 146.25
R2252 vss.n529 vss.n527 146.25
R2253 vss.n529 vss.n509 146.25
R2254 vss.n2075 vss.n2074 146.25
R2255 vss.n2074 vss.n2073 146.25
R2256 vss.n527 vss.n519 146.25
R2257 vss.n519 vss.n510 146.25
R2258 vss.n521 vss.n516 146.25
R2259 vss.n523 vss.n521 146.25
R2260 vss.n527 vss.n526 146.25
R2261 vss.n526 vss.n511 146.25
R2262 vss.n1969 vss.n1968 140.127
R2263 vss.n1645 vss.n630 140.127
R2264 vss.n2216 vss.n290 140.127
R2265 vss.n1275 vss.n1169 140.127
R2266 vss.n2183 vss.n303 140.127
R2267 vss.n1334 vss.n1068 140.127
R2268 vss.n2091 vss.n459 140.127
R2269 vss.n1724 vss.n1715 140.127
R2270 vss.n730 vss.t175 134.131
R2271 vss.n1592 vss.t178 134.131
R2272 vss.t181 vss.n1241 134.131
R2273 vss.n1765 vss.t147 134.131
R2274 vss.t150 vss.n1423 134.131
R2275 vss.t153 vss.n1027 134.131
R2276 vss.n1856 vss.t144 134.131
R2277 vss.t159 vss.n517 134.131
R2278 vss.n1904 vss.n1903 132.518
R2279 vss.n1904 vss.n572 132.518
R2280 vss.n1668 vss.n402 132.518
R2281 vss.n1669 vss.n1668 132.518
R2282 vss.n2116 vss.n424 132.518
R2283 vss.n2117 vss.n2116 132.518
R2284 vss.n445 vss.n438 132.518
R2285 vss.n438 vss.n403 132.518
R2286 vss.n1676 vss.n1675 132.518
R2287 vss.n1677 vss.n1676 132.518
R2288 vss.n1909 vss.n1908 132.518
R2289 vss.n1908 vss.n565 132.518
R2290 vss.n1915 vss.n1914 132.518
R2291 vss.n1915 vss.n1911 132.518
R2292 vss.n2112 vss.n2111 132.518
R2293 vss.n2112 vss.n431 132.518
R2294 vss.n1100 vss.n1099 132.518
R2295 vss.n1101 vss.n1100 132.518
R2296 vss.n1123 vss.n931 132.518
R2297 vss.n1123 vss.n1122 132.518
R2298 vss.n1478 vss.n1477 132.518
R2299 vss.n1477 vss.n932 132.518
R2300 vss.n1499 vss.n959 132.518
R2301 vss.n1499 vss.n958 132.518
R2302 vss.n1128 vss.n1127 132.518
R2303 vss.n1127 vss.n1085 132.518
R2304 vss.n1111 vss.n955 132.518
R2305 vss.n1112 vss.n1111 132.518
R2306 vss.n1472 vss.n954 132.518
R2307 vss.n1502 vss.n954 132.518
R2308 vss.n1495 vss.n1494 132.518
R2309 vss.n1495 vss.n953 132.518
R2310 vss.n2031 vss.t112 126.871
R2311 vss.n2033 vss.t109 126.871
R2312 vss.n880 vss.t135 126.871
R2313 vss.n1599 vss.t134 126.871
R2314 vss.t118 vss.n818 126.871
R2315 vss.n815 vss.t116 126.871
R2316 vss.n1356 vss.t106 126.871
R2317 vss.t96 vss.n1016 126.871
R2318 vss.n1860 vss.t99 126.871
R2319 vss.t98 vss.n1810 126.871
R2320 vss.n1436 vss.t105 126.871
R2321 vss.n1438 vss.t104 126.871
R2322 vss.t102 vss.n1761 126.871
R2323 vss.n1758 vss.t101 126.871
R2324 vss.t129 vss.n2072 126.871
R2325 vss.t122 vss.n2071 126.871
R2326 vss.t120 vss.n2025 126.871
R2327 vss.n2027 vss.t108 126.871
R2328 vss.t132 vss.n751 126.871
R2329 vss.n753 vss.t131 126.871
R2330 vss.t124 vss.n704 126.871
R2331 vss.t123 vss.n703 126.871
R2332 vss.t119 vss.n1206 126.871
R2333 vss.n1203 vss.t114 126.871
R2334 vss.n1244 vss.t138 126.871
R2335 vss.t137 vss.n1179 126.871
R2336 vss.t128 vss.n1198 126.871
R2337 vss.t127 vss.n1197 126.871
R2338 vss.t126 vss.n810 126.871
R2339 vss.n807 vss.t125 126.871
R2340 vss.t117 vss.n719 126.871
R2341 vss.n716 vss.t111 126.871
R2342 vss.t130 vss.t175 125.356
R2343 vss.t133 vss.t178 125.356
R2344 vss.t136 vss.t181 125.356
R2345 vss.t100 vss.t147 125.356
R2346 vss.t150 vss.t103 125.356
R2347 vss.t95 vss.t153 125.356
R2348 vss.t144 vss.t97 125.356
R2349 vss.t121 vss.t159 125.356
R2350 vss.n1631 vss.n637 122.85
R2351 vss.n1591 vss.n1583 122.85
R2352 vss.n1261 vss.n1260 122.85
R2353 vss.n1732 vss.n593 122.85
R2354 vss.n1458 vss.n1457 122.85
R2355 vss.n1348 vss.n1347 122.85
R2356 vss.n1879 vss.n1878 122.85
R2357 vss.n1983 vss.n516 122.85
R2358 vss.n638 vss.n634 120.343
R2359 vss.n1576 vss.n1575 120.343
R2360 vss.n1250 vss.n1172 120.343
R2361 vss.n1740 vss.n1739 120.343
R2362 vss.n1446 vss.n1417 120.343
R2363 vss.n1034 vss.n1033 120.343
R2364 vss.n1866 vss.n1798 120.343
R2365 vss.n1976 vss.n542 120.343
R2366 vss.t275 vss.n488 117.46
R2367 vss.t276 vss.n489 117.46
R2368 vss.t297 vss.n793 117.46
R2369 vss.t301 vss.n794 117.46
R2370 vss.t303 vss.n1238 117.46
R2371 vss.n1186 vss.t299 117.46
R2372 vss.n866 vss.t279 117.46
R2373 vss.n864 vss.t278 117.46
R2374 vss.t288 vss.n1228 117.46
R2375 vss.n1225 vss.t287 117.46
R2376 vss.t199 vss.n1366 117.46
R2377 vss.n989 vss.t188 117.46
R2378 vss.t285 vss.n1024 117.46
R2379 vss.n1022 vss.t267 117.46
R2380 vss.t262 vss.n1853 117.46
R2381 vss.t261 vss.n1852 117.46
R2382 vss.t283 vss.n1428 117.46
R2383 vss.n1430 vss.t282 117.46
R2384 vss.t265 vss.n589 117.46
R2385 vss.t264 vss.n588 117.46
R2386 vss.t284 vss.n775 117.46
R2387 vss.n772 vss.t280 117.46
R2388 vss.t195 vss.n332 117.46
R2389 vss.t194 vss.n331 117.46
R2390 vss.n2171 vss.t198 117.46
R2391 vss.t197 vss.n378 117.46
R2392 vss.n2068 vss.t272 117.46
R2393 vss.t271 vss.n2066 117.46
R2394 vss.n2018 vss.t200 117.46
R2395 vss.t192 vss.n2016 117.46
R2396 vss.n2063 vss.t289 117.46
R2397 vss.t274 vss.n2061 117.46
R2398 vss.t290 vss.n767 117.46
R2399 vss.n769 vss.t269 117.46
R2400 vss.n764 vss.t201 117.46
R2401 vss.t190 vss.n762 117.46
R2402 vss.t295 vss.n756 117.46
R2403 vss.n758 vss.t294 117.46
R2404 vss.t302 vss.n1220 117.46
R2405 vss.n1222 vss.t300 117.46
R2406 vss.n1217 vss.t207 117.46
R2407 vss.t206 vss.n1215 117.46
R2408 vss.n801 vss.t204 117.46
R2409 vss.t203 vss.n799 117.46
R2410 vss.n871 vss.t292 117.46
R2411 vss.t291 vss.n869 117.46
R2412 vss.n1849 vss.t186 117.46
R2413 vss.t185 vss.n1847 117.46
R2414 vss.t273 vss.n491 117.001
R2415 vss.n491 vss.n489 117.001
R2416 vss.n771 vss.t268 117.001
R2417 vss.n775 vss.n771 117.001
R2418 vss.t277 vss.n867 117.001
R2419 vss.n867 vss.n866 117.001
R2420 vss.n1224 vss.t286 117.001
R2421 vss.n1228 vss.n1224 117.001
R2422 vss.t107 vss.n2034 117.001
R2423 vss.n2034 vss.n2033 117.001
R2424 vss.t107 vss.n2022 117.001
R2425 vss.n2031 vss.n2022 117.001
R2426 vss.n714 vss.t110 117.001
R2427 vss.n716 vss.n714 117.001
R2428 vss.n715 vss.t110 117.001
R2429 vss.n719 vss.n715 117.001
R2430 vss.n813 vss.t115 117.001
R2431 vss.n815 vss.n813 117.001
R2432 vss.n814 vss.t115 117.001
R2433 vss.n818 vss.n814 117.001
R2434 vss.n1201 vss.t113 117.001
R2435 vss.n1203 vss.n1201 117.001
R2436 vss.n1202 vss.t113 117.001
R2437 vss.n1206 vss.n1202 117.001
R2438 vss.t107 vss.n2028 117.001
R2439 vss.n2028 vss.n2027 117.001
R2440 vss.t107 vss.n2023 117.001
R2441 vss.n2025 vss.n2023 117.001
R2442 vss.n700 vss.t110 117.001
R2443 vss.n703 vss.n700 117.001
R2444 vss.n702 vss.t110 117.001
R2445 vss.n704 vss.n702 117.001
R2446 vss.n805 vss.t115 117.001
R2447 vss.n807 vss.n805 117.001
R2448 vss.n806 vss.t115 117.001
R2449 vss.n810 vss.n806 117.001
R2450 vss.n1194 vss.t113 117.001
R2451 vss.n1197 vss.n1194 117.001
R2452 vss.n1196 vss.t113 117.001
R2453 vss.n1198 vss.n1196 117.001
R2454 vss.n2060 vss.t273 117.001
R2455 vss.n2061 vss.n2060 117.001
R2456 vss.t268 vss.n770 117.001
R2457 vss.n770 vss.n769 117.001
R2458 vss.n868 vss.t277 117.001
R2459 vss.n869 vss.n868 117.001
R2460 vss.t286 vss.n1223 117.001
R2461 vss.n1223 vss.n1222 117.001
R2462 vss.t191 vss.n2064 117.001
R2463 vss.n2064 vss.n2063 117.001
R2464 vss.t191 vss.n2012 117.001
R2465 vss.n2016 vss.n2012 117.001
R2466 vss.t191 vss.n2019 117.001
R2467 vss.n2019 vss.n2018 117.001
R2468 vss.n2065 vss.t191 117.001
R2469 vss.n2066 vss.n2065 117.001
R2470 vss.n1851 vss.t184 117.001
R2471 vss.n1853 vss.n1851 117.001
R2472 vss.t184 vss.n1843 117.001
R2473 vss.n1847 vss.n1843 117.001
R2474 vss.t184 vss.n1850 117.001
R2475 vss.n1850 vss.n1849 117.001
R2476 vss.t184 vss.n490 117.001
R2477 vss.n490 vss.n488 117.001
R2478 vss.n755 vss.t293 117.001
R2479 vss.n756 vss.n755 117.001
R2480 vss.n1601 vss.t296 117.001
R2481 vss.n1601 vss.n794 117.001
R2482 vss.t130 vss.n754 117.001
R2483 vss.n754 vss.n753 117.001
R2484 vss.t130 vss.n728 117.001
R2485 vss.n751 vss.n728 117.001
R2486 vss.t133 vss.n1600 117.001
R2487 vss.n1600 vss.n1599 117.001
R2488 vss.t133 vss.n876 117.001
R2489 vss.n880 vss.n876 117.001
R2490 vss.n766 vss.t189 117.001
R2491 vss.n767 vss.n766 117.001
R2492 vss.t202 vss.n872 117.001
R2493 vss.n872 vss.n871 117.001
R2494 vss.t189 vss.n725 117.001
R2495 vss.n762 vss.n725 117.001
R2496 vss.t189 vss.n765 117.001
R2497 vss.n765 vss.n764 117.001
R2498 vss.t202 vss.n796 117.001
R2499 vss.n799 vss.n796 117.001
R2500 vss.t202 vss.n802 117.001
R2501 vss.n802 vss.n801 117.001
R2502 vss.t189 vss.n759 117.001
R2503 vss.n759 vss.n758 117.001
R2504 vss.n873 vss.t202 117.001
R2505 vss.n873 vss.n793 117.001
R2506 vss.n1185 vss.t298 117.001
R2507 vss.n1238 vss.n1185 117.001
R2508 vss.t136 vss.n1242 117.001
R2509 vss.n1242 vss.n1179 117.001
R2510 vss.n1243 vss.t136 117.001
R2511 vss.n1244 vss.n1243 117.001
R2512 vss.n1219 vss.t205 117.001
R2513 vss.n1220 vss.n1219 117.001
R2514 vss.t205 vss.n1212 117.001
R2515 vss.n1215 vss.n1212 117.001
R2516 vss.t205 vss.n1218 117.001
R2517 vss.n1218 vss.n1217 117.001
R2518 vss.t205 vss.n1184 117.001
R2519 vss.n1186 vss.n1184 117.001
R2520 vss.n863 vss.t193 117.001
R2521 vss.n864 vss.n863 117.001
R2522 vss.n1767 vss.t196 117.001
R2523 vss.n1767 vss.n589 117.001
R2524 vss.n1427 vss.t193 117.001
R2525 vss.n1428 vss.n1427 117.001
R2526 vss.n376 vss.t196 117.001
R2527 vss.n378 vss.n376 117.001
R2528 vss.n377 vss.t196 117.001
R2529 vss.n2171 vss.n377 117.001
R2530 vss.t193 vss.n333 117.001
R2531 vss.n333 vss.n331 117.001
R2532 vss.t193 vss.n334 117.001
R2533 vss.n334 vss.n332 117.001
R2534 vss.n723 vss.t196 117.001
R2535 vss.n772 vss.n723 117.001
R2536 vss.t100 vss.n1756 117.001
R2537 vss.n1758 vss.n1756 117.001
R2538 vss.n1757 vss.t100 117.001
R2539 vss.n1761 vss.n1757 117.001
R2540 vss.t103 vss.n1439 117.001
R2541 vss.n1439 vss.n1438 117.001
R2542 vss.t103 vss.n1424 117.001
R2543 vss.n1436 vss.n1424 117.001
R2544 vss.t263 vss.n590 117.001
R2545 vss.n590 vss.n588 117.001
R2546 vss.t281 vss.n1431 117.001
R2547 vss.n1431 vss.n1430 117.001
R2548 vss.t95 vss.n1354 117.001
R2549 vss.n1354 vss.n1016 117.001
R2550 vss.n1355 vss.t95 117.001
R2551 vss.n1356 vss.n1355 117.001
R2552 vss.n1020 vss.t266 117.001
R2553 vss.n1022 vss.n1020 117.001
R2554 vss.n1021 vss.t187 117.001
R2555 vss.n1024 vss.n1021 117.001
R2556 vss.n987 vss.t187 117.001
R2557 vss.n989 vss.n987 117.001
R2558 vss.n988 vss.t187 117.001
R2559 vss.n1366 vss.n988 117.001
R2560 vss.n1210 vss.t187 117.001
R2561 vss.n1225 vss.n1210 117.001
R2562 vss.t97 vss.n1808 117.001
R2563 vss.n1810 vss.n1808 117.001
R2564 vss.t97 vss.n1809 117.001
R2565 vss.n1860 vss.n1809 117.001
R2566 vss.n1811 vss.t260 117.001
R2567 vss.n1852 vss.n1811 117.001
R2568 vss.t270 vss.n2069 117.001
R2569 vss.n2069 vss.n2068 117.001
R2570 vss.t121 vss.n518 117.001
R2571 vss.n2071 vss.n518 117.001
R2572 vss.n2070 vss.t121 117.001
R2573 vss.n2072 vss.n2070 117.001
R2574 vss.n1682 vss.n572 115.201
R2575 vss.n1669 vss.n1667 115.201
R2576 vss.n2106 vss.n424 115.201
R2577 vss.n446 vss.n445 115.201
R2578 vss.n1678 vss.n1677 115.201
R2579 vss.n617 vss.n565 115.201
R2580 vss.n1914 vss.n1913 115.201
R2581 vss.n2111 vss.n2110 115.201
R2582 vss.n1102 vss.n1101 115.201
R2583 vss.n1122 vss.n1121 115.201
R2584 vss.n1478 vss.n956 115.201
R2585 vss.n1485 vss.n959 115.201
R2586 vss.n1117 vss.n1085 115.201
R2587 vss.n1113 vss.n1112 115.201
R2588 vss.n1474 vss.n1472 115.201
R2589 vss.n1494 vss.n1493 115.201
R2590 vss.n1919 vss.n550 110.234
R2591 vss.n1654 vss.n1653 110.234
R2592 vss.n1313 vss.n1303 110.234
R2593 vss.n1284 vss.n1283 110.234
R2594 vss.n1405 vss.n1404 110.234
R2595 vss.n1326 vss.n1071 110.234
R2596 vss.n1786 vss.n1785 110.234
R2597 vss.n1896 vss.n1895 110.234
R2598 vss.n453 vss.t7 108.992
R2599 vss.n442 vss.t34 108.992
R2600 vss.n1672 vss.t48 108.992
R2601 vss.n614 vss.t41 108.992
R2602 vss.t16 vss.n297 108.992
R2603 vss.n1482 vss.t0 108.992
R2604 vss.n1108 vss.t13 108.992
R2605 vss.t45 vss.n918 108.992
R2606 vss.t309 vss.t311 106.3
R2607 vss.t313 vss.t312 106.3
R2608 vss.t304 vss.t321 106.3
R2609 vss.t323 vss.t322 106.3
R2610 vss.n2050 vss.t234 105.627
R2611 vss.t238 vss.n391 105.627
R2612 vss.t228 vss.n272 105.627
R2613 vss.n1523 vss.t242 105.627
R2614 vss.n1362 vss.n990 100.285
R2615 vss.n1362 vss.n1361 100.285
R2616 vss.n1872 vss.n496 100.285
R2617 vss.n527 vss.n496 100.285
R2618 vss.n1906 vss.n1905 97.5005
R2619 vss.n1905 vss.n1904 97.5005
R2620 vss.n1906 vss.n568 97.5005
R2621 vss.n1668 vss.n568 97.5005
R2622 vss.n2115 vss.n2114 97.5005
R2623 vss.n2116 vss.n2115 97.5005
R2624 vss.n2114 vss.n426 97.5005
R2625 vss.n438 vss.n426 97.5005
R2626 vss.n1125 vss.n1087 97.5005
R2627 vss.n1111 vss.n1087 97.5005
R2628 vss.n1126 vss.n1125 97.5005
R2629 vss.n1127 vss.n1126 97.5005
R2630 vss.n1497 vss.n1496 97.5005
R2631 vss.n1496 vss.n1495 97.5005
R2632 vss.n1497 vss.n962 97.5005
R2633 vss.n962 vss.n954 97.5005
R2634 vss.n1907 vss.n1906 97.5005
R2635 vss.n1908 vss.n1907 97.5005
R2636 vss.n1906 vss.n569 97.5005
R2637 vss.n1676 vss.n569 97.5005
R2638 vss.n2114 vss.n2113 97.5005
R2639 vss.n2113 vss.n2112 97.5005
R2640 vss.n2114 vss.n428 97.5005
R2641 vss.n1915 vss.n428 97.5005
R2642 vss.n1125 vss.n1089 97.5005
R2643 vss.n1100 vss.n1089 97.5005
R2644 vss.n1125 vss.n1124 97.5005
R2645 vss.n1124 vss.n1123 97.5005
R2646 vss.n1497 vss.n963 97.5005
R2647 vss.n1477 vss.n963 97.5005
R2648 vss.n1498 vss.n1497 97.5005
R2649 vss.n1499 vss.n1498 97.5005
R2650 vss.n2050 vss.n451 92.8445
R2651 vss.n2141 vss.n391 92.8445
R2652 vss.n2247 vss.n272 92.8445
R2653 vss.n1525 vss.n1523 92.8445
R2654 vss.t80 vss.n630 91.5504
R2655 vss.t139 vss.n1169 91.5504
R2656 vss.n1068 vss.t70 91.5504
R2657 vss.n1715 vss.t67 91.5504
R2658 vss.n537 vss.n535 91.085
R2659 vss.n2005 vss.n534 91.085
R2660 vss.n2001 vss.n533 91.085
R2661 vss.n1997 vss.n532 91.085
R2662 vss.n1993 vss.n531 91.085
R2663 vss.n1989 vss.n530 91.085
R2664 vss.n1839 vss.n1817 91.085
R2665 vss.n1835 vss.n1816 91.085
R2666 vss.n1831 vss.n1815 91.085
R2667 vss.n1827 vss.n1814 91.085
R2668 vss.n1823 vss.n1813 91.085
R2669 vss.n1819 vss.n1812 91.085
R2670 vss.n1946 vss.n1929 91.085
R2671 vss.n1947 vss.n1928 91.085
R2672 vss.n1954 vss.n1930 91.085
R2673 vss.n1955 vss.n1927 91.085
R2674 vss.n1961 vss.n1931 91.085
R2675 vss.n1967 vss.n1933 91.085
R2676 vss.n666 vss.n665 91.085
R2677 vss.n670 vss.n669 91.085
R2678 vss.n673 vss.n672 91.085
R2679 vss.n677 vss.n676 91.085
R2680 vss.n680 vss.n679 91.085
R2681 vss.n684 vss.n683 91.085
R2682 vss.n645 vss.n640 91.085
R2683 vss.n1610 vss.n644 91.085
R2684 vss.n1614 vss.n643 91.085
R2685 vss.n1618 vss.n642 91.085
R2686 vss.n1619 vss.n646 91.085
R2687 vss.n1626 vss.n647 91.085
R2688 vss.n279 vss.n278 91.085
R2689 vss.n2239 vss.n2238 91.085
R2690 vss.n283 vss.n281 91.085
R2691 vss.n2232 vss.n2231 91.085
R2692 vss.n286 vss.n284 91.085
R2693 vss.n2225 vss.n2224 91.085
R2694 vss.n2195 vss.n294 91.085
R2695 vss.n2199 vss.n293 91.085
R2696 vss.n2203 vss.n292 91.085
R2697 vss.n2204 vss.n295 91.085
R2698 vss.n2210 vss.n291 91.085
R2699 vss.n2215 vss.n296 91.085
R2700 vss.n1148 vss.n1138 91.085
R2701 vss.n1150 vss.n1139 91.085
R2702 vss.n1155 vss.n1140 91.085
R2703 vss.n1157 vss.n1141 91.085
R2704 vss.n1162 vss.n1142 91.085
R2705 vss.n1168 vss.n1143 91.085
R2706 vss.n1563 vss.n1562 91.085
R2707 vss.n1543 vss.n908 91.085
R2708 vss.n1544 vss.n907 91.085
R2709 vss.n1550 vss.n909 91.085
R2710 vss.n1555 vss.n906 91.085
R2711 vss.n1560 vss.n911 91.085
R2712 vss.n2148 vss.n382 91.085
R2713 vss.n2153 vss.n384 91.085
R2714 vss.n2159 vss.n380 91.085
R2715 vss.n2162 vss.n379 91.085
R2716 vss.n2166 vss.n386 91.085
R2717 vss.n362 vss.n340 91.085
R2718 vss.n358 vss.n339 91.085
R2719 vss.n354 vss.n338 91.085
R2720 vss.n350 vss.n337 91.085
R2721 vss.n346 vss.n336 91.085
R2722 vss.n342 vss.n335 91.085
R2723 vss.n2185 vss.n2184 91.085
R2724 vss.n307 vss.n301 91.085
R2725 vss.n317 vss.n306 91.085
R2726 vss.n320 vss.n304 91.085
R2727 vss.n326 vss.n308 91.085
R2728 vss.n1062 vss.n1043 91.085
R2729 vss.n1059 vss.n1041 91.085
R2730 vss.n1056 vss.n1040 91.085
R2731 vss.n1049 vss.n1038 91.085
R2732 vss.n1048 vss.n1039 91.085
R2733 vss.n1386 vss.n1373 91.085
R2734 vss.n1387 vss.n1372 91.085
R2735 vss.n1376 vss.n1374 91.085
R2736 vss.n1383 vss.n1371 91.085
R2737 vss.n1379 vss.n1370 91.085
R2738 vss.n1397 vss.n986 91.085
R2739 vss.n1373 vss.n923 91.085
R2740 vss.n1390 vss.n1372 91.085
R2741 vss.n1391 vss.n1374 91.085
R2742 vss.n1375 vss.n1371 91.085
R2743 vss.n1382 vss.n1370 91.085
R2744 vss.n1398 vss.n1397 91.085
R2745 vss.n1045 vss.n1039 91.085
R2746 vss.n1052 vss.n1038 91.085
R2747 vss.n1053 vss.n1040 91.085
R2748 vss.n1057 vss.n1041 91.085
R2749 vss.n1044 vss.n1043 91.085
R2750 vss.n2184 vss.n302 91.085
R2751 vss.n314 vss.n307 91.085
R2752 vss.n315 vss.n306 91.085
R2753 vss.n323 vss.n304 91.085
R2754 vss.n324 vss.n308 91.085
R2755 vss.n2092 vss.n458 91.085
R2756 vss.n471 vss.n461 91.085
R2757 vss.n475 vss.n462 91.085
R2758 vss.n478 vss.n463 91.085
R2759 vss.n483 vss.n460 91.085
R2760 vss.n1710 vss.n600 91.085
R2761 vss.n1705 vss.n605 91.085
R2762 vss.n1700 vss.n602 91.085
R2763 vss.n1694 vss.n604 91.085
R2764 vss.n1690 vss.n603 91.085
R2765 vss.n1812 vss.n450 91.085
R2766 vss.n1820 vss.n1813 91.085
R2767 vss.n1824 vss.n1814 91.085
R2768 vss.n1828 vss.n1815 91.085
R2769 vss.n1832 vss.n1816 91.085
R2770 vss.n1836 vss.n1817 91.085
R2771 vss.n1693 vss.n603 91.085
R2772 vss.n1697 vss.n604 91.085
R2773 vss.n1698 vss.n602 91.085
R2774 vss.n1703 vss.n605 91.085
R2775 vss.n1708 vss.n600 91.085
R2776 vss.n2093 vss.n2092 91.085
R2777 vss.n468 vss.n461 91.085
R2778 vss.n472 vss.n462 91.085
R2779 vss.n476 vss.n463 91.085
R2780 vss.n481 vss.n460 91.085
R2781 vss.n335 vss.n269 91.085
R2782 vss.n343 vss.n336 91.085
R2783 vss.n347 vss.n337 91.085
R2784 vss.n351 vss.n338 91.085
R2785 vss.n355 vss.n339 91.085
R2786 vss.n359 vss.n340 91.085
R2787 vss.n2146 vss.n382 91.085
R2788 vss.n2151 vss.n384 91.085
R2789 vss.n2156 vss.n380 91.085
R2790 vss.n2160 vss.n379 91.085
R2791 vss.n2166 vss.n2165 91.085
R2792 vss.n1986 vss.n530 91.085
R2793 vss.n1990 vss.n531 91.085
R2794 vss.n1994 vss.n532 91.085
R2795 vss.n1998 vss.n533 91.085
R2796 vss.n2002 vss.n534 91.085
R2797 vss.n2006 vss.n535 91.085
R2798 vss.n1562 vss.n904 91.085
R2799 vss.n1540 vss.n908 91.085
R2800 vss.n1547 vss.n907 91.085
R2801 vss.n1548 vss.n909 91.085
R2802 vss.n1553 vss.n906 91.085
R2803 vss.n1560 vss.n1559 91.085
R2804 vss.n1168 vss.n1167 91.085
R2805 vss.n1164 vss.n1142 91.085
R2806 vss.n1161 vss.n1141 91.085
R2807 vss.n1158 vss.n1140 91.085
R2808 vss.n1154 vss.n1139 91.085
R2809 vss.n1151 vss.n1138 91.085
R2810 vss.n294 vss.n289 91.085
R2811 vss.n2196 vss.n293 91.085
R2812 vss.n2200 vss.n292 91.085
R2813 vss.n2207 vss.n295 91.085
R2814 vss.n2208 vss.n291 91.085
R2815 vss.n2215 vss.n2214 91.085
R2816 vss.n2224 vss.n2223 91.085
R2817 vss.n2226 vss.n286 91.085
R2818 vss.n2231 vss.n2230 91.085
R2819 vss.n2233 vss.n283 91.085
R2820 vss.n2238 vss.n2237 91.085
R2821 vss.n2240 vss.n279 91.085
R2822 vss.n1606 vss.n645 91.085
R2823 vss.n1607 vss.n644 91.085
R2824 vss.n1611 vss.n643 91.085
R2825 vss.n1615 vss.n642 91.085
R2826 vss.n1621 vss.n646 91.085
R2827 vss.n1626 vss.n1625 91.085
R2828 vss.n685 vss.n684 91.085
R2829 vss.n679 vss.n650 91.085
R2830 vss.n678 vss.n677 91.085
R2831 vss.n672 vss.n653 91.085
R2832 vss.n671 vss.n670 91.085
R2833 vss.n665 vss.n656 91.085
R2834 vss.n1942 vss.n1929 91.085
R2835 vss.n1950 vss.n1928 91.085
R2836 vss.n1951 vss.n1930 91.085
R2837 vss.n1958 vss.n1927 91.085
R2838 vss.n1959 vss.n1931 91.085
R2839 vss.n1967 vss.n1966 91.085
R2840 vss.t213 vss.t18 89.682
R2841 vss.t19 vss.t213 89.682
R2842 vss.t36 vss.t19 89.682
R2843 vss.t52 vss.t33 89.682
R2844 vss.t33 vss.t50 89.682
R2845 vss.t50 vss.t212 89.682
R2846 vss.t210 vss.t8 89.682
R2847 vss.t38 vss.t210 89.682
R2848 vss.t211 vss.t38 89.682
R2849 vss.t208 vss.t64 89.682
R2850 vss.t9 vss.t208 89.682
R2851 vss.t15 vss.t9 89.682
R2852 vss.t47 vss.t1 89.682
R2853 vss.t22 vss.t47 89.682
R2854 vss.t77 vss.t22 89.682
R2855 vss.t46 vss.t21 89.682
R2856 vss.t21 vss.t39 89.682
R2857 vss.t39 vss.t17 89.682
R2858 vss.t32 vss.t215 89.682
R2859 vss.t54 vss.t32 89.682
R2860 vss.t35 vss.t54 89.682
R2861 vss.t4 vss.t209 89.682
R2862 vss.t31 vss.t4 89.682
R2863 vss.t214 vss.t31 89.682
R2864 vss.t88 vss.t28 89.682
R2865 vss.t89 vss.t88 89.682
R2866 vss.t78 vss.t89 89.682
R2867 vss.t40 vss.t81 89.682
R2868 vss.t81 vss.t79 89.682
R2869 vss.t79 vss.t82 89.682
R2870 vss.t44 vss.t25 89.682
R2871 vss.t83 vss.t44 89.682
R2872 vss.t23 vss.t83 89.682
R2873 vss.t12 vss.t24 89.682
R2874 vss.t24 vss.t59 89.682
R2875 vss.t59 vss.t60 89.682
R2876 vss.t55 vss.t37 89.682
R2877 vss.t56 vss.t55 89.682
R2878 vss.t76 vss.t56 89.682
R2879 vss.t61 vss.t57 89.682
R2880 vss.t57 vss.t49 89.682
R2881 vss.t49 vss.t58 89.682
R2882 vss.t3 vss.t43 89.682
R2883 vss.t29 vss.t3 89.682
R2884 vss.t10 vss.t29 89.682
R2885 vss.t27 vss.t53 89.682
R2886 vss.t53 vss.t5 89.682
R2887 vss.t5 vss.t51 89.682
R2888 vss.n1681 vss.n1680 83.5719
R2889 vss.n1682 vss.n1681 83.5719
R2890 vss.n1680 vss.n612 83.5719
R2891 vss.n1667 vss.n612 83.5719
R2892 vss.n2108 vss.n435 83.5719
R2893 vss.n446 vss.n435 83.5719
R2894 vss.n2108 vss.n2107 83.5719
R2895 vss.n2107 vss.n2106 83.5719
R2896 vss.n1119 vss.n1094 83.5719
R2897 vss.n1113 vss.n1094 83.5719
R2898 vss.n1119 vss.n1118 83.5719
R2899 vss.n1118 vss.n1117 83.5719
R2900 vss.n1491 vss.n1475 83.5719
R2901 vss.n1475 vss.n1474 83.5719
R2902 vss.n1492 vss.n1491 83.5719
R2903 vss.n1493 vss.n1492 83.5719
R2904 vss.n1680 vss.n613 83.5719
R2905 vss.n617 vss.n613 83.5719
R2906 vss.n1680 vss.n1679 83.5719
R2907 vss.n1679 vss.n1678 83.5719
R2908 vss.n2108 vss.n436 83.5719
R2909 vss.n1913 vss.n436 83.5719
R2910 vss.n2109 vss.n2108 83.5719
R2911 vss.n2110 vss.n2109 83.5719
R2912 vss.n1119 vss.n1103 83.5719
R2913 vss.n1103 vss.n1102 83.5719
R2914 vss.n1120 vss.n1119 83.5719
R2915 vss.n1121 vss.n1120 83.5719
R2916 vss.n1491 vss.n1476 83.5719
R2917 vss.n1485 vss.n1476 83.5719
R2918 vss.n1491 vss.n1490 83.5719
R2919 vss.n1490 vss.n956 83.5719
R2920 vss.n687 vss.n686 79.0985
R2921 vss.n2218 vss.n2217 79.0985
R2922 vss.n1144 vss.n901 79.0985
R2923 vss.n2182 vss.n310 79.0985
R2924 vss.n1067 vss.n1066 79.0985
R2925 vss.n1067 vss.n985 79.0985
R2926 vss.n2182 vss.n2181 79.0985
R2927 vss.n2090 vss.n465 79.0985
R2928 vss.n1714 vss.n607 79.0985
R2929 vss.n1714 vss.n1713 79.0985
R2930 vss.n2090 vss.n2089 79.0985
R2931 vss.n1565 vss.n901 79.0985
R2932 vss.n2219 vss.n2218 79.0985
R2933 vss.n686 vss.n639 79.0985
R2934 vss.n2127 vss.n410 76.6035
R2935 vss.n2127 vss.n412 76.6035
R2936 vss.n1512 vss.n939 76.6035
R2937 vss.n1512 vss.n941 76.6035
R2938 vss.n1512 vss.n942 76.6035
R2939 vss.n1512 vss.n935 76.6035
R2940 vss.n2127 vss.n413 76.6035
R2941 vss.n2127 vss.n406 76.6035
R2942 vss.t212 vss.n410 74.7351
R2943 vss.t8 vss.n412 74.7351
R2944 vss.t17 vss.n939 74.7351
R2945 vss.t215 vss.n941 74.7351
R2946 vss.t82 vss.n942 74.7351
R2947 vss.t25 vss.n935 74.7351
R2948 vss.t58 vss.n413 74.7351
R2949 vss.t43 vss.n406 74.7351
R2950 vss.t140 vss.n499 73.1255
R2951 vss.n501 vss.n499 73.1255
R2952 vss.t140 vss.n500 73.1255
R2953 vss.n502 vss.n500 73.1255
R2954 vss.t142 vss.n786 73.1255
R2955 vss.n786 vss.n785 73.1255
R2956 vss.t142 vss.n698 73.1255
R2957 vss.n783 vss.n698 73.1255
R2958 vss.t161 vss.n858 73.1255
R2959 vss.n858 vss.n857 73.1255
R2960 vss.t161 vss.n822 73.1255
R2961 vss.n828 vss.n822 73.1255
R2962 vss.t157 vss.n925 73.1255
R2963 vss.n927 vss.n925 73.1255
R2964 vss.t157 vss.n926 73.1255
R2965 vss.n1520 vss.n926 73.1255
R2966 vss.t140 vss.n2055 73.1255
R2967 vss.n2055 vss.n2054 73.1255
R2968 vss.t140 vss.n2021 73.1255
R2969 vss.n2052 vss.n2021 73.1255
R2970 vss.t142 vss.n779 73.1255
R2971 vss.n779 vss.n694 73.1255
R2972 vss.n787 vss.t142 73.1255
R2973 vss.n788 vss.n787 73.1255
R2974 vss.t161 vss.n824 73.1255
R2975 vss.n845 vss.n824 73.1255
R2976 vss.t161 vss.n823 73.1255
R2977 vss.n849 vss.n823 73.1255
R2978 vss.t157 vss.n1232 73.1255
R2979 vss.n1232 vss.n1190 73.1255
R2980 vss.n1233 vss.t157 73.1255
R2981 vss.n1234 vss.n1233 73.1255
R2982 vss.n736 vss.t175 73.1255
R2983 vss.n736 vss.n734 73.1255
R2984 vss.n739 vss.t175 73.1255
R2985 vss.n740 vss.n739 73.1255
R2986 vss.n1584 vss.t178 73.1255
R2987 vss.n1587 vss.n1584 73.1255
R2988 vss.n1586 vss.t178 73.1255
R2989 vss.n1588 vss.n1586 73.1255
R2990 vss.t181 vss.n1175 73.1255
R2991 vss.n1177 vss.n1175 73.1255
R2992 vss.t181 vss.n1176 73.1255
R2993 vss.n1257 vss.n1176 73.1255
R2994 vss.n1744 vss.t147 73.1255
R2995 vss.n1744 vss.n1742 73.1255
R2996 vss.n1747 vss.t147 73.1255
R2997 vss.n1748 vss.n1747 73.1255
R2998 vss.t150 vss.n1422 73.1255
R2999 vss.n1441 vss.n1422 73.1255
R3000 vss.n1440 vss.t150 73.1255
R3001 vss.n1454 vss.n1440 73.1255
R3002 vss.t153 vss.n1353 73.1255
R3003 vss.n1353 vss.n1352 73.1255
R3004 vss.t153 vss.n1019 73.1255
R3005 vss.n1350 vss.n1019 73.1255
R3006 vss.t144 vss.n1803 73.1255
R3007 vss.n1805 vss.n1803 73.1255
R3008 vss.t144 vss.n1804 73.1255
R3009 vss.n1875 vss.n1804 73.1255
R3010 vss.n520 vss.t159 73.1255
R3011 vss.n522 vss.n520 73.1255
R3012 vss.n525 vss.t159 73.1255
R3013 vss.n525 vss.n524 73.1255
R3014 vss.n2058 vss.t140 71.9883
R3015 vss.t142 vss.n778 71.9883
R3016 vss.n859 vss.t161 71.9883
R3017 vss.t157 vss.n1231 71.9883
R3018 vss.t140 vss.t107 67.2788
R3019 vss.t142 vss.t110 67.2788
R3020 vss.t161 vss.t115 67.2788
R3021 vss.t157 vss.t113 67.2788
R3022 vss.t85 vss.n620 65.0005
R3023 vss.n1662 vss.n620 65.0005
R3024 vss.n1659 vss.t85 65.0005
R3025 vss.n1659 vss.n621 65.0005
R3026 vss.n548 vss.t87 65.0005
R3027 vss.n109 vss.n548 65.0005
R3028 vss.n549 vss.t87 65.0005
R3029 vss.n1923 vss.n549 65.0005
R3030 vss.n561 vss.t86 65.0005
R3031 vss.n562 vss.n561 65.0005
R3032 vss.t86 vss.n560 65.0005
R3033 vss.n560 vss.n559 65.0005
R3034 vss.n627 vss.t84 65.0005
R3035 vss.n629 vss.n627 65.0005
R3036 vss.n628 vss.t84 65.0005
R3037 vss.n1649 vss.n628 65.0005
R3038 vss.n1638 vss.n631 65.0005
R3039 vss.n633 vss.n631 65.0005
R3040 vss.n1638 vss.n632 65.0005
R3041 vss.n1642 vss.n632 65.0005
R3042 vss.n635 vss.n634 65.0005
R3043 vss.n101 vss.n635 65.0005
R3044 vss.n636 vss.n634 65.0005
R3045 vss.n1634 vss.n636 65.0005
R3046 vss.n1576 vss.n887 65.0005
R3047 vss.n94 vss.n887 65.0005
R3048 vss.n1576 vss.n888 65.0005
R3049 vss.n1580 vss.n888 65.0005
R3050 vss.n889 vss.t92 65.0005
R3051 vss.n1568 vss.n889 65.0005
R3052 vss.n890 vss.t92 65.0005
R3053 vss.n1571 vss.n890 65.0005
R3054 vss.t90 vss.n1290 65.0005
R3055 vss.n1290 vss.n894 65.0005
R3056 vss.t90 vss.n1135 65.0005
R3057 vss.n1287 vss.n1135 65.0005
R3058 vss.n1304 vss.t91 65.0005
R3059 vss.n1304 vss.n891 65.0005
R3060 vss.n1305 vss.t91 65.0005
R3061 vss.n1309 vss.n1305 65.0005
R3062 vss.t75 vss.n1295 65.0005
R3063 vss.n1295 vss.n893 65.0005
R3064 vss.n1297 vss.t75 65.0005
R3065 vss.n1300 vss.n1297 65.0005
R3066 vss.n1136 vss.t93 65.0005
R3067 vss.n1136 vss.n896 65.0005
R3068 vss.n1137 vss.t93 65.0005
R3069 vss.n1279 vss.n1137 65.0005
R3070 vss.n1268 vss.n1170 65.0005
R3071 vss.n1170 vss.n897 65.0005
R3072 vss.n1268 vss.n1171 65.0005
R3073 vss.n1272 vss.n1171 65.0005
R3074 vss.n1173 vss.n1172 65.0005
R3075 vss.n1173 vss.n898 65.0005
R3076 vss.n1174 vss.n1172 65.0005
R3077 vss.n1264 vss.n1174 65.0005
R3078 vss.n598 vss.n597 65.0005
R3079 vss.n1727 vss.n598 65.0005
R3080 vss.n599 vss.n597 65.0005
R3081 vss.n599 vss.n586 65.0005
R3082 vss.n1739 vss.n1738 65.0005
R3083 vss.n1738 vss.n1737 65.0005
R3084 vss.n1739 vss.n596 65.0005
R3085 vss.n596 vss.n587 65.0005
R3086 vss.n1418 vss.n1417 65.0005
R3087 vss.n1420 vss.n1418 65.0005
R3088 vss.n1419 vss.n1417 65.0005
R3089 vss.n1461 vss.n1419 65.0005
R3090 vss.n1416 vss.t69 65.0005
R3091 vss.n1416 vss.n1415 65.0005
R3092 vss.n1467 vss.t69 65.0005
R3093 vss.n1468 vss.n1467 65.0005
R3094 vss.t74 vss.n1409 65.0005
R3095 vss.n1409 vss.n1408 65.0005
R3096 vss.n1410 vss.t74 65.0005
R3097 vss.n1411 vss.n1410 65.0005
R3098 vss.t73 vss.n969 65.0005
R3099 vss.n974 vss.n969 65.0005
R3100 vss.n973 vss.t73 65.0005
R3101 vss.n1401 vss.n973 65.0005
R3102 vss.t72 vss.n1078 65.0005
R3103 vss.n1078 vss.n1077 65.0005
R3104 vss.t72 vss.n1072 65.0005
R3105 vss.n1072 vss.n977 65.0005
R3106 vss.n1069 vss.t71 65.0005
R3107 vss.n1330 vss.n1069 65.0005
R3108 vss.n1070 vss.t71 65.0005
R3109 vss.n1070 vss.n979 65.0005
R3110 vss.n1036 vss.n1035 65.0005
R3111 vss.n1337 vss.n1036 65.0005
R3112 vss.n1037 vss.n1035 65.0005
R3113 vss.n1037 vss.n980 65.0005
R3114 vss.n1034 vss.n1029 65.0005
R3115 vss.n1344 vss.n1029 65.0005
R3116 vss.n1034 vss.n1030 65.0005
R3117 vss.n1030 vss.n981 65.0005
R3118 vss.t65 vss.n1790 65.0005
R3119 vss.n1790 vss.n1789 65.0005
R3120 vss.n1791 vss.t65 65.0005
R3121 vss.n1792 vss.n1791 65.0005
R3122 vss.t63 vss.n1776 65.0005
R3123 vss.n1782 vss.n1776 65.0005
R3124 vss.n1779 vss.t63 65.0005
R3125 vss.n1779 vss.n1770 65.0005
R3126 vss.t62 vss.n580 65.0005
R3127 vss.n583 vss.n580 65.0005
R3128 vss.n582 vss.t62 65.0005
R3129 vss.n1892 vss.n582 65.0005
R3130 vss.n1716 vss.t68 65.0005
R3131 vss.n1720 vss.n1716 65.0005
R3132 vss.n1717 vss.t68 65.0005
R3133 vss.n1717 vss.n585 65.0005
R3134 vss.n1799 vss.n1798 65.0005
R3135 vss.n1801 vss.n1799 65.0005
R3136 vss.n1800 vss.n1798 65.0005
R3137 vss.n1882 vss.n1800 65.0005
R3138 vss.n1797 vss.t66 65.0005
R3139 vss.n1797 vss.n1796 65.0005
R3140 vss.n1888 vss.t66 65.0005
R3141 vss.n1889 vss.n1888 65.0005
R3142 vss.n1976 vss.n543 65.0005
R3143 vss.n99 vss.n543 65.0005
R3144 vss.n1976 vss.n544 65.0005
R3145 vss.n1980 vss.n544 65.0005
R3146 vss.n545 vss.t94 65.0005
R3147 vss.n547 vss.n545 65.0005
R3148 vss.n546 vss.t94 65.0005
R3149 vss.n1972 vss.n546 65.0005
R3150 vss.n2098 vss.n2097 64.6669
R3151 vss.n2100 vss.n2099 64.6669
R3152 vss.n2142 vss.n390 64.6669
R3153 vss.n1688 vss.n1687 64.6669
R3154 vss.n2190 vss.n2189 64.6669
R3155 vss.n2248 vss.n270 64.6669
R3156 vss.n1527 vss.n1526 64.6669
R3157 vss.n1533 vss.n919 64.6669
R3158 vss.n1936 vss.n1934 64.6669
R3159 vss.n1939 vss.n1938 64.6669
R3160 vss.n664 vss.n663 64.6669
R3161 vss.n659 vss.n392 64.6669
R3162 vss.n2246 vss.n273 64.6669
R3163 vss.n2192 vss.n274 64.6669
R3164 vss.n1535 vss.n916 64.6669
R3165 vss.n1524 vss.n914 64.6669
R3166 vss.n1528 vss.n1527 64.6669
R3167 vss.n1533 vss.n1532 64.6669
R3168 vss.n2190 vss.n298 64.6669
R3169 vss.n2101 vss.n2100 64.6669
R3170 vss.n1689 vss.n1688 64.6669
R3171 vss.n2097 vss.n2096 64.6669
R3172 vss.n2249 vss.n2248 64.6669
R3173 vss.n2143 vss.n2142 64.6669
R3174 vss.n1938 vss.n536 64.6669
R3175 vss.n1524 vss.n912 64.6669
R3176 vss.n1536 vss.n1535 64.6669
R3177 vss.n2193 vss.n2192 64.6669
R3178 vss.n2246 vss.n2245 64.6669
R3179 vss.n648 vss.n392 64.6669
R3180 vss.n663 vss.n662 64.6669
R3181 vss.n1937 vss.n1936 64.6669
R3182 vss.t7 vss.t30 64.5877
R3183 vss.t34 vss.t20 64.5877
R3184 vss.t48 vss.t2 64.5877
R3185 vss.t41 vss.t11 64.5877
R3186 vss.t42 vss.t16 64.5877
R3187 vss.t0 vss.t26 64.5877
R3188 vss.t13 vss.t14 64.5877
R3189 vss.t6 vss.t45 64.5877
R3190 vss.n748 vss.n730 62.6786
R3191 vss.n1593 vss.n1592 62.6786
R3192 vss.n1241 vss.n1183 62.6786
R3193 vss.n1765 vss.n1764 62.6786
R3194 vss.n1432 vss.n1423 62.6786
R3195 vss.n1028 vss.n1027 62.6786
R3196 vss.n1857 vss.n1856 62.6786
R3197 vss.n2075 vss.n517 62.6786
R3198 vss.n2127 vss.n409 58.5005
R3199 vss.n423 vss.n409 58.5005
R3200 vss.n2128 vss.n2127 58.5005
R3201 vss.n2129 vss.n2128 58.5005
R3202 vss.n1512 vss.n938 58.5005
R3203 vss.n1084 vss.n938 58.5005
R3204 vss.n1512 vss.n936 58.5005
R3205 vss.n1501 vss.n936 58.5005
R3206 vss.n2127 vss.n408 58.5005
R3207 vss.n408 vss.n401 58.5005
R3208 vss.n2127 vss.n407 58.5005
R3209 vss.n1910 vss.n407 58.5005
R3210 vss.n1513 vss.n1512 58.5005
R3211 vss.n1514 vss.n1513 58.5005
R3212 vss.n1512 vss.n937 58.5005
R3213 vss.n1098 vss.n937 58.5005
R3214 vss.n748 vss.t230 53.9036
R3215 vss.t256 vss.n1593 53.9036
R3216 vss.n1183 vss.t254 53.9036
R3217 vss.n1764 vss.t219 53.9036
R3218 vss.n1432 vss.t222 53.9036
R3219 vss.t225 vss.n1028 53.9036
R3220 vss.n1857 vss.t216 53.9036
R3221 vss.t232 vss.n2075 53.9036
R3222 vss.n2084 vss.n496 53.8231
R3223 vss.n1362 vss.n1007 53.8231
R3224 vss.n614 vss.n611 53.1823
R3225 vss.n611 vss.n610 53.1823
R3226 vss.n1672 vss.n1671 53.1823
R3227 vss.n1671 vss.n1670 53.1823
R3228 vss.n443 vss.n442 53.1823
R3229 vss.n444 vss.n443 53.1823
R3230 vss.n453 vss.n437 53.1823
R3231 vss.n447 vss.n437 53.1823
R3232 vss.n1104 vss.n918 53.1823
R3233 vss.n1114 vss.n1104 53.1823
R3234 vss.n1109 vss.n1108 53.1823
R3235 vss.n1110 vss.n1109 53.1823
R3236 vss.n1482 vss.n1481 53.1823
R3237 vss.n1481 vss.n1469 53.1823
R3238 vss.n1471 vss.n297 53.1823
R3239 vss.n1473 vss.n1471 53.1823
R3240 vss.n615 vss.n614 53.1823
R3241 vss.n1665 vss.n615 53.1823
R3242 vss.n1673 vss.n1672 53.1823
R3243 vss.n1674 vss.n1673 53.1823
R3244 vss.n442 vss.n441 53.1823
R3245 vss.n441 vss.n432 53.1823
R3246 vss.n453 vss.n434 53.1823
R3247 vss.n434 vss.n433 53.1823
R3248 vss.n1093 vss.n918 53.1823
R3249 vss.n1093 vss.n1092 53.1823
R3250 vss.n1108 vss.n1107 53.1823
R3251 vss.n1107 vss.n1091 53.1823
R3252 vss.n1483 vss.n1482 53.1823
R3253 vss.n1483 vss.n1479 53.1823
R3254 vss.n1489 vss.n297 53.1823
R3255 vss.n1489 vss.n1488 53.1823
R3256 vss.n2114 vss.t306 53.1503
R3257 vss.n2114 vss.t308 53.1503
R3258 vss.n2127 vss.t311 53.1503
R3259 vss.n2127 vss.t312 53.1503
R3260 vss.n1906 vss.t314 53.1503
R3261 vss.n1906 vss.t316 53.1503
R3262 vss.n1497 vss.t318 53.1503
R3263 vss.n1497 vss.t320 53.1503
R3264 vss.n1512 vss.t321 53.1503
R3265 vss.n1512 vss.t322 53.1503
R3266 vss.n1125 vss.t324 53.1503
R3267 vss.n1125 vss.t326 53.1503
R3268 vss.n1631 vss.n1630 50.1429
R3269 vss.n1583 vss.n886 50.1429
R3270 vss.n1261 vss.n902 50.1429
R3271 vss.n1732 vss.n595 50.1429
R3272 vss.n1458 vss.n1421 50.1429
R3273 vss.n1347 vss.n984 50.1429
R3274 vss.n1879 vss.n1802 50.1429
R3275 vss.n1984 vss.n1983 50.1429
R3276 vss.n1899 vss.n1898 48.7505
R3277 vss.n1898 vss.n417 48.7505
R3278 vss.n2122 vss.n2121 48.7505
R3279 vss.n2123 vss.n2122 48.7505
R3280 vss.n1323 vss.n1322 48.7505
R3281 vss.n1323 vss.n946 48.7505
R3282 vss.n1507 vss.n1506 48.7505
R3283 vss.n1508 vss.n1507 48.7505
R3284 vss.n2121 vss.n420 48.7505
R3285 vss.n552 vss.n420 48.7505
R3286 vss.n1899 vss.n576 48.7505
R3287 vss.n625 vss.n576 48.7505
R3288 vss.n1506 vss.n949 48.7505
R3289 vss.n1316 vss.n949 48.7505
R3290 vss.n1322 vss.n1321 48.7505
R3291 vss.n1321 vss.n1320 48.7505
R3292 vss.n1658 vss.n1657 48.7505
R3293 vss.n1657 vss.n618 48.7505
R3294 vss.n558 vss.n551 48.7505
R3295 vss.n1916 vss.n551 48.7505
R3296 vss.n1292 vss.n1291 48.7505
R3297 vss.n1292 vss.n895 48.7505
R3298 vss.n1296 vss.n1294 48.7505
R3299 vss.n1294 vss.n892 48.7505
R3300 vss.n972 vss.n971 48.7505
R3301 vss.n971 vss.n970 48.7505
R3302 vss.n1080 vss.n1079 48.7505
R3303 vss.n1080 vss.n978 48.7505
R3304 vss.n1778 vss.n1777 48.7505
R3305 vss.n1777 vss.n1771 48.7505
R3306 vss.n581 vss.n577 48.7505
R3307 vss.n584 vss.n577 48.7505
R3308 vss.n1683 vss.n1682 45.177
R3309 vss.n2106 vss.n2105 45.177
R3310 vss.n1664 vss.n617 45.177
R3311 vss.n1913 vss.n1912 45.177
R3312 vss.n1102 vss.n1096 45.177
R3313 vss.n1487 vss.n1485 45.177
R3314 vss.n1117 vss.n1116 45.177
R3315 vss.n1493 vss.n1470 45.177
R3316 vss.n558 vss.t36 44.8413
R3317 vss.n1658 vss.t64 44.8413
R3318 vss.n1296 vss.t77 44.8413
R3319 vss.n1291 vss.t209 44.8413
R3320 vss.n972 vss.t78 44.8413
R3321 vss.n1079 vss.t12 44.8413
R3322 vss.n1778 vss.t76 44.8413
R3323 vss.n581 vss.t27 44.8413
R3324 vss.n1920 vss.n1919 42.9729
R3325 vss.n1654 vss.n1652 42.9729
R3326 vss.n1313 vss.n1312 42.9729
R3327 vss.n1283 vss.n1282 42.9729
R3328 vss.n1406 vss.n1405 42.9729
R3329 vss.n1327 vss.n1326 42.9729
R3330 vss.n1787 vss.n1786 42.9729
R3331 vss.n1896 vss.n579 42.9729
R3332 vss.t234 vss.n2047 41.7862
R3333 vss.n2047 vss.n2046 41.7862
R3334 vss.t234 vss.n2035 41.7862
R3335 vss.n2044 vss.n2035 41.7862
R3336 vss.t238 vss.n395 41.7862
R3337 vss.n397 vss.n395 41.7862
R3338 vss.t238 vss.n396 41.7862
R3339 vss.n2137 vss.n396 41.7862
R3340 vss.t228 vss.n841 41.7862
R3341 vss.n841 vss.n840 41.7862
R3342 vss.t228 vss.n834 41.7862
R3343 vss.n838 vss.n834 41.7862
R3344 vss.n992 vss.t242 41.7862
R3345 vss.n994 vss.n992 41.7862
R3346 vss.n997 vss.t242 41.7862
R3347 vss.n997 vss.n996 41.7862
R3348 vss.t234 vss.n2037 41.7862
R3349 vss.n2038 vss.n2037 41.7862
R3350 vss.t234 vss.n2036 41.7862
R3351 vss.n2039 vss.n2036 41.7862
R3352 vss.t238 vss.n713 41.7862
R3353 vss.n713 vss.n712 41.7862
R3354 vss.t238 vss.n707 41.7862
R3355 vss.n710 vss.n707 41.7862
R3356 vss.t228 vss.n835 41.7862
R3357 vss.n835 vss.n830 41.7862
R3358 vss.n842 vss.t228 41.7862
R3359 vss.n843 vss.n842 41.7862
R3360 vss.n999 vss.t242 41.7862
R3361 vss.n1001 vss.n999 41.7862
R3362 vss.n1000 vss.t242 41.7862
R3363 vss.n1004 vss.n1000 41.7862
R3364 vss.t230 vss.n747 41.7862
R3365 vss.n747 vss.n746 41.7862
R3366 vss.t230 vss.n731 41.7862
R3367 vss.n744 vss.n731 41.7862
R3368 vss.t256 vss.n1594 41.7862
R3369 vss.n1594 vss.n882 41.7862
R3370 vss.n1595 vss.t256 41.7862
R3371 vss.n1596 vss.n1595 41.7862
R3372 vss.n1248 vss.t254 41.7862
R3373 vss.n1248 vss.n1246 41.7862
R3374 vss.n1252 vss.t254 41.7862
R3375 vss.n1253 vss.n1252 41.7862
R3376 vss.t219 vss.n1755 41.7862
R3377 vss.n1755 vss.n1754 41.7862
R3378 vss.t219 vss.n592 41.7862
R3379 vss.n1752 vss.n592 41.7862
R3380 vss.n1444 vss.t222 41.7862
R3381 vss.n1444 vss.n1442 41.7862
R3382 vss.n1448 vss.t222 41.7862
R3383 vss.n1448 vss.n1443 41.7862
R3384 vss.t225 vss.n1011 41.7862
R3385 vss.n1013 vss.n1011 41.7862
R3386 vss.t225 vss.n1012 41.7862
R3387 vss.n1014 vss.n1012 41.7862
R3388 vss.n1863 vss.t216 41.7862
R3389 vss.n1865 vss.n1863 41.7862
R3390 vss.n1864 vss.t216 41.7862
R3391 vss.n1869 vss.n1864 41.7862
R3392 vss.n2077 vss.t232 41.7862
R3393 vss.n2078 vss.n2077 41.7862
R3394 vss.t232 vss.n2076 41.7862
R3395 vss.n2076 vss.n512 41.7862
R3396 vss.t18 vss.n550 41.1045
R3397 vss.n1653 vss.t15 41.1045
R3398 vss.n1303 vss.t1 41.1045
R3399 vss.n1284 vss.t214 41.1045
R3400 vss.n1404 vss.t28 41.1045
R3401 vss.t60 vss.n1071 41.1045
R3402 vss.n1785 vss.t37 41.1045
R3403 vss.n1895 vss.t51 41.1045
R3404 vss.n1655 vss.n1654 34.4123
R3405 vss.n1655 vss.n626 34.4123
R3406 vss.n1919 vss.n1918 34.4123
R3407 vss.n1918 vss.n1917 34.4123
R3408 vss.n2127 vss.n411 34.4123
R3409 vss.n623 vss.n411 34.4123
R3410 vss.n1283 vss.n1132 34.4123
R3411 vss.n1134 vss.n1132 34.4123
R3412 vss.n1314 vss.n1313 34.4123
R3413 vss.n1315 vss.n1314 34.4123
R3414 vss.n1512 vss.n940 34.4123
R3415 vss.n1318 vss.n940 34.4123
R3416 vss.n1326 vss.n1325 34.4123
R3417 vss.n1325 vss.n1324 34.4123
R3418 vss.n1405 vss.n948 34.4123
R3419 vss.n948 vss.n947 34.4123
R3420 vss.n1512 vss.n1511 34.4123
R3421 vss.n1511 vss.n1510 34.4123
R3422 vss.n1897 vss.n1896 34.4123
R3423 vss.n1897 vss.n578 34.4123
R3424 vss.n1786 vss.n419 34.4123
R3425 vss.n419 vss.n418 34.4123
R3426 vss.n2127 vss.n2126 34.4123
R3427 vss.n2126 vss.n2125 34.4123
R3428 vss.n2058 vss.n2020 33.6396
R3429 vss.n778 vss.n722 33.6396
R3430 vss.n859 vss.n821 33.6396
R3431 vss.n1231 vss.n1209 33.6396
R3432 vss.n2108 vss.t30 32.2941
R3433 vss.n2108 vss.t20 32.2941
R3434 vss.n1680 vss.t2 32.2941
R3435 vss.n1680 vss.t11 32.2941
R3436 vss.n1491 vss.t42 32.2941
R3437 vss.n1491 vss.t26 32.2941
R3438 vss.n1119 vss.t14 32.2941
R3439 vss.n1119 vss.t6 32.2941
R3440 vss.t293 vss.t130 31.3395
R3441 vss.t296 vss.t133 31.3395
R3442 vss.t136 vss.t298 31.3395
R3443 vss.t100 vss.t263 31.3395
R3444 vss.t103 vss.t281 31.3395
R3445 vss.t95 vss.t266 31.3395
R3446 vss.t97 vss.t260 31.3395
R3447 vss.t121 vss.t270 31.3395
R3448 vss.n2056 vss.t276 29.7417
R3449 vss.n2056 vss.t275 29.7417
R3450 vss.n2048 vss.t156 29.7417
R3451 vss.n2048 vss.t141 29.7417
R3452 vss.t112 vss.n2030 29.7417
R3453 vss.n2030 vss.t109 29.7417
R3454 vss.n874 vss.t301 29.7417
R3455 vss.n874 vss.t297 29.7417
R3456 vss.n884 vss.t258 29.7417
R3457 vss.n884 vss.t257 29.7417
R3458 vss.n1589 vss.t180 29.7417
R3459 vss.n1589 vss.t179 29.7417
R3460 vss.t135 vss.n879 29.7417
R3461 vss.n879 vss.t134 29.7417
R3462 vss.n1239 vss.t303 29.7417
R3463 vss.n1239 vss.t299 29.7417
R3464 vss.t251 vss.n1003 29.7417
R3465 vss.n1003 vss.t250 29.7417
R3466 vss.t244 vss.n995 29.7417
R3467 vss.n995 vss.t243 29.7417
R3468 vss.t165 vss.n827 29.7417
R3469 vss.n827 vss.t162 29.7417
R3470 vss.n819 vss.t118 29.7417
R3471 vss.n819 vss.t116 29.7417
R3472 vss.n862 vss.t279 29.7417
R3473 vss.t278 vss.n862 29.7417
R3474 vss.n1229 vss.t288 29.7417
R3475 vss.n1229 vss.t287 29.7417
R3476 vss.n1367 vss.t199 29.7417
R3477 vss.n1367 vss.t188 29.7417
R3478 vss.n1025 vss.t285 29.7417
R3479 vss.n1025 vss.t267 29.7417
R3480 vss.n1017 vss.t106 29.7417
R3481 vss.n1017 vss.t96 29.7417
R3482 vss.n1031 vss.t227 29.7417
R3483 vss.n1031 vss.t226 29.7417
R3484 vss.n1351 vss.t155 29.7417
R3485 vss.t154 vss.n1351 29.7417
R3486 vss.n1854 vss.t262 29.7417
R3487 vss.n1854 vss.t261 29.7417
R3488 vss.t99 vss.n1859 29.7417
R3489 vss.n1859 vss.t98 29.7417
R3490 vss.n1876 vss.t146 29.7417
R3491 vss.n1876 vss.t145 29.7417
R3492 vss.t218 vss.n1868 29.7417
R3493 vss.n1868 vss.t217 29.7417
R3494 vss.n1429 vss.t283 29.7417
R3495 vss.t282 vss.n1429 29.7417
R3496 vss.n591 vss.t265 29.7417
R3497 vss.n591 vss.t264 29.7417
R3498 vss.t105 vss.n1435 29.7417
R3499 vss.n1435 vss.t104 29.7417
R3500 vss.n1762 vss.t102 29.7417
R3501 vss.n1762 vss.t101 29.7417
R3502 vss.n1753 vss.t221 29.7417
R3503 vss.t220 vss.n1753 29.7417
R3504 vss.n1745 vss.t149 29.7417
R3505 vss.n1745 vss.t148 29.7417
R3506 vss.n1455 vss.t152 29.7417
R3507 vss.n1455 vss.t151 29.7417
R3508 vss.n1445 vss.t224 29.7417
R3509 vss.n1445 vss.t223 29.7417
R3510 vss.n776 vss.t284 29.7417
R3511 vss.n776 vss.t280 29.7417
R3512 vss.n365 vss.t195 29.7417
R3513 vss.n365 vss.t194 29.7417
R3514 vss.t198 vss.n2170 29.7417
R3515 vss.n2170 vss.t197 29.7417
R3516 vss.n832 vss.t249 29.7417
R3517 vss.n832 vss.t248 29.7417
R3518 vss.n2040 vss.t245 29.7417
R3519 vss.n2040 vss.t237 29.7417
R3520 vss.n514 vss.t252 29.7417
R3521 vss.n514 vss.t233 29.7417
R3522 vss.t174 vss.n523 29.7417
R3523 vss.n523 vss.t160 29.7417
R3524 vss.n2073 vss.t129 29.7417
R3525 vss.n2073 vss.t122 29.7417
R3526 vss.t272 vss.n2067 29.7417
R3527 vss.n2067 vss.t271 29.7417
R3528 vss.t200 vss.n2017 29.7417
R3529 vss.n2017 vss.t192 29.7417
R3530 vss.t289 vss.n2062 29.7417
R3531 vss.n2062 vss.t274 29.7417
R3532 vss.n2026 vss.t120 29.7417
R3533 vss.t108 vss.n2026 29.7417
R3534 vss.n2053 vss.t168 29.7417
R3535 vss.t167 vss.n2053 29.7417
R3536 vss.n2045 vss.t236 29.7417
R3537 vss.t235 vss.n2045 29.7417
R3538 vss.n711 vss.t247 29.7417
R3539 vss.t246 vss.n711 29.7417
R3540 vss.n752 vss.t132 29.7417
R3541 vss.t131 vss.n752 29.7417
R3542 vss.n737 vss.t177 29.7417
R3543 vss.n737 vss.t176 29.7417
R3544 vss.n745 vss.t253 29.7417
R3545 vss.t231 vss.n745 29.7417
R3546 vss.n696 vss.t169 29.7417
R3547 vss.n696 vss.t143 29.7417
R3548 vss.n705 vss.t124 29.7417
R3549 vss.n705 vss.t123 29.7417
R3550 vss.n768 vss.t290 29.7417
R3551 vss.t269 vss.n768 29.7417
R3552 vss.t201 vss.n763 29.7417
R3553 vss.n763 vss.t190 29.7417
R3554 vss.n757 vss.t295 29.7417
R3555 vss.t294 vss.n757 29.7417
R3556 vss.n2138 vss.t240 29.7417
R3557 vss.n2138 vss.t239 29.7417
R3558 vss.n839 vss.t241 29.7417
R3559 vss.t229 vss.n839 29.7417
R3560 vss.n1207 vss.t119 29.7417
R3561 vss.n1207 vss.t114 29.7417
R3562 vss.n1521 vss.t166 29.7417
R3563 vss.n1521 vss.t158 29.7417
R3564 vss.n1181 vss.t138 29.7417
R3565 vss.n1181 vss.t137 29.7417
R3566 vss.n1258 vss.t183 29.7417
R3567 vss.n1258 vss.t182 29.7417
R3568 vss.n1249 vss.t259 29.7417
R3569 vss.n1249 vss.t255 29.7417
R3570 vss.t173 vss.n1192 29.7417
R3571 vss.n1192 vss.t170 29.7417
R3572 vss.n1199 vss.t128 29.7417
R3573 vss.n1199 vss.t127 29.7417
R3574 vss.n1221 vss.t302 29.7417
R3575 vss.t300 vss.n1221 29.7417
R3576 vss.t207 vss.n1216 29.7417
R3577 vss.n1216 vss.t206 29.7417
R3578 vss.t204 vss.n800 29.7417
R3579 vss.n800 vss.t203 29.7417
R3580 vss.t292 vss.n870 29.7417
R3581 vss.n870 vss.t291 29.7417
R3582 vss.n811 vss.t126 29.7417
R3583 vss.n811 vss.t125 29.7417
R3584 vss.t172 vss.n848 29.7417
R3585 vss.n848 vss.t171 29.7417
R3586 vss.t186 vss.n1848 29.7417
R3587 vss.n1848 vss.t185 29.7417
R3588 vss.n784 vss.t164 29.7417
R3589 vss.t163 vss.n784 29.7417
R3590 vss.n720 vss.t117 29.7417
R3591 vss.n720 vss.t111 29.7417
R3592 vss.t234 vss.n2020 28.9302
R3593 vss.n722 vss.t238 28.9302
R3594 vss.t228 vss.n821 28.9302
R3595 vss.n1209 vss.t242 28.9302
R3596 vss.t86 vss.t52 28.026
R3597 vss.t85 vss.t211 28.026
R3598 vss.t75 vss.t46 28.026
R3599 vss.t90 vss.t35 28.026
R3600 vss.t73 vss.t40 28.026
R3601 vss.t72 vss.t23 28.026
R3602 vss.t63 vss.t61 28.026
R3603 vss.t62 vss.t10 28.026
R3604 vss.n1901 vss.n1900 27.8576
R3605 vss.n1902 vss.n1901 27.8576
R3606 vss.n2120 vss.n2119 27.8576
R3607 vss.n2119 vss.n2118 27.8576
R3608 vss.n1131 vss.n1130 27.8576
R3609 vss.n1130 vss.n1129 27.8576
R3610 vss.n1505 vss.n1504 27.8576
R3611 vss.n1504 vss.n1503 27.8576
R3612 vss.n1900 vss.n574 27.8576
R3613 vss.n574 vss.n564 27.8576
R3614 vss.n2120 vss.n421 27.8576
R3615 vss.n563 vss.n421 27.8576
R3616 vss.n1131 vss.n1081 27.8576
R3617 vss.n1097 vss.n1081 27.8576
R3618 vss.n1505 vss.n950 27.8576
R3619 vss.n957 vss.n950 27.8576
R3620 vss.n1970 vss.n1969 22.5005
R3621 vss.n1971 vss.n1970 22.5005
R3622 vss.n1645 vss.n1644 22.5005
R3623 vss.n1644 vss.n1643 22.5005
R3624 vss.n1640 vss.n1639 22.5005
R3625 vss.n1641 vss.n1640 22.5005
R3626 vss.n1632 vss.n1631 22.5005
R3627 vss.n1633 vss.n1632 22.5005
R3628 vss.n1637 vss.n1636 22.5005
R3629 vss.n1636 vss.n1635 22.5005
R3630 vss.n1578 vss.n1577 22.5005
R3631 vss.n1579 vss.n1578 22.5005
R3632 vss.n1583 vss.n1582 22.5005
R3633 vss.n1582 vss.n1581 22.5005
R3634 vss.n1574 vss.n1573 22.5005
R3635 vss.n1573 vss.n1572 22.5005
R3636 vss.n1569 vss.n290 22.5005
R3637 vss.n1570 vss.n1569 22.5005
R3638 vss.n1275 vss.n1274 22.5005
R3639 vss.n1274 vss.n1273 22.5005
R3640 vss.n1270 vss.n1269 22.5005
R3641 vss.n1271 vss.n1270 22.5005
R3642 vss.n1262 vss.n1261 22.5005
R3643 vss.n1263 vss.n1262 22.5005
R3644 vss.n1267 vss.n1266 22.5005
R3645 vss.n1266 vss.n1265 22.5005
R3646 vss.n1730 vss.n1729 22.5005
R3647 vss.n1729 vss.n1728 22.5005
R3648 vss.n1733 vss.n1732 22.5005
R3649 vss.n1735 vss.n1733 22.5005
R3650 vss.n1734 vss.n1731 22.5005
R3651 vss.n1736 vss.n1734 22.5005
R3652 vss.n1464 vss.n1463 22.5005
R3653 vss.n1463 vss.n1462 22.5005
R3654 vss.n1459 vss.n1458 22.5005
R3655 vss.n1460 vss.n1459 22.5005
R3656 vss.n1466 vss.n1465 22.5005
R3657 vss.n1466 vss.n1413 22.5005
R3658 vss.n1414 vss.n303 22.5005
R3659 vss.n1414 vss.n1412 22.5005
R3660 vss.n1335 vss.n1334 22.5005
R3661 vss.n1336 vss.n1335 22.5005
R3662 vss.n1340 vss.n1339 22.5005
R3663 vss.n1339 vss.n1338 22.5005
R3664 vss.n1347 vss.n1346 22.5005
R3665 vss.n1346 vss.n1345 22.5005
R3666 vss.n1342 vss.n1341 22.5005
R3667 vss.n1343 vss.n1342 22.5005
R3668 vss.n1795 vss.n459 22.5005
R3669 vss.n1795 vss.n1793 22.5005
R3670 vss.n1725 vss.n1724 22.5005
R3671 vss.n1726 vss.n1725 22.5005
R3672 vss.n1885 vss.n1884 22.5005
R3673 vss.n1884 vss.n1883 22.5005
R3674 vss.n1880 vss.n1879 22.5005
R3675 vss.n1881 vss.n1880 22.5005
R3676 vss.n1887 vss.n1886 22.5005
R3677 vss.n1887 vss.n1794 22.5005
R3678 vss.n1978 vss.n1977 22.5005
R3679 vss.n1979 vss.n1978 22.5005
R3680 vss.n1983 vss.n1982 22.5005
R3681 vss.n1982 vss.n1981 22.5005
R3682 vss.n1975 vss.n1974 22.5005
R3683 vss.n1974 vss.n1973 22.5005
R3684 vss.n1653 vss.n622 21.6672
R3685 vss.n622 vss.n619 21.6672
R3686 vss.n1660 vss.n412 21.6672
R3687 vss.n1661 vss.n1660 21.6672
R3688 vss.n1921 vss.n1920 21.6672
R3689 vss.n1922 vss.n1921 21.6672
R3690 vss.n1926 vss.n1925 21.6672
R3691 vss.n1925 vss.n1924 21.6672
R3692 vss.n556 vss.n410 21.6672
R3693 vss.n556 vss.n554 21.6672
R3694 vss.n557 vss.n550 21.6672
R3695 vss.n557 vss.n555 21.6672
R3696 vss.n1647 vss.n1646 21.6672
R3697 vss.n1648 vss.n1647 21.6672
R3698 vss.n1652 vss.n1651 21.6672
R3699 vss.n1651 vss.n1650 21.6672
R3700 vss.n1285 vss.n1284 21.6672
R3701 vss.n1286 vss.n1285 21.6672
R3702 vss.n1289 vss.n941 21.6672
R3703 vss.n1289 vss.n1288 21.6672
R3704 vss.n1312 vss.n1311 21.6672
R3705 vss.n1311 vss.n1310 21.6672
R3706 vss.n1307 vss.n1306 21.6672
R3707 vss.n1308 vss.n1307 21.6672
R3708 vss.n1298 vss.n939 21.6672
R3709 vss.n1299 vss.n1298 21.6672
R3710 vss.n1303 vss.n1302 21.6672
R3711 vss.n1302 vss.n1301 21.6672
R3712 vss.n1277 vss.n1276 21.6672
R3713 vss.n1278 vss.n1277 21.6672
R3714 vss.n1282 vss.n1281 21.6672
R3715 vss.n1281 vss.n1280 21.6672
R3716 vss.n1406 vss.n967 21.6672
R3717 vss.n967 vss.n965 21.6672
R3718 vss.n1407 vss.n968 21.6672
R3719 vss.n968 vss.n966 21.6672
R3720 vss.n975 vss.n942 21.6672
R3721 vss.n976 vss.n975 21.6672
R3722 vss.n1404 vss.n1403 21.6672
R3723 vss.n1403 vss.n1402 21.6672
R3724 vss.n1073 vss.n1071 21.6672
R3725 vss.n1075 vss.n1073 21.6672
R3726 vss.n1074 vss.n935 21.6672
R3727 vss.n1076 vss.n1074 21.6672
R3728 vss.n1333 vss.n1332 21.6672
R3729 vss.n1332 vss.n1331 21.6672
R3730 vss.n1328 vss.n1327 21.6672
R3731 vss.n1329 vss.n1328 21.6672
R3732 vss.n1787 vss.n1774 21.6672
R3733 vss.n1774 vss.n1772 21.6672
R3734 vss.n1788 vss.n1775 21.6672
R3735 vss.n1775 vss.n1773 21.6672
R3736 vss.n1780 vss.n413 21.6672
R3737 vss.n1781 vss.n1780 21.6672
R3738 vss.n1785 vss.n1784 21.6672
R3739 vss.n1784 vss.n1783 21.6672
R3740 vss.n1895 vss.n1894 21.6672
R3741 vss.n1894 vss.n1893 21.6672
R3742 vss.n1890 vss.n406 21.6672
R3743 vss.n1891 vss.n1890 21.6672
R3744 vss.n1723 vss.n1722 21.6672
R3745 vss.n1722 vss.n1721 21.6672
R3746 vss.n1718 vss.n579 21.6672
R3747 vss.n1719 vss.n1718 21.6672
R3748 vss.n1539 vss.n903 17.3181
R3749 vss.n1541 vss.n131 4.48498
R3750 vss.n1542 vss.n1541 17.3181
R3751 vss.n1545 vss.n132 4.48498
R3752 vss.n1546 vss.n1545 17.3181
R3753 vss.n1549 vss.n133 4.48498
R3754 vss.n1551 vss.n1549 17.3181
R3755 vss.n1552 vss.n134 4.48498
R3756 vss.n1554 vss.n1552 17.3181
R3757 vss.n1556 vss.n135 4.48498
R3758 vss.n1557 vss.n1556 17.3181
R3759 vss.n1558 vss.n136 4.48498
R3760 vss.n1558 vss.n913 17.3181
R3761 vss.n2222 vss.n285 17.3181
R3762 vss.n2227 vss.n143 4.48498
R3763 vss.n2228 vss.n2227 17.3181
R3764 vss.n2229 vss.n144 4.48498
R3765 vss.n2229 vss.n282 17.3181
R3766 vss.n2234 vss.n145 4.48498
R3767 vss.n2235 vss.n2234 17.3181
R3768 vss.n2236 vss.n146 4.48498
R3769 vss.n2236 vss.n277 17.3181
R3770 vss.n2241 vss.n147 4.48498
R3771 vss.n2241 vss.n276 17.3181
R3772 vss.n2242 vss.n148 4.48498
R3773 vss.n2243 vss.n2242 17.3181
R3774 vss.n2220 vss.n288 17.3181
R3775 vss.n2194 vss.n137 4.48498
R3776 vss.n2197 vss.n2194 17.3181
R3777 vss.n2198 vss.n138 4.48498
R3778 vss.n2201 vss.n2198 17.3181
R3779 vss.n2202 vss.n139 4.48498
R3780 vss.n2205 vss.n2202 17.3181
R3781 vss.n2206 vss.n140 4.48498
R3782 vss.n2209 vss.n2206 17.3181
R3783 vss.n2211 vss.n141 4.48498
R3784 vss.n2212 vss.n2211 17.3181
R3785 vss.n2213 vss.n142 4.48498
R3786 vss.n2213 vss.n244 17.3181
R3787 vss.n1529 vss.n922 17.3181
R3788 vss.n1385 vss.n155 4.48498
R3789 vss.n1388 vss.n1385 17.3181
R3790 vss.n1389 vss.n156 4.48498
R3791 vss.n1392 vss.n1389 17.3181
R3792 vss.n1393 vss.n157 4.48498
R3793 vss.n1394 vss.n1393 17.3181
R3794 vss.n158 vss.n1377 4.48498
R3795 vss.n1384 vss.n1377 17.3181
R3796 vss.n159 vss.n1381 4.48498
R3797 vss.n1381 vss.n1380 17.3181
R3798 vss.n160 vss.n1378 4.48498
R3799 vss.n1378 vss.n982 17.3181
R3800 vss.n1531 vss.n921 17.3181
R3801 vss.n1046 vss.n149 4.48498
R3802 vss.n1047 vss.n1046 17.3181
R3803 vss.n1050 vss.n150 4.48498
R3804 vss.n1051 vss.n1050 17.3181
R3805 vss.n1054 vss.n151 4.48498
R3806 vss.n1055 vss.n1054 17.3181
R3807 vss.n1058 vss.n152 4.48498
R3808 vss.n1060 vss.n1058 17.3181
R3809 vss.n1061 vss.n153 4.48498
R3810 vss.n1063 vss.n1061 17.3181
R3811 vss.n1064 vss.n154 4.48498
R3812 vss.n1065 vss.n1064 17.3181
R3813 vss.n2250 vss.n268 17.3181
R3814 vss.n341 vss.n161 4.48498
R3815 vss.n344 vss.n341 17.3181
R3816 vss.n345 vss.n162 4.48498
R3817 vss.n348 vss.n345 17.3181
R3818 vss.n349 vss.n163 4.48498
R3819 vss.n352 vss.n349 17.3181
R3820 vss.n353 vss.n164 4.48498
R3821 vss.n356 vss.n353 17.3181
R3822 vss.n357 vss.n165 4.48498
R3823 vss.n360 vss.n357 17.3181
R3824 vss.n361 vss.n166 4.48498
R3825 vss.n361 vss.n329 17.3181
R3826 vss.n2187 vss.n299 17.3181
R3827 vss.n2186 vss.n167 4.48498
R3828 vss.n2186 vss.n300 17.3181
R3829 vss.n313 vss.n168 4.48498
R3830 vss.n316 vss.n313 17.3181
R3831 vss.n318 vss.n169 4.48498
R3832 vss.n319 vss.n318 17.3181
R3833 vss.n321 vss.n170 4.48498
R3834 vss.n322 vss.n321 17.3181
R3835 vss.n325 vss.n171 4.48498
R3836 vss.n327 vss.n325 17.3181
R3837 vss.n328 vss.n172 4.48498
R3838 vss.n328 vss.n312 17.3181
R3839 vss.n2102 vss.n449 17.3181
R3840 vss.n1818 vss.n173 4.48498
R3841 vss.n1821 vss.n1818 17.3181
R3842 vss.n1822 vss.n174 4.48498
R3843 vss.n1825 vss.n1822 17.3181
R3844 vss.n1826 vss.n175 4.48498
R3845 vss.n1829 vss.n1826 17.3181
R3846 vss.n1830 vss.n176 4.48498
R3847 vss.n1833 vss.n1830 17.3181
R3848 vss.n1834 vss.n177 4.48498
R3849 vss.n1837 vss.n1834 17.3181
R3850 vss.n1838 vss.n178 4.48498
R3851 vss.n1838 vss.n485 17.3181
R3852 vss.n2095 vss.n456 17.3181
R3853 vss.n2094 vss.n179 4.48498
R3854 vss.n2094 vss.n457 17.3181
R3855 vss.n469 vss.n180 4.48498
R3856 vss.n470 vss.n469 17.3181
R3857 vss.n473 vss.n181 4.48498
R3858 vss.n474 vss.n473 17.3181
R3859 vss.n477 vss.n182 4.48498
R3860 vss.n479 vss.n477 17.3181
R3861 vss.n480 vss.n183 4.48498
R3862 vss.n482 vss.n480 17.3181
R3863 vss.n484 vss.n184 4.48498
R3864 vss.n484 vss.n467 17.3181
R3865 vss.n1691 vss.n609 17.3181
R3866 vss.n1692 vss.n185 4.48498
R3867 vss.n1695 vss.n1692 17.3181
R3868 vss.n1696 vss.n186 4.48498
R3869 vss.n1699 vss.n1696 17.3181
R3870 vss.n1701 vss.n187 4.48498
R3871 vss.n1702 vss.n1701 17.3181
R3872 vss.n1704 vss.n188 4.48498
R3873 vss.n1706 vss.n1704 17.3181
R3874 vss.n1707 vss.n189 4.48498
R3875 vss.n1709 vss.n1707 17.3181
R3876 vss.n1711 vss.n190 4.48498
R3877 vss.n1711 vss.n608 17.3181
R3878 vss.n2145 vss.n2144 17.3181
R3879 vss.n2147 vss.n191 4.48498
R3880 vss.n2149 vss.n2147 17.3181
R3881 vss.n2150 vss.n192 4.48498
R3882 vss.n2152 vss.n2150 17.3181
R3883 vss.n2154 vss.n193 4.48498
R3884 vss.n2155 vss.n2154 17.3181
R3885 vss.n2157 vss.n194 4.48498
R3886 vss.n2158 vss.n2157 17.3181
R3887 vss.n2161 vss.n195 4.48498
R3888 vss.n2163 vss.n2161 17.3181
R3889 vss.n197 vss.n196 4.48498
R3890 vss.n2164 vss.n196 17.3181
R3891 vss.n1945 vss.n1944 17.3181
R3892 vss.n1948 vss.n204 4.48498
R3893 vss.n1949 vss.n1948 17.3181
R3894 vss.n1952 vss.n205 4.48498
R3895 vss.n1953 vss.n1952 17.3181
R3896 vss.n1956 vss.n206 4.48498
R3897 vss.n1957 vss.n1956 17.3181
R3898 vss.n1960 vss.n207 4.48498
R3899 vss.n1962 vss.n1960 17.3181
R3900 vss.n1963 vss.n208 4.48498
R3901 vss.n1964 vss.n1963 17.3181
R3902 vss.n1965 vss.n209 4.48498
R3903 vss.n1965 vss.n1935 17.3181
R3904 vss.n1988 vss.n1987 17.3181
R3905 vss.n1991 vss.n198 4.48498
R3906 vss.n1992 vss.n1991 17.3181
R3907 vss.n1995 vss.n199 4.48498
R3908 vss.n1996 vss.n1995 17.3181
R3909 vss.n1999 vss.n200 4.48498
R3910 vss.n2000 vss.n1999 17.3181
R3911 vss.n2003 vss.n201 4.48498
R3912 vss.n2004 vss.n2003 17.3181
R3913 vss.n2007 vss.n202 4.48498
R3914 vss.n2007 vss.n539 17.3181
R3915 vss.n2008 vss.n203 4.48498
R3916 vss.n2008 vss.n538 17.3181
R3917 vss.n1604 vss.n239 17.3181
R3918 vss.n1605 vss.n216 4.48498
R3919 vss.n1608 vss.n1605 17.3181
R3920 vss.n1609 vss.n217 4.48498
R3921 vss.n1612 vss.n1609 17.3181
R3922 vss.n1613 vss.n218 4.48498
R3923 vss.n1616 vss.n1613 17.3181
R3924 vss.n1617 vss.n219 4.48498
R3925 vss.n1620 vss.n1617 17.3181
R3926 vss.n1622 vss.n220 4.48498
R3927 vss.n1623 vss.n1622 17.3181
R3928 vss.n1624 vss.n221 4.48498
R3929 vss.n1624 vss.n260 17.3181
R3930 vss.n688 vss.n649 17.3181
R3931 vss.n682 vss.n210 4.48498
R3932 vss.n682 vss.n651 17.3181
R3933 vss.n681 vss.n211 4.48498
R3934 vss.n681 vss.n652 17.3181
R3935 vss.n675 vss.n212 4.48498
R3936 vss.n675 vss.n654 17.3181
R3937 vss.n674 vss.n213 4.48498
R3938 vss.n674 vss.n655 17.3181
R3939 vss.n668 vss.n214 4.48498
R3940 vss.n668 vss.n657 17.3181
R3941 vss.n667 vss.n215 4.48498
R3942 vss.n667 vss.n658 17.3181
R3943 vss.n1166 vss.n900 17.3181
R3944 vss.n125 vss.n1145 4.48498
R3945 vss.n1165 vss.n1145 17.3181
R3946 vss.n126 vss.n1163 4.48498
R3947 vss.n1163 vss.n1160 17.3181
R3948 vss.n127 vss.n1146 4.48498
R3949 vss.n1159 vss.n1146 17.3181
R3950 vss.n128 vss.n1156 4.48498
R3951 vss.n1156 vss.n1153 17.3181
R3952 vss.n129 vss.n1147 4.48498
R3953 vss.n1152 vss.n1147 17.3181
R3954 vss.n130 vss.n1149 4.48498
R3955 vss.n1149 vss.n915 17.3181
R3956 vss.t107 vss.t273 16.8201
R3957 vss.t268 vss.t110 16.8201
R3958 vss.t277 vss.t115 16.8201
R3959 vss.t286 vss.t113 16.8201
R3960 vss.t86 vss.n558 16.8158
R3961 vss.t85 vss.n1658 16.8158
R3962 vss.t75 vss.n1296 16.8158
R3963 vss.n1291 vss.t90 16.8158
R3964 vss.t73 vss.n972 16.8158
R3965 vss.n1079 vss.t72 16.8158
R3966 vss.t63 vss.n1778 16.8158
R3967 vss.t62 vss.n581 16.8158
R3968 vss.n223 vss.n899 4.32863
R3969 vss.n226 vss.n2221 4.32863
R3970 vss.n225 vss.n224 4.32863
R3971 vss.n1400 vss.n228 4.32863
R3972 vss.n227 vss.n983 4.32863
R3973 vss.n2179 vss.n229 4.32863
R3974 vss.n2180 vss.n230 4.32863
R3975 vss.n2087 vss.n231 4.32863
R3976 vss.n2088 vss.n232 4.32863
R3977 vss.n1712 vss.n233 4.32863
R3978 vss.n234 vss.n388 4.32863
R3979 vss.n236 vss.n1943 4.32863
R3980 vss.n235 vss.n540 4.32863
R3981 vss.n240 vss.n238 4.32863
R3982 vss.n689 vss.n237 4.32863
R3983 vss.n1566 vss.n222 4.32863
R3984 vss.n1870 vss.n1806 15.1234
R3985 vss.n1451 vss.n1450 15.1234
R3986 vss.n11 vss.n1597 15.1234
R3987 vss.n1359 vss.n1358 15.1234
R3988 vss.n1751 vss.n1750 15.1234
R3989 vss.n6 vss.n2079 15.1234
R3990 vss.n743 vss.n742 15.1234
R3991 vss.n1255 vss.n1254 15.1234
R3992 vss.n3 vss.n504 14.7068
R3993 vss.n1684 vss.n1683 14.4654
R3994 vss.n2105 vss.n2104 14.4654
R3995 vss.n1664 vss.n1663 14.4654
R3996 vss.n1912 vss.n60 14.4654
R3997 vss.n1096 vss.n1095 14.4654
R3998 vss.n1487 vss.n1486 14.4654
R3999 vss.n1116 vss.n1115 14.4654
R4000 vss.n1470 vss.n61 14.4654
R4001 vss.n266 vss.n978 14.3439
R4002 vss.n970 vss.n118 14.3439
R4003 vss.n263 vss.n584 14.3439
R4004 vss.n262 vss.n1771 14.3439
R4005 vss.n265 vss.n895 14.3439
R4006 vss.n111 vss.n892 14.3439
R4007 vss.n123 vss.n618 14.3439
R4008 vss.n1916 vss.n264 14.3439
R4009 vss.n1667 vss.t310 14.2229
R4010 vss.n446 vss.n0 14.2229
R4011 vss.n1678 vss.t328 14.2229
R4012 vss.n2110 vss.t328 14.2229
R4013 vss.n1121 vss.n56 14.2229
R4014 vss.n54 vss.n956 14.2229
R4015 vss.n1113 vss.n58 14.2229
R4016 vss.n1474 vss.n103 14.2229
R4017 vss.t310 vss.n2129 14.1543
R4018 vss.t328 vss.n401 14.1543
R4019 vss.n55 vss.n1514 14.1543
R4020 vss.n1501 vss.n59 14.1543
R4021 vss.n2116 vss.t307 14.0922
R4022 vss.n1908 vss.t332 14.0922
R4023 vss.t317 vss.n1915 14.0922
R4024 vss.n1100 vss.t340 14.0922
R4025 vss.t337 vss.n1499 14.0922
R4026 vss.n1495 vss.t319 14.0922
R4027 vss.n1127 vss.t325 14.0922
R4028 vss.n1904 vss.t315 14.0922
R4029 vss.n17 vss.n26 14.0838
R4030 vss.n123 vss.n1662 13.9161
R4031 vss.n265 vss.n894 13.9161
R4032 vss.n95 vss.n898 13.9161
R4033 vss.n114 vss.n897 13.9161
R4034 vss.n115 vss.n896 13.9161
R4035 vss.n96 vss.n981 13.9161
R4036 vss.n120 vss.n980 13.9161
R4037 vss.n121 vss.n979 13.9161
R4038 vss.n266 vss.n977 13.9161
R4039 vss.n1401 vss.n118 13.9161
R4040 vss.n117 vss.n1468 13.9161
R4041 vss.n119 vss.n1411 13.9161
R4042 vss.n104 vss.n1889 13.9161
R4043 vss.n1882 vss.n98 13.9161
R4044 vss.n106 vss.n586 13.9161
R4045 vss.n107 vss.n585 13.9161
R4046 vss.n1892 vss.n263 13.9161
R4047 vss.n262 vss.n1770 13.9161
R4048 vss.n105 vss.n1792 13.9161
R4049 vss.n1461 vss.n97 13.9161
R4050 vss.n93 vss.n587 13.9161
R4051 vss.n108 vss.n547 13.9161
R4052 vss.n7 vss.n99 13.9161
R4053 vss.n102 vss.n101 13.9161
R4054 vss.n100 vss.n633 13.9161
R4055 vss.n629 vss.n124 13.9161
R4056 vss.n111 vss.n893 13.9161
R4057 vss.n112 vss.n891 13.9161
R4058 vss.n1568 vss.n1567 13.9161
R4059 vss.n12 vss.n94 13.9161
R4060 vss.n264 vss.n562 13.9161
R4061 vss.n110 vss.n109 13.9161
R4062 vss.n27 vss.n2086 13.8943
R4063 vss.n2082 vss.n2081 13.8943
R4064 vss.n2032 vss.n27 13.8943
R4065 vss.n13 vss.n1603 13.8943
R4066 vss.n11 vss.n881 13.8943
R4067 vss.n1598 vss.n13 13.8943
R4068 vss.n1237 vss.n52 13.8943
R4069 vss.n1005 vss.n1 13.8943
R4070 vss.n2 vss.n929 13.8943
R4071 vss.n856 vss.n855 13.8943
R4072 vss.n817 vss.n20 13.8943
R4073 vss.n865 vss.n20 13.8943
R4074 vss.n1227 vss.n22 13.8943
R4075 vss.n1365 vss.n21 13.8943
R4076 vss.n1023 vss.n50 13.8943
R4077 vss.n50 vss.n1357 13.8943
R4078 vss.n1358 vss.n1015 13.8943
R4079 vss.n15 vss.n486 13.8943
R4080 vss.n1861 vss.n15 13.8943
R4081 vss.n1874 vss.n1806 13.8943
R4082 vss.n10 vss.n330 13.8943
R4083 vss.n53 vss.n1769 13.8943
R4084 vss.n1437 vss.n10 13.8943
R4085 vss.n1760 vss.n53 13.8943
R4086 vss.n1750 vss.n1749 13.8943
R4087 vss.n1453 vss.n1451 13.8943
R4088 vss.n774 vss.n30 13.8943
R4089 vss.n9 vss.n2178 13.8943
R4090 vss.n2172 vss.n29 13.8943
R4091 vss.n852 vss.n844 13.8943
R4092 vss.n6 vss.n511 13.8943
R4093 vss.n8 vss.n510 13.8943
R4094 vss.n8 vss.n509 13.8943
R4095 vss.n18 vss.n508 13.8943
R4096 vss.n19 vss.n507 13.8943
R4097 vss.n19 vss.n506 13.8943
R4098 vss.n2080 vss.n505 13.8943
R4099 vss.n5 vss.n503 13.8943
R4100 vss.n709 vss.n399 13.8943
R4101 vss.n750 vss.n49 13.8943
R4102 vss.n742 vss.n741 13.8943
R4103 vss.n16 vss.n789 13.8943
R4104 vss.n17 vss.n693 13.8943
R4105 vss.n17 vss.n692 13.8943
R4106 vss.n48 vss.n691 13.8943
R4107 vss.n49 vss.n690 13.8943
R4108 vss.n2136 vss.n2135 13.8943
R4109 vss.n854 vss.n829 13.8943
R4110 vss.n1205 vss.n22 13.8943
R4111 vss.n1519 vss.n1518 13.8943
R4112 vss.n52 vss.n1245 13.8943
R4113 vss.n1256 vss.n1255 13.8943
R4114 vss.n23 vss.n1235 13.8943
R4115 vss.n24 vss.n1189 13.8943
R4116 vss.n24 vss.n1188 13.8943
R4117 vss.n51 vss.n1187 13.8943
R4118 vss.n25 vss.n792 13.8943
R4119 vss.n26 vss.n791 13.8943
R4120 vss.n809 vss.n26 13.8943
R4121 vss.n851 vss.n850 13.8943
R4122 vss.n14 vss.n487 13.8943
R4123 vss.n782 vss.n28 13.8943
R4124 vss.n718 vss.n30 13.8943
R4125 vss.n1538 vss.n242 3.85735
R4126 vss.n2244 vss.n246 3.85735
R4127 vss.n245 vss.n243 3.85735
R4128 vss.n249 vss.n248 3.85735
R4129 vss.n247 vss.n1530 3.85735
R4130 vss.n250 vss.n267 3.85735
R4131 vss.n2188 vss.n251 3.85735
R4132 vss.n252 vss.n448 3.85735
R4133 vss.n253 vss.n452 3.85735
R4134 vss.n1686 vss.n254 3.85735
R4135 vss.n255 vss.n389 3.85735
R4136 vss.n1941 vss.n258 3.85735
R4137 vss.n1940 vss.n257 3.85735
R4138 vss.n660 vss.n261 3.85735
R4139 vss.n661 vss.n259 3.85735
R4140 vss.n1537 vss.n241 3.85735
R4141 vss.n54 vss.t337 11.675
R4142 vss.t328 vss.t332 11.675
R4143 vss.n103 vss.t319 11.675
R4144 vss.t317 vss.t328 11.675
R4145 vss.t310 vss.t315 11.675
R4146 vss.n0 vss.t307 11.675
R4147 vss.n58 vss.t325 11.675
R4148 vss.t340 vss.n56 11.675
R4149 vss.n23 vss.n1 10.213
R4150 vss.n1518 vss.n2 10.213
R4151 vss.n855 vss.n854 10.213
R4152 vss.n852 vss.n851 10.213
R4153 vss.n2081 vss.n5 10.213
R4154 vss.n16 vss.n399 10.213
R4155 vss.n2135 vss.n28 10.213
R4156 vss.n3 vss.n2080 10.1514
R4157 vss.n75 vss.n223 2.48719
R4158 vss.n76 vss.n222 2.48719
R4159 vss.n241 vss.n915 3.85735
R4160 vss.n900 vss.n222 4.32863
R4161 vss.n1166 vss.n125 4.48498
R4162 vss.n76 vss.n125 2.40901
R4163 vss.n126 vss.n1165 4.48498
R4164 vss.n126 vss.n76 2.40901
R4165 vss.n1160 vss.n127 4.48498
R4166 vss.n39 vss.n127 2.40901
R4167 vss.n128 vss.n1159 4.48498
R4168 vss.n128 vss.n39 2.40901
R4169 vss.n1153 vss.n129 4.48498
R4170 vss.n40 vss.n129 2.40901
R4171 vss.n130 vss.n1152 4.48498
R4172 vss.n130 vss.n40 2.40901
R4173 vss.n241 vss.n40 2.72283
R4174 vss.n41 vss.n242 2.72283
R4175 vss.n242 vss.n913 3.85735
R4176 vss.n136 vss.n41 2.40901
R4177 vss.n1557 vss.n136 4.48498
R4178 vss.n135 vss.n41 2.40901
R4179 vss.n1554 vss.n135 4.48498
R4180 vss.n134 vss.n74 2.40901
R4181 vss.n1551 vss.n134 4.48498
R4182 vss.n133 vss.n74 2.40901
R4183 vss.n1546 vss.n133 4.48498
R4184 vss.n132 vss.n75 2.40901
R4185 vss.n1542 vss.n132 4.48498
R4186 vss.n131 vss.n75 2.40901
R4187 vss.n1539 vss.n131 4.48498
R4188 vss.n903 vss.n223 4.32863
R4189 vss.n246 vss.n43 2.72283
R4190 vss.n42 vss.n245 2.72283
R4191 vss.n245 vss.n244 3.85735
R4192 vss.n142 vss.n42 2.40901
R4193 vss.n2212 vss.n142 4.48498
R4194 vss.n141 vss.n42 2.40901
R4195 vss.n2209 vss.n141 4.48498
R4196 vss.n140 vss.n72 2.40901
R4197 vss.n2205 vss.n140 4.48498
R4198 vss.n139 vss.n72 2.40901
R4199 vss.n2201 vss.n139 4.48498
R4200 vss.n138 vss.n73 2.40901
R4201 vss.n2197 vss.n138 4.48498
R4202 vss.n137 vss.n73 2.40901
R4203 vss.n288 vss.n137 4.48498
R4204 vss.n225 vss.n2220 4.32863
R4205 vss.n73 vss.n225 2.48719
R4206 vss.n226 vss.n71 2.48719
R4207 vss.n2243 vss.n246 3.85735
R4208 vss.n2222 vss.n226 4.32863
R4209 vss.n143 vss.n285 4.48498
R4210 vss.n143 vss.n71 2.40901
R4211 vss.n2228 vss.n144 4.48498
R4212 vss.n144 vss.n71 2.40901
R4213 vss.n145 vss.n282 4.48498
R4214 vss.n145 vss.n70 2.40901
R4215 vss.n2235 vss.n146 4.48498
R4216 vss.n146 vss.n70 2.40901
R4217 vss.n277 vss.n147 4.48498
R4218 vss.n43 vss.n147 2.40901
R4219 vss.n148 vss.n276 4.48498
R4220 vss.n148 vss.n43 2.40901
R4221 vss.n249 vss.n1529 3.85735
R4222 vss.n922 vss.n155 4.48498
R4223 vss.n155 vss.n90 2.40901
R4224 vss.n1388 vss.n156 4.48498
R4225 vss.n156 vss.n90 2.40901
R4226 vss.n1392 vss.n157 4.48498
R4227 vss.n157 vss.n89 2.40901
R4228 vss.n1394 vss.n158 4.48498
R4229 vss.n89 vss.n158 2.40901
R4230 vss.n159 vss.n1384 4.48498
R4231 vss.n159 vss.n32 2.40901
R4232 vss.n1380 vss.n160 4.48498
R4233 vss.n32 vss.n160 2.40901
R4234 vss.n982 vss.n228 4.32863
R4235 vss.n90 vss.n249 2.72283
R4236 vss.n247 vss.n92 2.72283
R4237 vss.n1065 vss.n227 4.32863
R4238 vss.n154 vss.n31 2.40901
R4239 vss.n1063 vss.n154 4.48498
R4240 vss.n153 vss.n31 2.40901
R4241 vss.n1060 vss.n153 4.48498
R4242 vss.n152 vss.n91 2.40901
R4243 vss.n1055 vss.n152 4.48498
R4244 vss.n151 vss.n91 2.40901
R4245 vss.n1051 vss.n151 4.48498
R4246 vss.n150 vss.n92 2.40901
R4247 vss.n1047 vss.n150 4.48498
R4248 vss.n149 vss.n92 2.40901
R4249 vss.n149 vss.n921 4.48498
R4250 vss.n1531 vss.n247 3.85735
R4251 vss.n32 vss.n228 2.48719
R4252 vss.n227 vss.n31 2.48719
R4253 vss.n230 vss.n34 2.48719
R4254 vss.n229 vss.n33 2.48719
R4255 vss.n229 vss.n329 4.32863
R4256 vss.n166 vss.n33 2.40901
R4257 vss.n360 vss.n166 4.48498
R4258 vss.n165 vss.n33 2.40901
R4259 vss.n356 vss.n165 4.48498
R4260 vss.n164 vss.n87 2.40901
R4261 vss.n352 vss.n164 4.48498
R4262 vss.n163 vss.n87 2.40901
R4263 vss.n348 vss.n163 4.48498
R4264 vss.n162 vss.n88 2.40901
R4265 vss.n344 vss.n162 4.48498
R4266 vss.n161 vss.n88 2.40901
R4267 vss.n268 vss.n161 4.48498
R4268 vss.n250 vss.n2250 3.85735
R4269 vss.n251 vss.n86 2.72283
R4270 vss.n88 vss.n250 2.72283
R4271 vss.n2187 vss.n251 3.85735
R4272 vss.n167 vss.n299 4.48498
R4273 vss.n86 vss.n167 2.40901
R4274 vss.n300 vss.n168 4.48498
R4275 vss.n168 vss.n86 2.40901
R4276 vss.n316 vss.n169 4.48498
R4277 vss.n169 vss.n85 2.40901
R4278 vss.n319 vss.n170 4.48498
R4279 vss.n170 vss.n85 2.40901
R4280 vss.n322 vss.n171 4.48498
R4281 vss.n171 vss.n34 2.40901
R4282 vss.n327 vss.n172 4.48498
R4283 vss.n34 vss.n172 2.40901
R4284 vss.n230 vss.n312 4.32863
R4285 vss.n232 vss.n36 2.48719
R4286 vss.n231 vss.n35 2.48719
R4287 vss.n231 vss.n485 4.32863
R4288 vss.n178 vss.n35 2.40901
R4289 vss.n1837 vss.n178 4.48498
R4290 vss.n177 vss.n35 2.40901
R4291 vss.n1833 vss.n177 4.48498
R4292 vss.n176 vss.n83 2.40901
R4293 vss.n1829 vss.n176 4.48498
R4294 vss.n175 vss.n83 2.40901
R4295 vss.n1825 vss.n175 4.48498
R4296 vss.n174 vss.n84 2.40901
R4297 vss.n1821 vss.n174 4.48498
R4298 vss.n173 vss.n84 2.40901
R4299 vss.n449 vss.n173 4.48498
R4300 vss.n252 vss.n2102 3.85735
R4301 vss.n253 vss.n82 2.72283
R4302 vss.n84 vss.n252 2.72283
R4303 vss.n2095 vss.n253 3.85735
R4304 vss.n179 vss.n456 4.48498
R4305 vss.n82 vss.n179 2.40901
R4306 vss.n457 vss.n180 4.48498
R4307 vss.n180 vss.n82 2.40901
R4308 vss.n470 vss.n181 4.48498
R4309 vss.n181 vss.n81 2.40901
R4310 vss.n474 vss.n182 4.48498
R4311 vss.n182 vss.n81 2.40901
R4312 vss.n479 vss.n183 4.48498
R4313 vss.n183 vss.n36 2.40901
R4314 vss.n482 vss.n184 4.48498
R4315 vss.n36 vss.n184 2.40901
R4316 vss.n232 vss.n467 4.32863
R4317 vss.n38 vss.n234 2.48719
R4318 vss.n233 vss.n37 2.48719
R4319 vss.n233 vss.n608 4.32863
R4320 vss.n37 vss.n190 2.40901
R4321 vss.n1709 vss.n190 4.48498
R4322 vss.n189 vss.n37 2.40901
R4323 vss.n1706 vss.n189 4.48498
R4324 vss.n188 vss.n79 2.40901
R4325 vss.n1702 vss.n188 4.48498
R4326 vss.n187 vss.n79 2.40901
R4327 vss.n1699 vss.n187 4.48498
R4328 vss.n186 vss.n80 2.40901
R4329 vss.n1695 vss.n186 4.48498
R4330 vss.n185 vss.n80 2.40901
R4331 vss.n1691 vss.n185 4.48498
R4332 vss.n254 vss.n609 3.85735
R4333 vss.n78 vss.n255 2.72283
R4334 vss.n254 vss.n80 2.72283
R4335 vss.n2144 vss.n255 3.85735
R4336 vss.n2145 vss.n191 4.48498
R4337 vss.n191 vss.n78 2.40901
R4338 vss.n2149 vss.n192 4.48498
R4339 vss.n192 vss.n78 2.40901
R4340 vss.n2152 vss.n193 4.48498
R4341 vss.n193 vss.n77 2.40901
R4342 vss.n2155 vss.n194 4.48498
R4343 vss.n194 vss.n77 2.40901
R4344 vss.n2158 vss.n195 4.48498
R4345 vss.n195 vss.n38 2.40901
R4346 vss.n197 vss.n2163 4.48498
R4347 vss.n38 vss.n197 2.40901
R4348 vss.n2164 vss.n234 4.32863
R4349 vss.n67 vss.n236 2.48719
R4350 vss.n69 vss.n235 2.48719
R4351 vss.n257 vss.n538 3.85735
R4352 vss.n1987 vss.n235 4.32863
R4353 vss.n1988 vss.n198 4.48498
R4354 vss.n198 vss.n69 2.40901
R4355 vss.n1992 vss.n199 4.48498
R4356 vss.n199 vss.n69 2.40901
R4357 vss.n1996 vss.n200 4.48498
R4358 vss.n200 vss.n68 2.40901
R4359 vss.n2000 vss.n201 4.48498
R4360 vss.n201 vss.n68 2.40901
R4361 vss.n2004 vss.n202 4.48498
R4362 vss.n44 vss.n202 2.40901
R4363 vss.n203 vss.n539 4.48498
R4364 vss.n203 vss.n44 2.40901
R4365 vss.n257 vss.n44 2.72283
R4366 vss.n45 vss.n258 2.72283
R4367 vss.n258 vss.n1935 3.85735
R4368 vss.n209 vss.n45 2.40901
R4369 vss.n1964 vss.n209 4.48498
R4370 vss.n208 vss.n45 2.40901
R4371 vss.n1962 vss.n208 4.48498
R4372 vss.n207 vss.n66 2.40901
R4373 vss.n1957 vss.n207 4.48498
R4374 vss.n206 vss.n66 2.40901
R4375 vss.n1953 vss.n206 4.48498
R4376 vss.n205 vss.n67 2.40901
R4377 vss.n1949 vss.n205 4.48498
R4378 vss.n204 vss.n67 2.40901
R4379 vss.n1945 vss.n204 4.48498
R4380 vss.n1944 vss.n236 4.32863
R4381 vss.n63 vss.n240 2.48719
R4382 vss.n65 vss.n237 2.48719
R4383 vss.n658 vss.n259 3.85735
R4384 vss.n688 vss.n237 4.32863
R4385 vss.n210 vss.n649 4.48498
R4386 vss.n210 vss.n65 2.40901
R4387 vss.n211 vss.n651 4.48498
R4388 vss.n65 vss.n211 2.40901
R4389 vss.n652 vss.n212 4.48498
R4390 vss.n212 vss.n64 2.40901
R4391 vss.n213 vss.n654 4.48498
R4392 vss.n64 vss.n213 2.40901
R4393 vss.n655 vss.n214 4.48498
R4394 vss.n214 vss.n46 2.40901
R4395 vss.n215 vss.n657 4.48498
R4396 vss.n46 vss.n215 2.40901
R4397 vss.n259 vss.n46 2.72283
R4398 vss.n47 vss.n261 2.72283
R4399 vss.n261 vss.n260 3.85735
R4400 vss.n221 vss.n47 2.40901
R4401 vss.n1623 vss.n221 4.48498
R4402 vss.n220 vss.n47 2.40901
R4403 vss.n1620 vss.n220 4.48498
R4404 vss.n219 vss.n62 2.40901
R4405 vss.n1616 vss.n219 4.48498
R4406 vss.n218 vss.n62 2.40901
R4407 vss.n1612 vss.n218 4.48498
R4408 vss.n217 vss.n63 2.40901
R4409 vss.n1608 vss.n217 4.48498
R4410 vss.n216 vss.n63 2.40901
R4411 vss.n1604 vss.n216 4.48498
R4412 vss.n240 vss.n239 4.32863
R4413 vss.n2121 vss.n2120 8.07389
R4414 vss.n1900 vss.n1899 8.07389
R4415 vss.n1506 vss.n1505 8.07389
R4416 vss.n1322 vss.n1131 8.07389
R4417 vss.n2252 vss.n20 7.0414
R4418 vss.n2252 vss.n30 7.0414
R4419 vss.n930 vss.n400 6.20189
R4420 vss.n2133 vss.n2132 6.20189
R4421 vss.n2 vss.n1517 6.12203
R4422 vss.n5 vss.n4 6.12203
R4423 vss.n95 vss.n75 5.19633
R4424 vss.n41 vss.n113 5.19633
R4425 vss.n790 vss.n43 5.19633
R4426 vss.n71 vss.n12 5.19633
R4427 vss.n96 vss.n32 5.19633
R4428 vss.n90 vss.n116 5.19633
R4429 vss.n2251 vss.n88 5.19633
R4430 vss.n33 vss.n97 5.19633
R4431 vss.n2103 vss.n84 5.19633
R4432 vss.n35 vss.n98 5.19633
R4433 vss.n78 vss.n1685 5.19633
R4434 vss.n93 vss.n38 5.19633
R4435 vss.n69 vss.n7 5.19633
R4436 vss.n44 vss.n256 5.19633
R4437 vss.n63 vss.n102 5.19633
R4438 vss.n47 vss.n122 5.19633
R4439 vss.t328 vss.n2130 4.5223
R4440 vss.n854 vss.n853 3.8455
R4441 vss.n853 vss.n852 3.8455
R4442 vss.n2134 vss.n399 3.8455
R4443 vss.n2135 vss.n2134 3.8455
R4444 vss.n2130 vss.n0 3.81107
R4445 vss.n1500 vss.n55 3.81107
R4446 vss.n59 vss.n1500 3.81107
R4447 vss.n2131 vss.t310 3.81107
R4448 vss.n1516 vss.n1515 3.81107
R4449 vss.n1516 vss.n57 3.81107
R4450 vss.n1517 vss.n930 3.73661
R4451 vss.n2132 vss.n4 3.73661
R4452 vss.n2130 vss.n4 3.4105
R4453 vss.n1500 vss.n930 3.4105
R4454 vss.n1517 vss.n1516 3.4105
R4455 vss.n853 vss.n400 3.4105
R4456 vss.n2134 vss.n2133 3.4105
R4457 vss.n2132 vss.n2131 3.4105
R4458 vss.n1685 vss.n1684 3.2005
R4459 vss.n2104 vss.n2103 3.2005
R4460 vss.n1095 vss.n113 3.2005
R4461 vss.n1486 vss.n790 3.2005
R4462 vss.n1115 vss.n116 3.2005
R4463 vss.n2251 vss.n61 3.2005
R4464 vss.n60 vss.n256 3.2005
R4465 vss.n1663 vss.n122 3.2005
R4466 vss.n75 vss.n76 2.82403
R4467 vss.n41 vss.n40 2.82403
R4468 vss.n42 vss.n43 2.82403
R4469 vss.n71 vss.n73 2.82403
R4470 vss.n92 vss.n90 2.82403
R4471 vss.n32 vss.n31 2.82403
R4472 vss.n33 vss.n34 2.82403
R4473 vss.n88 vss.n86 2.82403
R4474 vss.n35 vss.n36 2.82403
R4475 vss.n84 vss.n82 2.82403
R4476 vss.n37 vss.n38 2.82403
R4477 vss.n80 vss.n78 2.82403
R4478 vss.n67 vss.n69 2.82403
R4479 vss.n45 vss.n44 2.82403
R4480 vss.n63 vss.n65 2.82403
R4481 vss.n46 vss.n47 2.82403
R4482 vss.n107 vss.t315 2.563
R4483 vss.n105 vss.t307 2.563
R4484 vss.n110 vss.t317 2.563
R4485 vss.n112 vss.t337 2.563
R4486 vss.n121 vss.t325 2.563
R4487 vss.t319 vss.n119 2.563
R4488 vss.t332 vss.n124 2.563
R4489 vss.n115 vss.t340 2.563
R4490 vss.n2133 vss.n400 1.89633
R4491 vss.n2103 vss.n27 1.56786
R4492 vss.n26 vss.n790 1.56786
R4493 vss.n20 vss.n2251 1.56786
R4494 vss.n19 vss.n256 1.56786
R4495 vss.n17 vss.n122 1.56786
R4496 vss.n22 vss.n116 1.56786
R4497 vss.n24 vss.n113 1.56786
R4498 vss.n1685 vss.n30 1.56786
R4499 vss.n58 vss.t305 1.51509
R4500 vss.n102 vss.n49 1.43071
R4501 vss.n96 vss.n50 1.43071
R4502 vss.n95 vss.n52 1.43071
R4503 vss.n93 vss.n53 1.43071
R4504 vss vss.n2252 1.41344
R4505 vss.n8 vss.n7 1.37118
R4506 vss.n98 vss.n15 1.37118
R4507 vss.n97 vss.n10 1.37118
R4508 vss.n13 vss.n12 1.37118
R4509 vss.n53 vss.n29 1.36925
R4510 vss.n52 vss.n51 1.36925
R4511 vss.n50 vss.n21 1.36925
R4512 vss.n49 vss.n48 1.36925
R4513 vss.t334 vss.n56 1.34617
R4514 vss.n77 vss.n38 1.34241
R4515 vss.n79 vss.n37 1.34241
R4516 vss.n81 vss.n36 1.34241
R4517 vss.n83 vss.n35 1.34241
R4518 vss.n85 vss.n34 1.34241
R4519 vss.n87 vss.n33 1.34241
R4520 vss.n89 vss.n32 1.34241
R4521 vss.n91 vss.n31 1.34241
R4522 vss.n1095 vss.t340 1.32612
R4523 vss.n1663 vss.t332 1.32612
R4524 vss.t319 vss.n61 1.32612
R4525 vss.n1115 vss.t325 1.32612
R4526 vss.n1486 vss.t337 1.32612
R4527 vss.t317 vss.n60 1.32612
R4528 vss.n2104 vss.t307 1.32612
R4529 vss.n1684 vss.t315 1.32612
R4530 vss.n62 vss.n47 1.313
R4531 vss.n64 vss.n46 1.313
R4532 vss.n66 vss.n45 1.313
R4533 vss.n68 vss.n44 1.313
R4534 vss.n70 vss.n43 1.313
R4535 vss.n72 vss.n42 1.313
R4536 vss.n74 vss.n41 1.313
R4537 vss.n40 vss.n39 1.313
R4538 vss.t334 vss.n55 0.319676
R4539 vss.t305 vss.n103 0.34732
R4540 vss.n39 vss.n76 1.17329
R4541 vss.n75 vss.n74 1.17329
R4542 vss.n73 vss.n72 1.17329
R4543 vss.n71 vss.n70 1.17329
R4544 vss.n69 vss.n68 1.17329
R4545 vss.n67 vss.n66 1.17329
R4546 vss.n65 vss.n64 1.17329
R4547 vss.n63 vss.n62 1.17329
R4548 vss.n92 vss.n91 1.14388
R4549 vss.n90 vss.n89 1.14388
R4550 vss.n88 vss.n87 1.14388
R4551 vss.n86 vss.n85 1.14388
R4552 vss.n84 vss.n83 1.14388
R4553 vss.n82 vss.n81 1.14388
R4554 vss.n80 vss.n79 1.14388
R4555 vss.n78 vss.n77 1.14388
R4556 vss.n105 vss.n104 1.0005
R4557 vss.n263 vss.n262 1.0005
R4558 vss.n107 vss.n106 1.0005
R4559 vss.n110 vss.n108 1.0005
R4560 vss.n123 vss.n264 1.0005
R4561 vss.n1567 vss.n112 1.0005
R4562 vss.n111 vss.n265 1.0005
R4563 vss.n115 vss.n114 1.0005
R4564 vss.n119 vss.n117 1.0005
R4565 vss.n118 vss.n266 1.0005
R4566 vss.n121 vss.n120 1.0005
R4567 vss.n100 vss.n124 1.0005
R4568 vss.n124 vss.n123 1.0005
R4569 vss.n266 vss.n121 1.0005
R4570 vss.n119 vss.n118 1.0005
R4571 vss.n265 vss.n115 1.0005
R4572 vss.n112 vss.n111 1.0005
R4573 vss.n264 vss.n110 1.0005
R4574 vss.n263 vss.n107 1.0005
R4575 vss.n262 vss.n105 1.0005
R4576 vss.n1515 vss.n55 0.969944
R4577 vss.n59 vss.n57 0.969944
R4578 vss.n104 vss.n98 0.96925
R4579 vss.n106 vss.n93 0.96925
R4580 vss.n108 vss.n7 0.96925
R4581 vss.n1567 vss.n12 0.96925
R4582 vss.n114 vss.n95 0.96925
R4583 vss.n117 vss.n97 0.96925
R4584 vss.n120 vss.n96 0.96925
R4585 vss.n102 vss.n100 0.96925
R4586 vss.n30 vss.n28 0.813
R4587 vss.n2081 vss.n27 0.813
R4588 vss.n1806 vss.n15 0.813
R4589 vss.n13 vss.n11 0.813
R4590 vss.n851 vss.n26 0.813
R4591 vss.n24 vss.n23 0.813
R4592 vss.n1518 vss.n22 0.813
R4593 vss.n855 vss.n20 0.813
R4594 vss.n1451 vss.n10 0.813
R4595 vss.n1358 vss.n50 0.813
R4596 vss.n1750 vss.n53 0.813
R4597 vss.n8 vss.n6 0.813
R4598 vss.n2080 vss.n19 0.813
R4599 vss.n17 vss.n16 0.813
R4600 vss.n742 vss.n49 0.813
R4601 vss.n1255 vss.n52 0.813
R4602 vss.n58 vss.n57 0.7805
R4603 vss.n59 vss.t305 0.20875
R4604 vss.n1515 vss.n56 0.7805
R4605 vss.t334 vss.n54 0.254928
R4606 vss.n2131 vss.t328 4.06832
R4607 vss.n5 vss.n3 1.58005
R4608 vss.n30 vss.n29 1.5005
R4609 vss.n14 vss.n27 1.5005
R4610 vss.n26 vss.n25 1.5005
R4611 vss.n51 vss.n24 1.5005
R4612 vss.n22 vss.n21 1.5005
R4613 vss.n9 vss.n20 1.5005
R4614 vss.n19 vss.n18 1.5005
R4615 vss.n48 vss.n17 1.5005
R4616 vss.n15 vss.n14 1.5005
R4617 vss.n25 vss.n13 1.5005
R4618 vss.n10 vss.n9 1.5005
R4619 vss.n18 vss.n8 1.5005
R4620 vss.n2 vss.n1 1.5005
R4621 vss.t310 vss.n0 1.23527
R4622 a_n5096_n3348.n29 a_n5096_n3348.t22 838.681
R4623 a_n5096_n3348.n28 a_n5096_n3348.t21 838.681
R4624 a_n5096_n3348.n26 a_n5096_n3348.t20 838.681
R4625 a_n5096_n3348.n25 a_n5096_n3348.t19 838.681
R4626 a_n5096_n3348.n24 a_n5096_n3348.t18 838.681
R4627 a_n5096_n3348.n23 a_n5096_n3348.t17 838.681
R4628 a_n5096_n3348.n22 a_n5096_n3348.t16 838.681
R4629 a_n5096_n3348.n19 a_n5096_n3348.t15 838.681
R4630 a_n5096_n3348.n35 a_n5096_n3348.t23 517.347
R4631 a_n5096_n3348.n38 a_n5096_n3348.t24 517.347
R4632 a_n5096_n3348.n39 a_n5096_n3348.t25 517.347
R4633 a_n5096_n3348.n40 a_n5096_n3348.t26 517.347
R4634 a_n5096_n3348.n46 a_n5096_n3348.t12 433.488
R4635 a_n5096_n3348.t12 a_n5096_n3348.n42 433.488
R4636 a_n5096_n3348.t13 a_n5096_n3348.n43 433.488
R4637 a_n5096_n3348.n44 a_n5096_n3348.t13 433.488
R4638 a_n5096_n3348.n30 a_n5096_n3348.n29 158.304
R4639 a_n5096_n3348.n20 a_n5096_n3348.n19 158.304
R4640 a_n5096_n3348.n36 a_n5096_n3348.n35 158.284
R4641 a_n5096_n3348.n47 a_n5096_n3348.t11 157.577
R4642 a_n5096_n3348.n45 a_n5096_n3348.t14 157.577
R4643 a_n5096_n3348.n39 a_n5096_n3348.n34 152
R4644 a_n5096_n3348.n38 a_n5096_n3348.n37 152
R4645 a_n5096_n3348.n22 a_n5096_n3348.n21 152
R4646 a_n5096_n3348.n23 a_n5096_n3348.n18 152
R4647 a_n5096_n3348.n33 a_n5096_n3348.n24 152
R4648 a_n5096_n3348.n32 a_n5096_n3348.n25 152
R4649 a_n5096_n3348.n31 a_n5096_n3348.n26 152
R4650 a_n5096_n3348.n28 a_n5096_n3348.n27 152
R4651 a_n5096_n3348.n5 a_n5096_n3348.n45 124.763
R4652 a_n5096_n3348.n45 a_n5096_n3348.n10 124.763
R4653 a_n5096_n3348.n40 a_n5096_n3348.n39 70.1096
R4654 a_n5096_n3348.n39 a_n5096_n3348.n38 70.1096
R4655 a_n5096_n3348.n38 a_n5096_n3348.n35 70.1096
R4656 a_n5096_n3348.n29 a_n5096_n3348.n28 70.1096
R4657 a_n5096_n3348.n28 a_n5096_n3348.n26 70.1096
R4658 a_n5096_n3348.n26 a_n5096_n3348.n25 70.1096
R4659 a_n5096_n3348.n25 a_n5096_n3348.n24 70.1096
R4660 a_n5096_n3348.n24 a_n5096_n3348.n23 70.1096
R4661 a_n5096_n3348.n23 a_n5096_n3348.n22 70.1096
R4662 a_n5096_n3348.n22 a_n5096_n3348.n19 70.1096
R4663 a_n5096_n3348.n41 a_n5096_n3348.n1 62.5967
R4664 a_n5096_n3348.n11 a_n5096_n3348.n16 57.3314
R4665 a_n5096_n3348.n11 a_n5096_n3348.n15 57.3314
R4666 a_n5096_n3348.t7 a_n5096_n3348.n11 56.9981
R4667 a_n5096_n3348.n11 a_n5096_n3348.n17 56.9981
R4668 a_n5096_n3348.n47 a_n5096_n3348.n7 124.763
R4669 a_n5096_n3348.n44 a_n5096_n3348.n42 41.6005
R4670 a_n5096_n3348.n47 a_n5096_n3348.n4 124.763
R4671 a_n5096_n3348.n46 a_n5096_n3348.n43 41.6005
R4672 a_n5096_n3348.n40 a_n5096_n3348.n13 158.142
R4673 a_n5096_n3348.n37 a_n5096_n3348.n34 36.1417
R4674 a_n5096_n3348.n31 a_n5096_n3348.n27 36.1417
R4675 a_n5096_n3348.n32 a_n5096_n3348.n31 36.1417
R4676 a_n5096_n3348.n33 a_n5096_n3348.n14 6.14104
R4677 a_n5096_n3348.n33 a_n5096_n3348.n18 36.1417
R4678 a_n5096_n3348.n21 a_n5096_n3348.n18 36.1417
R4679 a_n5096_n3348.n0 a_n5096_n3348.t6 24.5153
R4680 a_n5096_n3348.n49 a_n5096_n3348.t5 21.1053
R4681 a_n5096_n3348.n8 a_n5096_n3348.t10 11.871
R4682 a_n5096_n3348.n0 a_n5096_n3348.n48 11.3205
R4683 a_n5096_n3348.n12 a_n5096_n3348.n13 1.58098
R4684 a_n5096_n3348.n34 a_n5096_n3348.n13 6.14104
R4685 a_n5096_n3348.n32 a_n5096_n3348.n14 6.14104
R4686 a_n5096_n3348.n31 a_n5096_n3348.n1 9.3005
R4687 a_n5096_n3348.n18 a_n5096_n3348.n1 9.3005
R4688 a_n5096_n3348.n2 a_n5096_n3348.n5 1.43771
R4689 a_n5096_n3348.n4 a_n5096_n3348.n3 1.43771
R4690 a_n5096_n3348.n46 a_n5096_n3348.n4 6.42758
R4691 a_n5096_n3348.n5 a_n5096_n3348.n43 6.42758
R4692 a_n5096_n3348.n10 a_n5096_n3348.n9 1.43771
R4693 a_n5096_n3348.n10 a_n5096_n3348.n44 6.42758
R4694 a_n5096_n3348.n42 a_n5096_n3348.n7 6.42758
R4695 a_n5096_n3348.n6 a_n5096_n3348.n7 1.43771
R4696 a_n5096_n3348.n41 a_n5096_n3348.n12 7.94258
R4697 a_n5096_n3348.n37 a_n5096_n3348.n36 6.11192
R4698 a_n5096_n3348.n30 a_n5096_n3348.n27 6.10787
R4699 a_n5096_n3348.n21 a_n5096_n3348.n20 6.10787
R4700 a_n5096_n3348.n0 a_n5096_n3348.n41 4.90797
R4701 a_n5096_n3348.n11 a_n5096_n3348.n49 3.98257
R4702 a_n5096_n3348.t0 a_n5096_n3348.t7 3.9605
R4703 a_n5096_n3348.n17 a_n5096_n3348.t4 3.9605
R4704 a_n5096_n3348.n17 a_n5096_n3348.t3 3.9605
R4705 a_n5096_n3348.n16 a_n5096_n3348.t9 3.9605
R4706 a_n5096_n3348.n16 a_n5096_n3348.t2 3.9605
R4707 a_n5096_n3348.n15 a_n5096_n3348.t1 3.9605
R4708 a_n5096_n3348.n15 a_n5096_n3348.t8 3.9605
R4709 a_n5096_n3348.n49 a_n5096_n3348.n0 3.8476
R4710 a_n5096_n3348.n1 a_n5096_n3348.n14 2.29518
R4711 a_n5096_n3348.n36 a_n5096_n3348.n12 2.11511
R4712 a_n5096_n3348.n1 a_n5096_n3348.n30 1.92
R4713 a_n5096_n3348.n20 a_n5096_n3348.n1 1.92
R4714 a_n5096_n3348.n0 a_n5096_n3348.t10 1.87933
R4715 a_n5096_n3348.n2 a_n5096_n3348.n8 1.57416
R4716 a_n5096_n3348.n48 a_n5096_n3348.n3 1.57416
R4717 a_n5096_n3348.n48 a_n5096_n3348.n6 1.57416
R4718 a_n5096_n3348.n9 a_n5096_n3348.n8 1.57416
R4719 a_n5096_n3348.n9 a_n5096_n3348.n6 1.21925
R4720 a_n5096_n3348.n3 a_n5096_n3348.n2 1.21925
R4721 a_n6092_n3348.n28 a_n6092_n3348.t22 838.681
R4722 a_n6092_n3348.n27 a_n6092_n3348.t21 838.681
R4723 a_n6092_n3348.n25 a_n6092_n3348.t20 838.681
R4724 a_n6092_n3348.n24 a_n6092_n3348.t19 838.681
R4725 a_n6092_n3348.n23 a_n6092_n3348.t18 838.681
R4726 a_n6092_n3348.n22 a_n6092_n3348.t17 838.681
R4727 a_n6092_n3348.n21 a_n6092_n3348.t16 838.681
R4728 a_n6092_n3348.n18 a_n6092_n3348.t15 838.681
R4729 a_n6092_n3348.n33 a_n6092_n3348.t23 517.347
R4730 a_n6092_n3348.n34 a_n6092_n3348.t24 517.347
R4731 a_n6092_n3348.n35 a_n6092_n3348.t25 517.347
R4732 a_n6092_n3348.n36 a_n6092_n3348.t26 517.347
R4733 a_n6092_n3348.n45 a_n6092_n3348.t12 433.488
R4734 a_n6092_n3348.t12 a_n6092_n3348.n41 433.488
R4735 a_n6092_n3348.t13 a_n6092_n3348.n42 433.488
R4736 a_n6092_n3348.n43 a_n6092_n3348.t13 433.488
R4737 a_n6092_n3348.n29 a_n6092_n3348.n28 158.304
R4738 a_n6092_n3348.n19 a_n6092_n3348.n18 158.304
R4739 a_n6092_n3348.n37 a_n6092_n3348.n36 158.284
R4740 a_n6092_n3348.n46 a_n6092_n3348.t11 157.577
R4741 a_n6092_n3348.n44 a_n6092_n3348.t14 157.577
R4742 a_n6092_n3348.n38 a_n6092_n3348.n35 152
R4743 a_n6092_n3348.n39 a_n6092_n3348.n34 152
R4744 a_n6092_n3348.n12 a_n6092_n3348.n33 158.142
R4745 a_n6092_n3348.n21 a_n6092_n3348.n20 152
R4746 a_n6092_n3348.n22 a_n6092_n3348.n17 152
R4747 a_n6092_n3348.n32 a_n6092_n3348.n23 152
R4748 a_n6092_n3348.n31 a_n6092_n3348.n24 152
R4749 a_n6092_n3348.n30 a_n6092_n3348.n25 152
R4750 a_n6092_n3348.n27 a_n6092_n3348.n26 152
R4751 a_n6092_n3348.n4 a_n6092_n3348.n44 124.763
R4752 a_n6092_n3348.n44 a_n6092_n3348.n9 124.763
R4753 a_n6092_n3348.n36 a_n6092_n3348.n35 70.1096
R4754 a_n6092_n3348.n35 a_n6092_n3348.n34 70.1096
R4755 a_n6092_n3348.n34 a_n6092_n3348.n33 70.1096
R4756 a_n6092_n3348.n28 a_n6092_n3348.n27 70.1096
R4757 a_n6092_n3348.n27 a_n6092_n3348.n25 70.1096
R4758 a_n6092_n3348.n25 a_n6092_n3348.n24 70.1096
R4759 a_n6092_n3348.n24 a_n6092_n3348.n23 70.1096
R4760 a_n6092_n3348.n23 a_n6092_n3348.n22 70.1096
R4761 a_n6092_n3348.n22 a_n6092_n3348.n21 70.1096
R4762 a_n6092_n3348.n21 a_n6092_n3348.n18 70.1096
R4763 a_n6092_n3348.n40 a_n6092_n3348.n0 60.436
R4764 a_n6092_n3348.n10 a_n6092_n3348.n15 57.3314
R4765 a_n6092_n3348.t6 a_n6092_n3348.n10 57.3314
R4766 a_n6092_n3348.n10 a_n6092_n3348.n16 56.9981
R4767 a_n6092_n3348.n10 a_n6092_n3348.n49 56.9981
R4768 a_n6092_n3348.n46 a_n6092_n3348.n6 124.763
R4769 a_n6092_n3348.n43 a_n6092_n3348.n41 41.6005
R4770 a_n6092_n3348.n46 a_n6092_n3348.n3 124.763
R4771 a_n6092_n3348.n45 a_n6092_n3348.n42 41.6005
R4772 a_n6092_n3348.n39 a_n6092_n3348.n38 36.1417
R4773 a_n6092_n3348.n30 a_n6092_n3348.n26 36.1417
R4774 a_n6092_n3348.n31 a_n6092_n3348.n30 36.1417
R4775 a_n6092_n3348.n32 a_n6092_n3348.n13 6.14104
R4776 a_n6092_n3348.n32 a_n6092_n3348.n17 36.1417
R4777 a_n6092_n3348.n20 a_n6092_n3348.n17 36.1417
R4778 a_n6092_n3348.n14 a_n6092_n3348.t9 24.5153
R4779 a_n6092_n3348.n48 a_n6092_n3348.t7 21.1053
R4780 a_n6092_n3348.n7 a_n6092_n3348.t10 11.871
R4781 a_n6092_n3348.t10 a_n6092_n3348.n47 11.3205
R4782 a_n6092_n3348.n1 a_n6092_n3348.n4 1.43771
R4783 a_n6092_n3348.n3 a_n6092_n3348.n2 1.43771
R4784 a_n6092_n3348.n45 a_n6092_n3348.n3 6.42758
R4785 a_n6092_n3348.n4 a_n6092_n3348.n42 6.42758
R4786 a_n6092_n3348.n9 a_n6092_n3348.n8 1.43771
R4787 a_n6092_n3348.n9 a_n6092_n3348.n43 6.42758
R4788 a_n6092_n3348.n41 a_n6092_n3348.n6 6.42758
R4789 a_n6092_n3348.n5 a_n6092_n3348.n6 1.43771
R4790 a_n6092_n3348.n11 a_n6092_n3348.n12 1.58098
R4791 a_n6092_n3348.n39 a_n6092_n3348.n12 6.14104
R4792 a_n6092_n3348.n31 a_n6092_n3348.n13 6.14104
R4793 a_n6092_n3348.n30 a_n6092_n3348.n0 9.3005
R4794 a_n6092_n3348.n17 a_n6092_n3348.n0 9.3005
R4795 a_n6092_n3348.n40 a_n6092_n3348.n11 7.94258
R4796 a_n6092_n3348.n38 a_n6092_n3348.n37 6.11192
R4797 a_n6092_n3348.n29 a_n6092_n3348.n26 6.10787
R4798 a_n6092_n3348.n20 a_n6092_n3348.n19 6.10787
R4799 a_n6092_n3348.n14 a_n6092_n3348.n40 4.90797
R4800 a_n6092_n3348.n10 a_n6092_n3348.n48 3.98257
R4801 a_n6092_n3348.t0 a_n6092_n3348.t6 3.9605
R4802 a_n6092_n3348.n15 a_n6092_n3348.t4 3.9605
R4803 a_n6092_n3348.n15 a_n6092_n3348.t1 3.9605
R4804 a_n6092_n3348.n16 a_n6092_n3348.t5 3.9605
R4805 a_n6092_n3348.n16 a_n6092_n3348.t2 3.9605
R4806 a_n6092_n3348.n49 a_n6092_n3348.t3 3.9605
R4807 a_n6092_n3348.n49 a_n6092_n3348.t8 3.9605
R4808 a_n6092_n3348.n48 a_n6092_n3348.n14 3.8476
R4809 a_n6092_n3348.n0 a_n6092_n3348.n13 2.29518
R4810 a_n6092_n3348.n37 a_n6092_n3348.n11 2.11511
R4811 a_n6092_n3348.n0 a_n6092_n3348.n29 1.92
R4812 a_n6092_n3348.n19 a_n6092_n3348.n0 1.92
R4813 a_n6092_n3348.n14 a_n6092_n3348.t10 1.63745
R4814 a_n6092_n3348.n1 a_n6092_n3348.n7 1.57416
R4815 a_n6092_n3348.n47 a_n6092_n3348.n2 1.57416
R4816 a_n6092_n3348.n47 a_n6092_n3348.n5 1.57416
R4817 a_n6092_n3348.n8 a_n6092_n3348.n7 1.57416
R4818 a_n6092_n3348.n8 a_n6092_n3348.n5 1.21925
R4819 a_n6092_n3348.n2 a_n6092_n3348.n1 1.21925
R4820 a_n8760_n4271.n18 a_n8760_n4271.t19 838.681
R4821 a_n8760_n4271.n21 a_n8760_n4271.t20 838.681
R4822 a_n8760_n4271.n22 a_n8760_n4271.t21 838.681
R4823 a_n8760_n4271.n23 a_n8760_n4271.t22 838.681
R4824 a_n8760_n4271.n24 a_n8760_n4271.t23 838.681
R4825 a_n8760_n4271.n25 a_n8760_n4271.t24 838.681
R4826 a_n8760_n4271.n27 a_n8760_n4271.t25 838.681
R4827 a_n8760_n4271.n28 a_n8760_n4271.t26 838.681
R4828 a_n8760_n4271.n36 a_n8760_n4271.t18 517.347
R4829 a_n8760_n4271.n35 a_n8760_n4271.t17 517.347
R4830 a_n8760_n4271.n34 a_n8760_n4271.t16 517.347
R4831 a_n8760_n4271.n33 a_n8760_n4271.t15 517.347
R4832 a_n8760_n4271.n45 a_n8760_n4271.t12 433.488
R4833 a_n8760_n4271.t12 a_n8760_n4271.n41 433.488
R4834 a_n8760_n4271.t13 a_n8760_n4271.n42 433.488
R4835 a_n8760_n4271.n43 a_n8760_n4271.t13 433.488
R4836 a_n8760_n4271.n19 a_n8760_n4271.n18 158.304
R4837 a_n8760_n4271.n29 a_n8760_n4271.n28 158.304
R4838 a_n8760_n4271.n37 a_n8760_n4271.n36 158.284
R4839 a_n8760_n4271.n46 a_n8760_n4271.t11 157.577
R4840 a_n8760_n4271.n44 a_n8760_n4271.t14 157.577
R4841 a_n8760_n4271.n12 a_n8760_n4271.n33 158.142
R4842 a_n8760_n4271.n39 a_n8760_n4271.n34 152
R4843 a_n8760_n4271.n38 a_n8760_n4271.n35 152
R4844 a_n8760_n4271.n27 a_n8760_n4271.n26 152
R4845 a_n8760_n4271.n30 a_n8760_n4271.n25 152
R4846 a_n8760_n4271.n31 a_n8760_n4271.n24 152
R4847 a_n8760_n4271.n32 a_n8760_n4271.n23 152
R4848 a_n8760_n4271.n22 a_n8760_n4271.n17 152
R4849 a_n8760_n4271.n21 a_n8760_n4271.n20 152
R4850 a_n8760_n4271.n4 a_n8760_n4271.n44 124.763
R4851 a_n8760_n4271.n44 a_n8760_n4271.n9 124.763
R4852 a_n8760_n4271.n36 a_n8760_n4271.n35 70.1096
R4853 a_n8760_n4271.n35 a_n8760_n4271.n34 70.1096
R4854 a_n8760_n4271.n34 a_n8760_n4271.n33 70.1096
R4855 a_n8760_n4271.n28 a_n8760_n4271.n27 70.1096
R4856 a_n8760_n4271.n27 a_n8760_n4271.n25 70.1096
R4857 a_n8760_n4271.n25 a_n8760_n4271.n24 70.1096
R4858 a_n8760_n4271.n24 a_n8760_n4271.n23 70.1096
R4859 a_n8760_n4271.n23 a_n8760_n4271.n22 70.1096
R4860 a_n8760_n4271.n22 a_n8760_n4271.n21 70.1096
R4861 a_n8760_n4271.n21 a_n8760_n4271.n18 70.1096
R4862 a_n8760_n4271.n10 a_n8760_n4271.n15 57.3314
R4863 a_n8760_n4271.t8 a_n8760_n4271.n10 57.3314
R4864 a_n8760_n4271.n10 a_n8760_n4271.n16 56.9981
R4865 a_n8760_n4271.n10 a_n8760_n4271.n49 56.9981
R4866 a_n8760_n4271.n40 a_n8760_n4271.n0 43.4241
R4867 a_n8760_n4271.n46 a_n8760_n4271.n6 124.763
R4868 a_n8760_n4271.n43 a_n8760_n4271.n41 41.6005
R4869 a_n8760_n4271.n46 a_n8760_n4271.n3 124.763
R4870 a_n8760_n4271.n45 a_n8760_n4271.n42 41.6005
R4871 a_n8760_n4271.n39 a_n8760_n4271.n38 36.1417
R4872 a_n8760_n4271.n30 a_n8760_n4271.n26 36.1417
R4873 a_n8760_n4271.n31 a_n8760_n4271.n30 36.1417
R4874 a_n8760_n4271.n32 a_n8760_n4271.n13 6.14104
R4875 a_n8760_n4271.n32 a_n8760_n4271.n17 36.1417
R4876 a_n8760_n4271.n20 a_n8760_n4271.n17 36.1417
R4877 a_n8760_n4271.n14 a_n8760_n4271.t1 24.5153
R4878 a_n8760_n4271.n48 a_n8760_n4271.t0 21.1053
R4879 a_n8760_n4271.n7 a_n8760_n4271.t10 11.871
R4880 a_n8760_n4271.t10 a_n8760_n4271.n47 11.3205
R4881 a_n8760_n4271.n1 a_n8760_n4271.n4 1.43771
R4882 a_n8760_n4271.n3 a_n8760_n4271.n2 1.43771
R4883 a_n8760_n4271.n45 a_n8760_n4271.n3 6.42758
R4884 a_n8760_n4271.n4 a_n8760_n4271.n42 6.42758
R4885 a_n8760_n4271.n9 a_n8760_n4271.n8 1.43771
R4886 a_n8760_n4271.n9 a_n8760_n4271.n43 6.42758
R4887 a_n8760_n4271.n41 a_n8760_n4271.n6 6.42758
R4888 a_n8760_n4271.n5 a_n8760_n4271.n6 1.43771
R4889 a_n8760_n4271.n11 a_n8760_n4271.n12 1.58098
R4890 a_n8760_n4271.n39 a_n8760_n4271.n12 6.14104
R4891 a_n8760_n4271.n31 a_n8760_n4271.n13 6.14104
R4892 a_n8760_n4271.n30 a_n8760_n4271.n0 9.3005
R4893 a_n8760_n4271.n17 a_n8760_n4271.n0 9.3005
R4894 a_n8760_n4271.n40 a_n8760_n4271.n11 7.94258
R4895 a_n8760_n4271.n38 a_n8760_n4271.n37 6.11192
R4896 a_n8760_n4271.n29 a_n8760_n4271.n26 6.10787
R4897 a_n8760_n4271.n20 a_n8760_n4271.n19 6.10787
R4898 a_n8760_n4271.n14 a_n8760_n4271.n40 4.90797
R4899 a_n8760_n4271.n10 a_n8760_n4271.n48 3.98257
R4900 a_n8760_n4271.t9 a_n8760_n4271.t8 3.9605
R4901 a_n8760_n4271.n16 a_n8760_n4271.t4 3.9605
R4902 a_n8760_n4271.n16 a_n8760_n4271.t5 3.9605
R4903 a_n8760_n4271.n15 a_n8760_n4271.t2 3.9605
R4904 a_n8760_n4271.n15 a_n8760_n4271.t3 3.9605
R4905 a_n8760_n4271.n49 a_n8760_n4271.t6 3.9605
R4906 a_n8760_n4271.n49 a_n8760_n4271.t7 3.9605
R4907 a_n8760_n4271.n48 a_n8760_n4271.n14 3.8476
R4908 a_n8760_n4271.n0 a_n8760_n4271.n13 2.29518
R4909 a_n8760_n4271.n37 a_n8760_n4271.n11 2.11511
R4910 a_n8760_n4271.n19 a_n8760_n4271.n0 1.92
R4911 a_n8760_n4271.n0 a_n8760_n4271.n29 1.92
R4912 a_n8760_n4271.n14 a_n8760_n4271.t10 1.63745
R4913 a_n8760_n4271.n1 a_n8760_n4271.n7 1.57416
R4914 a_n8760_n4271.n47 a_n8760_n4271.n2 1.57416
R4915 a_n8760_n4271.n47 a_n8760_n4271.n5 1.57416
R4916 a_n8760_n4271.n8 a_n8760_n4271.n7 1.57416
R4917 a_n8760_n4271.n8 a_n8760_n4271.n5 1.21925
R4918 a_n8760_n4271.n2 a_n8760_n4271.n1 1.21925
R4919 a_n6092_3282.n18 a_n6092_3282.t19 838.681
R4920 a_n6092_3282.n21 a_n6092_3282.t20 838.681
R4921 a_n6092_3282.n22 a_n6092_3282.t21 838.681
R4922 a_n6092_3282.n23 a_n6092_3282.t22 838.681
R4923 a_n6092_3282.n24 a_n6092_3282.t23 838.681
R4924 a_n6092_3282.n25 a_n6092_3282.t24 838.681
R4925 a_n6092_3282.n27 a_n6092_3282.t25 838.681
R4926 a_n6092_3282.n28 a_n6092_3282.t26 838.681
R4927 a_n6092_3282.n39 a_n6092_3282.t18 517.347
R4928 a_n6092_3282.n38 a_n6092_3282.t17 517.347
R4929 a_n6092_3282.n37 a_n6092_3282.t16 517.347
R4930 a_n6092_3282.n34 a_n6092_3282.t15 517.347
R4931 a_n6092_3282.n45 a_n6092_3282.t12 433.488
R4932 a_n6092_3282.t12 a_n6092_3282.n41 433.488
R4933 a_n6092_3282.t13 a_n6092_3282.n42 433.488
R4934 a_n6092_3282.n43 a_n6092_3282.t13 433.488
R4935 a_n6092_3282.n19 a_n6092_3282.n18 158.304
R4936 a_n6092_3282.n29 a_n6092_3282.n28 158.304
R4937 a_n6092_3282.n35 a_n6092_3282.n34 158.284
R4938 a_n6092_3282.n46 a_n6092_3282.t11 157.577
R4939 a_n6092_3282.n44 a_n6092_3282.t14 157.577
R4940 a_n6092_3282.n37 a_n6092_3282.n36 152
R4941 a_n6092_3282.n38 a_n6092_3282.n33 152
R4942 a_n6092_3282.n27 a_n6092_3282.n26 152
R4943 a_n6092_3282.n30 a_n6092_3282.n25 152
R4944 a_n6092_3282.n31 a_n6092_3282.n24 152
R4945 a_n6092_3282.n32 a_n6092_3282.n23 152
R4946 a_n6092_3282.n22 a_n6092_3282.n17 152
R4947 a_n6092_3282.n21 a_n6092_3282.n20 152
R4948 a_n6092_3282.n5 a_n6092_3282.n44 124.763
R4949 a_n6092_3282.n44 a_n6092_3282.n10 124.763
R4950 a_n6092_3282.n39 a_n6092_3282.n38 70.1096
R4951 a_n6092_3282.n38 a_n6092_3282.n37 70.1096
R4952 a_n6092_3282.n37 a_n6092_3282.n34 70.1096
R4953 a_n6092_3282.n28 a_n6092_3282.n27 70.1096
R4954 a_n6092_3282.n27 a_n6092_3282.n25 70.1096
R4955 a_n6092_3282.n25 a_n6092_3282.n24 70.1096
R4956 a_n6092_3282.n24 a_n6092_3282.n23 70.1096
R4957 a_n6092_3282.n23 a_n6092_3282.n22 70.1096
R4958 a_n6092_3282.n22 a_n6092_3282.n21 70.1096
R4959 a_n6092_3282.n21 a_n6092_3282.n18 70.1096
R4960 a_n6092_3282.n11 a_n6092_3282.n15 57.3314
R4961 a_n6092_3282.t8 a_n6092_3282.n11 57.3314
R4962 a_n6092_3282.n11 a_n6092_3282.n16 56.9981
R4963 a_n6092_3282.n11 a_n6092_3282.n49 56.9981
R4964 a_n6092_3282.n40 a_n6092_3282.n1 43.4241
R4965 a_n6092_3282.n46 a_n6092_3282.n7 124.763
R4966 a_n6092_3282.n43 a_n6092_3282.n41 41.6005
R4967 a_n6092_3282.n46 a_n6092_3282.n4 124.763
R4968 a_n6092_3282.n45 a_n6092_3282.n42 41.6005
R4969 a_n6092_3282.n39 a_n6092_3282.n13 158.142
R4970 a_n6092_3282.n36 a_n6092_3282.n33 36.1417
R4971 a_n6092_3282.n30 a_n6092_3282.n26 36.1417
R4972 a_n6092_3282.n31 a_n6092_3282.n30 36.1417
R4973 a_n6092_3282.n32 a_n6092_3282.n14 6.14104
R4974 a_n6092_3282.n32 a_n6092_3282.n17 36.1417
R4975 a_n6092_3282.n20 a_n6092_3282.n17 36.1417
R4976 a_n6092_3282.n0 a_n6092_3282.t0 24.5153
R4977 a_n6092_3282.n48 a_n6092_3282.t1 21.1053
R4978 a_n6092_3282.n8 a_n6092_3282.t10 11.871
R4979 a_n6092_3282.n0 a_n6092_3282.n47 11.3205
R4980 a_n6092_3282.n12 a_n6092_3282.n13 1.58098
R4981 a_n6092_3282.n33 a_n6092_3282.n13 6.14104
R4982 a_n6092_3282.n31 a_n6092_3282.n14 6.14104
R4983 a_n6092_3282.n30 a_n6092_3282.n1 9.3005
R4984 a_n6092_3282.n17 a_n6092_3282.n1 9.3005
R4985 a_n6092_3282.n2 a_n6092_3282.n5 1.43771
R4986 a_n6092_3282.n4 a_n6092_3282.n3 1.43771
R4987 a_n6092_3282.n45 a_n6092_3282.n4 6.42758
R4988 a_n6092_3282.n5 a_n6092_3282.n42 6.42758
R4989 a_n6092_3282.n10 a_n6092_3282.n9 1.43771
R4990 a_n6092_3282.n10 a_n6092_3282.n43 6.42758
R4991 a_n6092_3282.n41 a_n6092_3282.n7 6.42758
R4992 a_n6092_3282.n6 a_n6092_3282.n7 1.43771
R4993 a_n6092_3282.n40 a_n6092_3282.n12 7.94258
R4994 a_n6092_3282.n36 a_n6092_3282.n35 6.11192
R4995 a_n6092_3282.n29 a_n6092_3282.n26 6.10787
R4996 a_n6092_3282.n20 a_n6092_3282.n19 6.10787
R4997 a_n6092_3282.n0 a_n6092_3282.n40 4.90797
R4998 a_n6092_3282.n11 a_n6092_3282.n48 3.98257
R4999 a_n6092_3282.t9 a_n6092_3282.t8 3.9605
R5000 a_n6092_3282.n16 a_n6092_3282.t4 3.9605
R5001 a_n6092_3282.n16 a_n6092_3282.t5 3.9605
R5002 a_n6092_3282.n15 a_n6092_3282.t2 3.9605
R5003 a_n6092_3282.n15 a_n6092_3282.t3 3.9605
R5004 a_n6092_3282.n49 a_n6092_3282.t6 3.9605
R5005 a_n6092_3282.n49 a_n6092_3282.t7 3.9605
R5006 a_n6092_3282.n48 a_n6092_3282.n0 3.8476
R5007 a_n6092_3282.n1 a_n6092_3282.n14 2.29518
R5008 a_n6092_3282.n35 a_n6092_3282.n12 2.11511
R5009 a_n6092_3282.n19 a_n6092_3282.n1 1.92
R5010 a_n6092_3282.n1 a_n6092_3282.n29 1.92
R5011 a_n6092_3282.n0 a_n6092_3282.t10 1.87933
R5012 a_n6092_3282.n2 a_n6092_3282.n8 1.57416
R5013 a_n6092_3282.n47 a_n6092_3282.n3 1.57416
R5014 a_n6092_3282.n47 a_n6092_3282.n6 1.57416
R5015 a_n6092_3282.n9 a_n6092_3282.n8 1.57416
R5016 a_n6092_3282.n9 a_n6092_3282.n6 1.21925
R5017 a_n6092_3282.n3 a_n6092_3282.n2 1.21925
R5018 a_5324_n3348.n28 a_5324_n3348.t18 838.681
R5019 a_5324_n3348.n27 a_5324_n3348.t17 838.681
R5020 a_5324_n3348.n25 a_5324_n3348.t16 838.681
R5021 a_5324_n3348.n24 a_5324_n3348.t15 838.681
R5022 a_5324_n3348.n23 a_5324_n3348.t14 838.681
R5023 a_5324_n3348.n22 a_5324_n3348.t13 838.681
R5024 a_5324_n3348.n21 a_5324_n3348.t12 838.681
R5025 a_5324_n3348.n18 a_5324_n3348.t11 838.681
R5026 a_5324_n3348.n39 a_5324_n3348.t22 517.347
R5027 a_5324_n3348.n38 a_5324_n3348.t21 517.347
R5028 a_5324_n3348.n37 a_5324_n3348.t20 517.347
R5029 a_5324_n3348.n34 a_5324_n3348.t19 517.347
R5030 a_5324_n3348.n43 a_5324_n3348.t24 433.488
R5031 a_5324_n3348.n46 a_5324_n3348.t24 433.488
R5032 a_5324_n3348.n42 a_5324_n3348.t25 433.488
R5033 a_5324_n3348.n47 a_5324_n3348.t25 433.488
R5034 a_5324_n3348.n29 a_5324_n3348.n28 158.304
R5035 a_5324_n3348.n19 a_5324_n3348.n18 158.304
R5036 a_5324_n3348.n35 a_5324_n3348.n34 158.284
R5037 a_5324_n3348.n44 a_5324_n3348.t23 157.577
R5038 a_5324_n3348.n41 a_5324_n3348.t26 157.577
R5039 a_5324_n3348.n37 a_5324_n3348.n36 152
R5040 a_5324_n3348.n38 a_5324_n3348.n33 152
R5041 a_5324_n3348.n21 a_5324_n3348.n20 152
R5042 a_5324_n3348.n22 a_5324_n3348.n17 152
R5043 a_5324_n3348.n32 a_5324_n3348.n23 152
R5044 a_5324_n3348.n31 a_5324_n3348.n24 152
R5045 a_5324_n3348.n30 a_5324_n3348.n25 152
R5046 a_5324_n3348.n27 a_5324_n3348.n26 152
R5047 a_5324_n3348.n5 a_5324_n3348.n41 124.763
R5048 a_5324_n3348.n9 a_5324_n3348.n41 124.763
R5049 a_5324_n3348.n39 a_5324_n3348.n38 70.1096
R5050 a_5324_n3348.n38 a_5324_n3348.n37 70.1096
R5051 a_5324_n3348.n37 a_5324_n3348.n34 70.1096
R5052 a_5324_n3348.n28 a_5324_n3348.n27 70.1096
R5053 a_5324_n3348.n27 a_5324_n3348.n25 70.1096
R5054 a_5324_n3348.n25 a_5324_n3348.n24 70.1096
R5055 a_5324_n3348.n24 a_5324_n3348.n23 70.1096
R5056 a_5324_n3348.n23 a_5324_n3348.n22 70.1096
R5057 a_5324_n3348.n22 a_5324_n3348.n21 70.1096
R5058 a_5324_n3348.n21 a_5324_n3348.n18 70.1096
R5059 a_5324_n3348.n10 a_5324_n3348.n15 57.3314
R5060 a_5324_n3348.n10 a_5324_n3348.n14 57.3314
R5061 a_5324_n3348.t2 a_5324_n3348.n10 56.9981
R5062 a_5324_n3348.n10 a_5324_n3348.n16 56.9981
R5063 a_5324_n3348.n6 a_5324_n3348.n44 124.763
R5064 a_5324_n3348.n47 a_5324_n3348.n46 41.6005
R5065 a_5324_n3348.n44 a_5324_n3348.n3 124.763
R5066 a_5324_n3348.n43 a_5324_n3348.n42 41.6005
R5067 a_5324_n3348.n40 a_5324_n3348.n1 39.9271
R5068 a_5324_n3348.n39 a_5324_n3348.n12 158.142
R5069 a_5324_n3348.n36 a_5324_n3348.n33 36.1417
R5070 a_5324_n3348.n30 a_5324_n3348.n26 36.1417
R5071 a_5324_n3348.n31 a_5324_n3348.n30 36.1417
R5072 a_5324_n3348.n32 a_5324_n3348.n13 6.14104
R5073 a_5324_n3348.n32 a_5324_n3348.n17 36.1417
R5074 a_5324_n3348.n20 a_5324_n3348.n17 36.1417
R5075 a_5324_n3348.n0 a_5324_n3348.t7 24.4926
R5076 a_5324_n3348.n49 a_5324_n3348.t8 21.0826
R5077 a_5324_n3348.n45 a_5324_n3348.t10 11.871
R5078 a_5324_n3348.n0 a_5324_n3348.n48 11.3205
R5079 a_5324_n3348.n5 a_5324_n3348.n4 1.43771
R5080 a_5324_n3348.n2 a_5324_n3348.n3 1.43771
R5081 a_5324_n3348.n43 a_5324_n3348.n3 6.42758
R5082 a_5324_n3348.n42 a_5324_n3348.n5 6.42758
R5083 a_5324_n3348.n7 a_5324_n3348.n9 1.43771
R5084 a_5324_n3348.n47 a_5324_n3348.n9 6.42758
R5085 a_5324_n3348.n46 a_5324_n3348.n6 6.42758
R5086 a_5324_n3348.n8 a_5324_n3348.n6 1.43771
R5087 a_5324_n3348.n11 a_5324_n3348.n12 1.58098
R5088 a_5324_n3348.n33 a_5324_n3348.n12 6.14104
R5089 a_5324_n3348.n31 a_5324_n3348.n13 6.14104
R5090 a_5324_n3348.n30 a_5324_n3348.n1 9.3005
R5091 a_5324_n3348.n17 a_5324_n3348.n1 9.3005
R5092 a_5324_n3348.n40 a_5324_n3348.n11 7.96394
R5093 a_5324_n3348.n36 a_5324_n3348.n35 6.11192
R5094 a_5324_n3348.n29 a_5324_n3348.n26 6.10787
R5095 a_5324_n3348.n20 a_5324_n3348.n19 6.10787
R5096 a_5324_n3348.n0 a_5324_n3348.n40 4.90797
R5097 a_5324_n3348.n10 a_5324_n3348.n49 3.98257
R5098 a_5324_n3348.t0 a_5324_n3348.t2 3.9605
R5099 a_5324_n3348.n16 a_5324_n3348.t9 3.9605
R5100 a_5324_n3348.n16 a_5324_n3348.t1 3.9605
R5101 a_5324_n3348.n15 a_5324_n3348.t3 3.9605
R5102 a_5324_n3348.n15 a_5324_n3348.t4 3.9605
R5103 a_5324_n3348.n14 a_5324_n3348.t5 3.9605
R5104 a_5324_n3348.n14 a_5324_n3348.t6 3.9605
R5105 a_5324_n3348.n49 a_5324_n3348.n0 3.7912
R5106 a_5324_n3348.n1 a_5324_n3348.n13 2.29518
R5107 a_5324_n3348.n35 a_5324_n3348.n11 2.11511
R5108 a_5324_n3348.n0 a_5324_n3348.t10 1.93573
R5109 a_5324_n3348.n1 a_5324_n3348.n29 1.92
R5110 a_5324_n3348.n19 a_5324_n3348.n1 1.92
R5111 a_5324_n3348.n45 a_5324_n3348.n2 1.57416
R5112 a_5324_n3348.n48 a_5324_n3348.n4 1.57416
R5113 a_5324_n3348.n48 a_5324_n3348.n7 1.57416
R5114 a_5324_n3348.n8 a_5324_n3348.n45 1.57416
R5115 a_5324_n3348.n8 a_5324_n3348.n7 1.21925
R5116 a_5324_n3348.n4 a_5324_n3348.n2 1.21925
R5117 a_1660_3469.n27 a_1660_3469.t18 838.681
R5118 a_1660_3469.n26 a_1660_3469.t17 838.681
R5119 a_1660_3469.n24 a_1660_3469.t16 838.681
R5120 a_1660_3469.n23 a_1660_3469.t15 838.681
R5121 a_1660_3469.n22 a_1660_3469.t14 838.681
R5122 a_1660_3469.n21 a_1660_3469.t13 838.681
R5123 a_1660_3469.n20 a_1660_3469.t12 838.681
R5124 a_1660_3469.n17 a_1660_3469.t11 838.681
R5125 a_1660_3469.n35 a_1660_3469.t22 517.347
R5126 a_1660_3469.n34 a_1660_3469.t21 517.347
R5127 a_1660_3469.n33 a_1660_3469.t20 517.347
R5128 a_1660_3469.n32 a_1660_3469.t19 517.347
R5129 a_1660_3469.n42 a_1660_3469.t24 433.488
R5130 a_1660_3469.n45 a_1660_3469.t24 433.488
R5131 a_1660_3469.n41 a_1660_3469.t25 433.488
R5132 a_1660_3469.n46 a_1660_3469.t25 433.488
R5133 a_1660_3469.n28 a_1660_3469.n27 158.304
R5134 a_1660_3469.n18 a_1660_3469.n17 158.304
R5135 a_1660_3469.n36 a_1660_3469.n35 158.284
R5136 a_1660_3469.n43 a_1660_3469.t23 157.577
R5137 a_1660_3469.n40 a_1660_3469.t26 157.577
R5138 a_1660_3469.n11 a_1660_3469.n32 158.142
R5139 a_1660_3469.n38 a_1660_3469.n33 152
R5140 a_1660_3469.n37 a_1660_3469.n34 152
R5141 a_1660_3469.n20 a_1660_3469.n19 152
R5142 a_1660_3469.n21 a_1660_3469.n16 152
R5143 a_1660_3469.n31 a_1660_3469.n22 152
R5144 a_1660_3469.n30 a_1660_3469.n23 152
R5145 a_1660_3469.n29 a_1660_3469.n24 152
R5146 a_1660_3469.n26 a_1660_3469.n25 152
R5147 a_1660_3469.n4 a_1660_3469.n40 124.763
R5148 a_1660_3469.n8 a_1660_3469.n40 124.763
R5149 a_1660_3469.n35 a_1660_3469.n34 70.1096
R5150 a_1660_3469.n34 a_1660_3469.n33 70.1096
R5151 a_1660_3469.n33 a_1660_3469.n32 70.1096
R5152 a_1660_3469.n27 a_1660_3469.n26 70.1096
R5153 a_1660_3469.n26 a_1660_3469.n24 70.1096
R5154 a_1660_3469.n24 a_1660_3469.n23 70.1096
R5155 a_1660_3469.n23 a_1660_3469.n22 70.1096
R5156 a_1660_3469.n22 a_1660_3469.n21 70.1096
R5157 a_1660_3469.n21 a_1660_3469.n20 70.1096
R5158 a_1660_3469.n20 a_1660_3469.n17 70.1096
R5159 a_1660_3469.t8 a_1660_3469.n9 57.3314
R5160 a_1660_3469.n9 a_1660_3469.n14 57.3314
R5161 a_1660_3469.n9 a_1660_3469.n15 56.9981
R5162 a_1660_3469.n9 a_1660_3469.n49 56.9981
R5163 a_1660_3469.n5 a_1660_3469.n43 124.763
R5164 a_1660_3469.n46 a_1660_3469.n45 41.6005
R5165 a_1660_3469.n43 a_1660_3469.n2 124.763
R5166 a_1660_3469.n42 a_1660_3469.n41 41.6005
R5167 a_1660_3469.n39 a_1660_3469.n0 39.9271
R5168 a_1660_3469.n38 a_1660_3469.n37 36.1417
R5169 a_1660_3469.n29 a_1660_3469.n25 36.1417
R5170 a_1660_3469.n30 a_1660_3469.n29 36.1417
R5171 a_1660_3469.n31 a_1660_3469.n12 6.14104
R5172 a_1660_3469.n31 a_1660_3469.n16 36.1417
R5173 a_1660_3469.n19 a_1660_3469.n16 36.1417
R5174 a_1660_3469.n13 a_1660_3469.t3 24.4926
R5175 a_1660_3469.n48 a_1660_3469.t2 21.0826
R5176 a_1660_3469.n44 a_1660_3469.t10 11.871
R5177 a_1660_3469.t10 a_1660_3469.n47 11.3205
R5178 a_1660_3469.n4 a_1660_3469.n3 1.43771
R5179 a_1660_3469.n1 a_1660_3469.n2 1.43771
R5180 a_1660_3469.n42 a_1660_3469.n2 6.42758
R5181 a_1660_3469.n41 a_1660_3469.n4 6.42758
R5182 a_1660_3469.n6 a_1660_3469.n8 1.43771
R5183 a_1660_3469.n46 a_1660_3469.n8 6.42758
R5184 a_1660_3469.n45 a_1660_3469.n5 6.42758
R5185 a_1660_3469.n7 a_1660_3469.n5 1.43771
R5186 a_1660_3469.n10 a_1660_3469.n11 1.58098
R5187 a_1660_3469.n38 a_1660_3469.n11 6.14104
R5188 a_1660_3469.n30 a_1660_3469.n12 6.14104
R5189 a_1660_3469.n29 a_1660_3469.n0 9.3005
R5190 a_1660_3469.n16 a_1660_3469.n0 9.3005
R5191 a_1660_3469.n39 a_1660_3469.n10 7.96394
R5192 a_1660_3469.n37 a_1660_3469.n36 6.11192
R5193 a_1660_3469.n28 a_1660_3469.n25 6.10787
R5194 a_1660_3469.n19 a_1660_3469.n18 6.10787
R5195 a_1660_3469.n13 a_1660_3469.n39 4.90797
R5196 a_1660_3469.n9 a_1660_3469.n48 3.98257
R5197 a_1660_3469.t0 a_1660_3469.t8 3.9605
R5198 a_1660_3469.n14 a_1660_3469.t5 3.9605
R5199 a_1660_3469.n14 a_1660_3469.t7 3.9605
R5200 a_1660_3469.n15 a_1660_3469.t1 3.9605
R5201 a_1660_3469.n15 a_1660_3469.t6 3.9605
R5202 a_1660_3469.n49 a_1660_3469.t9 3.9605
R5203 a_1660_3469.n49 a_1660_3469.t4 3.9605
R5204 a_1660_3469.n48 a_1660_3469.n13 3.7912
R5205 a_1660_3469.n0 a_1660_3469.n12 2.29518
R5206 a_1660_3469.n36 a_1660_3469.n10 2.11511
R5207 a_1660_3469.n0 a_1660_3469.n28 1.92
R5208 a_1660_3469.n18 a_1660_3469.n0 1.92
R5209 a_1660_3469.n13 a_1660_3469.t10 1.69385
R5210 a_1660_3469.n44 a_1660_3469.n1 1.57416
R5211 a_1660_3469.n47 a_1660_3469.n3 1.57416
R5212 a_1660_3469.n47 a_1660_3469.n6 1.57416
R5213 a_1660_3469.n7 a_1660_3469.n44 1.57416
R5214 a_1660_3469.n7 a_1660_3469.n6 1.21925
R5215 a_1660_3469.n3 a_1660_3469.n1 1.21925
R5216 a_n5033_3370.n27 a_n5033_3370.t22 838.681
R5217 a_n5033_3370.n26 a_n5033_3370.t21 838.681
R5218 a_n5033_3370.n24 a_n5033_3370.t20 838.681
R5219 a_n5033_3370.n23 a_n5033_3370.t19 838.681
R5220 a_n5033_3370.n22 a_n5033_3370.t18 838.681
R5221 a_n5033_3370.n21 a_n5033_3370.t17 838.681
R5222 a_n5033_3370.n20 a_n5033_3370.t16 838.681
R5223 a_n5033_3370.n17 a_n5033_3370.t15 838.681
R5224 a_n5033_3370.n38 a_n5033_3370.t14 517.347
R5225 a_n5033_3370.n37 a_n5033_3370.t13 517.347
R5226 a_n5033_3370.n36 a_n5033_3370.t12 517.347
R5227 a_n5033_3370.n33 a_n5033_3370.t11 517.347
R5228 a_n5033_3370.n42 a_n5033_3370.t24 433.488
R5229 a_n5033_3370.n45 a_n5033_3370.t24 433.488
R5230 a_n5033_3370.n41 a_n5033_3370.t25 433.488
R5231 a_n5033_3370.n46 a_n5033_3370.t25 433.488
R5232 a_n5033_3370.n28 a_n5033_3370.n27 158.304
R5233 a_n5033_3370.n18 a_n5033_3370.n17 158.304
R5234 a_n5033_3370.n34 a_n5033_3370.n33 158.284
R5235 a_n5033_3370.n43 a_n5033_3370.t23 157.577
R5236 a_n5033_3370.n40 a_n5033_3370.t26 157.577
R5237 a_n5033_3370.n36 a_n5033_3370.n35 152
R5238 a_n5033_3370.n37 a_n5033_3370.n32 152
R5239 a_n5033_3370.n20 a_n5033_3370.n19 152
R5240 a_n5033_3370.n21 a_n5033_3370.n16 152
R5241 a_n5033_3370.n31 a_n5033_3370.n22 152
R5242 a_n5033_3370.n30 a_n5033_3370.n23 152
R5243 a_n5033_3370.n29 a_n5033_3370.n24 152
R5244 a_n5033_3370.n26 a_n5033_3370.n25 152
R5245 a_n5033_3370.n5 a_n5033_3370.n40 124.763
R5246 a_n5033_3370.n9 a_n5033_3370.n40 124.763
R5247 a_n5033_3370.n38 a_n5033_3370.n37 70.1096
R5248 a_n5033_3370.n37 a_n5033_3370.n36 70.1096
R5249 a_n5033_3370.n36 a_n5033_3370.n33 70.1096
R5250 a_n5033_3370.n27 a_n5033_3370.n26 70.1096
R5251 a_n5033_3370.n26 a_n5033_3370.n24 70.1096
R5252 a_n5033_3370.n24 a_n5033_3370.n23 70.1096
R5253 a_n5033_3370.n23 a_n5033_3370.n22 70.1096
R5254 a_n5033_3370.n22 a_n5033_3370.n21 70.1096
R5255 a_n5033_3370.n21 a_n5033_3370.n20 70.1096
R5256 a_n5033_3370.n20 a_n5033_3370.n17 70.1096
R5257 a_n5033_3370.n39 a_n5033_3370.n1 60.2277
R5258 a_n5033_3370.t8 a_n5033_3370.n10 57.3314
R5259 a_n5033_3370.n10 a_n5033_3370.n14 57.3314
R5260 a_n5033_3370.n10 a_n5033_3370.n15 56.9981
R5261 a_n5033_3370.n10 a_n5033_3370.n49 56.9981
R5262 a_n5033_3370.n6 a_n5033_3370.n43 124.763
R5263 a_n5033_3370.n46 a_n5033_3370.n45 41.6005
R5264 a_n5033_3370.n43 a_n5033_3370.n3 124.763
R5265 a_n5033_3370.n42 a_n5033_3370.n41 41.6005
R5266 a_n5033_3370.n38 a_n5033_3370.n12 158.142
R5267 a_n5033_3370.n35 a_n5033_3370.n32 36.1417
R5268 a_n5033_3370.n29 a_n5033_3370.n25 36.1417
R5269 a_n5033_3370.n30 a_n5033_3370.n29 36.1417
R5270 a_n5033_3370.n31 a_n5033_3370.n13 6.14104
R5271 a_n5033_3370.n31 a_n5033_3370.n16 36.1417
R5272 a_n5033_3370.n19 a_n5033_3370.n16 36.1417
R5273 a_n5033_3370.n0 a_n5033_3370.t1 24.4926
R5274 a_n5033_3370.n48 a_n5033_3370.t0 21.0826
R5275 a_n5033_3370.n44 a_n5033_3370.t10 11.871
R5276 a_n5033_3370.n0 a_n5033_3370.n47 11.3205
R5277 a_n5033_3370.n5 a_n5033_3370.n4 1.43771
R5278 a_n5033_3370.n2 a_n5033_3370.n3 1.43771
R5279 a_n5033_3370.n42 a_n5033_3370.n3 6.42758
R5280 a_n5033_3370.n41 a_n5033_3370.n5 6.42758
R5281 a_n5033_3370.n7 a_n5033_3370.n9 1.43771
R5282 a_n5033_3370.n46 a_n5033_3370.n9 6.42758
R5283 a_n5033_3370.n45 a_n5033_3370.n6 6.42758
R5284 a_n5033_3370.n8 a_n5033_3370.n6 1.43771
R5285 a_n5033_3370.n11 a_n5033_3370.n12 1.58098
R5286 a_n5033_3370.n32 a_n5033_3370.n12 6.14104
R5287 a_n5033_3370.n30 a_n5033_3370.n13 6.14104
R5288 a_n5033_3370.n29 a_n5033_3370.n1 9.3005
R5289 a_n5033_3370.n16 a_n5033_3370.n1 9.3005
R5290 a_n5033_3370.n39 a_n5033_3370.n11 7.96394
R5291 a_n5033_3370.n35 a_n5033_3370.n34 6.11192
R5292 a_n5033_3370.n28 a_n5033_3370.n25 6.10787
R5293 a_n5033_3370.n19 a_n5033_3370.n18 6.10787
R5294 a_n5033_3370.n0 a_n5033_3370.n39 4.90797
R5295 a_n5033_3370.n10 a_n5033_3370.n48 3.98257
R5296 a_n5033_3370.t9 a_n5033_3370.t8 3.9605
R5297 a_n5033_3370.n15 a_n5033_3370.t4 3.9605
R5298 a_n5033_3370.n15 a_n5033_3370.t5 3.9605
R5299 a_n5033_3370.n14 a_n5033_3370.t2 3.9605
R5300 a_n5033_3370.n14 a_n5033_3370.t3 3.9605
R5301 a_n5033_3370.n49 a_n5033_3370.t6 3.9605
R5302 a_n5033_3370.n49 a_n5033_3370.t7 3.9605
R5303 a_n5033_3370.n48 a_n5033_3370.n0 3.7912
R5304 a_n5033_3370.n1 a_n5033_3370.n13 2.29518
R5305 a_n5033_3370.n34 a_n5033_3370.n11 2.11511
R5306 a_n5033_3370.n0 a_n5033_3370.t10 1.93573
R5307 a_n5033_3370.n1 a_n5033_3370.n28 1.92
R5308 a_n5033_3370.n18 a_n5033_3370.n1 1.92
R5309 a_n5033_3370.n44 a_n5033_3370.n2 1.57416
R5310 a_n5033_3370.n47 a_n5033_3370.n4 1.57416
R5311 a_n5033_3370.n47 a_n5033_3370.n7 1.57416
R5312 a_n5033_3370.n8 a_n5033_3370.n44 1.57416
R5313 a_n5033_3370.n8 a_n5033_3370.n7 1.21925
R5314 a_n5033_3370.n4 a_n5033_3370.n2 1.21925
R5315 a_n8760_3469.n27 a_n8760_3469.t22 838.681
R5316 a_n8760_3469.n26 a_n8760_3469.t21 838.681
R5317 a_n8760_3469.n24 a_n8760_3469.t20 838.681
R5318 a_n8760_3469.n23 a_n8760_3469.t19 838.681
R5319 a_n8760_3469.n22 a_n8760_3469.t18 838.681
R5320 a_n8760_3469.n21 a_n8760_3469.t17 838.681
R5321 a_n8760_3469.n20 a_n8760_3469.t16 838.681
R5322 a_n8760_3469.n17 a_n8760_3469.t15 838.681
R5323 a_n8760_3469.n35 a_n8760_3469.t14 517.347
R5324 a_n8760_3469.n34 a_n8760_3469.t13 517.347
R5325 a_n8760_3469.n33 a_n8760_3469.t12 517.347
R5326 a_n8760_3469.n32 a_n8760_3469.t11 517.347
R5327 a_n8760_3469.n42 a_n8760_3469.t24 433.488
R5328 a_n8760_3469.n45 a_n8760_3469.t24 433.488
R5329 a_n8760_3469.n41 a_n8760_3469.t25 433.488
R5330 a_n8760_3469.n46 a_n8760_3469.t25 433.488
R5331 a_n8760_3469.n28 a_n8760_3469.n27 158.304
R5332 a_n8760_3469.n18 a_n8760_3469.n17 158.304
R5333 a_n8760_3469.n36 a_n8760_3469.n35 158.284
R5334 a_n8760_3469.n43 a_n8760_3469.t23 157.577
R5335 a_n8760_3469.n40 a_n8760_3469.t26 157.577
R5336 a_n8760_3469.n11 a_n8760_3469.n32 158.142
R5337 a_n8760_3469.n38 a_n8760_3469.n33 152
R5338 a_n8760_3469.n37 a_n8760_3469.n34 152
R5339 a_n8760_3469.n20 a_n8760_3469.n19 152
R5340 a_n8760_3469.n21 a_n8760_3469.n16 152
R5341 a_n8760_3469.n31 a_n8760_3469.n22 152
R5342 a_n8760_3469.n30 a_n8760_3469.n23 152
R5343 a_n8760_3469.n29 a_n8760_3469.n24 152
R5344 a_n8760_3469.n26 a_n8760_3469.n25 152
R5345 a_n8760_3469.n4 a_n8760_3469.n40 124.763
R5346 a_n8760_3469.n8 a_n8760_3469.n40 124.763
R5347 a_n8760_3469.n35 a_n8760_3469.n34 70.1096
R5348 a_n8760_3469.n34 a_n8760_3469.n33 70.1096
R5349 a_n8760_3469.n33 a_n8760_3469.n32 70.1096
R5350 a_n8760_3469.n27 a_n8760_3469.n26 70.1096
R5351 a_n8760_3469.n26 a_n8760_3469.n24 70.1096
R5352 a_n8760_3469.n24 a_n8760_3469.n23 70.1096
R5353 a_n8760_3469.n23 a_n8760_3469.n22 70.1096
R5354 a_n8760_3469.n22 a_n8760_3469.n21 70.1096
R5355 a_n8760_3469.n21 a_n8760_3469.n20 70.1096
R5356 a_n8760_3469.n20 a_n8760_3469.n17 70.1096
R5357 a_n8760_3469.n39 a_n8760_3469.n0 62.3884
R5358 a_n8760_3469.t8 a_n8760_3469.n9 57.3314
R5359 a_n8760_3469.n9 a_n8760_3469.n14 57.3314
R5360 a_n8760_3469.n9 a_n8760_3469.n15 56.9981
R5361 a_n8760_3469.n9 a_n8760_3469.n49 56.9981
R5362 a_n8760_3469.n5 a_n8760_3469.n43 124.763
R5363 a_n8760_3469.n46 a_n8760_3469.n45 41.6005
R5364 a_n8760_3469.n43 a_n8760_3469.n2 124.763
R5365 a_n8760_3469.n42 a_n8760_3469.n41 41.6005
R5366 a_n8760_3469.n38 a_n8760_3469.n37 36.1417
R5367 a_n8760_3469.n29 a_n8760_3469.n25 36.1417
R5368 a_n8760_3469.n30 a_n8760_3469.n29 36.1417
R5369 a_n8760_3469.n31 a_n8760_3469.n12 6.14104
R5370 a_n8760_3469.n31 a_n8760_3469.n16 36.1417
R5371 a_n8760_3469.n19 a_n8760_3469.n16 36.1417
R5372 a_n8760_3469.n13 a_n8760_3469.t1 24.4926
R5373 a_n8760_3469.n48 a_n8760_3469.t0 21.0826
R5374 a_n8760_3469.n44 a_n8760_3469.t10 11.871
R5375 a_n8760_3469.t10 a_n8760_3469.n47 11.3205
R5376 a_n8760_3469.n4 a_n8760_3469.n3 1.43771
R5377 a_n8760_3469.n1 a_n8760_3469.n2 1.43771
R5378 a_n8760_3469.n42 a_n8760_3469.n2 6.42758
R5379 a_n8760_3469.n41 a_n8760_3469.n4 6.42758
R5380 a_n8760_3469.n6 a_n8760_3469.n8 1.43771
R5381 a_n8760_3469.n46 a_n8760_3469.n8 6.42758
R5382 a_n8760_3469.n45 a_n8760_3469.n5 6.42758
R5383 a_n8760_3469.n7 a_n8760_3469.n5 1.43771
R5384 a_n8760_3469.n10 a_n8760_3469.n11 1.58098
R5385 a_n8760_3469.n38 a_n8760_3469.n11 6.14104
R5386 a_n8760_3469.n30 a_n8760_3469.n12 6.14104
R5387 a_n8760_3469.n29 a_n8760_3469.n0 9.3005
R5388 a_n8760_3469.n16 a_n8760_3469.n0 9.3005
R5389 a_n8760_3469.n39 a_n8760_3469.n10 7.96394
R5390 a_n8760_3469.n37 a_n8760_3469.n36 6.11192
R5391 a_n8760_3469.n28 a_n8760_3469.n25 6.10787
R5392 a_n8760_3469.n19 a_n8760_3469.n18 6.10787
R5393 a_n8760_3469.n13 a_n8760_3469.n39 4.90797
R5394 a_n8760_3469.n9 a_n8760_3469.n48 3.98257
R5395 a_n8760_3469.t9 a_n8760_3469.t8 3.9605
R5396 a_n8760_3469.n15 a_n8760_3469.t4 3.9605
R5397 a_n8760_3469.n15 a_n8760_3469.t5 3.9605
R5398 a_n8760_3469.n14 a_n8760_3469.t2 3.9605
R5399 a_n8760_3469.n14 a_n8760_3469.t3 3.9605
R5400 a_n8760_3469.n49 a_n8760_3469.t6 3.9605
R5401 a_n8760_3469.n49 a_n8760_3469.t7 3.9605
R5402 a_n8760_3469.n48 a_n8760_3469.n13 3.7912
R5403 a_n8760_3469.n0 a_n8760_3469.n12 2.29518
R5404 a_n8760_3469.n36 a_n8760_3469.n10 2.11511
R5405 a_n8760_3469.n0 a_n8760_3469.n28 1.92
R5406 a_n8760_3469.n18 a_n8760_3469.n0 1.92
R5407 a_n8760_3469.n13 a_n8760_3469.t10 1.69385
R5408 a_n8760_3469.n44 a_n8760_3469.n1 1.57416
R5409 a_n8760_3469.n47 a_n8760_3469.n3 1.57416
R5410 a_n8760_3469.n47 a_n8760_3469.n6 1.57416
R5411 a_n8760_3469.n7 a_n8760_3469.n44 1.57416
R5412 a_n8760_3469.n7 a_n8760_3469.n6 1.21925
R5413 a_n8760_3469.n3 a_n8760_3469.n1 1.21925
C0 b0n vbias_q 0
C1 cfg1 a_9443_3117# 0.09184f
C2 cfg2 a_827_4557# 0.00138f
C3 cfg4 b2n 0.00278f
C4 cfg3 a_9443_n3183# 0
C5 a_n1227_6057# cfg2 0
C6 a_9393_5277# a_9443_4557# 0.05786f
C7 vdd_q a_9443_3117# 0.001f
C8 cfg0 a_827_5277# 0
C9 b1p a_9393_5277# 0.02491f
C10 a_n9593_4557# a_n9593_3837# 0.06202f
C11 cfg1 a_827_3117# 0.09235f
C12 cfg3 a_n1027_2397# 0.00275f
C13 b0p cfg1 0
C14 a_n9593_4557# cfg1 0.09184f
C15 a_9393_2397# a_9193_1617# 0.10246f
C16 cfg2 a_n977_n4623# 0.00138f
C17 a_9393_n5343# a_9443_n4623# 0.05786f
C18 a_9443_4557# cfg3 0
C19 ctrl a_827_n3183# 0.00554f
C20 b1n cfg2 0
C21 b1p cfg3 0
C22 cfg1 a_8793_577# 0.48259f
C23 b0p vdd_q 0.13655f
C24 a_n9593_4557# vdd_q 0.001f
C25 ctrl a_9443_3837# 0.06575f
C26 a_n9593_n3903# a_n9593_n4623# 0.06202f
C27 b0n a_n9593_7237# 0.492f
C28 cfg3 a_n1227_n6123# 0.12439f
C29 a_n9593_2397# a_n9593_1617# 0.10246f
C30 a_n9593_6057# cfg4 0.00239f
C31 a_8793_577# vdd_q 0.00157f
C32 ctrl b2p 0.03987f
C33 a_n6121_n4370# b3p 0.00518f
C34 a_n9593_n2463# ctrl 0.00587f
C35 a_9443_n3903# a_9443_n4623# 0.06202f
C36 a_n9593_577# cfg4 0.17811f
C37 cfg3 a_n9593_n7303# 0
C38 a_9393_n2463# b2p 0.00185f
C39 a_n9593_n1683# a_n9593_n3183# 0
C40 cfg0 a_n1627_577# 0.15398f
C41 a_n977_3117# ctrl 0.00554f
C42 cfg0 a_9393_n5343# 0.02819f
C43 a_9393_5277# ctrl 0.00587f
C44 a_827_n643# a_827_577# 0.20592f
C45 cfg3 a_827_1617# 0.12681f
C46 a_n1027_n2463# cfg1 0.00104f
C47 a_n1227_n1683# vbias_q 0
C48 a_n977_3117# a_n1227_1617# 0
C49 vbias_q a_3469_1610# 0.62235f
C50 cfg1 a_9193_1617# 0.00389f
C51 a_3469_n2210# a_827_n1683# 0.00403f
C52 a_n1027_5277# ctrl 0.00587f
C53 cfg1 a_n9593_1617# 0.00389f
C54 a_n1227_6057# a_n977_4557# 0
C55 a_n9593_n643# vdd_q 0.00157f
C56 cfg2 a_827_3837# 0
C57 cfg0 a_9443_n3903# 0.1209f
C58 vdd_q b3p 0.13655f
C59 vdd_q a_9193_1617# 0.00144f
C60 ctrl cfg3 0.29086f
C61 vdd_q a_n9593_1617# 0.00144f
C62 a_9393_n2463# cfg3 0.00281f
C63 cfg2 a_n9593_n4623# 0.00138f
C64 cfg4 a_827_n3183# 0.02443f
C65 cfg1 a_827_4557# 0.09235f
C66 b0n a_n9593_5277# 0.02491f
C67 b3n a_n9593_n6123# 0.25835f
C68 ctrl a_827_n5343# 0.00587f
C69 cfg1 a_n1227_6057# 0
C70 cfg3 a_n1227_1617# 0.12681f
C71 a_827_6057# a_827_5277# 0.10246f
C72 cfg0 a_9443_3117# 0.03011f
C73 a_827_n1683# a_827_n643# 0.14662f
C74 a_n1027_n2463# a_n1627_n643# 0
C75 b0p a_n6121_3370# 0.00518f
C76 cfg3 b2n 0.00128f
C77 cfg4 b2p 0.00996f
C78 cfg2 a_9443_n3183# 0.00138f
C79 a_n9593_n2463# cfg4 0.00499f
C80 a_n1227_6057# vdd_q 0
C81 cfg3 a_n9593_n5343# 0.00275f
C82 a_827_n5343# b2n 0.02491f
C83 cfg1 a_n977_n4623# 0.09235f
C84 b0p a_n6951_1610# 0.64426f
C85 cfg0 a_827_3117# 0.00105f
C86 cfg2 a_n1027_2397# 0.10218f
C87 b0p cfg0 0.01298f
C88 b1n cfg1 0
C89 a_n9593_4557# cfg0 0.03011f
C90 a_9443_4557# cfg2 0.00138f
C91 cfg0 a_8793_577# 0.17164f
C92 b1p cfg2 0
C93 b1n vdd_q 0.13655f
C94 ctrl a_n9593_n3903# 0.06575f
C95 a_n1227_n1683# a_n977_n3183# 0
C96 a_n977_n3183# a_n977_n3903# 0.06202f
C97 cfg2 a_n1227_n6123# 0
C98 a_8793_n643# a_8793_577# 0.20736f
C99 cfg4 cfg3 16.1096f
C100 a_n9593_6057# cfg3 0.12404f
C101 a_n9593_577# cfg3 0
C102 a_n9593_3117# ctrl 0.00554f
C103 cfg4 a_827_n5343# 0.02381f
C104 vbias_q a_n1627_577# 0.19707f
C105 a_3469_n2210# a_9193_n1683# 0.00403f
C106 a_n9593_n3903# a_n9593_n5343# 0
C107 cfg2 a_827_1617# 0.00283f
C108 cfg1 a_827_3837# 0.0021f
C109 a_827_n7303# a_827_n6123# 0.10722f
C110 a_n9593_n643# cfg0 0.042f
C111 a_n1027_n2463# cfg0 0.02384f
C112 cfg0 a_9193_1617# 0.21514f
C113 a_n9593_n1683# a_n6951_n2210# 0.00403f
C114 a_n6951_1610# a_n9593_1617# 0.00444f
C115 a_9393_5277# a_9443_3837# 0
C116 a_827_577# a_827_1617# 0.14662f
C117 cfg0 a_n9593_1617# 0.21514f
C118 a_827_n2463# a_827_n643# 0
C119 cfg1 a_n9593_n4623# 0.09184f
C120 b1p a_9393_2397# 0.00185f
C121 ctrl cfg2 0.18141f
C122 cfg0 a_827_4557# 0.00105f
C123 cfg3 a_827_n3183# 0
C124 vdd_q a_n9593_n4623# 0.001f
C125 a_9393_n2463# cfg2 0.10164f
C126 a_827_3117# a_827_2397# 0.05786f
C127 vdd_q a_827_7237# 0.70951f
C128 a_3469_n2210# a_4299_n4370# 0.15268f
C129 cfg1 a_9443_n3183# 0.09184f
C130 cfg2 a_n1227_1617# 0.00283f
C131 cfg0 a_n1227_6057# 0.02696f
C132 ctrl a_9193_n6123# 0.00178f
C133 a_n1027_n5343# a_n977_n3903# 0
C134 cfg3 b2p 0.00128f
C135 cfg2 b2n 0
C136 vdd_q a_9443_n3183# 0.001f
C137 a_n9593_n2463# cfg3 0.00281f
C138 cfg1 a_n1027_2397# 0.00112f
C139 a_n6951_n2210# vbias_q 0.62235f
C140 cfg2 a_n9593_n5343# 0.09933f
C141 a_n977_3117# cfg3 0
C142 cfg0 a_n977_n4623# 0.02548f
C143 cfg1 a_9443_4557# 0.09184f
C144 b1n cfg0 0.01298f
C145 b1p cfg1 0
C146 a_9393_5277# cfg3 0.00275f
C147 a_827_n1683# ctrl 0.18563f
C148 cfg1 a_n1227_n6123# 0
C149 b1n a_4299_3370# 0.00518f
C150 a_n9593_n1683# a_n9593_n643# 0.14662f
C151 a_9443_4557# vdd_q 0.001f
C152 ctrl a_9393_2397# 0.00587f
C153 a_n1027_5277# cfg3 0.00275f
C154 b1p vdd_q 0.13655f
C155 ctrl a_n9593_2397# 0.00587f
C156 a_9193_n1683# a_9443_n3183# 0
C157 vdd_q a_n1227_n6123# 0
C158 cfg4 cfg2 1.17909f
C159 b0p a_n1627_7237# 0.492f
C160 a_n9593_6057# cfg2 0
C161 a_n6121_n4370# ctrl 0.47423f
C162 a_827_n1683# b2n 0.00163f
C163 ctrl a_n977_4557# 0.00554f
C164 a_827_577# cfg4 0.20208f
C165 a_n9593_577# cfg2 0.7711f
C166 vdd_q a_n9593_n7303# 0.71129f
C167 cfg1 a_827_1617# 0.00389f
C168 cfg3 a_827_n5343# 0.00275f
C169 a_n9593_n2463# a_n9593_n3903# 0
C170 cfg4 a_9193_n6123# 0.00239f
C171 a_n9593_3837# ctrl 0.06575f
C172 a_n1027_2397# a_n977_3837# 0
C173 cfg0 a_827_3837# 0.09235f
C174 a_8793_n7303# cfg4 0.17702f
C175 vbias_q b3p 0
C176 cfg1 ctrl 0.15511f
C177 a_827_6057# a_827_4557# 0
C178 ctrl a_827_n3903# 0.06575f
C179 cfg0 a_n9593_n4623# 0.03011f
C180 cfg1 a_9393_n2463# 0.00104f
C181 cfg1 a_n1227_1617# 0.00389f
C182 a_827_n1683# cfg4 0.03383f
C183 cfg2 a_827_n3183# 0.00138f
C184 a_9393_n2463# vdd_q 0.00115f
C185 cfg4 a_9393_2397# 0
C186 cfg0 a_9443_n3183# 0.03011f
C187 b1n a_827_2397# 0.00185f
C188 cfg4 a_n9593_2397# 0
C189 cfg2 a_9443_3837# 0
C190 cfg1 a_n9593_n5343# 0.00104f
C191 a_n1627_n643# ctrl 0.12964f
C192 cfg2 b2p 0
C193 vdd_q b2n 0.13655f
C194 a_n9593_577# a_n9593_2397# 0
C195 a_827_n2463# ctrl 0.01213f
C196 a_n9593_n2463# cfg2 0.10164f
C197 a_n6121_n4370# cfg4 0.0112f
C198 b1n a_827_6057# 0.25835f
C199 cfg0 a_n1027_2397# 0.0301f
C200 a_n6951_n2210# b3n 0.64426f
C201 a_n9593_3117# cfg3 0
C202 vdd_q a_n9593_n5343# 0.00115f
C203 a_3469_n2210# vbias_q 0.62235f
C204 a_n977_3117# cfg2 0.00138f
C205 ctrl a_9193_n1683# 0.00178f
C206 a_n1627_7237# a_n1227_6057# 0.10722f
C207 a_9193_n6123# b2p 0.25835f
C208 cfg0 a_9443_4557# 0.03011f
C209 b1p cfg0 0.01298f
C210 b1n vbias_q 0
C211 a_9393_5277# cfg2 0.09933f
C212 a_n9593_4557# a_n9593_5277# 0.05786f
C213 a_9193_n1683# a_9393_n2463# 0.10246f
C214 ctrl a_n977_3837# 0.06575f
C215 a_827_n2463# b2n 0.00185f
C216 b1p a_4299_3370# 0.00518f
C217 cfg0 a_n1227_n6123# 0.02696f
C218 cfg1 cfg4 1.00096f
C219 a_8793_n7303# b2p 0.492f
C220 cfg1 a_n9593_6057# 0
C221 a_n1027_5277# cfg2 0.09981f
C222 a_827_n1683# a_827_n3183# 0
C223 a_n1027_n2463# a_n977_n3183# 0.05786f
C224 cfg4 a_827_n3903# 0.02443f
C225 cfg1 a_n9593_577# 0.48259f
C226 ctrl a_9443_n4623# 0.00554f
C227 a_827_2397# a_827_3837# 0
C228 cfg0 a_n9593_n7303# 0.01404f
C229 cfg4 vdd_q 4.43689f
C230 a_n9593_6057# vdd_q 0.00184f
C231 cfg3 cfg2 12.2285f
C232 a_827_n643# vbias_q 0.19707f
C233 a_9443_3837# a_9393_2397# 0
C234 b0n a_n9593_1617# 0.00211f
C235 a_4299_n4370# ctrl 0.4883f
C236 a_n9593_577# vdd_q 0.00157f
C237 a_827_577# cfg3 0
C238 a_n6121_3370# ctrl 0.47403f
C239 a_n6951_n2210# a_n1227_n1683# 0.00403f
C240 ctrl a_827_n4623# 0.00554f
C241 cfg0 a_827_1617# 0.18384f
C242 cfg2 a_827_n5343# 0.09981f
C243 cfg3 a_9193_n6123# 0.12404f
C244 a_n1627_n643# cfg4 0.66042f
C245 a_827_n2463# cfg4 0.02392f
C246 a_827_6057# a_827_7237# 0.10722f
C247 a_8793_n7303# cfg3 0
C248 ctrl a_n6951_1610# 0.08558f
C249 b1p a_8793_7237# 0.492f
C250 cfg0 ctrl 0.2436f
C251 a_4299_n4370# b2n 0.00518f
C252 a_9193_n1683# cfg4 0.05925f
C253 cfg1 a_827_n3183# 0.09235f
C254 cfg0 a_9393_n2463# 0.02819f
C255 a_4299_3370# ctrl 0.47403f
C256 a_n6951_1610# a_n1227_1617# 0.00444f
C257 a_827_n3903# a_827_n3183# 0.06202f
C258 cfg0 a_n1227_1617# 0.2108f
C259 cfg1 a_9443_3837# 0.0021f
C260 a_8793_n643# a_9393_n2463# 0
C261 a_827_n1683# cfg3 0.12876f
C262 cfg3 a_9393_2397# 0.00275f
C263 a_n9593_n3903# cfg2 0
C264 a_9193_6057# a_9443_4557# 0
C265 cfg3 a_n9593_2397# 0.00275f
C266 a_n9593_n2463# cfg1 0.00104f
C267 vdd_q a_9443_3837# 0.001f
C268 b1p a_9193_6057# 0.25835f
C269 a_n1027_5277# a_n977_4557# 0.05786f
C270 b3p a_n1627_n7303# 0.492f
C271 a_n1027_n5343# b3p 0.02491f
C272 cfg0 a_n9593_n5343# 0.02819f
C273 vdd_q b2p 0.13655f
C274 cfg1 a_n977_3117# 0.09235f
C275 a_n6121_n4370# cfg3 0
C276 a_n9593_n2463# vdd_q 0.00115f
C277 cfg3 a_n977_4557# 0
C278 a_9393_5277# cfg1 0.00104f
C279 a_n1227_n1683# a_n1027_n2463# 0.10246f
C280 a_4299_n4370# cfg4 0
C281 a_n1227_n1683# b3p 0.00163f
C282 a_n9593_3117# cfg2 0.00138f
C283 a_827_n2463# a_827_n3183# 0.05786f
C284 a_n1027_n2463# a_n977_n3903# 0
C285 a_9393_n5343# a_9443_n3903# 0
C286 cfg4 a_827_n4623# 0.02443f
C287 a_3469_1610# a_9193_1617# 0.00444f
C288 cfg1 a_n1027_5277# 0.00104f
C289 a_9393_5277# vdd_q 0.00115f
C290 a_827_2397# a_827_1617# 0.10246f
C291 cfg1 cfg3 1.07442f
C292 cfg0 cfg4 1.04463f
C293 cfg0 a_n9593_6057# 0.03129f
C294 a_n9593_n1683# ctrl 0.00178f
C295 a_9193_n1683# b2p 0.00163f
C296 a_8793_n643# cfg4 0.6606f
C297 cfg0 a_n9593_577# 0.17164f
C298 cfg3 vdd_q 0.80773f
C299 cfg1 a_827_n5343# 0.00104f
C300 ctrl a_827_2397# 0.00587f
C301 a_n9593_n6123# a_n9593_n4623# 0
C302 a_9193_6057# ctrl 0.00178f
C303 a_n1027_n5343# a_n977_n4623# 0.05786f
C304 a_827_n5343# a_827_n3903# 0
C305 a_827_577# cfg2 0.76572f
C306 vbias_q a_827_1617# 0
C307 cfg2 a_9193_n6123# 0
C308 a_827_6057# ctrl 0.00178f
C309 a_n977_3117# a_n977_3837# 0.06202f
C310 a_n977_n4623# a_n977_n3903# 0.06202f
C311 a_n1627_n643# cfg3 0.76619f
C312 a_827_n2463# cfg3 0.00281f
C313 b1n a_3469_1610# 0.64426f
C314 a_n9593_3117# a_n9593_2397# 0.05786f
C315 vbias_q ctrl 0.94436f
C316 a_4299_n4370# b2p 0.00518f
C317 a_827_5277# a_827_4557# 0.05786f
C318 a_9193_n1683# cfg3 0.12841f
C319 a_n1027_5277# a_n977_3837# 0
C320 cfg4 a_8793_7237# 0.17702f
C321 cfg0 a_827_n3183# 0.00105f
C322 cfg1 a_n9593_n3903# 0.0021f
C323 a_8793_n7303# a_9193_n6123# 0.10722f
C324 cfg0 a_9443_3837# 0.1209f
C325 vbias_q a_n1227_1617# 0
C326 a_827_n1683# cfg2 0
C327 cfg2 a_9393_2397# 0.10171f
C328 a_n9593_3117# a_n9593_3837# 0.06202f
C329 a_n9593_n3903# vdd_q 0.001f
C330 a_n9593_n1683# cfg4 0.05925f
C331 cfg2 a_n9593_2397# 0.10171f
C332 a_n9593_n2463# cfg0 0.02819f
C333 cfg3 a_9443_n4623# 0
C334 a_n9593_3117# cfg1 0.09184f
C335 cfg0 a_n977_3117# 0.02548f
C336 cfg4 a_827_2397# 0.02384f
C337 b1n a_827_5277# 0.02491f
C338 a_9193_6057# cfg4 0.00239f
C339 a_9393_5277# cfg0 0.02819f
C340 cfg2 a_n977_4557# 0.00138f
C341 a_n9593_n6123# a_n9593_n7303# 0.10722f
C342 a_4299_n4370# cfg3 0
C343 a_n9593_3117# vdd_q 0.001f
C344 cfg3 a_827_n4623# 0
C345 a_827_6057# cfg4 0.02934f
C346 cfg0 a_n1027_5277# 0.02384f
C347 a_n9593_3837# cfg2 0
C348 a_827_n5343# a_827_n4623# 0.05786f
C349 cfg1 cfg2 16.0176f
C350 cfg0 cfg3 1.30581f
C351 vbias_q cfg4 0.22408f
C352 cfg2 a_827_n3903# 0
C353 a_8793_n643# cfg3 0.77157f
C354 ctrl a_n977_n3183# 0.00554f
C355 cfg1 a_827_577# 0.4827f
C356 ctrl a_n9593_n6123# 0.00178f
C357 cfg2 vdd_q 0.39659f
C358 b3n a_n9593_n7303# 0.492f
C359 cfg0 a_827_n5343# 0
C360 b0n ctrl 0.04022f
C361 a_9443_3117# a_9193_1617# 0
C362 cfg1 a_9193_n6123# 0
C363 a_n1627_7237# cfg4 0.17723f
C364 a_827_5277# a_827_3837# 0
C365 a_n6951_n2210# b3p 0.64426f
C366 vdd_q a_9193_n6123# 0.00184f
C367 a_n9593_n1683# a_n9593_n2463# 0.10246f
C368 a_n1227_n6123# a_n1627_n7303# 0.10722f
C369 a_n1227_n6123# a_n1027_n5343# 0.10246f
C370 a_827_n2463# cfg2 0.10211f
C371 b1p a_3469_1610# 0.64426f
C372 a_8793_n7303# vdd_q 0.71129f
C373 a_n9593_5277# ctrl 0.00587f
C374 b3n ctrl 0.03938f
C375 cfg4 a_n9593_7237# 0.17702f
C376 a_n9593_6057# a_n9593_7237# 0.10722f
C377 a_n9593_n5343# a_n9593_n6123# 0.10246f
C378 a_9193_n1683# cfg2 0
C379 a_827_n1683# cfg1 0
C380 a_n9593_3837# a_n9593_2397# 0
C381 a_8793_577# a_9193_1617# 0.14662f
C382 cfg1 a_9393_2397# 0.00112f
C383 cfg3 a_8793_7237# 0
C384 cfg0 a_n9593_n3903# 0.1209f
C385 cfg1 a_n9593_2397# 0.00112f
C386 a_9193_6057# a_9393_5277# 0.10246f
C387 cfg2 a_n977_3837# 0
C388 vdd_q a_9393_2397# 0.00115f
C389 ctrl a_827_n6123# 0.00178f
C390 a_n9593_n1683# cfg3 0.12841f
C391 b0p a_n1227_6057# 0.25835f
C392 vbias_q b2p 0
C393 vdd_q a_n9593_2397# 0.00115f
C394 cfg1 a_n977_4557# 0.09235f
C395 cfg2 a_9443_n4623# 0.00138f
C396 a_827_1617# a_3469_1610# 0.00444f
C397 cfg4 a_n9593_n6123# 0.00239f
C398 a_n9593_3117# cfg0 0.03011f
C399 b0n cfg4 0.0021f
C400 b3n a_n9593_n5343# 0.02491f
C401 b0n a_n9593_6057# 0.25835f
C402 cfg3 a_827_2397# 0.00275f
C403 ctrl a_n1027_n5343# 0.00587f
C404 a_9193_6057# cfg3 0.12404f
C405 a_827_n1683# a_827_n2463# 0.10246f
C406 a_n9593_3837# cfg1 0.0021f
C407 a_827_n6123# b2n 0.25835f
C408 a_n6121_3370# cfg2 0
C409 a_n1027_n2463# b3p 0.00185f
C410 a_n1227_n1683# ctrl 0.18563f
C411 cfg2 a_827_n4623# 0.00138f
C412 a_9193_n6123# a_9443_n4623# 0
C413 ctrl a_3469_1610# 0.08558f
C414 a_827_n7303# b2n 0.492f
C415 ctrl a_n977_n3903# 0.06575f
C416 a_827_6057# cfg3 0.12439f
C417 a_n9593_3837# vdd_q 0.001f
C418 cfg1 a_827_n3903# 0.0021f
C419 a_n9593_6057# a_n9593_5277# 0.10246f
C420 cfg2 a_n6951_1610# 0.00151f
C421 cfg1 vdd_q 0.24402f
C422 cfg0 cfg2 1.16547f
C423 vbias_q cfg3 0.35832f
C424 b3n cfg4 0.00996f
C425 a_n1627_577# a_n1027_2397# 0
C426 a_4299_3370# cfg2 0
C427 ctrl a_n9593_n3183# 0.00554f
C428 cfg0 a_827_577# 0.12964f
C429 cfg0 a_9193_n6123# 0.03129f
C430 cfg4 a_827_n6123# 0.02934f
C431 a_9443_n3903# a_9443_n3183# 0.06202f
C432 a_n1627_7237# cfg3 0
C433 a_827_n2463# cfg1 0.00104f
C434 a_827_n7303# cfg4 0.18984f
C435 a_n977_4557# a_n977_3837# 0.06202f
C436 cfg0 a_8793_n7303# 0.01404f
C437 a_827_5277# ctrl 0.00587f
C438 a_827_3117# a_827_3837# 0.06202f
C439 a_827_n2463# a_827_n3903# 0
C440 cfg4 a_n1627_n7303# 0.17723f
C441 cfg1 a_9193_n1683# 0
C442 cfg3 a_n9593_7237# 0
C443 a_n1227_n1683# cfg4 0.00687f
C444 cfg1 a_n977_3837# 0.0021f
C445 a_9193_n1683# vdd_q 0.00144f
C446 cfg0 a_9393_2397# 0.03445f
C447 cfg0 a_n9593_2397# 0.03445f
C448 cfg1 a_9443_n4623# 0.09184f
C449 a_n9593_n1683# cfg2 0
C450 a_n9593_n2463# b3n 0.00185f
C451 cfg3 a_n977_n3183# 0
C452 cfg0 a_n977_4557# 0.02548f
C453 a_n6121_3370# cfg1 0
C454 vdd_q a_9443_n4623# 0.001f
C455 cfg3 a_n9593_n6123# 0.12404f
C456 b0n cfg3 0
C457 b0p a_n1027_2397# 0.00185f
C458 cfg1 a_827_n4623# 0.09235f
C459 cfg2 a_827_2397# 0.10218f
C460 ctrl a_9393_n5343# 0.00587f
C461 a_9193_6057# cfg2 0
C462 a_827_n3903# a_827_n4623# 0.06202f
C463 a_n9593_3837# cfg0 0.1209f
C464 a_827_577# a_827_2397# 0
C465 a_n1627_577# a_n1227_1617# 0.14662f
C466 a_827_6057# cfg2 0
C467 a_827_5277# cfg4 0.02381f
C468 cfg1 a_n6951_1610# 0.00204f
C469 cfg1 cfg0 16.0085f
C470 ctrl a_9443_n3903# 0.06575f
C471 cfg0 a_827_n3903# 0.09235f
C472 cfg1 a_4299_3370# 0
C473 a_n9593_5277# cfg3 0.00275f
C474 a_827_4557# a_827_3837# 0.06202f
C475 vbias_q cfg2 0.35239f
C476 b3n cfg3 0.00128f
C477 cfg0 vdd_q 0.15313f
C478 a_9393_n2463# a_9443_n3903# 0
C479 a_8793_n643# vdd_q 0.00157f
C480 vbias_q a_827_577# 0.19707f
C481 ctrl a_9443_3117# 0.00554f
C482 a_827_3117# a_827_1617# 0
C483 cfg3 a_827_n6123# 0.12439f
C484 a_n1627_n643# cfg0 0.02434f
C485 a_827_n7303# cfg3 0
C486 a_827_n2463# cfg0 0
C487 a_n6951_n2210# ctrl 0.11436f
C488 cfg3 a_n1627_n7303# 0
C489 a_n1627_577# cfg4 0.17774f
C490 a_827_n6123# a_827_n5343# 0.10246f
C491 cfg3 a_n1027_n5343# 0.00275f
C492 cfg0 a_9193_n1683# 0.03129f
C493 a_n9593_n2463# a_n9593_n3183# 0.05786f
C494 b1p a_9193_1617# 0.00211f
C495 a_827_3117# ctrl 0.00554f
C496 b0p ctrl 0.04071f
C497 a_n9593_4557# ctrl 0.00554f
C498 a_n1227_n1683# cfg3 0.12876f
C499 a_n1227_n6123# b3p 0.25835f
C500 a_8793_n643# a_9193_n1683# 0.14662f
C501 cfg0 a_n977_3837# 0.1168f
C502 b1n a_827_7237# 0.492f
C503 a_827_n1683# vbias_q 0
C504 vdd_q a_8793_7237# 0.71129f
C505 b0p a_n1227_1617# 0.00211f
C506 a_n9593_n1683# cfg1 0
C507 cfg0 a_9443_n4623# 0.03011f
C508 a_n9593_n1683# vdd_q 0.00144f
C509 cfg1 a_827_2397# 0.00112f
C510 a_9193_6057# cfg1 0
C511 a_n6121_n4370# vbias_q 1.19183f
C512 a_n6121_3370# a_n6951_1610# 0.15268f
C513 cfg2 a_n977_n3183# 0.00138f
C514 a_n9593_n3183# cfg3 0
C515 cfg2 a_n9593_n6123# 0
C516 a_n6121_3370# cfg0 0.01406f
C517 cfg0 a_827_n4623# 0.00105f
C518 b0n cfg2 0
C519 cfg1 a_827_6057# 0
C520 a_9193_6057# vdd_q 0.00184f
C521 a_n1027_n2463# ctrl 0.01213f
C522 a_n6951_n2210# cfg4 0.02749f
C523 ctrl b3p 0.05003f
C524 a_827_5277# cfg3 0.00275f
C525 ctrl a_9193_1617# 0.00178f
C526 a_827_6057# vdd_q 0
C527 cfg0 a_n6951_1610# 0.05988f
C528 cfg1 vbias_q 0.12105f
C529 a_n1227_n6123# a_n977_n4623# 0
C530 ctrl a_n9593_1617# 0.00178f
C531 a_827_3117# cfg4 0.02443f
C532 b0p cfg4 0.0021f
C533 a_9393_n5343# b2p 0.02491f
C534 cfg0 a_4299_3370# 0.01406f
C535 a_8793_n643# cfg0 0.042f
C536 a_n9593_5277# cfg2 0.09933f
C537 a_n9593_4557# a_n9593_6057# 0
C538 b3n cfg2 0
C539 ctrl a_827_4557# 0.00554f
C540 a_8793_577# cfg4 0.17811f
C541 a_n1227_6057# ctrl 0.00178f
C542 a_n9593_n3183# a_n9593_n3903# 0.06202f
C543 cfg2 a_827_n6123# 0
C544 b1n a_827_1617# 0.00211f
C545 a_n1627_7237# vdd_q 0.70951f
C546 a_n1627_n643# vbias_q 0.19707f
C547 b0n a_n9593_2397# 0.00185f
C548 a_9443_3837# a_9443_3117# 0.06202f
C549 a_3469_n2210# ctrl 0.12595f
C550 a_n1627_577# cfg3 0
C551 cfg2 a_n1027_n5343# 0.09981f
C552 ctrl a_n977_n4623# 0.00554f
C553 cfg3 a_9393_n5343# 0.00275f
C554 b1n ctrl 0.04022f
C555 cfg0 a_8793_7237# 0.01404f
C556 a_n9593_n643# cfg4 0.6606f
C557 vdd_q a_n9593_7237# 0.71129f
C558 a_n1227_n1683# cfg2 0
C559 a_n1027_n2463# cfg4 0
C560 cfg4 b3p 0.00278f
C561 cfg2 a_3469_1610# 0.00151f
C562 cfg2 a_n977_n3903# 0
C563 cfg4 a_9193_1617# 0.003f
C564 a_n9593_n643# a_n9593_577# 0.20736f
C565 a_n9593_n1683# cfg0 0.03129f
C566 cfg4 a_n9593_1617# 0.003f
C567 a_3469_n2210# b2n 0.64426f
C568 cfg1 a_n977_n3183# 0.09235f
C569 cfg1 a_n9593_n6123# 0
C570 a_827_n643# ctrl 0.12964f
C571 a_n9593_577# a_n9593_1617# 0.14662f
C572 b0n cfg1 0
C573 cfg0 a_827_2397# 0.00629f
C574 cfg4 a_827_4557# 0.02443f
C575 a_9193_6057# cfg0 0.03129f
C576 a_n6121_n4370# b3n 0.00518f
C577 a_n9593_n3183# cfg2 0.00138f
C578 a_4299_n4370# vbias_q 1.19183f
C579 a_n6121_3370# vbias_q 1.19183f
C580 vdd_q a_n9593_n6123# 0.00184f
C581 a_n1227_6057# cfg4 0.00239f
C582 b0n vdd_q 0.13655f
C583 cfg3 a_9443_3117# 0
C584 a_n9593_3837# a_n9593_5277# 0
C585 ctrl a_827_3837# 0.06575f
C586 a_n6951_n2210# cfg3 0.00165f
C587 b0p a_n1027_5277# 0.02491f
C588 vbias_q a_n6951_1610# 0.62235f
C589 a_827_5277# cfg2 0.09981f
C590 cfg1 a_n9593_5277# 0.00104f
C591 a_3469_n2210# cfg4 0.01925f
C592 cfg0 vbias_q 0.28541f
C593 a_827_3117# cfg3 0
C594 ctrl a_n9593_n4623# 0.00554f
C595 b1n cfg4 0.0021f
C596 b0p cfg3 0
C597 vbias_q a_4299_3370# 1.19183f
C598 a_n9593_5277# vdd_q 0.00115f
C599 a_n9593_4557# cfg3 0
C600 b3n vdd_q 0.13655f
C601 a_n9593_n2463# a_n9593_n643# 0
C602 a_8793_577# cfg3 0
C603 cfg1 a_827_n6123# 0
C604 cfg0 a_n1627_7237# 0.01256f
C605 ctrl a_9443_n3183# 0.00554f
C606 a_9193_6057# a_8793_7237# 0.10722f
C607 a_827_n643# cfg4 0.68489f
C608 a_9393_n2463# a_9443_n3183# 0.05786f
C609 vdd_q a_827_n6123# 0
C610 cfg1 a_n1027_n5343# 0.00104f
C611 a_827_n7303# vdd_q 0.70951f
C612 ctrl a_n1027_2397# 0.00587f
C613 a_n9593_n5343# a_n9593_n4623# 0.05786f
C614 cfg0 a_n9593_7237# 0.01404f
C615 a_n1627_577# cfg2 0.76572f
C616 a_n1227_n1683# cfg1 0
C617 vdd_q a_n1627_n7303# 0.70951f
C618 cfg1 a_3469_1610# 0.00204f
C619 cfg1 a_n977_n3903# 0.0021f
C620 cfg2 a_9393_n5343# 0.09933f
C621 a_9443_4557# ctrl 0.00554f
C622 b1p ctrl 0.04071f
C623 a_n1027_2397# a_n1227_1617# 0.10246f
C624 a_n9593_n643# cfg3 0.77157f
C625 cfg4 a_827_3837# 0.02443f
C626 b0n a_n6121_3370# 0.00518f
C627 a_n1027_n2463# cfg3 0.00281f
C628 cfg3 b3p 0.00128f
C629 cfg3 a_9193_1617# 0.12646f
C630 ctrl a_n1227_n6123# 0.00178f
C631 a_9393_n5343# a_9193_n6123# 0.10246f
C632 cfg3 a_n9593_1617# 0.12646f
C633 a_3469_n2210# b2p 0.64426f
C634 cfg2 a_9443_n3903# 0
C635 cfg4 a_827_7237# 0.18984f
C636 cfg1 a_n9593_n3183# 0.09184f
C637 cfg0 a_n977_n3183# 0.02548f
C638 cfg0 a_n9593_n6123# 0.03129f
C639 b0n a_n6951_1610# 0.64426f
C640 b0n cfg0 0.01298f
C641 a_n1227_6057# a_n1027_5277# 0.10246f
C642 a_n1227_n1683# a_n1627_n643# 0.14662f
C643 cfg3 a_827_4557# 0
C644 a_n9593_n3183# vdd_q 0.001f
C645 ctrl a_827_1617# 0.00178f
C646 a_n1227_6057# cfg3 0.12439f
C647 cfg2 a_9443_3117# 0.00138f
C648 cfg1 a_827_5277# 0.00104f
C649 cfg4 a_n1027_2397# 0
C650 cfg0 a_n9593_5277# 0.02819f
C651 a_3469_n2210# cfg3 0.00165f
C652 a_827_n6123# a_827_n4623# 0
C653 cfg3 a_n977_n4623# 0
C654 a_827_3117# cfg2 0.00138f
C655 ctrl a_9393_n2463# 0.00587f
C656 b1n cfg3 0
C657 b1p cfg4 0.0021f
C658 b0p cfg2 0
C659 a_n9593_4557# cfg2 0.00138f
C660 ctrl a_n1227_1617# 0.00178f
C661 cfg4 a_n1227_n6123# 0.00239f
C662 a_8793_577# cfg2 0.7711f
C663 ctrl b2n 0.04953f
C664 cfg4 a_n9593_n7303# 0.17702f
C665 a_827_n643# cfg3 0.76625f
C666 cfg1 a_n1627_577# 0.48276f
C667 ctrl a_n9593_n5343# 0.00587f
C668 cfg0 a_n1627_n7303# 0.01256f
C669 cfg0 a_n1027_n5343# 0.02384f
C670 a_n9593_3117# a_n9593_1617# 0
C671 a_9443_3117# a_9393_2397# 0.05786f
C672 cfg1 a_9393_n5343# 0.00104f
C673 cfg4 a_827_1617# 0.02995f
C674 a_n1227_n1683# cfg0 0.02696f
C675 cfg0 a_3469_1610# 0.05988f
C676 cfg0 a_n977_n3903# 0.1168f
C677 vdd_q a_9393_n5343# 0.00115f
C678 a_4299_3370# a_3469_1610# 0.15268f
C679 a_n1027_n2463# cfg2 0.10211f
C680 cfg1 a_9443_n3903# 0.0021f
C681 cfg2 b3p 0
C682 cfg2 a_9193_1617# 0.00283f
C683 ctrl cfg4 2.13306f
C684 a_9443_4557# a_9443_3837# 0.06202f
C685 a_n9593_6057# ctrl 0.00178f
C686 cfg2 a_n9593_1617# 0.00283f
C687 a_n9593_n1683# b3n 0.00163f
C688 a_n6951_n2210# a_n6121_n4370# 0.15268f
C689 a_n1627_n643# a_n1627_577# 0.20592f
C690 cfg3 a_n9593_n4623# 0
C691 a_9393_n2463# cfg4 0.00499f
C692 vdd_q a_9443_n3903# 0.001f
C693 a_8793_577# a_9393_2397# 0
C694 a_n977_3117# a_n1027_2397# 0.05786f
C695 cfg3 a_827_7237# 0
C696 cfg0 a_n9593_n3183# 0.03011f
C697 cfg4 a_n1227_1617# 0.003f
C698 b2p vss 3.80825f
C699 b2n vss 3.80795f
C700 b3p vss 3.80795f
C701 b3n vss 3.80825f
C702 vbias_q vss 27.0447f
C703 cfg0 vss 23.001f
C704 cfg1 vss 19.7669f
C705 b1p vss 3.80979f
C706 b1n vss 3.80976f
C707 b0p vss 3.80976f
C708 b0n vss 3.80844f
C709 vdd_q vss 55.6824f
C710 cfg2 vss 23.1617f
C711 cfg3 vss 22.758f
C712 cfg4 vss 29.9942f
C713 ctrl vss 47.18483f
C714 a_8793_n7303# vss 2.27253f
C715 a_827_n7303# vss 2.27832f
C716 a_9193_n6123# vss 1.40184f
C717 a_9393_n5343# vss 0.99203f
C718 a_n1627_n7303# vss 2.27884f
C719 a_n9593_n7303# vss 2.27213f
C720 a_827_n6123# vss 1.41016f
C721 a_n1227_n6123# vss 1.41016f
C722 a_827_n5343# vss 0.99898f
C723 a_n1027_n5343# vss 0.99898f
C724 a_n9593_n6123# vss 1.40184f
C725 a_n9593_n5343# vss 0.99203f
C726 a_9443_n4623# vss 0.62042f
C727 a_9443_n3903# vss 0.46093f
C728 a_9443_n3183# vss 0.5662f
C729 a_827_n4623# vss 0.62701f
C730 a_n977_n4623# vss 0.62701f
C731 a_827_n3903# vss 0.46753f
C732 a_n977_n3903# vss 0.46752f
C733 a_827_n3183# vss 0.57279f
C734 a_n977_n3183# vss 0.57279f
C735 a_n9593_n4623# vss 0.62042f
C736 a_n9593_n3903# vss 0.46093f
C737 a_n9593_n3183# vss 0.5662f
C738 a_9393_n2463# vss 0.84294f
C739 a_9193_n1683# vss 1.06355f
C740 a_4299_n4370# vss 3.46211f
C741 a_3469_n2210# vss 2.57532f
C742 a_827_n2463# vss 0.84669f
C743 a_n1027_n2463# vss 0.84669f
C744 a_827_n1683# vss 1.05209f
C745 a_n1227_n1683# vss 1.05209f
C746 a_n6121_n4370# vss 3.46211f
C747 a_n6951_n2210# vss 2.57629f
C748 a_n9593_n2463# vss 0.84294f
C749 a_n9593_n1683# vss 1.06355f
C750 a_8793_n643# vss 1.84134f
C751 a_827_n643# vss 1.58314f
C752 a_n1627_n643# vss 1.58261f
C753 a_n9593_n643# vss 1.84299f
C754 a_8793_577# vss 1.83121f
C755 a_827_577# vss 1.58684f
C756 a_n1627_577# vss 1.58699f
C757 a_n9593_577# vss 1.82944f
C758 a_9193_1617# vss 1.04927f
C759 a_9393_2397# vss 0.84212f
C760 a_3469_1610# vss 2.57405f
C761 a_827_1617# vss 1.05311f
C762 a_n1227_1617# vss 1.05311f
C763 a_827_2397# vss 0.84669f
C764 a_n1027_2397# vss 0.84669f
C765 a_n6951_1610# vss 2.57405f
C766 a_n9593_1617# vss 1.04927f
C767 a_n9593_2397# vss 0.84212f
C768 a_9443_3117# vss 0.5662f
C769 a_9443_3837# vss 0.46093f
C770 a_9443_4557# vss 0.62042f
C771 a_4299_3370# vss 3.45235f
C772 a_827_3117# vss 0.57279f
C773 a_n977_3117# vss 0.57279f
C774 a_827_3837# vss 0.46753f
C775 a_n977_3837# vss 0.46752f
C776 a_827_4557# vss 0.62701f
C777 a_n977_4557# vss 0.62701f
C778 a_n6121_3370# vss 3.45235f
C779 a_n9593_3117# vss 0.5662f
C780 a_n9593_3837# vss 0.46093f
C781 a_n9593_4557# vss 0.62042f
C782 a_9393_5277# vss 0.99203f
C783 a_9193_6057# vss 1.40184f
C784 a_827_5277# vss 0.99898f
C785 a_n1027_5277# vss 0.99898f
C786 a_827_6057# vss 1.41016f
C787 a_n1227_6057# vss 1.41016f
C788 a_8793_7237# vss 2.27213f
C789 a_827_7237# vss 2.27872f
C790 a_n9593_5277# vss 0.99203f
C791 a_n9593_6057# vss 1.40184f
C792 a_n1627_7237# vss 2.27844f
C793 a_n9593_7237# vss 2.27253f
C794 a_n8760_3469.t10 vss 20.9635f
C795 a_n8760_3469.n0 vss 1.17854f
C796 a_n8760_3469.n1 vss 0.10608f
C797 a_n8760_3469.n2 vss 0.1518f
C798 a_n8760_3469.n3 vss 0.10608f
C799 a_n8760_3469.n4 vss 0.1518f
C800 a_n8760_3469.n5 vss 0.1518f
C801 a_n8760_3469.n6 vss 0.10608f
C802 a_n8760_3469.n7 vss 0.10608f
C803 a_n8760_3469.n8 vss 0.1518f
C804 a_n8760_3469.n9 vss 0.52956f
C805 a_n8760_3469.n10 vss 0.0475f
C806 a_n8760_3469.n11 vss 0.00642f
C807 a_n8760_3469.n13 vss 1.53995f
C808 a_n8760_3469.t3 vss 0.03374f
C809 a_n8760_3469.t2 vss 0.03374f
C810 a_n8760_3469.n14 vss 0.10804f
C811 a_n8760_3469.t5 vss 0.03374f
C812 a_n8760_3469.t4 vss 0.03374f
C813 a_n8760_3469.n15 vss 0.1073f
C814 a_n8760_3469.t0 vss 0.89087f
C815 a_n8760_3469.n16 vss 0.00667f
C816 a_n8760_3469.t18 vss 0.04889f
C817 a_n8760_3469.t17 vss 0.04889f
C818 a_n8760_3469.t16 vss 0.04889f
C819 a_n8760_3469.t15 vss 0.04889f
C820 a_n8760_3469.n17 vss 0.02924f
C821 a_n8760_3469.n18 vss 0.00912f
C822 a_n8760_3469.n19 vss 0.00667f
C823 a_n8760_3469.n20 vss 0.02897f
C824 a_n8760_3469.n21 vss 0.02897f
C825 a_n8760_3469.n22 vss 0.02897f
C826 a_n8760_3469.t19 vss 0.04889f
C827 a_n8760_3469.n23 vss 0.02897f
C828 a_n8760_3469.t20 vss 0.04889f
C829 a_n8760_3469.n24 vss 0.02897f
C830 a_n8760_3469.n25 vss 0.00667f
C831 a_n8760_3469.t22 vss 0.04889f
C832 a_n8760_3469.t21 vss 0.04889f
C833 a_n8760_3469.n26 vss 0.02897f
C834 a_n8760_3469.n27 vss 0.02924f
C835 a_n8760_3469.n28 vss 0.00912f
C836 a_n8760_3469.n29 vss 0.00667f
C837 a_n8760_3469.n30 vss 0.00667f
C838 a_n8760_3469.n31 vss 0.00667f
C839 a_n8760_3469.t11 vss 0.03049f
C840 a_n8760_3469.n32 vss 0.02309f
C841 a_n8760_3469.t12 vss 0.03049f
C842 a_n8760_3469.n33 vss 0.02283f
C843 a_n8760_3469.t13 vss 0.03049f
C844 a_n8760_3469.n34 vss 0.02283f
C845 a_n8760_3469.t14 vss 0.03049f
C846 a_n8760_3469.n35 vss 0.02311f
C847 a_n8760_3469.n36 vss 0.00947f
C848 a_n8760_3469.n37 vss 0.00667f
C849 a_n8760_3469.n38 vss 0.00667f
C850 a_n8760_3469.n39 vss 1.46292f
C851 a_n8760_3469.t26 vss 0.16789f
C852 a_n8760_3469.n40 vss 0.01649f
C853 a_n8760_3469.t25 vss 0.16789f
C854 a_n8760_3469.t24 vss 0.16789f
C855 a_n8760_3469.n41 vss 0.07933f
C856 a_n8760_3469.n42 vss 0.07933f
C857 a_n8760_3469.t23 vss 0.16789f
C858 a_n8760_3469.n43 vss 0.01649f
C859 a_n8760_3469.n44 vss 0.10831f
C860 a_n8760_3469.n45 vss 0.07933f
C861 a_n8760_3469.n46 vss 0.07933f
C862 a_n8760_3469.n47 vss 0.10321f
C863 a_n8760_3469.t1 vss 0.98784f
C864 a_n8760_3469.n48 vss 0.77327f
C865 a_n8760_3469.t7 vss 0.03374f
C866 a_n8760_3469.t6 vss 0.03374f
C867 a_n8760_3469.n49 vss 0.1073f
C868 a_n8760_3469.t8 vss 0.14178f
C869 a_n8760_3469.t9 vss 0.03374f
C870 a_n5033_3370.n0 vss 6.44983f
C871 a_n5033_3370.n1 vss 1.0738f
C872 a_n5033_3370.n2 vss 0.1012f
C873 a_n5033_3370.n3 vss 0.14481f
C874 a_n5033_3370.n4 vss 0.1012f
C875 a_n5033_3370.n5 vss 0.14481f
C876 a_n5033_3370.n6 vss 0.14481f
C877 a_n5033_3370.n7 vss 0.1012f
C878 a_n5033_3370.n8 vss 0.1012f
C879 a_n5033_3370.n9 vss 0.14481f
C880 a_n5033_3370.n10 vss 0.50517f
C881 a_n5033_3370.t10 vss 15.017f
C882 a_n5033_3370.n11 vss 0.04531f
C883 a_n5033_3370.n12 vss 0.00612f
C884 a_n5033_3370.t3 vss 0.03219f
C885 a_n5033_3370.t2 vss 0.03219f
C886 a_n5033_3370.n14 vss 0.10307f
C887 a_n5033_3370.t5 vss 0.03219f
C888 a_n5033_3370.t4 vss 0.03219f
C889 a_n5033_3370.n15 vss 0.10236f
C890 a_n5033_3370.t0 vss 0.84984f
C891 a_n5033_3370.n16 vss 0.00637f
C892 a_n5033_3370.t18 vss 0.04664f
C893 a_n5033_3370.t17 vss 0.04664f
C894 a_n5033_3370.t16 vss 0.04664f
C895 a_n5033_3370.t15 vss 0.04664f
C896 a_n5033_3370.n17 vss 0.0279f
C897 a_n5033_3370.n18 vss 0.0087f
C898 a_n5033_3370.n19 vss 0.00637f
C899 a_n5033_3370.n20 vss 0.02763f
C900 a_n5033_3370.n21 vss 0.02763f
C901 a_n5033_3370.n22 vss 0.02763f
C902 a_n5033_3370.t19 vss 0.04664f
C903 a_n5033_3370.n23 vss 0.02763f
C904 a_n5033_3370.t20 vss 0.04664f
C905 a_n5033_3370.n24 vss 0.02763f
C906 a_n5033_3370.n25 vss 0.00637f
C907 a_n5033_3370.t22 vss 0.04664f
C908 a_n5033_3370.t21 vss 0.04664f
C909 a_n5033_3370.n26 vss 0.02763f
C910 a_n5033_3370.n27 vss 0.0279f
C911 a_n5033_3370.n28 vss 0.0087f
C912 a_n5033_3370.n29 vss 0.00637f
C913 a_n5033_3370.n30 vss 0.00637f
C914 a_n5033_3370.n31 vss 0.00637f
C915 a_n5033_3370.n32 vss 0.00637f
C916 a_n5033_3370.t14 vss 0.02908f
C917 a_n5033_3370.t13 vss 0.02908f
C918 a_n5033_3370.t12 vss 0.02908f
C919 a_n5033_3370.t11 vss 0.02908f
C920 a_n5033_3370.n33 vss 0.02204f
C921 a_n5033_3370.n34 vss 0.00903f
C922 a_n5033_3370.n35 vss 0.00637f
C923 a_n5033_3370.n36 vss 0.02178f
C924 a_n5033_3370.n37 vss 0.02178f
C925 a_n5033_3370.n38 vss 0.02203f
C926 a_n5033_3370.n39 vss 1.34025f
C927 a_n5033_3370.t26 vss 0.16015f
C928 a_n5033_3370.n40 vss 0.01573f
C929 a_n5033_3370.t25 vss 0.16015f
C930 a_n5033_3370.t24 vss 0.16015f
C931 a_n5033_3370.n41 vss 0.07568f
C932 a_n5033_3370.n42 vss 0.07568f
C933 a_n5033_3370.t23 vss 0.16015f
C934 a_n5033_3370.n43 vss 0.01573f
C935 a_n5033_3370.n44 vss 0.10332f
C936 a_n5033_3370.n45 vss 0.07568f
C937 a_n5033_3370.n46 vss 0.07568f
C938 a_n5033_3370.n47 vss 0.09845f
C939 a_n5033_3370.t1 vss 0.94234f
C940 a_n5033_3370.n48 vss 0.73764f
C941 a_n5033_3370.t7 vss 0.03219f
C942 a_n5033_3370.t6 vss 0.03219f
C943 a_n5033_3370.n49 vss 0.10236f
C944 a_n5033_3370.t8 vss 0.13525f
C945 a_n5033_3370.t9 vss 0.03219f
C946 a_1660_3469.t10 vss 18.5176f
C947 a_1660_3469.n0 vss 0.56772f
C948 a_1660_3469.n1 vss 0.0937f
C949 a_1660_3469.n2 vss 0.13409f
C950 a_1660_3469.n3 vss 0.0937f
C951 a_1660_3469.n4 vss 0.13409f
C952 a_1660_3469.n5 vss 0.13409f
C953 a_1660_3469.n6 vss 0.0937f
C954 a_1660_3469.n7 vss 0.0937f
C955 a_1660_3469.n8 vss 0.13409f
C956 a_1660_3469.n9 vss 0.46778f
C957 a_1660_3469.n10 vss 0.04196f
C958 a_1660_3469.n11 vss 0.00567f
C959 a_1660_3469.n13 vss 1.36028f
C960 a_1660_3469.t7 vss 0.0298f
C961 a_1660_3469.t5 vss 0.0298f
C962 a_1660_3469.n14 vss 0.09544f
C963 a_1660_3469.t6 vss 0.0298f
C964 a_1660_3469.t1 vss 0.0298f
C965 a_1660_3469.n15 vss 0.09478f
C966 a_1660_3469.t2 vss 0.78694f
C967 a_1660_3469.n16 vss 0.0059f
C968 a_1660_3469.t14 vss 0.04319f
C969 a_1660_3469.t13 vss 0.04319f
C970 a_1660_3469.t12 vss 0.04319f
C971 a_1660_3469.t11 vss 0.04319f
C972 a_1660_3469.n17 vss 0.02583f
C973 a_1660_3469.n18 vss 0.00806f
C974 a_1660_3469.n19 vss 0.0059f
C975 a_1660_3469.n20 vss 0.02559f
C976 a_1660_3469.n21 vss 0.02559f
C977 a_1660_3469.n22 vss 0.02559f
C978 a_1660_3469.t15 vss 0.04319f
C979 a_1660_3469.n23 vss 0.02559f
C980 a_1660_3469.t16 vss 0.04319f
C981 a_1660_3469.n24 vss 0.02559f
C982 a_1660_3469.n25 vss 0.0059f
C983 a_1660_3469.t18 vss 0.04319f
C984 a_1660_3469.t17 vss 0.04319f
C985 a_1660_3469.n26 vss 0.02559f
C986 a_1660_3469.n27 vss 0.02583f
C987 a_1660_3469.n28 vss 0.00806f
C988 a_1660_3469.n29 vss 0.0059f
C989 a_1660_3469.n30 vss 0.0059f
C990 a_1660_3469.n31 vss 0.0059f
C991 a_1660_3469.t19 vss 0.02693f
C992 a_1660_3469.n32 vss 0.0204f
C993 a_1660_3469.t20 vss 0.02693f
C994 a_1660_3469.n33 vss 0.02017f
C995 a_1660_3469.t21 vss 0.02693f
C996 a_1660_3469.n34 vss 0.02017f
C997 a_1660_3469.t22 vss 0.02693f
C998 a_1660_3469.n35 vss 0.02041f
C999 a_1660_3469.n36 vss 0.00836f
C1000 a_1660_3469.n37 vss 0.0059f
C1001 a_1660_3469.n38 vss 0.0059f
C1002 a_1660_3469.n39 vss 0.73827f
C1003 a_1660_3469.t26 vss 0.1483f
C1004 a_1660_3469.n40 vss 0.01457f
C1005 a_1660_3469.t25 vss 0.1483f
C1006 a_1660_3469.t24 vss 0.1483f
C1007 a_1660_3469.n41 vss 0.07008f
C1008 a_1660_3469.n42 vss 0.07008f
C1009 a_1660_3469.t23 vss 0.1483f
C1010 a_1660_3469.n43 vss 0.01457f
C1011 a_1660_3469.n44 vss 0.09567f
C1012 a_1660_3469.n45 vss 0.07008f
C1013 a_1660_3469.n46 vss 0.07008f
C1014 a_1660_3469.n47 vss 0.09117f
C1015 a_1660_3469.t3 vss 0.87259f
C1016 a_1660_3469.n48 vss 0.68305f
C1017 a_1660_3469.t4 vss 0.0298f
C1018 a_1660_3469.t9 vss 0.0298f
C1019 a_1660_3469.n49 vss 0.09478f
C1020 a_1660_3469.t8 vss 0.12524f
C1021 a_1660_3469.t0 vss 0.0298f
C1022 a_5324_n3348.n0 vss 5.96765f
C1023 a_5324_n3348.n1 vss 0.55421f
C1024 a_5324_n3348.n2 vss 0.09363f
C1025 a_5324_n3348.n3 vss 0.13398f
C1026 a_5324_n3348.n4 vss 0.09363f
C1027 a_5324_n3348.n5 vss 0.13398f
C1028 a_5324_n3348.n6 vss 0.13398f
C1029 a_5324_n3348.n7 vss 0.09363f
C1030 a_5324_n3348.n8 vss 0.09363f
C1031 a_5324_n3348.n9 vss 0.13398f
C1032 a_5324_n3348.n10 vss 0.4674f
C1033 a_5324_n3348.t10 vss 13.8943f
C1034 a_5324_n3348.n11 vss 0.04192f
C1035 a_5324_n3348.n12 vss 0.00566f
C1036 a_5324_n3348.t6 vss 0.02978f
C1037 a_5324_n3348.t5 vss 0.02978f
C1038 a_5324_n3348.n14 vss 0.09536f
C1039 a_5324_n3348.t4 vss 0.02978f
C1040 a_5324_n3348.t3 vss 0.02978f
C1041 a_5324_n3348.n15 vss 0.09536f
C1042 a_5324_n3348.t1 vss 0.02978f
C1043 a_5324_n3348.t9 vss 0.02978f
C1044 a_5324_n3348.n16 vss 0.09471f
C1045 a_5324_n3348.t8 vss 0.7863f
C1046 a_5324_n3348.n17 vss 0.00589f
C1047 a_5324_n3348.t14 vss 0.04315f
C1048 a_5324_n3348.t13 vss 0.04315f
C1049 a_5324_n3348.t12 vss 0.04315f
C1050 a_5324_n3348.t11 vss 0.04315f
C1051 a_5324_n3348.n18 vss 0.02581f
C1052 a_5324_n3348.n19 vss 0.00805f
C1053 a_5324_n3348.n20 vss 0.00589f
C1054 a_5324_n3348.n21 vss 0.02557f
C1055 a_5324_n3348.n22 vss 0.02557f
C1056 a_5324_n3348.n23 vss 0.02557f
C1057 a_5324_n3348.t15 vss 0.04315f
C1058 a_5324_n3348.n24 vss 0.02557f
C1059 a_5324_n3348.t16 vss 0.04315f
C1060 a_5324_n3348.n25 vss 0.02557f
C1061 a_5324_n3348.n26 vss 0.00589f
C1062 a_5324_n3348.t18 vss 0.04315f
C1063 a_5324_n3348.t17 vss 0.04315f
C1064 a_5324_n3348.n27 vss 0.02557f
C1065 a_5324_n3348.n28 vss 0.02581f
C1066 a_5324_n3348.n29 vss 0.00805f
C1067 a_5324_n3348.n30 vss 0.00589f
C1068 a_5324_n3348.n31 vss 0.00589f
C1069 a_5324_n3348.n32 vss 0.00589f
C1070 a_5324_n3348.n33 vss 0.00589f
C1071 a_5324_n3348.t22 vss 0.02691f
C1072 a_5324_n3348.t21 vss 0.02691f
C1073 a_5324_n3348.t20 vss 0.02691f
C1074 a_5324_n3348.t19 vss 0.02691f
C1075 a_5324_n3348.n34 vss 0.0204f
C1076 a_5324_n3348.n35 vss 0.00836f
C1077 a_5324_n3348.n36 vss 0.00589f
C1078 a_5324_n3348.n37 vss 0.02015f
C1079 a_5324_n3348.n38 vss 0.02015f
C1080 a_5324_n3348.n39 vss 0.02038f
C1081 a_5324_n3348.n40 vss 0.75074f
C1082 a_5324_n3348.t26 vss 0.14818f
C1083 a_5324_n3348.n41 vss 0.01455f
C1084 a_5324_n3348.t25 vss 0.14818f
C1085 a_5324_n3348.t24 vss 0.14818f
C1086 a_5324_n3348.n42 vss 0.07002f
C1087 a_5324_n3348.n43 vss 0.07002f
C1088 a_5324_n3348.t23 vss 0.14818f
C1089 a_5324_n3348.n44 vss 0.01455f
C1090 a_5324_n3348.n45 vss 0.09559f
C1091 a_5324_n3348.n46 vss 0.07002f
C1092 a_5324_n3348.n47 vss 0.07002f
C1093 a_5324_n3348.n48 vss 0.09109f
C1094 a_5324_n3348.t7 vss 0.87189f
C1095 a_5324_n3348.n49 vss 0.6825f
C1096 a_5324_n3348.t2 vss 0.12449f
C1097 a_5324_n3348.t0 vss 0.02978f
C1098 a_n6092_3282.n0 vss 6.06184f
C1099 a_n6092_3282.n1 vss 0.65444f
C1100 a_n6092_3282.n2 vss 0.09514f
C1101 a_n6092_3282.n3 vss 0.09514f
C1102 a_n6092_3282.n4 vss 0.13615f
C1103 a_n6092_3282.n5 vss 0.13615f
C1104 a_n6092_3282.n6 vss 0.09514f
C1105 a_n6092_3282.n7 vss 0.13615f
C1106 a_n6092_3282.n8 vss 0.09714f
C1107 a_n6092_3282.n9 vss 0.09514f
C1108 a_n6092_3282.n10 vss 0.13615f
C1109 a_n6092_3282.n11 vss 0.47495f
C1110 a_n6092_3282.t10 vss 14.1187f
C1111 a_n6092_3282.n12 vss 0.04252f
C1112 a_n6092_3282.n13 vss 0.00575f
C1113 a_n6092_3282.t3 vss 0.03026f
C1114 a_n6092_3282.t2 vss 0.03026f
C1115 a_n6092_3282.n15 vss 0.0969f
C1116 a_n6092_3282.t5 vss 0.03026f
C1117 a_n6092_3282.t4 vss 0.03026f
C1118 a_n6092_3282.n16 vss 0.09624f
C1119 a_n6092_3282.t1 vss 0.79887f
C1120 a_n6092_3282.n17 vss 0.00599f
C1121 a_n6092_3282.t22 vss 0.04385f
C1122 a_n6092_3282.t21 vss 0.04385f
C1123 a_n6092_3282.t20 vss 0.04385f
C1124 a_n6092_3282.t19 vss 0.04385f
C1125 a_n6092_3282.n18 vss 0.02623f
C1126 a_n6092_3282.n19 vss 0.00818f
C1127 a_n6092_3282.n20 vss 0.00599f
C1128 a_n6092_3282.n21 vss 0.02598f
C1129 a_n6092_3282.n22 vss 0.02598f
C1130 a_n6092_3282.n23 vss 0.02598f
C1131 a_n6092_3282.t23 vss 0.04385f
C1132 a_n6092_3282.n24 vss 0.02598f
C1133 a_n6092_3282.t24 vss 0.04385f
C1134 a_n6092_3282.n25 vss 0.02598f
C1135 a_n6092_3282.n26 vss 0.00599f
C1136 a_n6092_3282.t26 vss 0.04385f
C1137 a_n6092_3282.t25 vss 0.04385f
C1138 a_n6092_3282.n27 vss 0.02598f
C1139 a_n6092_3282.n28 vss 0.02623f
C1140 a_n6092_3282.n29 vss 0.00818f
C1141 a_n6092_3282.n30 vss 0.00599f
C1142 a_n6092_3282.n31 vss 0.00599f
C1143 a_n6092_3282.n32 vss 0.00599f
C1144 a_n6092_3282.n33 vss 0.00599f
C1145 a_n6092_3282.t18 vss 0.02734f
C1146 a_n6092_3282.t17 vss 0.02734f
C1147 a_n6092_3282.t16 vss 0.02734f
C1148 a_n6092_3282.t15 vss 0.02734f
C1149 a_n6092_3282.n34 vss 0.02073f
C1150 a_n6092_3282.n35 vss 0.00849f
C1151 a_n6092_3282.n36 vss 0.00599f
C1152 a_n6092_3282.n37 vss 0.02048f
C1153 a_n6092_3282.n38 vss 0.02048f
C1154 a_n6092_3282.n39 vss 0.02071f
C1155 a_n6092_3282.n40 vss 0.84097f
C1156 a_n6092_3282.n41 vss 0.07115f
C1157 a_n6092_3282.n42 vss 0.07115f
C1158 a_n6092_3282.t12 vss 0.15057f
C1159 a_n6092_3282.t13 vss 0.15057f
C1160 a_n6092_3282.n43 vss 0.07115f
C1161 a_n6092_3282.t14 vss 0.15057f
C1162 a_n6092_3282.n44 vss 0.01479f
C1163 a_n6092_3282.n45 vss 0.07115f
C1164 a_n6092_3282.t11 vss 0.15057f
C1165 a_n6092_3282.n46 vss 0.01479f
C1166 a_n6092_3282.n47 vss 0.09256f
C1167 a_n6092_3282.t0 vss 0.88578f
C1168 a_n6092_3282.n48 vss 0.696f
C1169 a_n6092_3282.t7 vss 0.03026f
C1170 a_n6092_3282.t6 vss 0.03026f
C1171 a_n6092_3282.n49 vss 0.09624f
C1172 a_n6092_3282.t8 vss 0.12716f
C1173 a_n6092_3282.t9 vss 0.03026f
C1174 a_n8760_n4271.t10 vss 18.8305f
C1175 a_n8760_n4271.n0 vss 0.64323f
C1176 a_n8760_n4271.n1 vss 0.09529f
C1177 a_n8760_n4271.n2 vss 0.09529f
C1178 a_n8760_n4271.n3 vss 0.13635f
C1179 a_n8760_n4271.n4 vss 0.13635f
C1180 a_n8760_n4271.n5 vss 0.09529f
C1181 a_n8760_n4271.n6 vss 0.13635f
C1182 a_n8760_n4271.n7 vss 0.09729f
C1183 a_n8760_n4271.n8 vss 0.09529f
C1184 a_n8760_n4271.n9 vss 0.13635f
C1185 a_n8760_n4271.n10 vss 0.47568f
C1186 a_n8760_n4271.n11 vss 0.04259f
C1187 a_n8760_n4271.n12 vss 0.00576f
C1188 a_n8760_n4271.n14 vss 1.3811f
C1189 a_n8760_n4271.t3 vss 0.03031f
C1190 a_n8760_n4271.t2 vss 0.03031f
C1191 a_n8760_n4271.n15 vss 0.09705f
C1192 a_n8760_n4271.t5 vss 0.03031f
C1193 a_n8760_n4271.t4 vss 0.03031f
C1194 a_n8760_n4271.n16 vss 0.09639f
C1195 a_n8760_n4271.t0 vss 0.8001f
C1196 a_n8760_n4271.n17 vss 0.006f
C1197 a_n8760_n4271.t22 vss 0.04392f
C1198 a_n8760_n4271.t21 vss 0.04392f
C1199 a_n8760_n4271.t20 vss 0.04392f
C1200 a_n8760_n4271.t19 vss 0.04392f
C1201 a_n8760_n4271.n18 vss 0.02627f
C1202 a_n8760_n4271.n19 vss 0.00819f
C1203 a_n8760_n4271.n20 vss 0.006f
C1204 a_n8760_n4271.n21 vss 0.02602f
C1205 a_n8760_n4271.n22 vss 0.02602f
C1206 a_n8760_n4271.n23 vss 0.02602f
C1207 a_n8760_n4271.t23 vss 0.04392f
C1208 a_n8760_n4271.n24 vss 0.02602f
C1209 a_n8760_n4271.t24 vss 0.04392f
C1210 a_n8760_n4271.n25 vss 0.02602f
C1211 a_n8760_n4271.n26 vss 0.006f
C1212 a_n8760_n4271.t26 vss 0.04392f
C1213 a_n8760_n4271.t25 vss 0.04392f
C1214 a_n8760_n4271.n27 vss 0.02602f
C1215 a_n8760_n4271.n28 vss 0.02627f
C1216 a_n8760_n4271.n29 vss 0.00819f
C1217 a_n8760_n4271.n30 vss 0.006f
C1218 a_n8760_n4271.n31 vss 0.006f
C1219 a_n8760_n4271.n32 vss 0.006f
C1220 a_n8760_n4271.t15 vss 0.02739f
C1221 a_n8760_n4271.n33 vss 0.02074f
C1222 a_n8760_n4271.t16 vss 0.02739f
C1223 a_n8760_n4271.n34 vss 0.02051f
C1224 a_n8760_n4271.t17 vss 0.02739f
C1225 a_n8760_n4271.n35 vss 0.02051f
C1226 a_n8760_n4271.t18 vss 0.02739f
C1227 a_n8760_n4271.n36 vss 0.02076f
C1228 a_n8760_n4271.n37 vss 0.00851f
C1229 a_n8760_n4271.n38 vss 0.006f
C1230 a_n8760_n4271.n39 vss 0.006f
C1231 a_n8760_n4271.n40 vss 0.85448f
C1232 a_n8760_n4271.n41 vss 0.07126f
C1233 a_n8760_n4271.n42 vss 0.07126f
C1234 a_n8760_n4271.t12 vss 0.1508f
C1235 a_n8760_n4271.t13 vss 0.1508f
C1236 a_n8760_n4271.n43 vss 0.07126f
C1237 a_n8760_n4271.t14 vss 0.1508f
C1238 a_n8760_n4271.n44 vss 0.01481f
C1239 a_n8760_n4271.n45 vss 0.07126f
C1240 a_n8760_n4271.t11 vss 0.1508f
C1241 a_n8760_n4271.n46 vss 0.01481f
C1242 a_n8760_n4271.n47 vss 0.09271f
C1243 a_n8760_n4271.t1 vss 0.88714f
C1244 a_n8760_n4271.n48 vss 0.69707f
C1245 a_n8760_n4271.t7 vss 0.03031f
C1246 a_n8760_n4271.t6 vss 0.03031f
C1247 a_n8760_n4271.n49 vss 0.09639f
C1248 a_n8760_n4271.t8 vss 0.12736f
C1249 a_n8760_n4271.t9 vss 0.03031f
C1250 a_n6092_n3348.t10 vss 19.882f
C1251 a_n6092_n3348.n0 vss 1.06474f
C1252 a_n6092_n3348.n1 vss 0.10061f
C1253 a_n6092_n3348.n2 vss 0.10061f
C1254 a_n6092_n3348.n3 vss 0.14397f
C1255 a_n6092_n3348.n4 vss 0.14397f
C1256 a_n6092_n3348.n5 vss 0.10061f
C1257 a_n6092_n3348.n6 vss 0.14397f
C1258 a_n6092_n3348.n7 vss 0.10272f
C1259 a_n6092_n3348.n8 vss 0.10061f
C1260 a_n6092_n3348.n9 vss 0.14397f
C1261 a_n6092_n3348.n10 vss 0.50224f
C1262 a_n6092_n3348.n11 vss 0.04496f
C1263 a_n6092_n3348.n12 vss 0.00608f
C1264 a_n6092_n3348.n14 vss 1.45822f
C1265 a_n6092_n3348.t1 vss 0.032f
C1266 a_n6092_n3348.t4 vss 0.032f
C1267 a_n6092_n3348.n15 vss 0.10247f
C1268 a_n6092_n3348.t2 vss 0.032f
C1269 a_n6092_n3348.t5 vss 0.032f
C1270 a_n6092_n3348.n16 vss 0.10177f
C1271 a_n6092_n3348.t7 vss 0.84478f
C1272 a_n6092_n3348.n17 vss 0.00633f
C1273 a_n6092_n3348.t18 vss 0.04637f
C1274 a_n6092_n3348.t17 vss 0.04637f
C1275 a_n6092_n3348.t16 vss 0.04637f
C1276 a_n6092_n3348.t15 vss 0.04637f
C1277 a_n6092_n3348.n18 vss 0.02773f
C1278 a_n6092_n3348.n19 vss 0.00865f
C1279 a_n6092_n3348.n20 vss 0.00633f
C1280 a_n6092_n3348.n21 vss 0.02747f
C1281 a_n6092_n3348.n22 vss 0.02747f
C1282 a_n6092_n3348.n23 vss 0.02747f
C1283 a_n6092_n3348.t19 vss 0.04637f
C1284 a_n6092_n3348.n24 vss 0.02747f
C1285 a_n6092_n3348.t20 vss 0.04637f
C1286 a_n6092_n3348.n25 vss 0.02747f
C1287 a_n6092_n3348.n26 vss 0.00633f
C1288 a_n6092_n3348.t22 vss 0.04637f
C1289 a_n6092_n3348.t21 vss 0.04637f
C1290 a_n6092_n3348.n27 vss 0.02747f
C1291 a_n6092_n3348.n28 vss 0.02773f
C1292 a_n6092_n3348.n29 vss 0.00865f
C1293 a_n6092_n3348.n30 vss 0.00633f
C1294 a_n6092_n3348.n31 vss 0.00633f
C1295 a_n6092_n3348.n32 vss 0.00633f
C1296 a_n6092_n3348.t23 vss 0.02892f
C1297 a_n6092_n3348.n33 vss 0.0219f
C1298 a_n6092_n3348.t24 vss 0.02892f
C1299 a_n6092_n3348.n34 vss 0.02165f
C1300 a_n6092_n3348.t25 vss 0.02892f
C1301 a_n6092_n3348.n35 vss 0.02165f
C1302 a_n6092_n3348.t26 vss 0.02892f
C1303 a_n6092_n3348.n36 vss 0.02192f
C1304 a_n6092_n3348.n37 vss 0.00898f
C1305 a_n6092_n3348.n38 vss 0.00633f
C1306 a_n6092_n3348.n39 vss 0.00633f
C1307 a_n6092_n3348.n40 vss 1.33417f
C1308 a_n6092_n3348.n41 vss 0.07524f
C1309 a_n6092_n3348.n42 vss 0.07524f
C1310 a_n6092_n3348.t12 vss 0.15923f
C1311 a_n6092_n3348.t13 vss 0.15923f
C1312 a_n6092_n3348.n43 vss 0.07524f
C1313 a_n6092_n3348.t14 vss 0.15923f
C1314 a_n6092_n3348.n44 vss 0.01564f
C1315 a_n6092_n3348.n45 vss 0.07524f
C1316 a_n6092_n3348.t11 vss 0.15923f
C1317 a_n6092_n3348.n46 vss 0.01564f
C1318 a_n6092_n3348.n47 vss 0.09788f
C1319 a_n6092_n3348.t9 vss 0.93668f
C1320 a_n6092_n3348.n48 vss 0.73599f
C1321 a_n6092_n3348.t8 vss 0.032f
C1322 a_n6092_n3348.t3 vss 0.032f
C1323 a_n6092_n3348.n49 vss 0.10177f
C1324 a_n6092_n3348.t6 vss 0.13447f
C1325 a_n6092_n3348.t0 vss 0.032f
C1326 a_n5096_n3348.n0 vss 6.67741f
C1327 a_n5096_n3348.n1 vss 1.16131f
C1328 a_n5096_n3348.n2 vss 0.1048f
C1329 a_n5096_n3348.n3 vss 0.1048f
C1330 a_n5096_n3348.n4 vss 0.14997f
C1331 a_n5096_n3348.n5 vss 0.14997f
C1332 a_n5096_n3348.n6 vss 0.1048f
C1333 a_n5096_n3348.n7 vss 0.14997f
C1334 a_n5096_n3348.n8 vss 0.107f
C1335 a_n5096_n3348.n9 vss 0.1048f
C1336 a_n5096_n3348.n10 vss 0.14997f
C1337 a_n5096_n3348.n11 vss 0.52318f
C1338 a_n5096_n3348.t10 vss 15.5524f
C1339 a_n5096_n3348.n12 vss 0.04684f
C1340 a_n5096_n3348.n13 vss 0.00634f
C1341 a_n5096_n3348.t8 vss 0.03333f
C1342 a_n5096_n3348.t1 vss 0.03333f
C1343 a_n5096_n3348.n15 vss 0.10674f
C1344 a_n5096_n3348.t2 vss 0.03333f
C1345 a_n5096_n3348.t9 vss 0.03333f
C1346 a_n5096_n3348.n16 vss 0.10674f
C1347 a_n5096_n3348.t3 vss 0.03333f
C1348 a_n5096_n3348.t4 vss 0.03333f
C1349 a_n5096_n3348.n17 vss 0.10601f
C1350 a_n5096_n3348.t5 vss 0.88f
C1351 a_n5096_n3348.n18 vss 0.00659f
C1352 a_n5096_n3348.t18 vss 0.0483f
C1353 a_n5096_n3348.t17 vss 0.0483f
C1354 a_n5096_n3348.t16 vss 0.0483f
C1355 a_n5096_n3348.t15 vss 0.0483f
C1356 a_n5096_n3348.n19 vss 0.02889f
C1357 a_n5096_n3348.n20 vss 0.00901f
C1358 a_n5096_n3348.n21 vss 0.00659f
C1359 a_n5096_n3348.n22 vss 0.02862f
C1360 a_n5096_n3348.n23 vss 0.02862f
C1361 a_n5096_n3348.n24 vss 0.02862f
C1362 a_n5096_n3348.t19 vss 0.0483f
C1363 a_n5096_n3348.n25 vss 0.02862f
C1364 a_n5096_n3348.t20 vss 0.0483f
C1365 a_n5096_n3348.n26 vss 0.02862f
C1366 a_n5096_n3348.n27 vss 0.00659f
C1367 a_n5096_n3348.t22 vss 0.0483f
C1368 a_n5096_n3348.t21 vss 0.0483f
C1369 a_n5096_n3348.n28 vss 0.02862f
C1370 a_n5096_n3348.n29 vss 0.02889f
C1371 a_n5096_n3348.n30 vss 0.00901f
C1372 a_n5096_n3348.n31 vss 0.00659f
C1373 a_n5096_n3348.n32 vss 0.00659f
C1374 a_n5096_n3348.n33 vss 0.00659f
C1375 a_n5096_n3348.n34 vss 0.00659f
C1376 a_n5096_n3348.t26 vss 0.03012f
C1377 a_n5096_n3348.t25 vss 0.03012f
C1378 a_n5096_n3348.t24 vss 0.03012f
C1379 a_n5096_n3348.t23 vss 0.03012f
C1380 a_n5096_n3348.n35 vss 0.02283f
C1381 a_n5096_n3348.n36 vss 0.00936f
C1382 a_n5096_n3348.n37 vss 0.00659f
C1383 a_n5096_n3348.n38 vss 0.02256f
C1384 a_n5096_n3348.n39 vss 0.02256f
C1385 a_n5096_n3348.n40 vss 0.02281f
C1386 a_n5096_n3348.n41 vss 1.44711f
C1387 a_n5096_n3348.n42 vss 0.07838f
C1388 a_n5096_n3348.n43 vss 0.07838f
C1389 a_n5096_n3348.t12 vss 0.16586f
C1390 a_n5096_n3348.t13 vss 0.16586f
C1391 a_n5096_n3348.n44 vss 0.07838f
C1392 a_n5096_n3348.t14 vss 0.16586f
C1393 a_n5096_n3348.n45 vss 0.01629f
C1394 a_n5096_n3348.n46 vss 0.07838f
C1395 a_n5096_n3348.t11 vss 0.16586f
C1396 a_n5096_n3348.n47 vss 0.01629f
C1397 a_n5096_n3348.n48 vss 0.10196f
C1398 a_n5096_n3348.t6 vss 0.97573f
C1399 a_n5096_n3348.n49 vss 0.76667f
C1400 a_n5096_n3348.t7 vss 0.13934f
C1401 a_n5096_n3348.t0 vss 0.03333f
C1402 ctrl.n0 vss 1.21388f
C1403 ctrl.n1 vss 0.18844f
C1404 ctrl.n2 vss 0.17334f
C1405 ctrl.n3 vss 0.26903f
C1406 ctrl.n4 vss 0.8196f
C1407 ctrl.n5 vss 0.26978f
C1408 ctrl.n6 vss 0.19394f
C1409 ctrl.n7 vss 0.25262f
C1410 ctrl.n8 vss 0.16748f
C1411 ctrl.n9 vss 0.26909f
C1412 ctrl.n10 vss 0.16748f
C1413 ctrl.n11 vss 0.26978f
C1414 ctrl.n12 vss 0.26903f
C1415 ctrl.n13 vss 0.16748f
C1416 ctrl.n14 vss 0.21528f
C1417 ctrl.n15 vss 0.21261f
C1418 ctrl.n16 vss 0.26978f
C1419 ctrl.n17 vss 0.26909f
C1420 ctrl.n18 vss 0.16748f
C1421 ctrl.n19 vss 0.21589f
C1422 ctrl.n20 vss 0.212f
C1423 ctrl.n21 vss 0.26903f
C1424 ctrl.n22 vss 0.26978f
C1425 ctrl.n23 vss 0.19394f
C1426 ctrl.n24 vss 0.25262f
C1427 ctrl.n25 vss 0.16748f
C1428 ctrl.n26 vss 0.26909f
C1429 ctrl.n27 vss 0.26978f
C1430 ctrl.n28 vss 0.19394f
C1431 ctrl.n29 vss 0.25262f
C1432 ctrl.n30 vss 0.16748f
C1433 ctrl.n31 vss 0.26978f
C1434 ctrl.n32 vss 0.26903f
C1435 ctrl.n33 vss 0.16748f
C1436 ctrl.n34 vss 0.21528f
C1437 ctrl.n35 vss 0.21261f
C1438 ctrl.n36 vss 0.26978f
C1439 ctrl.n37 vss 0.26909f
C1440 ctrl.n38 vss 0.16748f
C1441 ctrl.n39 vss 0.21589f
C1442 ctrl.n40 vss 0.212f
C1443 ctrl.n41 vss 0.26849f
C1444 ctrl.n42 vss 0.22168f
C1445 ctrl.n43 vss 0.18873f
C1446 ctrl.n44 vss 0.26592f
C1447 ctrl.n45 vss 0.24497f
C1448 ctrl.n46 vss 0.22168f
C1449 ctrl.n47 vss 0.26592f
C1450 ctrl.n48 vss 0.18873f
C1451 ctrl.n49 vss 0.26849f
C1452 ctrl.n50 vss 0.24497f
C1453 ctrl.n51 vss 0.26521f
C1454 ctrl.n52 vss 0.18844f
C1455 ctrl.n53 vss 0.26919f
C1456 ctrl.n54 vss 0.26849f
C1457 ctrl.n55 vss 0.22168f
C1458 ctrl.n56 vss 0.18873f
C1459 ctrl.n57 vss 0.26592f
C1460 ctrl.n58 vss 0.26919f
C1461 ctrl.n59 vss 0.24497f
C1462 ctrl.n60 vss 0.18844f
C1463 ctrl.n61 vss 0.26521f
C1464 ctrl.n62 vss 0.22168f
C1465 ctrl.n63 vss 0.26592f
C1466 ctrl.n64 vss 0.18873f
C1467 ctrl.n65 vss 0.26849f
C1468 ctrl.n66 vss 0.24497f
C1469 ctrl.n67 vss 0.26521f
C1470 ctrl.n68 vss 0.18844f
C1471 ctrl.n69 vss 0.26919f
C1472 ctrl.n70 vss 0.13909f
C1473 ctrl.n71 vss 0.16555f
C1474 ctrl.n72 vss 0.82829f
C1475 ctrl.n73 vss 0.16555f
C1476 ctrl.n74 vss 0.16555f
C1477 ctrl.n75 vss 0.8196f
C1478 ctrl.n76 vss 0.13909f
C1479 ctrl.n77 vss 0.17334f
C1480 ctrl.n78 vss 0.8196f
C1481 ctrl.n79 vss 0.16555f
C1482 ctrl.n80 vss 0.16555f
C1483 ctrl.n81 vss 0.8196f
C1484 ctrl.n82 vss 0.16555f
C1485 ctrl.t54 vss 0.13361f
C1486 ctrl.n83 vss 0.60125f
C1487 ctrl.t4 vss 0.13361f
C1488 ctrl.t26 vss 0.13361f
C1489 ctrl.n84 vss 0.8196f
C1490 ctrl.n85 vss 0.6518f
C1491 ctrl.n86 vss 0.16555f
C1492 ctrl.t62 vss 0.13361f
C1493 ctrl.n87 vss 0.16555f
C1494 ctrl.n88 vss 0.6518f
C1495 ctrl.n89 vss 0.8196f
C1496 ctrl.t28 vss 0.13361f
C1497 ctrl.n90 vss 0.60125f
C1498 ctrl.t56 vss 0.13361f
C1499 ctrl.t2 vss 0.13361f
C1500 ctrl.n91 vss 0.81961f
C1501 ctrl.n92 vss 0.6518f
C1502 ctrl.n93 vss 0.16555f
C1503 ctrl.t40 vss 0.13361f
C1504 ctrl.n94 vss 0.16555f
C1505 ctrl.n95 vss 0.6518f
C1506 ctrl.n96 vss 0.81961f
C1507 ctrl.n97 vss 0.82959f
C1508 ctrl.t16 vss 0.13361f
C1509 ctrl.t48 vss 0.13361f
C1510 ctrl.n98 vss 0.6518f
C1511 ctrl.t12 vss 0.13361f
C1512 ctrl.n99 vss 0.17334f
C1513 ctrl.t58 vss 0.13361f
C1514 ctrl.n100 vss 0.8196f
C1515 ctrl.n101 vss 0.60125f
C1516 ctrl.n102 vss 0.6518f
C1517 ctrl.t50 vss 0.13361f
C1518 ctrl.t0 vss 0.13361f
C1519 ctrl.n103 vss 0.8196f
C1520 ctrl.n104 vss 0.6518f
C1521 ctrl.t6 vss 0.13361f
C1522 ctrl.t14 vss 0.13361f
C1523 ctrl.n105 vss 0.16727f
C1524 ctrl.n106 vss 0.60125f
C1525 ctrl.n107 vss 0.6518f
C1526 ctrl.n108 vss 0.16555f
C1527 ctrl.n109 vss 0.72201f
C1528 ctrl.n110 vss 0.7835f
C1529 ctrl.t42 vss 0.13361f
C1530 ctrl.n111 vss 0.60125f
C1531 ctrl.t22 vss 0.13361f
C1532 ctrl.t20 vss 0.13361f
C1533 ctrl.n112 vss 0.8196f
C1534 ctrl.n113 vss 0.6518f
C1535 ctrl.t18 vss 0.13361f
C1536 ctrl.n114 vss 0.16555f
C1537 ctrl.n115 vss 0.6518f
C1538 ctrl.t36 vss 0.13361f
C1539 ctrl.n116 vss 0.60125f
C1540 ctrl.t44 vss 0.13361f
C1541 ctrl.t46 vss 0.13361f
C1542 ctrl.n117 vss 0.6518f
C1543 ctrl.t38 vss 0.13361f
C1544 ctrl.n118 vss 0.16555f
C1545 ctrl.n119 vss 0.16555f
C1546 ctrl.n120 vss 0.6518f
C1547 ctrl.n121 vss 0.81961f
C1548 ctrl.n122 vss 0.82959f
C1549 ctrl.t32 vss 0.13361f
C1550 ctrl.t8 vss 0.13361f
C1551 ctrl.n123 vss 0.8196f
C1552 ctrl.n124 vss 0.6518f
C1553 ctrl.t34 vss 0.13361f
C1554 ctrl.n125 vss 0.17334f
C1555 ctrl.t24 vss 0.13361f
C1556 ctrl.n126 vss 0.8196f
C1557 ctrl.n127 vss 0.13909f
C1558 ctrl.n128 vss 0.60125f
C1559 ctrl.n129 vss 0.6518f
C1560 ctrl.n130 vss 0.16555f
C1561 ctrl.t52 vss 0.13361f
C1562 ctrl.t10 vss 0.13361f
C1563 ctrl.n131 vss 0.8196f
C1564 ctrl.n132 vss 0.6518f
C1565 ctrl.t60 vss 0.13361f
C1566 ctrl.t30 vss 0.13361f
C1567 ctrl.n133 vss 0.60125f
C1568 ctrl.n134 vss 0.6518f
C1569 ctrl.n135 vss 0.16555f
C1570 ctrl.n136 vss 0.72201f
C1571 ctrl.n137 vss 1.35099f
.ends
