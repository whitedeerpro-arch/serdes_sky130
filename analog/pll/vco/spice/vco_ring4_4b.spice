* PLL r5 candidate VCO with the finer capacitor bank (cap_bank_4b.spice): 15 half units, code in half units of pll_vco_ring4_pvt_candidate's.
* 2026-11-11: bank unit MIM 2.35 x 2.5 -> 2.52 x 2.68 um (C x 1.15), switch W 2.5 -> 2.68 um (x sqrt 1.15).  With the
* layout-equivalent fixed-width high_po cards (serdes_flow.rcorner.to_pdk_fixed, hh / ll ~+-15 %, short loads +-17.5 %)
* the old bank could not reach 2 GHz at SF -40 C ll code 15 (2.10 GHz at Vctrl 0.80 V); now 0.945 V there and the slow
* end FS 1.65 V 85 C hh code 0 at 1.123 V (window top 1.21 V).  analog/pll/vco/tb/tuning/fixed_cards.py,
* results/analog/pll/vco/fixed_cards/20261111T125140Z.  The code table predates this change and the fixed cards.
* Same ring and varactors.  Dependencies are loaded by the testbench.
.subckt pll_vco_ring4_4b q0p q0n q1p q1n q2p q2n q3p q3n
+ vctrl b0 b1 b2 b3 vbias vdd vss
+ params: wn=40 nfin=8 wt=20 lt=0.5 rload=400
+ varw=4.5 varl=0.5 varvm=4 capw=2.52 capl=2.68 sw=2.68

X0 q3n q3p q0p q0n vbias vdd vss serdes_cml_delay
+ wn={wn} nfin={nfin} wt={wt} lt={lt} rload={rload}
X1 q0p q0n q1p q1n vbias vdd vss serdes_cml_delay
+ wn={wn} nfin={nfin} wt={wt} lt={lt} rload={rload}
X2 q1p q1n q2p q2n vbias vdd vss serdes_cml_delay
+ wn={wn} nfin={nfin} wt={wt} lt={lt} rload={rload}
X3 q2p q2n q3p q3n vbias vdd vss serdes_cml_delay
+ wn={wn} nfin={nfin} wt={wt} lt={lt} rload={rload}

* Accumulation varactor: gate at oscillator output, well/control at vctrl,
* substrate at vss. Increasing vctrl reduces gate-to-well bias.
Xv0p q0p vctrl vss sky130_fd_pr__cap_var_lvt w={varw} l={varl} vm={varvm}
Xv0n q0n vctrl vss sky130_fd_pr__cap_var_lvt w={varw} l={varl} vm={varvm}
Xv1p q1p vctrl vss sky130_fd_pr__cap_var_lvt w={varw} l={varl} vm={varvm}
Xv1n q1n vctrl vss sky130_fd_pr__cap_var_lvt w={varw} l={varl} vm={varvm}
Xv2p q2p vctrl vss sky130_fd_pr__cap_var_lvt w={varw} l={varl} vm={varvm}
Xv2n q2n vctrl vss sky130_fd_pr__cap_var_lvt w={varw} l={varl} vm={varvm}
Xv3p q3p vctrl vss sky130_fd_pr__cap_var_lvt w={varw} l={varl} vm={varvm}
Xv3n q3n vctrl vss sky130_fd_pr__cap_var_lvt w={varw} l={varl} vm={varvm}

Xc0p q0p b0 b1 b2 b3 vss pll_vco_cap_bank4 capw={capw} capl={capl} sw={sw}
Xc0n q0n b0 b1 b2 b3 vss pll_vco_cap_bank4 capw={capw} capl={capl} sw={sw}
Xc1p q1p b0 b1 b2 b3 vss pll_vco_cap_bank4 capw={capw} capl={capl} sw={sw}
Xc1n q1n b0 b1 b2 b3 vss pll_vco_cap_bank4 capw={capw} capl={capl} sw={sw}
Xc2p q2p b0 b1 b2 b3 vss pll_vco_cap_bank4 capw={capw} capl={capl} sw={sw}
Xc2n q2n b0 b1 b2 b3 vss pll_vco_cap_bank4 capw={capw} capl={capl} sw={sw}
Xc3p q3p b0 b1 b2 b3 vss pll_vco_cap_bank4 capw={capw} capl={capl} sw={sw}
Xc3n q3n b0 b1 b2 b3 vss pll_vco_cap_bank4 capw={capw} capl={capl} sw={sw}
.ends pll_vco_ring4_4b
