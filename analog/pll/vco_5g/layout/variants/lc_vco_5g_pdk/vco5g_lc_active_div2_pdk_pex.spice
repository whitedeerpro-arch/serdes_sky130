* NGSPICE file created from vco5g_lc_active_div2_pdk.ext - technology: sky130A

.subckt vco5g_lc_active_div2_pdk vp vn ip in qp qn vctrl b0 b1 b2 b3 vdd vss
X0 a_1059_n850# b1 a_1151_n850# vss sky130_fd_pr__nfet_01v8_lvt ad=0.66 pd=4.33 as=0.66 ps=4.33 w=4 l=0.15
X1 a_11139_n850# b3 vss vss sky130_fd_pr__nfet_01v8 ad=0.29 pd=2.58 as=0.29 ps=2.58 w=1 l=0.5
X2 a_1151_n850# b1 vdd vdd sky130_fd_pr__pfet_01v8 ad=0.29 pd=2.58 as=0.29 ps=2.58 w=1 l=0.5
X3 vn a_n7249_n850# sky130_fd_pr__cap_mim_m3_1 l=4.2 w=4.2
X4 a_n1616_n13041# a_n2699_n11028# vss sky130_fd_pr__res_high_po_1p41 l=80
X5 vn vctrl vss sky130_fd_pr__cap_var_lvt w=5.2 l=0.5
X6 vn vp a_n19835_n3460# vss sky130_fd_pr__nfet_01v8_lvt ad=0.4125 pd=2.83 as=0.775 ps=5.62 w=2.5 l=0.15
X7 a_11231_n850# b3 vss vss sky130_fd_pr__nfet_01v8 ad=0.29 pd=2.58 as=0.29 ps=2.58 w=1 l=0.5
X8 vdd vn vp vdd sky130_fd_pr__pfet_01v8_lvt ad=0.58 pd=4.29 as=0.58 ps=4.29 w=4 l=0.35
X9 a_n10609_n850# b3 a_n10701_n850# vss sky130_fd_pr__nfet_01v8_lvt ad=0.66 pd=4.33 as=0.66 ps=4.33 w=4 l=0.15
X10 a_n3981_n850# b2 a_n3889_n850# vss sky130_fd_pr__nfet_01v8_lvt ad=1.24 pd=8.62 as=0.66 ps=4.33 w=4 l=0.15
X11 a_n5241_n9240# qn ip vss sky130_fd_pr__nfet_01v8_lvt ad=0.66 pd=4.33 as=0.66 ps=4.33 w=4 l=0.15
X12 vp a_9459_n850# sky130_fd_pr__cap_mim_m3_1 l=4.2 w=4.2
X13 vp vctrl vss sky130_fd_pr__cap_var_lvt w=5.2 l=0.5
X14 ip qn a_n5241_n9240# vss sky130_fd_pr__nfet_01v8_lvt ad=0.66 pd=4.33 as=0.66 ps=4.33 w=4 l=0.15
X15 vn vctrl vss sky130_fd_pr__cap_var_lvt w=5.2 l=0.5
X16 vp vn a_n19835_n3460# vss sky130_fd_pr__nfet_01v8_lvt ad=0.4125 pd=2.83 as=0.4125 ps=2.83 w=2.5 l=0.15
X17 a_n2209_n850# b1 a_n2301_n850# vss sky130_fd_pr__nfet_01v8_lvt ad=0.66 pd=4.33 as=1.24 ps=8.62 w=4 l=0.15
X18 a_n5661_n850# b2 vdd vdd sky130_fd_pr__pfet_01v8 ad=0.29 pd=2.58 as=0.29 ps=2.58 w=1 l=0.5
X19 a_n19835_n3460# a_n19935_n3730# vss vss sky130_fd_pr__nfet_01v8 ad=0.725 pd=5.29 as=0.725 ps=5.29 w=5 l=0.5
X20 vdd a_n1616_n13041# vss sky130_fd_pr__res_high_po_1p41 l=60
X21 a_2739_n850# b2 a_2831_n850# vss sky130_fd_pr__nfet_01v8_lvt ad=0.66 pd=4.33 as=0.66 ps=4.33 w=4 l=0.15
X22 a_n19835_n3460# vn vp vss sky130_fd_pr__nfet_01v8_lvt ad=0.4125 pd=2.83 as=0.4125 ps=2.83 w=2.5 l=0.15
X23 a_n10609_n850# b3 vdd vdd sky130_fd_pr__pfet_01v8 ad=0.29 pd=2.58 as=0.29 ps=2.58 w=1 l=0.5
X24 a_n19835_n3460# a_n19935_n3730# vss vss sky130_fd_pr__nfet_01v8 ad=0.725 pd=5.29 as=0.725 ps=5.29 w=5 l=0.5
X25 qn qp a_2799_n9190# vss sky130_fd_pr__nfet_01v8_lvt ad=0.5775 pd=3.83 as=0.5775 ps=3.83 w=3.5 l=0.15
X26 a_n5241_n9240# qp in vss sky130_fd_pr__nfet_01v8_lvt ad=0.66 pd=4.33 as=0.66 ps=4.33 w=4 l=0.15
X27 a_2799_n9190# qp qn vss sky130_fd_pr__nfet_01v8_lvt ad=0.5775 pd=3.83 as=0.5775 ps=3.83 w=3.5 l=0.15
X28 in qp a_n5241_n9240# vss sky130_fd_pr__nfet_01v8_lvt ad=0.66 pd=4.33 as=0.66 ps=4.33 w=4 l=0.15
X29 a_9551_n850# b3 a_9459_n850# vss sky130_fd_pr__nfet_01v8_lvt ad=0.66 pd=4.33 as=0.66 ps=4.33 w=4 l=0.15
X30 a_n19835_n3460# vp vn vss sky130_fd_pr__nfet_01v8_lvt ad=0.4125 pd=2.83 as=0.4125 ps=2.83 w=2.5 l=0.15
X31 a_n10609_n850# b3 vss vss sky130_fd_pr__nfet_01v8 ad=0.29 pd=2.58 as=0.29 ps=2.58 w=1 l=0.5
X32 a_n7249_n850# b3 a_n7341_n850# vss sky130_fd_pr__nfet_01v8_lvt ad=0.66 pd=4.33 as=0.66 ps=4.33 w=4 l=0.15
X33 a_6099_n850# b3 vss vss sky130_fd_pr__nfet_01v8 ad=0.29 pd=2.58 as=0.29 ps=2.58 w=1 l=0.5
X34 vn a_1151_n850# sky130_fd_pr__cap_mim_m3_1 l=4.2 w=4.2
X35 vn vp vdd vdd sky130_fd_pr__pfet_01v8_lvt ad=0.58 pd=4.29 as=0.58 ps=4.29 w=4 l=0.35
X36 a_n3889_n850# b2 vdd vdd sky130_fd_pr__pfet_01v8 ad=0.29 pd=2.58 as=0.29 ps=2.58 w=1 l=0.5
X37 a_6191_n850# b3 vss vss sky130_fd_pr__nfet_01v8 ad=0.29 pd=2.58 as=0.29 ps=2.58 w=1 l=0.5
X38 vss a_n19935_n3730# a_n19835_n3460# vss sky130_fd_pr__nfet_01v8 ad=0.725 pd=5.29 as=0.725 ps=5.29 w=5 l=0.5
X39 vss a_n8583_n10876# a_n8513_n10850# vss sky130_fd_pr__nfet_01v8 ad=0.6525 pd=4.79 as=0.6525 ps=4.79 w=4.5 l=0.35
X40 vp vn vdd vdd sky130_fd_pr__pfet_01v8_lvt ad=0.58 pd=4.29 as=0.58 ps=4.29 w=4 l=0.35
X41 vn vp a_n19835_n3460# vss sky130_fd_pr__nfet_01v8_lvt ad=0.4125 pd=2.83 as=0.4125 ps=2.83 w=2.5 l=0.15
X42 qp qn a_2799_n9190# vss sky130_fd_pr__nfet_01v8_lvt ad=0.5775 pd=3.83 as=0.5775 ps=3.83 w=3.5 l=0.15
X43 a_n621_n850# b0 vdd vdd sky130_fd_pr__pfet_01v8 ad=0.29 pd=2.58 as=0.29 ps=2.58 w=1 l=0.5
X44 a_2799_n9190# qn qp vss sky130_fd_pr__nfet_01v8_lvt ad=0.5775 pd=3.83 as=0.5775 ps=3.83 w=3.5 l=0.15
X45 a_6191_n850# b3 a_6099_n850# vss sky130_fd_pr__nfet_01v8_lvt ad=0.66 pd=4.33 as=0.66 ps=4.33 w=4 l=0.15
X46 a_2319_n11000# a_n8583_n10876# vss vss sky130_fd_pr__nfet_01v8 ad=0.6525 pd=4.79 as=0.6525 ps=4.79 w=4.5 l=0.35
X47 a_n8513_n10850# a_n2699_n11028# a_n4201_n9190# vss sky130_fd_pr__nfet_01v8_lvt ad=0.825 pd=5.33 as=0.825 ps=5.33 w=5 l=0.15
X48 vp vn vdd vdd sky130_fd_pr__pfet_01v8_lvt ad=0.58 pd=4.29 as=0.58 ps=4.29 w=4 l=0.35
X49 a_n7249_n850# b3 vss vss sky130_fd_pr__nfet_01v8 ad=0.29 pd=2.58 as=0.29 ps=2.58 w=1 l=0.5
X50 vn a_11231_n850# sky130_fd_pr__cap_mim_m3_1 l=4.2 w=4.2
X51 vp a_n5661_n850# sky130_fd_pr__cap_mim_m3_1 l=4.2 w=4.2
X52 vp vn a_n19835_n3460# vss sky130_fd_pr__nfet_01v8_lvt ad=0.4125 pd=2.83 as=0.4125 ps=2.83 w=2.5 l=0.15
X53 vss a_n19935_n3730# a_n19835_n3460# vss sky130_fd_pr__nfet_01v8 ad=0.725 pd=5.29 as=0.725 ps=5.29 w=5 l=0.5
X54 a_2799_n9190# a_n18016_n12241# a_2319_n11000# vss sky130_fd_pr__nfet_01v8_lvt ad=0.825 pd=5.33 as=0.825 ps=5.33 w=5 l=0.15
X55 a_7779_n850# b3 a_7871_n850# vss sky130_fd_pr__nfet_01v8_lvt ad=0.66 pd=4.33 as=0.66 ps=4.33 w=4 l=0.15
X56 ip in a_n4201_n9190# vss sky130_fd_pr__nfet_01v8_lvt ad=0.5775 pd=3.83 as=1.085 ps=7.62 w=3.5 l=0.15
X57 vp a_n18016_n12241# sky130_fd_pr__cap_mim_m3_1 l=8 w=8
X58 a_n19835_n3460# vn vp vss sky130_fd_pr__nfet_01v8_lvt ad=0.4125 pd=2.83 as=0.4125 ps=2.83 w=2.5 l=0.15
X59 a_n12289_n850# b3 a_n12381_n850# vss sky130_fd_pr__nfet_01v8_lvt ad=0.66 pd=4.33 as=0.66 ps=4.33 w=4 l=0.15
X60 vdd qp vss sky130_fd_pr__res_high_po_2p85 l=5.6
X61 vn vp a_n19835_n3460# vss sky130_fd_pr__nfet_01v8_lvt ad=0.4125 pd=2.83 as=0.4125 ps=2.83 w=2.5 l=0.15
X62 a_n5661_n850# b2 a_n5569_n850# vss sky130_fd_pr__nfet_01v8_lvt ad=1.24 pd=8.62 as=0.66 ps=4.33 w=4 l=0.15
X63 a_n4201_n9190# a_n2699_n11028# a_n8513_n10850# vss sky130_fd_pr__nfet_01v8_lvt ad=0.825 pd=5.33 as=0.825 ps=5.33 w=5 l=0.15
X64 a_n529_n850# b0 a_n621_n850# vss sky130_fd_pr__nfet_01v8_lvt ad=0.66 pd=4.33 as=1.24 ps=8.62 w=4 l=0.15
X65 vp a_n2301_n850# sky130_fd_pr__cap_mim_m3_1 l=4.2 w=4.2
X66 a_n8513_n10850# a_n8583_n10876# vss vss sky130_fd_pr__nfet_01v8 ad=0.6525 pd=4.79 as=0.6525 ps=4.79 w=4.5 l=0.35
X67 vdd vn vp vdd sky130_fd_pr__pfet_01v8_lvt ad=0.58 pd=4.29 as=0.58 ps=4.29 w=4 l=0.35
X68 a_9459_n850# b3 vss vss sky130_fd_pr__nfet_01v8 ad=0.29 pd=2.58 as=0.29 ps=2.58 w=1 l=0.5
X69 a_n19835_n3460# a_n19935_n3730# vss vss sky130_fd_pr__nfet_01v8 ad=0.725 pd=5.29 as=0.725 ps=5.29 w=5 l=0.5
X70 a_n19835_n3460# vp vn vss sky130_fd_pr__nfet_01v8_lvt ad=0.4125 pd=2.83 as=0.4125 ps=2.83 w=2.5 l=0.15
X71 a_n8929_n850# b3 a_n9021_n850# vss sky130_fd_pr__nfet_01v8_lvt ad=0.66 pd=4.33 as=1.24 ps=8.62 w=4 l=0.15
X72 vn a_n12289_n850# sky130_fd_pr__cap_mim_m3_1 l=4.2 w=4.2
X73 a_2319_n11000# a_n18016_n12241# a_2799_n9190# vss sky130_fd_pr__nfet_01v8_lvt ad=0.825 pd=5.33 as=0.825 ps=5.33 w=5 l=0.15
X74 in ip a_n4201_n9190# vss sky130_fd_pr__nfet_01v8_lvt ad=0.5775 pd=3.83 as=1.085 ps=7.62 w=3.5 l=0.15
X75 vdd vp vn vdd sky130_fd_pr__pfet_01v8_lvt ad=0.58 pd=4.29 as=0.58 ps=4.29 w=4 l=0.35
X76 a_4419_n850# b2 a_4511_n850# vss sky130_fd_pr__nfet_01v8_lvt ad=0.66 pd=4.33 as=0.66 ps=4.33 w=4 l=0.15
X77 vp vctrl vss sky130_fd_pr__cap_var_lvt w=5.2 l=0.5
X78 vdd vn vp vdd sky130_fd_pr__pfet_01v8_lvt ad=0.58 pd=4.29 as=0.58 ps=4.29 w=4 l=0.35
X79 vn vctrl vss sky130_fd_pr__cap_var_lvt w=5.2 l=0.5
X80 a_n7341_n850# b3 a_n7249_n850# vss sky130_fd_pr__nfet_01v8_lvt ad=1.24 pd=8.62 as=0.66 ps=4.33 w=4 l=0.15
X81 vdd vp vn vdd sky130_fd_pr__pfet_01v8_lvt ad=0.58 pd=4.29 as=0.58 ps=4.29 w=4 l=0.35
X82 a_7779_n850# b3 vss vss sky130_fd_pr__nfet_01v8 ad=0.29 pd=2.58 as=0.29 ps=2.58 w=1 l=0.5
X83 a_11139_n850# b3 vdd vdd sky130_fd_pr__pfet_01v8 ad=0.29 pd=2.58 as=0.29 ps=2.58 w=1 l=0.5
X84 vp vctrl vss sky130_fd_pr__cap_var_lvt w=5.2 l=0.5
X85 vp vn a_n19835_n3460# vss sky130_fd_pr__nfet_01v8_lvt ad=0.4125 pd=2.83 as=0.4125 ps=2.83 w=2.5 l=0.15
X86 a_n5569_n850# b2 a_n5661_n850# vss sky130_fd_pr__nfet_01v8_lvt ad=0.66 pd=4.33 as=1.24 ps=8.62 w=4 l=0.15
X87 a_n8513_n10850# a_n8583_n10876# vss vss sky130_fd_pr__nfet_01v8 ad=0.6525 pd=4.79 as=0.6525 ps=4.79 w=4.5 l=0.35
X88 a_n19935_n3730# a_14859_1604# vss sky130_fd_pr__res_high_po_1p41 l=10
X89 a_7871_n850# b3 a_7779_n850# vss sky130_fd_pr__nfet_01v8_lvt ad=0.66 pd=4.33 as=0.66 ps=4.33 w=4 l=0.15
X90 vss a_n8583_n10876# a_2319_n11000# vss sky130_fd_pr__nfet_01v8 ad=0.6525 pd=4.79 as=0.6525 ps=4.79 w=4.5 l=0.35
X91 a_2831_n850# b2 a_2739_n850# vss sky130_fd_pr__nfet_01v8_lvt ad=0.66 pd=4.33 as=1.24 ps=8.62 w=4 l=0.15
X92 a_4419_n850# b2 vss vss sky130_fd_pr__nfet_01v8 ad=0.29 pd=2.58 as=0.29 ps=2.58 w=1 l=0.5
X93 a_11231_n850# b3 a_11139_n850# vss sky130_fd_pr__nfet_01v8_lvt ad=0.66 pd=4.33 as=0.66 ps=4.33 w=4 l=0.15
X94 vp a_n7341_n850# sky130_fd_pr__cap_mim_m3_1 l=4.2 w=4.2
X95 a_n18016_n12241# a_n1616_n13041# vss sky130_fd_pr__res_high_po_1p41 l=80
X96 vn vp vdd vdd sky130_fd_pr__pfet_01v8_lvt ad=0.58 pd=4.29 as=0.58 ps=4.29 w=4 l=0.35
X97 qn in a_1759_n9240# vss sky130_fd_pr__nfet_01v8_lvt ad=0.66 pd=4.33 as=0.66 ps=4.33 w=4 l=0.15
X98 a_n621_n850# b0 vss vss sky130_fd_pr__nfet_01v8 ad=0.29 pd=2.58 as=0.29 ps=2.58 w=1 l=0.5
X99 a_1059_n850# b1 a_1151_n850# vss sky130_fd_pr__nfet_01v8_lvt ad=1.24 pd=8.62 as=0.66 ps=4.33 w=4 l=0.15
X100 a_9459_n850# b3 a_9551_n850# vss sky130_fd_pr__nfet_01v8_lvt ad=0.66 pd=4.33 as=0.66 ps=4.33 w=4 l=0.15
X101 a_1759_n9240# in qn vss sky130_fd_pr__nfet_01v8_lvt ad=0.66 pd=4.33 as=0.66 ps=4.33 w=4 l=0.15
X102 a_n10701_n850# b3 vdd vdd sky130_fd_pr__pfet_01v8 ad=0.29 pd=2.58 as=0.29 ps=2.58 w=1 l=0.5
X103 vdd qn vss sky130_fd_pr__res_high_po_2p85 l=5.6
X104 vn vp vdd vdd sky130_fd_pr__pfet_01v8_lvt ad=0.58 pd=4.29 as=0.58 ps=4.29 w=4 l=0.35
X105 vn vp a_n19835_n3460# vss sky130_fd_pr__nfet_01v8_lvt ad=0.4125 pd=2.83 as=0.4125 ps=2.83 w=2.5 l=0.15
X106 vdd qn vss sky130_fd_pr__res_high_po_2p85 l=5.6
X107 vn a_2831_n850# sky130_fd_pr__cap_mim_m3_1 l=4.2 w=4.2
X108 a_n10609_n850# b3 a_n10701_n850# vss sky130_fd_pr__nfet_01v8_lvt ad=0.66 pd=4.33 as=1.24 ps=8.62 w=4 l=0.15
X109 vp a_n621_n850# sky130_fd_pr__cap_mim_m3_1 l=4.2 w=4.2
X110 vss a_n8583_n10876# a_2319_n11000# vss sky130_fd_pr__nfet_01v8 ad=0.6525 pd=4.79 as=0.6525 ps=4.79 w=4.5 l=0.35
X111 vp vn vdd vdd sky130_fd_pr__pfet_01v8_lvt ad=0.58 pd=4.29 as=0.58 ps=4.29 w=4 l=0.35
X112 a_n3981_n850# b2 a_n3889_n850# vss sky130_fd_pr__nfet_01v8_lvt ad=0.66 pd=4.33 as=0.66 ps=4.33 w=4 l=0.15
X113 a_n19835_n3460# vp vn vss sky130_fd_pr__nfet_01v8_lvt ad=0.4125 pd=2.83 as=0.4125 ps=2.83 w=2.5 l=0.15
X114 vp a_n9021_n850# sky130_fd_pr__cap_mim_m3_1 l=4.2 w=4.2
X115 a_1759_n9240# a_n2699_n11028# a_2319_n11000# vss sky130_fd_pr__nfet_01v8_lvt ad=0.825 pd=5.33 as=1.55 ps=10.62 w=5 l=0.15
X116 qp ip a_1759_n9240# vss sky130_fd_pr__nfet_01v8_lvt ad=0.66 pd=4.33 as=0.66 ps=4.33 w=4 l=0.15
X117 a_1759_n9240# ip qp vss sky130_fd_pr__nfet_01v8_lvt ad=0.66 pd=4.33 as=0.66 ps=4.33 w=4 l=0.15
X118 a_6099_n850# b3 a_6191_n850# vss sky130_fd_pr__nfet_01v8_lvt ad=0.66 pd=4.33 as=0.66 ps=4.33 w=4 l=0.15
X119 vn a_n5569_n850# sky130_fd_pr__cap_mim_m3_1 l=4.2 w=4.2
X120 vn a_n8929_n850# sky130_fd_pr__cap_mim_m3_1 l=4.2 w=4.2
X121 a_n8929_n850# b3 vdd vdd sky130_fd_pr__pfet_01v8 ad=0.29 pd=2.58 as=0.29 ps=2.58 w=1 l=0.5
X122 a_n19835_n3460# vn vp vss sky130_fd_pr__nfet_01v8_lvt ad=0.775 pd=5.62 as=0.4125 ps=2.83 w=2.5 l=0.15
X123 a_n621_n850# b0 a_n529_n850# vss sky130_fd_pr__nfet_01v8_lvt ad=1.24 pd=8.62 as=0.66 ps=4.33 w=4 l=0.15
X124 a_n529_n850# b0 vdd vdd sky130_fd_pr__pfet_01v8 ad=0.29 pd=2.58 as=0.29 ps=2.58 w=1 l=0.5
X125 a_11231_n850# b3 vdd vdd sky130_fd_pr__pfet_01v8 ad=0.29 pd=2.58 as=0.29 ps=2.58 w=1 l=0.5
X126 vn a_n2699_n11028# sky130_fd_pr__cap_mim_m3_1 l=8 w=8
X127 a_n8513_n10850# a_n18016_n12241# a_n5241_n9240# vss sky130_fd_pr__nfet_01v8_lvt ad=0.825 pd=5.33 as=0.825 ps=5.33 w=5 l=0.15
X128 vss a_n8583_n10876# a_n8513_n10850# vss sky130_fd_pr__nfet_01v8 ad=1.305 pd=9.58 as=0.6525 ps=4.79 w=4.5 l=0.35
X129 a_n9021_n850# b3 a_n8929_n850# vss sky130_fd_pr__nfet_01v8_lvt ad=1.24 pd=8.62 as=0.66 ps=4.33 w=4 l=0.15
X130 ip qn a_n5241_n9240# vss sky130_fd_pr__nfet_01v8_lvt ad=0.66 pd=4.33 as=1.24 ps=8.62 w=4 l=0.15
X131 vss a_n8583_n10876# a_n8513_n10850# vss sky130_fd_pr__nfet_01v8 ad=0.6525 pd=4.79 as=0.6525 ps=4.79 w=4.5 l=0.35
X132 a_n19835_n3460# vp vn vss sky130_fd_pr__nfet_01v8_lvt ad=0.4125 pd=2.83 as=0.4125 ps=2.83 w=2.5 l=0.15
X133 a_n7249_n850# b3 a_n7341_n850# vss sky130_fd_pr__nfet_01v8_lvt ad=0.66 pd=4.33 as=1.24 ps=8.62 w=4 l=0.15
X134 a_2319_n11000# a_n8583_n10876# vss vss sky130_fd_pr__nfet_01v8 ad=0.6525 pd=4.79 as=1.305 ps=9.58 w=4.5 l=0.35
X135 vdd vp vn vdd sky130_fd_pr__pfet_01v8_lvt ad=0.58 pd=4.29 as=0.58 ps=4.29 w=4 l=0.35
X136 a_9459_n850# b3 vdd vdd sky130_fd_pr__pfet_01v8 ad=0.29 pd=2.58 as=0.29 ps=2.58 w=1 l=0.5
X137 vn vp a_n19835_n3460# vss sky130_fd_pr__nfet_01v8_lvt ad=0.4125 pd=2.83 as=0.4125 ps=2.83 w=2.5 l=0.15
X138 in qp a_n5241_n9240# vss sky130_fd_pr__nfet_01v8_lvt ad=0.66 pd=4.33 as=1.24 ps=8.62 w=4 l=0.15
X139 a_n5241_n9240# a_n18016_n12241# a_n8513_n10850# vss sky130_fd_pr__nfet_01v8_lvt ad=0.825 pd=5.33 as=0.825 ps=5.33 w=5 l=0.15
X140 a_2799_n9190# qp qn vss sky130_fd_pr__nfet_01v8_lvt ad=1.085 pd=7.62 as=0.5775 ps=3.83 w=3.5 l=0.15
X141 vdd vp vn vdd sky130_fd_pr__pfet_01v8_lvt ad=0.58 pd=4.29 as=0.58 ps=4.29 w=4 l=0.35
X142 a_n12381_n850# b3 vdd vdd sky130_fd_pr__pfet_01v8 ad=0.29 pd=2.58 as=0.29 ps=2.58 w=1 l=0.5
X143 vp vn a_n19835_n3460# vss sky130_fd_pr__nfet_01v8_lvt ad=0.4125 pd=2.83 as=0.4125 ps=2.83 w=2.5 l=0.15
X144 a_n4201_n9190# in ip vss sky130_fd_pr__nfet_01v8_lvt ad=1.085 pd=7.62 as=0.5775 ps=3.83 w=3.5 l=0.15
X145 a_n8513_n10850# a_n8583_n10876# vss vss sky130_fd_pr__nfet_01v8 ad=0.6525 pd=4.79 as=0.6525 ps=4.79 w=4.5 l=0.35
X146 a_n2301_n850# b1 vss vss sky130_fd_pr__nfet_01v8 ad=0.29 pd=2.58 as=0.29 ps=2.58 w=1 l=0.5
X147 vss a_n19935_n3730# a_n19835_n3460# vss sky130_fd_pr__nfet_01v8 ad=0.725 pd=5.29 as=0.725 ps=5.29 w=5 l=0.5
X148 a_n19835_n3460# vn vp vss sky130_fd_pr__nfet_01v8_lvt ad=0.4125 pd=2.83 as=0.4125 ps=2.83 w=2.5 l=0.15
X149 a_n12289_n850# b3 vss vss sky130_fd_pr__nfet_01v8 ad=0.29 pd=2.58 as=0.29 ps=2.58 w=1 l=0.5
X150 vn a_n2209_n850# sky130_fd_pr__cap_mim_m3_1 l=4.2 w=4.2
X151 vp a_n10701_n850# sky130_fd_pr__cap_mim_m3_1 l=4.2 w=4.2
X152 vp vctrl vss sky130_fd_pr__cap_var_lvt w=5.2 l=0.5
X153 a_n12289_n850# b3 a_n12381_n850# vss sky130_fd_pr__nfet_01v8_lvt ad=0.66 pd=4.33 as=1.24 ps=8.62 w=4 l=0.15
X154 vss a_n19935_n3730# a_n19835_n3460# vss sky130_fd_pr__nfet_01v8 ad=0.725 pd=5.29 as=0.725 ps=5.29 w=5 l=0.5
X155 a_2799_n9190# a_n18016_n12241# a_2319_n11000# vss sky130_fd_pr__nfet_01v8_lvt ad=0.825 pd=5.33 as=1.55 ps=10.62 w=5 l=0.15
X156 a_2799_n9190# qn qp vss sky130_fd_pr__nfet_01v8_lvt ad=1.085 pd=7.62 as=0.5775 ps=3.83 w=3.5 l=0.15
X157 vdd vn vp vdd sky130_fd_pr__pfet_01v8_lvt ad=0.58 pd=4.29 as=0.58 ps=4.29 w=4 l=0.35
X158 a_n5661_n850# b2 a_n5569_n850# vss sky130_fd_pr__nfet_01v8_lvt ad=0.66 pd=4.33 as=0.66 ps=4.33 w=4 l=0.15
X159 a_1151_n850# b1 a_1059_n850# vss sky130_fd_pr__nfet_01v8_lvt ad=0.66 pd=4.33 as=1.24 ps=8.62 w=4 l=0.15
X160 a_n9021_n850# b3 vdd vdd sky130_fd_pr__pfet_01v8 ad=0.29 pd=2.58 as=0.29 ps=2.58 w=1 l=0.5
X161 vdd ip vss sky130_fd_pr__res_high_po_2p85 l=5.6
X162 a_n4201_n9190# ip in vss sky130_fd_pr__nfet_01v8_lvt ad=1.085 pd=7.62 as=0.5775 ps=3.83 w=3.5 l=0.15
X163 vn vctrl vss sky130_fd_pr__cap_var_lvt w=5.2 l=0.5
X164 a_n19835_n3460# vp vn vss sky130_fd_pr__nfet_01v8_lvt ad=0.775 pd=5.62 as=0.4125 ps=2.83 w=2.5 l=0.15
X165 a_n10701_n850# b3 a_n10609_n850# vss sky130_fd_pr__nfet_01v8_lvt ad=1.24 pd=8.62 as=0.66 ps=4.33 w=4 l=0.15
X166 a_4419_n850# b2 a_4511_n850# vss sky130_fd_pr__nfet_01v8_lvt ad=1.24 pd=8.62 as=0.66 ps=4.33 w=4 l=0.15
X167 a_7779_n850# b3 vdd vdd sky130_fd_pr__pfet_01v8 ad=0.29 pd=2.58 as=0.29 ps=2.58 w=1 l=0.5
X168 a_n19835_n3460# a_n19935_n3730# vss vss sky130_fd_pr__nfet_01v8 ad=0.725 pd=5.29 as=0.725 ps=5.29 w=5 l=0.5
X169 vdd vn vp vdd sky130_fd_pr__pfet_01v8_lvt ad=0.58 pd=4.29 as=0.58 ps=4.29 w=4 l=0.35
X170 a_11139_n850# b3 a_11231_n850# vss sky130_fd_pr__nfet_01v8_lvt ad=0.66 pd=4.33 as=0.66 ps=4.33 w=4 l=0.15
X171 vdd qp vss sky130_fd_pr__res_high_po_2p85 l=5.6
X172 a_2319_n11000# a_n8583_n10876# vss vss sky130_fd_pr__nfet_01v8 ad=0.6525 pd=4.79 as=0.6525 ps=4.79 w=4.5 l=0.35
X173 a_2319_n11000# a_n2699_n11028# a_1759_n9240# vss sky130_fd_pr__nfet_01v8_lvt ad=1.55 pd=10.62 as=0.825 ps=5.33 w=5 l=0.15
X174 vp vctrl vss sky130_fd_pr__cap_var_lvt w=5.2 l=0.5
X175 a_n19835_n3460# vn vp vss sky130_fd_pr__nfet_01v8_lvt ad=0.4125 pd=2.83 as=0.4125 ps=2.83 w=2.5 l=0.15
X176 a_n2301_n850# b1 a_n2209_n850# vss sky130_fd_pr__nfet_01v8_lvt ad=0.66 pd=4.33 as=0.66 ps=4.33 w=4 l=0.15
X177 a_n7249_n850# b3 vdd vdd sky130_fd_pr__pfet_01v8 ad=0.29 pd=2.58 as=0.29 ps=2.58 w=1 l=0.5
X178 vp a_2739_n850# sky130_fd_pr__cap_mim_m3_1 l=4.2 w=4.2
X179 a_4511_n850# b2 vdd vdd sky130_fd_pr__pfet_01v8 ad=0.29 pd=2.58 as=0.29 ps=2.58 w=1 l=0.5
X180 a_n19835_n3460# a_n19935_n3730# vss vss sky130_fd_pr__nfet_01v8 ad=0.725 pd=5.29 as=0.725 ps=5.29 w=5 l=0.5
X181 vn a_n10609_n850# sky130_fd_pr__cap_mim_m3_1 l=4.2 w=4.2
X182 vn vp vdd vdd sky130_fd_pr__pfet_01v8_lvt ad=0.58 pd=4.29 as=0.58 ps=4.29 w=4 l=0.35
X183 vp vn a_n19835_n3460# vss sky130_fd_pr__nfet_01v8_lvt ad=0.4125 pd=2.83 as=0.4125 ps=2.83 w=2.5 l=0.15
X184 a_n3889_n850# b2 a_n3981_n850# vss sky130_fd_pr__nfet_01v8_lvt ad=0.66 pd=4.33 as=0.66 ps=4.33 w=4 l=0.15
X185 a_2831_n850# b2 vss vss sky130_fd_pr__nfet_01v8 ad=0.29 pd=2.58 as=0.29 ps=2.58 w=1 l=0.5
X186 vp vn vdd vdd sky130_fd_pr__pfet_01v8_lvt ad=0.58 pd=4.29 as=0.58 ps=4.29 w=4 l=0.35
X187 a_n3981_n850# b2 vdd vdd sky130_fd_pr__pfet_01v8 ad=0.29 pd=2.58 as=0.29 ps=2.58 w=1 l=0.5
X188 a_n8513_n10850# a_n2699_n11028# a_n4201_n9190# vss sky130_fd_pr__nfet_01v8_lvt ad=1.55 pd=10.62 as=0.825 ps=5.33 w=5 l=0.15
X189 a_n8513_n10850# a_n8583_n10876# vss vss sky130_fd_pr__nfet_01v8 ad=0.6525 pd=4.79 as=1.305 ps=9.58 w=4.5 l=0.35
X190 vn vp vdd vdd sky130_fd_pr__pfet_01v8_lvt ad=0.58 pd=4.29 as=1.16 ps=8.58 w=4 l=0.35
X191 vn vp vdd vdd sky130_fd_pr__pfet_01v8_lvt ad=0.58 pd=4.29 as=0.58 ps=4.29 w=4 l=0.35
X192 a_n1616_n13041# vss vss sky130_fd_pr__res_high_po_1p41 l=96
X193 vss a_n8583_n10876# a_2319_n11000# vss sky130_fd_pr__nfet_01v8 ad=0.6525 pd=4.79 as=0.6525 ps=4.79 w=4.5 l=0.35
X194 a_2739_n850# b2 vdd vdd sky130_fd_pr__pfet_01v8 ad=0.29 pd=2.58 as=0.29 ps=2.58 w=1 l=0.5
X195 vss a_n8583_n10876# a_2319_n11000# vss sky130_fd_pr__nfet_01v8 ad=1.305 pd=9.58 as=0.6525 ps=4.79 w=4.5 l=0.35
X196 vss a_n19935_n3730# a_n19835_n3460# vss sky130_fd_pr__nfet_01v8 ad=0.725 pd=5.29 as=0.725 ps=5.29 w=5 l=0.5
X197 vn vp vdd vdd sky130_fd_pr__pfet_01v8_lvt ad=0.58 pd=4.29 as=0.58 ps=4.29 w=4 l=0.35
X198 a_n3981_n850# b2 vss vss sky130_fd_pr__nfet_01v8 ad=0.29 pd=2.58 as=0.29 ps=2.58 w=1 l=0.5
X199 a_9459_n850# b3 a_9551_n850# vss sky130_fd_pr__nfet_01v8_lvt ad=1.24 pd=8.62 as=0.66 ps=4.33 w=4 l=0.15
X200 vp a_n12381_n850# sky130_fd_pr__cap_mim_m3_1 l=4.2 w=4.2
X201 vn vp a_n19835_n3460# vss sky130_fd_pr__nfet_01v8_lvt ad=0.4125 pd=2.83 as=0.4125 ps=2.83 w=2.5 l=0.15
X202 a_n2209_n850# b1 vdd vdd sky130_fd_pr__pfet_01v8 ad=0.29 pd=2.58 as=0.29 ps=2.58 w=1 l=0.5
X203 vn a_9551_n850# sky130_fd_pr__cap_mim_m3_1 l=4.2 w=4.2
X204 a_n19835_n3460# a_n19935_n3730# vss vss sky130_fd_pr__nfet_01v8 ad=0.725 pd=5.29 as=0.725 ps=5.29 w=5 l=0.5
X205 vn a_6191_n850# sky130_fd_pr__cap_mim_m3_1 l=4.2 w=4.2
X206 vp a_7779_n850# sky130_fd_pr__cap_mim_m3_1 l=4.2 w=4.2
X207 a_7871_n850# b3 a_7779_n850# vss sky130_fd_pr__nfet_01v8_lvt ad=0.66 pd=4.33 as=1.24 ps=8.62 w=4 l=0.15
X208 vss a_n8583_n10876# a_n8513_n10850# vss sky130_fd_pr__nfet_01v8 ad=0.6525 pd=4.79 as=0.6525 ps=4.79 w=4.5 l=0.35
X209 a_n12381_n850# b3 a_n12289_n850# vss sky130_fd_pr__nfet_01v8_lvt ad=1.24 pd=8.62 as=0.66 ps=4.33 w=4 l=0.15
X210 a_6099_n850# b3 a_6191_n850# vss sky130_fd_pr__nfet_01v8_lvt ad=1.24 pd=8.62 as=0.66 ps=4.33 w=4 l=0.15
X211 a_9551_n850# b3 vdd vdd sky130_fd_pr__pfet_01v8 ad=0.29 pd=2.58 as=0.29 ps=2.58 w=1 l=0.5
X212 a_1759_n9240# in qn vss sky130_fd_pr__nfet_01v8_lvt ad=1.24 pd=8.62 as=0.66 ps=4.33 w=4 l=0.15
X213 a_n19835_n3460# vn vp vss sky130_fd_pr__nfet_01v8_lvt ad=0.4125 pd=2.83 as=0.4125 ps=2.83 w=2.5 l=0.15
X214 a_n5661_n850# b2 vss vss sky130_fd_pr__nfet_01v8 ad=0.29 pd=2.58 as=0.29 ps=2.58 w=1 l=0.5
X215 a_n621_n850# b0 a_n529_n850# vss sky130_fd_pr__nfet_01v8_lvt ad=0.66 pd=4.33 as=0.66 ps=4.33 w=4 l=0.15
X216 vss a_n19935_n3730# a_n19835_n3460# vss sky130_fd_pr__nfet_01v8 ad=1.45 pd=10.58 as=0.725 ps=5.29 w=5 l=0.5
X217 vss a_n19935_n3730# a_n19835_n3460# vss sky130_fd_pr__nfet_01v8 ad=0.725 pd=5.29 as=0.725 ps=5.29 w=5 l=0.5
X218 a_n5241_n9240# qn ip vss sky130_fd_pr__nfet_01v8_lvt ad=1.24 pd=8.62 as=0.66 ps=4.33 w=4 l=0.15
X219 vp a_4419_n850# sky130_fd_pr__cap_mim_m3_1 l=4.2 w=4.2
X220 vp vn a_n19835_n3460# vss sky130_fd_pr__nfet_01v8_lvt ad=0.4125 pd=2.83 as=0.4125 ps=2.83 w=2.5 l=0.15
X221 a_n9021_n850# b3 a_n8929_n850# vss sky130_fd_pr__nfet_01v8_lvt ad=0.66 pd=4.33 as=0.66 ps=4.33 w=4 l=0.15
X222 a_4511_n850# b2 a_4419_n850# vss sky130_fd_pr__nfet_01v8_lvt ad=0.66 pd=4.33 as=1.24 ps=8.62 w=4 l=0.15
X223 vdd in vss sky130_fd_pr__res_high_po_2p85 l=5.6
X224 vn a_n3889_n850# sky130_fd_pr__cap_mim_m3_1 l=4.2 w=4.2
X225 a_1759_n9240# ip qp vss sky130_fd_pr__nfet_01v8_lvt ad=1.24 pd=8.62 as=0.66 ps=4.33 w=4 l=0.15
X226 vdd vp vn vdd sky130_fd_pr__pfet_01v8_lvt ad=1.16 pd=8.58 as=0.58 ps=4.29 w=4 l=0.35
X227 a_n19835_n3460# vp vn vss sky130_fd_pr__nfet_01v8_lvt ad=0.4125 pd=2.83 as=0.4125 ps=2.83 w=2.5 l=0.15
X228 a_n5569_n850# b2 a_n5661_n850# vss sky130_fd_pr__nfet_01v8_lvt ad=0.66 pd=4.33 as=0.66 ps=4.33 w=4 l=0.15
X229 a_2739_n850# b2 a_2831_n850# vss sky130_fd_pr__nfet_01v8_lvt ad=1.24 pd=8.62 as=0.66 ps=4.33 w=4 l=0.15
X230 vdd in vss sky130_fd_pr__res_high_po_2p85 l=5.6
X231 vdd vn vp vdd sky130_fd_pr__pfet_01v8_lvt ad=0.58 pd=4.29 as=0.58 ps=4.29 w=4 l=0.35
X232 a_4511_n850# b2 vss vss sky130_fd_pr__nfet_01v8 ad=0.29 pd=2.58 as=0.29 ps=2.58 w=1 l=0.5
X233 a_n8583_n10876# a_n8583_n10876# vss vss sky130_fd_pr__nfet_01v8 ad=0.435 pd=3.29 as=0.87 ps=6.58 w=3 l=0.35
X234 qn qp a_2799_n9190# vss sky130_fd_pr__nfet_01v8_lvt ad=0.5775 pd=3.83 as=1.085 ps=7.62 w=3.5 l=0.15
X235 a_n5241_n9240# qp in vss sky130_fd_pr__nfet_01v8_lvt ad=1.24 pd=8.62 as=0.66 ps=4.33 w=4 l=0.15
X236 vn vp a_n19835_n3460# vss sky130_fd_pr__nfet_01v8_lvt ad=0.4125 pd=2.83 as=0.4125 ps=2.83 w=2.5 l=0.15
X237 vdd vn vp vdd sky130_fd_pr__pfet_01v8_lvt ad=1.16 pd=8.58 as=0.58 ps=4.29 w=4 l=0.35
X238 vdd vp vn vdd sky130_fd_pr__pfet_01v8_lvt ad=0.58 pd=4.29 as=0.58 ps=4.29 w=4 l=0.35
X239 vn vctrl vss sky130_fd_pr__cap_var_lvt w=5.2 l=0.5
X240 vp a_1059_n850# sky130_fd_pr__cap_mim_m3_1 l=4.2 w=4.2
X241 a_11231_n850# b3 a_11139_n850# vss sky130_fd_pr__nfet_01v8_lvt ad=0.66 pd=4.33 as=1.24 ps=8.62 w=4 l=0.15
X242 vss a_n8583_n10876# a_n8583_n10876# vss sky130_fd_pr__nfet_01v8 ad=0.87 pd=6.58 as=0.435 ps=3.29 w=3 l=0.35
X243 vp vn a_n19835_n3460# vss sky130_fd_pr__nfet_01v8_lvt ad=0.4125 pd=2.83 as=0.4125 ps=2.83 w=2.5 l=0.15
X244 a_n2209_n850# b1 a_n2301_n850# vss sky130_fd_pr__nfet_01v8_lvt ad=0.66 pd=4.33 as=0.66 ps=4.33 w=4 l=0.15
X245 a_1059_n850# b1 vss vss sky130_fd_pr__nfet_01v8 ad=0.29 pd=2.58 as=0.29 ps=2.58 w=1 l=0.5
X246 a_n8583_n10876# vdd vss sky130_fd_pr__res_high_po_1p41 l=14
X247 a_7871_n850# b3 vdd vdd sky130_fd_pr__pfet_01v8 ad=0.29 pd=2.58 as=0.29 ps=2.58 w=1 l=0.5
X248 vp vctrl vss sky130_fd_pr__cap_var_lvt w=5.2 l=0.5
X249 a_1151_n850# b1 vss vss sky130_fd_pr__nfet_01v8 ad=0.29 pd=2.58 as=0.29 ps=2.58 w=1 l=0.5
X250 a_2319_n11000# a_n18016_n12241# a_2799_n9190# vss sky130_fd_pr__nfet_01v8_lvt ad=1.55 pd=10.62 as=0.825 ps=5.33 w=5 l=0.15
X251 a_n10701_n850# b3 vss vss sky130_fd_pr__nfet_01v8 ad=0.29 pd=2.58 as=0.29 ps=2.58 w=1 l=0.5
X252 a_n19835_n3460# vn vp vss sky130_fd_pr__nfet_01v8_lvt ad=0.4125 pd=2.83 as=0.4125 ps=2.83 w=2.5 l=0.15
X253 a_n7341_n850# b3 vdd vdd sky130_fd_pr__pfet_01v8 ad=0.29 pd=2.58 as=0.29 ps=2.58 w=1 l=0.5
X254 qp qn a_2799_n9190# vss sky130_fd_pr__nfet_01v8_lvt ad=0.5775 pd=3.83 as=1.085 ps=7.62 w=3.5 l=0.15
X255 a_14859_1604# a_14859_1604# vss vss sky130_fd_pr__nfet_01v8 ad=0.435 pd=3.29 as=0.87 ps=6.58 w=3 l=0.5
X256 a_1151_n850# b1 a_1059_n850# vss sky130_fd_pr__nfet_01v8_lvt ad=0.66 pd=4.33 as=0.66 ps=4.33 w=4 l=0.15
X257 a_9551_n850# b3 a_9459_n850# vss sky130_fd_pr__nfet_01v8_lvt ad=0.66 pd=4.33 as=1.24 ps=8.62 w=4 l=0.15
X258 a_2319_n11000# a_n8583_n10876# vss vss sky130_fd_pr__nfet_01v8 ad=0.6525 pd=4.79 as=0.6525 ps=4.79 w=4.5 l=0.35
X259 vn vctrl vss sky130_fd_pr__cap_var_lvt w=5.2 l=0.5
X260 a_n2209_n850# b1 vss vss sky130_fd_pr__nfet_01v8 ad=0.29 pd=2.58 as=0.29 ps=2.58 w=1 l=0.5
X261 a_6099_n850# b3 vdd vdd sky130_fd_pr__pfet_01v8 ad=0.29 pd=2.58 as=0.29 ps=2.58 w=1 l=0.5
X262 vp vss sky130_fd_pr__cap_mim_m3_1 l=3 w=3
X263 a_n19835_n3460# vp vn vss sky130_fd_pr__nfet_01v8_lvt ad=0.4125 pd=2.83 as=0.4125 ps=2.83 w=2.5 l=0.15
X264 a_7779_n850# b3 a_7871_n850# vss sky130_fd_pr__nfet_01v8_lvt ad=1.24 pd=8.62 as=0.66 ps=4.33 w=4 l=0.15
X265 a_n4201_n9190# in ip vss sky130_fd_pr__nfet_01v8_lvt ad=0.5775 pd=3.83 as=0.5775 ps=3.83 w=3.5 l=0.15
X266 a_n10701_n850# b3 a_n10609_n850# vss sky130_fd_pr__nfet_01v8_lvt ad=0.66 pd=4.33 as=0.66 ps=4.33 w=4 l=0.15
X267 ip in a_n4201_n9190# vss sky130_fd_pr__nfet_01v8_lvt ad=0.5775 pd=3.83 as=0.5775 ps=3.83 w=3.5 l=0.15
X268 a_n19935_n3730# vss sky130_fd_pr__cap_mim_m3_1 l=22 w=22
X269 a_n7341_n850# b3 vss vss sky130_fd_pr__nfet_01v8 ad=0.29 pd=2.58 as=0.29 ps=2.58 w=1 l=0.5
X270 a_11139_n850# b3 a_11231_n850# vss sky130_fd_pr__nfet_01v8_lvt ad=1.24 pd=8.62 as=0.66 ps=4.33 w=4 l=0.15
X271 vn vp a_n19835_n3460# vss sky130_fd_pr__nfet_01v8_lvt ad=0.4125 pd=2.83 as=0.4125 ps=2.83 w=2.5 l=0.15
X272 a_n5569_n850# b2 vdd vdd sky130_fd_pr__pfet_01v8 ad=0.29 pd=2.58 as=0.29 ps=2.58 w=1 l=0.5
X273 a_n8513_n10850# a_n18016_n12241# a_n5241_n9240# vss sky130_fd_pr__nfet_01v8_lvt ad=1.55 pd=10.62 as=0.825 ps=5.33 w=5 l=0.15
X274 vp vn vdd vdd sky130_fd_pr__pfet_01v8_lvt ad=0.58 pd=4.29 as=0.58 ps=4.29 w=4 l=0.35
X275 a_6191_n850# b3 a_6099_n850# vss sky130_fd_pr__nfet_01v8_lvt ad=0.66 pd=4.33 as=1.24 ps=8.62 w=4 l=0.15
X276 a_2831_n850# b2 vdd vdd sky130_fd_pr__pfet_01v8 ad=0.29 pd=2.58 as=0.29 ps=2.58 w=1 l=0.5
X277 vn a_n529_n850# sky130_fd_pr__cap_mim_m3_1 l=4.2 w=4.2
X278 vp a_6099_n850# sky130_fd_pr__cap_mim_m3_1 l=4.2 w=4.2
X279 vss a_14859_1604# a_14859_1604# vss sky130_fd_pr__nfet_01v8 ad=0.87 pd=6.58 as=0.435 ps=3.29 w=3 l=0.5
X280 a_2831_n850# b2 a_2739_n850# vss sky130_fd_pr__nfet_01v8_lvt ad=0.66 pd=4.33 as=0.66 ps=4.33 w=4 l=0.15
X281 vdd ip vss sky130_fd_pr__res_high_po_2p85 l=5.6
X282 vp vn vdd vdd sky130_fd_pr__pfet_01v8_lvt ad=0.58 pd=4.29 as=0.58 ps=4.29 w=4 l=0.35
X283 vp vn a_n19835_n3460# vss sky130_fd_pr__nfet_01v8_lvt ad=0.4125 pd=2.83 as=0.775 ps=5.62 w=2.5 l=0.15
X284 a_n3889_n850# b2 vss vss sky130_fd_pr__nfet_01v8 ad=0.29 pd=2.58 as=0.29 ps=2.58 w=1 l=0.5
X285 a_n4201_n9190# a_n2699_n11028# a_n8513_n10850# vss sky130_fd_pr__nfet_01v8_lvt ad=0.825 pd=5.33 as=1.55 ps=10.62 w=5 l=0.15
X286 in ip a_n4201_n9190# vss sky130_fd_pr__nfet_01v8_lvt ad=0.5775 pd=3.83 as=0.5775 ps=3.83 w=3.5 l=0.15
X287 a_n4201_n9190# ip in vss sky130_fd_pr__nfet_01v8_lvt ad=0.5775 pd=3.83 as=0.5775 ps=3.83 w=3.5 l=0.15
X288 vp vn vdd vdd sky130_fd_pr__pfet_01v8_lvt ad=0.58 pd=4.29 as=1.16 ps=8.58 w=4 l=0.35
X289 a_n3889_n850# b2 a_n3981_n850# vss sky130_fd_pr__nfet_01v8_lvt ad=0.66 pd=4.33 as=1.24 ps=8.62 w=4 l=0.15
X290 a_n12289_n850# b3 vdd vdd sky130_fd_pr__pfet_01v8 ad=0.29 pd=2.58 as=0.29 ps=2.58 w=1 l=0.5
X291 a_n2301_n850# b1 vdd vdd sky130_fd_pr__pfet_01v8 ad=0.29 pd=2.58 as=0.29 ps=2.58 w=1 l=0.5
X292 a_n19835_n3460# a_n19935_n3730# vss vss sky130_fd_pr__nfet_01v8 ad=0.725 pd=5.29 as=0.725 ps=5.29 w=5 l=0.5
X293 vn a_7871_n850# sky130_fd_pr__cap_mim_m3_1 l=4.2 w=4.2
X294 vn vp vdd vdd sky130_fd_pr__pfet_01v8_lvt ad=0.58 pd=4.29 as=0.58 ps=4.29 w=4 l=0.35
X295 a_9551_n850# b3 vss vss sky130_fd_pr__nfet_01v8 ad=0.29 pd=2.58 as=0.29 ps=2.58 w=1 l=0.5
X296 a_n7341_n850# b3 a_n7249_n850# vss sky130_fd_pr__nfet_01v8_lvt ad=0.66 pd=4.33 as=0.66 ps=4.33 w=4 l=0.15
X297 a_1059_n850# b1 vdd vdd sky130_fd_pr__pfet_01v8 ad=0.29 pd=2.58 as=0.29 ps=2.58 w=1 l=0.5
X298 vp vn vdd vdd sky130_fd_pr__pfet_01v8_lvt ad=0.58 pd=4.29 as=0.58 ps=4.29 w=4 l=0.35
X299 a_n529_n850# b0 a_n621_n850# vss sky130_fd_pr__nfet_01v8_lvt ad=0.66 pd=4.33 as=0.66 ps=4.33 w=4 l=0.15
X300 a_n19835_n3460# vss sky130_fd_pr__cap_mim_m3_1 l=32 w=32
X301 a_n12381_n850# b3 vss vss sky130_fd_pr__nfet_01v8 ad=0.29 pd=2.58 as=0.29 ps=2.58 w=1 l=0.5
X302 a_n2301_n850# b1 a_n2209_n850# vss sky130_fd_pr__nfet_01v8_lvt ad=1.24 pd=8.62 as=0.66 ps=4.33 w=4 l=0.15
X303 a_2739_n850# b2 vss vss sky130_fd_pr__nfet_01v8 ad=0.29 pd=2.58 as=0.29 ps=2.58 w=1 l=0.5
X304 a_n19835_n3460# vp vn vss sky130_fd_pr__nfet_01v8_lvt ad=0.4125 pd=2.83 as=0.4125 ps=2.83 w=2.5 l=0.15
X305 a_1759_n9240# a_n2699_n11028# a_2319_n11000# vss sky130_fd_pr__nfet_01v8_lvt ad=0.825 pd=5.33 as=0.825 ps=5.33 w=5 l=0.15
X306 a_n8929_n850# b3 a_n9021_n850# vss sky130_fd_pr__nfet_01v8_lvt ad=0.66 pd=4.33 as=0.66 ps=4.33 w=4 l=0.15
X307 a_7871_n850# b3 vss vss sky130_fd_pr__nfet_01v8 ad=0.29 pd=2.58 as=0.29 ps=2.58 w=1 l=0.5
X308 vss a_n19935_n3730# a_n19835_n3460# vss sky130_fd_pr__nfet_01v8 ad=0.725 pd=5.29 as=0.725 ps=5.29 w=5 l=0.5
X309 a_6191_n850# b3 vdd vdd sky130_fd_pr__pfet_01v8 ad=0.29 pd=2.58 as=0.29 ps=2.58 w=1 l=0.5
X310 vdd vp vn vdd sky130_fd_pr__pfet_01v8_lvt ad=0.58 pd=4.29 as=0.58 ps=4.29 w=4 l=0.35
X311 a_n8929_n850# b3 vss vss sky130_fd_pr__nfet_01v8 ad=0.29 pd=2.58 as=0.29 ps=2.58 w=1 l=0.5
X312 vdd vp vn vdd sky130_fd_pr__pfet_01v8_lvt ad=0.58 pd=4.29 as=0.58 ps=4.29 w=4 l=0.35
X313 a_n12381_n850# b3 a_n12289_n850# vss sky130_fd_pr__nfet_01v8_lvt ad=0.66 pd=4.33 as=0.66 ps=4.33 w=4 l=0.15
X314 a_2319_n11000# a_n2699_n11028# a_1759_n9240# vss sky130_fd_pr__nfet_01v8_lvt ad=0.825 pd=5.33 as=0.825 ps=5.33 w=5 l=0.15
X315 qn in a_1759_n9240# vss sky130_fd_pr__nfet_01v8_lvt ad=0.66 pd=4.33 as=1.24 ps=8.62 w=4 l=0.15
X316 a_n9021_n850# b3 vss vss sky130_fd_pr__nfet_01v8 ad=0.29 pd=2.58 as=0.29 ps=2.58 w=1 l=0.5
X317 a_n19835_n3460# vn vp vss sky130_fd_pr__nfet_01v8_lvt ad=0.4125 pd=2.83 as=0.4125 ps=2.83 w=2.5 l=0.15
X318 a_4419_n850# b2 vdd vdd sky130_fd_pr__pfet_01v8 ad=0.29 pd=2.58 as=0.29 ps=2.58 w=1 l=0.5
X319 vn vss sky130_fd_pr__cap_mim_m3_1 l=3 w=3
X320 a_n529_n850# b0 vss vss sky130_fd_pr__nfet_01v8 ad=0.29 pd=2.58 as=0.29 ps=2.58 w=1 l=0.5
X321 vn a_4511_n850# sky130_fd_pr__cap_mim_m3_1 l=4.2 w=4.2
X322 a_4511_n850# b2 a_4419_n850# vss sky130_fd_pr__nfet_01v8_lvt ad=0.66 pd=4.33 as=0.66 ps=4.33 w=4 l=0.15
X323 a_n19835_n3460# a_n19935_n3730# vss vss sky130_fd_pr__nfet_01v8 ad=0.725 pd=5.29 as=1.45 ps=10.58 w=5 l=0.5
X324 vp a_11139_n850# sky130_fd_pr__cap_mim_m3_1 l=4.2 w=4.2
X325 vdd a_14859_1604# vss sky130_fd_pr__res_high_po_1p41 l=9.8
X326 a_n5569_n850# b2 vss vss sky130_fd_pr__nfet_01v8 ad=0.29 pd=2.58 as=0.29 ps=2.58 w=1 l=0.5
X327 vp a_n3981_n850# sky130_fd_pr__cap_mim_m3_1 l=4.2 w=4.2
X328 a_n5241_n9240# a_n18016_n12241# a_n8513_n10850# vss sky130_fd_pr__nfet_01v8_lvt ad=0.825 pd=5.33 as=1.55 ps=10.62 w=5 l=0.15
X329 qp ip a_1759_n9240# vss sky130_fd_pr__nfet_01v8_lvt ad=0.66 pd=4.33 as=1.24 ps=8.62 w=4 l=0.15
X330 vdd vn vp vdd sky130_fd_pr__pfet_01v8_lvt ad=0.58 pd=4.29 as=0.58 ps=4.29 w=4 l=0.35
C0 a_2319_n11000# qp 0.16259f
C1 a_2319_n11000# a_1759_n9240# 0.86614f
C2 vdd a_n2301_n850# 0.22862f
C3 a_2739_n850# vdd 0.22862f
C4 b0 b2 0.6302f
C5 a_9459_n850# b2 0.05892f
C6 a_7871_n850# a_7779_n850# 0.94626f
C7 a_n7249_n850# vn 2.09068f
C8 ip qn 0.50287f
C9 a_n9021_n850# a_n10701_n850# 0.09505f
C10 a_7779_n850# vp 2.0999f
C11 a_2319_n11000# in 0
C12 a_7871_n850# vp 0.00452f
C13 vctrl vp 7.8831f
C14 b1 a_6099_n850# 0.05904f
C15 ip a_2799_n9190# 0
C16 a_n621_n850# b1 0.06545f
C17 b2 a_n19935_n3730# 0.00132f
C18 a_11231_n850# vn 2.1225f
C19 a_6099_n850# vdd 0.22862f
C20 ip a_n2699_n11028# 0.1864f
C21 a_6191_n850# vn 2.09068f
C22 a_n621_n850# vdd 0.22862f
C23 a_2831_n850# vn 2.09068f
C24 b2 a_n3889_n850# 0.56671f
C25 a_n3981_n850# a_n5661_n850# 0.09505f
C26 a_n2301_n850# a_n19835_n3460# 0.01709f
C27 a_2739_n850# a_n19835_n3460# 0.00121f
C28 a_n3981_n850# b1 0.06098f
C29 a_n5661_n850# vn 0.00118f
C30 a_n12381_n850# vp 2.12809f
C31 vp a_4419_n850# 2.0999f
C32 b1 vn 0.0057f
C33 ip a_n18016_n12241# 0.61012f
C34 a_n7341_n850# vn 0.00118f
C35 a_n3981_n850# vdd 0.22862f
C36 a_7779_n850# b2 0.05892f
C37 a_7871_n850# b2 0.06079f
C38 a_6191_n850# a_4511_n850# 0.09665f
C39 vdd vn 10.8235f
C40 a_n8929_n850# b3 0.65641f
C41 vp b2 0.14669f
C42 a_4511_n850# a_2831_n850# 0.09665f
C43 qn a_2319_n11000# 0.18858f
C44 a_2831_n850# a_1151_n850# 0.09665f
C45 a_n10701_n850# b1 0.05904f
C46 a_n8929_n850# b0 0.10384f
C47 a_1759_n9240# qp 0.78076f
C48 a_n621_n850# a_n19835_n3460# 0.01252f
C49 a_11139_n850# vn 0.06258f
C50 a_9551_n850# vn 2.09068f
C51 a_n10701_n850# vdd 0.22862f
C52 a_2799_n9190# a_2319_n11000# 0.90834f
C53 a_4511_n850# b1 0.06121f
C54 a_1151_n850# b1 0.56629f
C55 in qp 1.66951f
C56 a_1759_n9240# in 0.21185f
C57 a_n5241_n9240# a_n4201_n9190# 0.25765f
C58 b1 a_n12289_n850# 0.06121f
C59 a_2319_n11000# a_n2699_n11028# 0.24565f
C60 a_n12381_n850# b2 0.05892f
C61 a_n9021_n850# b3 0.73055f
C62 a_n3981_n850# a_n19835_n3460# 0.01315f
C63 a_n8929_n850# a_n19935_n3730# 0.08015f
C64 a_n8513_n10850# a_n5241_n9240# 0.88648f
C65 a_n10609_n850# vn 2.09068f
C66 a_4511_n850# vdd 0.71306f
C67 a_4419_n850# b2 0.71636f
C68 a_1151_n850# vdd 0.71306f
C69 a_n9021_n850# b0 0.09682f
C70 vn a_n19835_n3460# 2.94718f
C71 a_n12289_n850# vdd 0.8009f
C72 a_n7249_n850# b3 0.60092f
C73 a_n10609_n850# a_n10701_n850# 0.94626f
C74 b1 a_n529_n850# 0.1176f
C75 a_2319_n11000# a_n18016_n12241# 0.27686f
C76 a_n8583_n10876# a_n5241_n9240# 0.56186f
C77 a_n3981_n850# a_n5569_n850# 0.03465f
C78 a_n7249_n850# b0 0.10384f
C79 a_n10701_n850# a_n19835_n3460# 0.00839f
C80 a_2831_n850# a_1059_n850# 0.00181f
C81 a_n529_n850# vdd 0.71306f
C82 a_n5569_n850# vn 2.09068f
C83 a_11231_n850# b3 0.53058f
C84 ip vdd 0.07633f
C85 a_11231_n850# b0 0.03885f
C86 a_6191_n850# b3 0.65552f
C87 a_n10609_n850# a_n12289_n850# 0.09665f
C88 a_n8929_n850# vp 0.00452f
C89 a_2831_n850# b3 0.09502f
C90 a_11231_n850# a_9459_n850# 0.00181f
C91 b1 a_1059_n850# 0.71206f
C92 a_n7249_n850# a_n19935_n3730# 0.08015f
C93 b0 a_6191_n850# 0.10384f
C94 qn a_1759_n9240# 0.79368f
C95 qn qp 3.33236f
C96 b0 a_2831_n850# 0.10384f
C97 a_n621_n850# a_n2301_n850# 0.09505f
C98 b1 a_n2209_n850# 0.56629f
C99 a_n5661_n850# b3 0.07565f
C100 a_1059_n850# vdd 0.22862f
C101 a_14859_1604# vn 0.00512f
C102 b1 b3 0.74214f
C103 a_2799_n9190# a_1759_n9240# 0.25765f
C104 a_11231_n850# a_n19935_n3730# 0.08015f
C105 a_2799_n9190# qp 0.83359f
C106 qn in 1.27985f
C107 a_n7341_n850# b3 0.72861f
C108 a_n5661_n850# b0 0.09682f
C109 a_n2209_n850# vdd 0.71306f
C110 b0 b1 6.64295f
C111 vp a_n18016_n12241# 6.19598f
C112 a_n7341_n850# b0 0.09682f
C113 a_6191_n850# a_n19935_n3730# 0.08015f
C114 a_n9021_n850# vp 2.0999f
C115 ip a_n4201_n9190# 0.83311f
C116 b3 vdd 8.50371f
C117 a_n2699_n11028# a_1759_n9240# 0.7368f
C118 ip a_n8513_n10850# 0.18858f
C119 a_9459_n850# b1 0.05904f
C120 a_n3981_n850# a_n2301_n850# 0.09505f
C121 a_n2699_n11028# qp 0.34367f
C122 a_2831_n850# a_n19935_n3730# 0.08015f
C123 a_2799_n9190# in 0
C124 b0 vdd 0.83191f
C125 vn a_n2301_n850# 0.01227f
C126 a_2739_n850# vn 0.00318f
C127 a_9459_n850# vdd 0.22862f
C128 a_11139_n850# b3 0.72817f
C129 a_n2699_n11028# in 0.20524f
C130 a_n8929_n850# b2 0.06079f
C131 a_n7249_n850# vp 0.00452f
C132 a_9551_n850# b3 0.65641f
C133 b1 a_n19935_n3730# 0
C134 a_11139_n850# b0 0.09639f
C135 ip a_n8583_n10876# 0.1456f
C136 a_n18016_n12241# a_1759_n9240# 0.115f
C137 a_9551_n850# b0 0.10384f
C138 a_n18016_n12241# qp 0.47462f
C139 a_11139_n850# a_9459_n850# 0.09505f
C140 a_1059_n850# a_n19835_n3460# 0.01709f
C141 a_n5661_n850# a_n3889_n850# 0.00181f
C142 a_9551_n850# a_9459_n850# 0.94626f
C143 a_n19935_n3730# vdd 0.79206f
C144 a_7779_n850# a_6191_n850# 0.03465f
C145 a_n10609_n850# b3 0.65641f
C146 a_11231_n850# vp 0.00452f
C147 b1 a_n3889_n850# 0.11671f
C148 a_7871_n850# a_6191_n850# 0.09665f
C149 a_n18016_n12241# in 0.56334f
C150 a_n10609_n850# b0 0.10384f
C151 vp a_6191_n850# 0.00452f
C152 a_6099_n850# vn 0.00118f
C153 b3 a_n19835_n3460# 0.20157f
C154 vp a_2831_n850# 0.00452f
C155 a_4511_n850# a_2739_n850# 0.00181f
C156 a_n9021_n850# b2 0.05892f
C157 vdd a_n3889_n850# 0.71306f
C158 a_n621_n850# vn 0.00118f
C159 a_9551_n850# a_n19935_n3730# 0.08015f
C160 a_1151_n850# a_2739_n850# 0.03465f
C161 b0 a_n19835_n3460# 0.00322f
C162 a_7779_n850# b1 0.05904f
C163 a_7871_n850# b1 0.06121f
C164 a_n5661_n850# vp 2.0999f
C165 vp b1 0.13806f
C166 a_n7249_n850# b2 0.11629f
C167 a_2799_n9190# qn 0.85183f
C168 a_n10609_n850# a_n19935_n3730# 0.08015f
C169 a_n5569_n850# b3 0.09591f
C170 a_n7341_n850# vp 2.0999f
C171 a_7779_n850# vdd 0.22862f
C172 a_n3981_n850# vn 0.00152f
C173 a_7871_n850# vdd 0.71306f
C174 vctrl vdd 2.53569f
C175 a_n5569_n850# b0 0.10384f
C176 a_n19935_n3730# a_n19835_n3460# 2.73763f
C177 a_4511_n850# a_6099_n850# 0.03465f
C178 a_6191_n850# a_4419_n850# 0.00181f
C179 qn a_n2699_n11028# 0.38975f
C180 vp vdd 9.00247f
C181 a_n529_n850# a_n2301_n850# 0.00181f
C182 a_2831_n850# a_4419_n850# 0.03465f
C183 a_11231_n850# b2 0.00923f
C184 a_7779_n850# a_9551_n850# 0.00181f
C185 a_n621_n850# a_1151_n850# 0.00181f
C186 a_7871_n850# a_9551_n850# 0.09665f
C187 a_2799_n9190# a_n2699_n11028# 0.15856f
C188 a_6191_n850# b2 0.06168f
C189 a_2319_n11000# a_n8583_n10876# 1.18478f
C190 a_11139_n850# vp 2.03671f
C191 a_9551_n850# vp 0.00452f
C192 a_n12381_n850# b1 0.05904f
C193 a_2831_n850# b2 0.62131f
C194 a_n8583_n10876# a_n19935_n3730# 0.00796f
C195 b1 a_4419_n850# 0.05904f
C196 a_n5569_n850# a_n19935_n3730# 0.08015f
C197 a_n10701_n850# vn 0.00118f
C198 qn a_n18016_n12241# 0.60713f
C199 vdd qp 0.03692f
C200 a_n12381_n850# vdd 0.22953f
C201 a_n5661_n850# b2 0.71384f
C202 a_2739_n850# a_1059_n850# 0.09505f
C203 a_n10609_n850# vp 0.00452f
C204 a_4419_n850# vdd 0.22862f
C205 b1 b2 6.69877f
C206 a_n5569_n850# a_n3889_n850# 0.09665f
C207 vctrl a_n19835_n3460# 0.58416f
C208 a_4511_n850# vn 2.09068f
C209 a_n621_n850# a_n529_n850# 0.94626f
C210 a_2799_n9190# a_n18016_n12241# 0.30712f
C211 a_n7341_n850# b2 0.06086f
C212 a_n2209_n850# a_n2301_n850# 0.94626f
C213 a_1151_n850# vn 2.09068f
C214 in vdd 0.04483f
C215 vp a_n19835_n3460# 3.81231f
C216 b3 a_n2301_n850# 0.07119f
C217 a_n8929_n850# a_n9021_n850# 0.94626f
C218 a_2739_n850# b3 0.07119f
C219 a_n12289_n850# vn 2.09061f
C220 b2 vdd 3.27862f
C221 a_n2699_n11028# a_n18016_n12241# 1.93995f
C222 a_14859_1604# a_n19935_n3730# 0.02211f
C223 b0 a_n2301_n850# 0.09876f
C224 b0 a_2739_n850# 0.09682f
C225 a_11139_n850# b2 0.05848f
C226 a_n10609_n850# a_n12381_n850# 0.00181f
C227 a_n8929_n850# a_n7249_n850# 0.09665f
C228 ip a_n5241_n9240# 0.77297f
C229 a_n5569_n850# vp 0.00452f
C230 a_n10701_n850# a_n12289_n850# 0.03465f
C231 a_9551_n850# b2 0.06079f
C232 a_n621_n850# a_1059_n850# 0.09505f
C233 qp a_n4201_n9190# 0
C234 a_n529_n850# vn 2.09068f
C235 a_n12381_n850# a_n19835_n3460# 0.00839f
C236 a_6099_n850# b3 0.72608f
C237 a_n621_n850# a_n2209_n850# 0.03465f
C238 a_n10609_n850# b2 0.06079f
C239 in a_n4201_n9190# 0.83251f
C240 a_n621_n850# b3 0.07119f
C241 a_n8513_n10850# in 0.16259f
C242 b0 a_6099_n850# 0.09682f
C243 a_n621_n850# b0 0.75007f
C244 b2 a_n19835_n3460# 0.03955f
C245 a_n3889_n850# a_n2301_n850# 0.03465f
C246 a_n8583_n10876# qp 0.12429f
C247 a_n8583_n10876# a_1759_n9240# 0.56222f
C248 a_n7249_n850# a_n9021_n850# 0.00181f
C249 a_n3981_n850# a_n2209_n850# 0.00181f
C250 a_1059_n850# vn 0.00766f
C251 a_n3981_n850# b3 0.07119f
C252 qn vdd 0.03855f
C253 a_1151_n850# a_n529_n850# 0.09665f
C254 a_n8583_n10876# in 0.12499f
C255 a_n2209_n850# vn 2.09068f
C256 a_n3981_n850# b0 0.09682f
C257 a_n8929_n850# b1 0.06121f
C258 b3 vn 0.03587f
C259 a_n5569_n850# b2 0.62131f
C260 a_n8929_n850# a_n7341_n850# 0.03465f
C261 vp a_n2301_n850# 2.10638f
C262 b0 vn 0.00342f
C263 vp a_2739_n850# 2.10034f
C264 a_n8929_n850# vdd 0.71306f
C265 a_9459_n850# vn 0.00118f
C266 a_n2699_n11028# vdd 0.08172f
C267 a_n10701_n850# b3 0.73055f
C268 a_1151_n850# a_1059_n850# 0.94626f
C269 b0 a_n10701_n850# 0.09682f
C270 a_n9021_n850# b1 0.05904f
C271 qn a_n4201_n9190# 0.01946f
C272 a_7779_n850# a_6099_n850# 0.09505f
C273 a_n9021_n850# a_n7341_n850# 0.09505f
C274 a_n19935_n3730# vn 1.80509f
C275 qn a_n8513_n10850# 0
C276 a_4511_n850# b3 0.15052f
C277 a_7871_n850# a_6099_n850# 0.00181f
C278 a_n3981_n850# a_n3889_n850# 0.94626f
C279 a_1151_n850# b3 0.09502f
C280 vp a_6099_n850# 2.0999f
C281 a_n18016_n12241# vdd 0.09484f
C282 b0 a_4511_n850# 0.10384f
C283 a_n9021_n850# vdd 0.22862f
C284 a_n12289_n850# b3 0.65552f
C285 a_2739_n850# a_4419_n850# 0.09505f
C286 a_n5661_n850# a_n7249_n850# 0.03465f
C287 a_n10609_n850# a_n8929_n850# 0.09665f
C288 a_n621_n850# vp 2.0999f
C289 b0 a_1151_n850# 0.10473f
C290 vn a_n3889_n850# 2.09068f
C291 a_n7249_n850# b1 0.06121f
C292 a_1059_n850# a_n529_n850# 0.03465f
C293 a_n7249_n850# a_n7341_n850# 0.94626f
C294 b0 a_n12289_n850# 0.10384f
C295 a_n2699_n11028# a_n4201_n9190# 0.41851f
C296 qn a_n8583_n10876# 0.1449f
C297 b2 a_n2301_n850# 0.06338f
C298 a_n8513_n10850# a_n2699_n11028# 0.24284f
C299 a_2739_n850# b2 0.71384f
C300 a_n7249_n850# vdd 0.71306f
C301 a_n529_n850# a_n2209_n850# 0.09665f
C302 a_11231_n850# b1 0.00953f
C303 a_4511_n850# a_n19935_n3730# 0.08015f
C304 a_n529_n850# b3 0.09502f
C305 a_n3981_n850# vp 2.10141f
C306 a_7779_n850# vn 0.00118f
C307 a_2799_n9190# a_n8583_n10876# 0.12329f
C308 a_1151_n850# a_n19935_n3730# 0.08015f
C309 a_7871_n850# vn 2.09068f
C310 vctrl vn 6.51111f
C311 a_6099_n850# a_4419_n850# 0.09505f
C312 b0 a_n529_n850# 0.60922f
C313 a_6191_n850# b1 0.06121f
C314 a_n12289_n850# a_n19935_n3730# 0.08015f
C315 a_n10609_n850# a_n9021_n850# 0.03465f
C316 vp vn 6.29284f
C317 a_2831_n850# b1 0.0621f
C318 a_11231_n850# vdd 0.76641f
C319 a_n18016_n12241# a_n4201_n9190# 0.0473f
C320 a_n2699_n11028# a_n8583_n10876# 1.22379f
C321 a_n8513_n10850# a_n18016_n12241# 0.27777f
C322 a_n9021_n850# a_n19835_n3460# 0.00787f
C323 a_6191_n850# vdd 0.71306f
C324 a_6099_n850# b2 0.06338f
C325 a_2831_n850# vdd 0.71306f
C326 a_n5661_n850# b1 0.05904f
C327 a_11139_n850# a_11231_n850# 0.94626f
C328 a_n5661_n850# a_n7341_n850# 0.09505f
C329 a_n621_n850# b2 0.05892f
C330 a_9551_n850# a_11231_n850# 0.09665f
C331 a_1059_n850# b3 0.07119f
C332 vp a_n10701_n850# 2.0999f
C333 a_n5241_n9240# qp 0.21204f
C334 a_n529_n850# a_n19935_n3730# 0.08015f
C335 a_n7341_n850# b1 0.05904f
C336 a_n5661_n850# vdd 0.22862f
C337 b0 a_1059_n850# 0.10129f
C338 a_n8583_n10876# a_n18016_n12241# 0.37905f
C339 a_n2209_n850# b3 0.09502f
C340 a_n12381_n850# vn 0.00118f
C341 b1 vdd 1.64829f
C342 vp a_4511_n850# 0.00452f
C343 a_4419_n850# vn 0.00118f
C344 a_n7341_n850# vdd 0.22862f
C345 in a_n5241_n9240# 0.78089f
C346 b0 a_n2209_n850# 0.15934f
C347 vp a_1151_n850# 0.00452f
C348 a_n3981_n850# b2 0.71636f
C349 b0 b3 1.22539f
C350 vp a_n12289_n850# 0.01569f
C351 a_11139_n850# b1 0.05861f
C352 a_9459_n850# b3 0.73055f
C353 b2 vn 0.01027f
C354 a_9551_n850# b1 0.06121f
C355 a_n7249_n850# a_n5569_n850# 0.09665f
C356 a_n12381_n850# a_n10701_n850# 0.09505f
C357 a_9459_n850# b0 0.09682f
C358 a_11139_n850# vdd 0.22862f
C359 a_n2209_n850# a_n19935_n3730# 0.08015f
C360 a_9551_n850# vdd 0.71306f
C361 a_n10609_n850# b1 0.06121f
C362 vp a_n529_n850# 0.00452f
C363 b3 a_n19935_n3730# 0.03737f
C364 a_4511_n850# a_4419_n850# 0.94626f
C365 a_n10701_n850# b2 0.05892f
C366 a_n5661_n850# a_n19835_n3460# 0.00839f
C367 a_n12381_n850# a_n12289_n850# 0.94626f
C368 b0 a_n19935_n3730# 0
C369 b1 a_n19835_n3460# 0.00352f
C370 a_11139_n850# a_9551_n850# 0.03465f
C371 a_n2209_n850# a_n3889_n850# 0.09665f
C372 a_n7341_n850# a_n19835_n3460# 0.00839f
C373 a_n10609_n850# vdd 0.71306f
C374 b3 a_n3889_n850# 0.09502f
C375 a_4511_n850# b2 0.56671f
C376 a_1151_n850# b2 0.11629f
C377 vdd a_n19835_n3460# 0.20601f
C378 b0 a_n3889_n850# 0.10384f
C379 a_n12289_n850# b2 0.06079f
C380 a_n5661_n850# a_n5569_n850# 0.94626f
C381 vp a_1059_n850# 2.11099f
C382 qn a_n5241_n9240# 0.22991f
C383 a_n5569_n850# b1 0.06121f
C384 ip qp 0.70266f
C385 ip a_1759_n9240# 0.21184f
C386 a_n7341_n850# a_n5569_n850# 0.00181f
C387 a_7779_n850# b3 0.73055f
C388 a_7871_n850# b3 0.65641f
C389 vp a_n2209_n850# 0.00452f
C390 a_n8583_n10876# vdd 0.19639f
C391 a_7779_n850# b0 0.09682f
C392 a_n5569_n850# vdd 0.71306f
C393 vp b3 0.20222f
C394 a_7871_n850# b0 0.10384f
C395 ip in 3.4166f
C396 a_n19935_n3730# a_n3889_n850# 0.08015f
C397 a_n529_n850# b2 0.06079f
C398 a_7779_n850# a_9459_n850# 0.09505f
C399 b0 vp 0.15611f
C400 a_7871_n850# a_9459_n850# 0.03465f
C401 a_n2699_n11028# a_n5241_n9240# 0.39765f
C402 a_9459_n850# vp 2.0999f
C403 a_n8929_n850# vn 2.09068f
C404 a_n8513_n10850# a_n4201_n9190# 0.8893f
C405 a_n2699_n11028# vn 6.21691f
C406 a_2831_n850# a_2739_n850# 0.94626f
C407 a_7871_n850# a_n19935_n3730# 0.08015f
C408 a_n12381_n850# b3 0.72608f
C409 vp a_n19935_n3730# 0.07798f
C410 a_4419_n850# b3 0.07313f
C411 a_1059_n850# b2 0.06086f
C412 a_n8929_n850# a_n10701_n850# 0.00181f
C413 a_n18016_n12241# a_n5241_n9240# 0.45402f
C414 a_n8583_n10876# a_n4201_n9190# 0.12364f
C415 a_n12381_n850# b0 0.09682f
C416 a_n8513_n10850# a_n8583_n10876# 1.17783f
C417 b0 a_4419_n850# 0.09682f
C418 b1 a_n2301_n850# 0.71206f
C419 a_n2209_n850# b2 0.06168f
C420 a_2739_n850# b1 0.06351f
C421 a_n18016_n12241# vn 0.00387f
C422 a_n9021_n850# vn 0.00118f
C423 vp a_n3889_n850# 0.00452f
C424 b2 b3 7.22491f
C425 a_6191_n850# a_6099_n850# 0.94626f
C426 qn vss 8.91175f
C427 qp vss 7.29737f
C428 in vss 8.03055f
C429 ip vss 8.61965f
C430 b0 vss 12.0685f
C431 b1 vss 8.2988f
C432 b2 vss 11.1236f
C433 b3 vss 19.8673f
C434 vp vss 31.2868f
C435 vn vss 30.2526f
C436 vdd vss 0.19851p
C437 vctrl vss 37.6538f
C438 a_n1616_n13041# vss 4.72102f
C439 a_2319_n11000# vss 4.82254f
C440 a_n2699_n11028# vss 13.4219f
C441 a_n8513_n10850# vss 4.82107f
C442 a_n18016_n12241# vss 15.5219f
C443 a_2799_n9190# vss 1.60341f
C444 a_1759_n9240# vss 1.83132f
C445 a_n4201_n9190# vss 1.61437f
C446 a_n5241_n9240# vss 1.81976f
C447 a_n8583_n10876# vss 19.9366f
C448 a_11231_n850# vss 1.99192f
C449 a_11139_n850# vss 2.6037f
C450 a_9551_n850# vss 1.71728f
C451 a_9459_n850# vss 2.41477f
C452 a_7871_n850# vss 1.71728f
C453 a_7779_n850# vss 2.41802f
C454 a_6191_n850# vss 1.71728f
C455 a_6099_n850# vss 2.41677f
C456 a_4511_n850# vss 1.73017f
C457 a_4419_n850# vss 2.41648f
C458 a_2831_n850# vss 1.72993f
C459 a_2739_n850# vss 2.51052f
C460 a_1151_n850# vss 1.72911f
C461 a_1059_n850# vss 2.50358f
C462 a_n529_n850# vss 1.71728f
C463 a_n621_n850# vss 2.51867f
C464 a_n2209_n850# vss 1.72894f
C465 a_n2301_n850# vss 2.50358f
C466 a_n3889_n850# vss 1.72993f
C467 a_n3981_n850# vss 2.49915f
C468 a_n5569_n850# vss 1.73031f
C469 a_n5661_n850# vss 2.41648f
C470 a_n7249_n850# vss 1.71728f
C471 a_n7341_n850# vss 2.41677f
C472 a_n8929_n850# vss 1.71728f
C473 a_n9021_n850# vss 2.41801f
C474 a_n10609_n850# vss 1.71728f
C475 a_n10701_n850# vss 2.41477f
C476 a_n12289_n850# vss 1.69689f
C477 a_n12381_n850# vss 2.63998f
C478 a_n19935_n3730# vss 71.6408f
C479 a_14859_1604# vss 3.40065f
C480 a_n19835_n3460# vss 0.10962p
.ends
