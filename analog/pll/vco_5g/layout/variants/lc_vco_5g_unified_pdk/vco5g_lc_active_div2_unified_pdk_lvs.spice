* NGSPICE file created from vco5g_lc_active_div2_unified_pdk.ext - technology: sky130A

.subckt vco5g_lc_active_div2_unified_pdk vp vn ip in qp qn vctrl b0 b1 b2 b3 vdd vss
X0 a_1059_n850# b1 a_1151_n850# vss sky130_fd_pr__nfet_01v8_lvt ad=0.66 pd=4.33 as=0.66 ps=4.33 w=4 l=0.15
X1 a_11139_n850# b3 vss vss sky130_fd_pr__nfet_01v8 ad=0.29 pd=2.58 as=0.29 ps=2.58 w=1 l=0.5
X2 a_1151_n850# b1 vdd vdd sky130_fd_pr__pfet_01v8 ad=0.29 pd=2.58 as=0.29 ps=2.58 w=1 l=0.5
X3 vn a_n12289_n850# sky130_fd_pr__cap_mim_m3_1 l=4 w=4
X4 a_n1616_n13041# a_n2699_n11028# vss sky130_fd_pr__res_high_po_1p41 l=80
X5 vn vctrl vss sky130_fd_pr__cap_var_lvt w=5.2 l=0.5
X6 vn vp a_n19519_n3460# vss sky130_fd_pr__nfet_01v8_lvt ad=0.4125 pd=2.83 as=0.775 ps=5.62 w=2.5 l=0.15
X7 a_11231_n850# b3 vss vss sky130_fd_pr__nfet_01v8 ad=0.29 pd=2.58 as=0.29 ps=2.58 w=1 l=0.5
X8 vdd vn vp vdd sky130_fd_pr__pfet_01v8_lvt ad=0.58 pd=4.29 as=0.58 ps=4.29 w=4 l=0.35
X9 a_n10609_n850# b3 a_n10701_n850# vss sky130_fd_pr__nfet_01v8_lvt ad=0.66 pd=4.33 as=0.66 ps=4.33 w=4 l=0.15
X10 a_n3981_n850# b2 a_n3889_n850# vss sky130_fd_pr__nfet_01v8_lvt ad=1.24 pd=8.62 as=0.66 ps=4.33 w=4 l=0.15
X11 a_n5241_n9240# qn ip vss sky130_fd_pr__nfet_01v8_lvt ad=0.66 pd=4.33 as=0.66 ps=4.33 w=4 l=0.15
X12 vp vctrl vss sky130_fd_pr__cap_var_lvt w=5.2 l=0.5
X13 ip qn a_n5241_n9240# vss sky130_fd_pr__nfet_01v8_lvt ad=0.66 pd=4.33 as=0.66 ps=4.33 w=4 l=0.15
X14 vn vctrl vss sky130_fd_pr__cap_var_lvt w=5.2 l=0.5
X15 vp vn a_n19519_n3460# vss sky130_fd_pr__nfet_01v8_lvt ad=0.4125 pd=2.83 as=0.4125 ps=2.83 w=2.5 l=0.15
X16 a_n2209_n850# b1 a_n2301_n850# vss sky130_fd_pr__nfet_01v8_lvt ad=0.66 pd=4.33 as=1.24 ps=8.62 w=4 l=0.15
X17 a_n5661_n850# b2 vdd vdd sky130_fd_pr__pfet_01v8 ad=0.29 pd=2.58 as=0.29 ps=2.58 w=1 l=0.5
X18 vdd a_n1616_n13041# vss sky130_fd_pr__res_high_po_1p41 l=60
X19 a_2739_n850# b2 a_2831_n850# vss sky130_fd_pr__nfet_01v8_lvt ad=0.66 pd=4.33 as=0.66 ps=4.33 w=4 l=0.15
X20 a_n19519_n3460# vn vp vss sky130_fd_pr__nfet_01v8_lvt ad=0.4125 pd=2.83 as=0.4125 ps=2.83 w=2.5 l=0.15
X21 a_n10609_n850# b3 vdd vdd sky130_fd_pr__pfet_01v8 ad=0.29 pd=2.58 as=0.29 ps=2.58 w=1 l=0.5
X22 a_n19519_n3460# a_n19619_n3730# vss vss sky130_fd_pr__nfet_01v8 ad=0.725 pd=5.29 as=0.725 ps=5.29 w=5 l=0.5
X23 vn a_6191_n850# sky130_fd_pr__cap_mim_m3_1 l=4 w=4
X24 qn qp a_2799_n9190# vss sky130_fd_pr__nfet_01v8_lvt ad=0.5775 pd=3.83 as=0.5775 ps=3.83 w=3.5 l=0.15
X25 a_n5241_n9240# qp in vss sky130_fd_pr__nfet_01v8_lvt ad=0.66 pd=4.33 as=0.66 ps=4.33 w=4 l=0.15
X26 a_2799_n9190# qp qn vss sky130_fd_pr__nfet_01v8_lvt ad=0.5775 pd=3.83 as=0.5775 ps=3.83 w=3.5 l=0.15
X27 in qp a_n5241_n9240# vss sky130_fd_pr__nfet_01v8_lvt ad=0.66 pd=4.33 as=0.66 ps=4.33 w=4 l=0.15
X28 a_9551_n850# b3 a_9459_n850# vss sky130_fd_pr__nfet_01v8_lvt ad=0.66 pd=4.33 as=0.66 ps=4.33 w=4 l=0.15
X29 a_n19519_n3460# vp vn vss sky130_fd_pr__nfet_01v8_lvt ad=0.4125 pd=2.83 as=0.4125 ps=2.83 w=2.5 l=0.15
X30 a_n10609_n850# b3 vss vss sky130_fd_pr__nfet_01v8 ad=0.29 pd=2.58 as=0.29 ps=2.58 w=1 l=0.5
X31 a_n7249_n850# b3 a_n7341_n850# vss sky130_fd_pr__nfet_01v8_lvt ad=0.66 pd=4.33 as=0.66 ps=4.33 w=4 l=0.15
X32 a_6099_n850# b3 vss vss sky130_fd_pr__nfet_01v8 ad=0.29 pd=2.58 as=0.29 ps=2.58 w=1 l=0.5
X33 vn vp vdd vdd sky130_fd_pr__pfet_01v8_lvt ad=0.58 pd=4.29 as=0.58 ps=4.29 w=4 l=0.35
X34 a_n3889_n850# b2 vdd vdd sky130_fd_pr__pfet_01v8 ad=0.29 pd=2.58 as=0.29 ps=2.58 w=1 l=0.5
X35 a_6191_n850# b3 vss vss sky130_fd_pr__nfet_01v8 ad=0.29 pd=2.58 as=0.29 ps=2.58 w=1 l=0.5
X36 vss a_n19619_n3730# a_n19519_n3460# vss sky130_fd_pr__nfet_01v8 ad=1.45 pd=10.58 as=0.725 ps=5.29 w=5 l=0.5
X37 vss a_n8583_n10876# a_n8513_n10850# vss sky130_fd_pr__nfet_01v8 ad=0.6525 pd=4.79 as=0.6525 ps=4.79 w=4.5 l=0.35
X38 vp vn vdd vdd sky130_fd_pr__pfet_01v8_lvt ad=0.58 pd=4.29 as=0.58 ps=4.29 w=4 l=0.35
X39 vn vp a_n19519_n3460# vss sky130_fd_pr__nfet_01v8_lvt ad=0.4125 pd=2.83 as=0.4125 ps=2.83 w=2.5 l=0.15
X40 qp qn a_2799_n9190# vss sky130_fd_pr__nfet_01v8_lvt ad=0.5775 pd=3.83 as=0.5775 ps=3.83 w=3.5 l=0.15
X41 a_n621_n850# b0 vdd vdd sky130_fd_pr__pfet_01v8 ad=0.29 pd=2.58 as=0.29 ps=2.58 w=1 l=0.5
X42 vp a_n5661_n850# sky130_fd_pr__cap_mim_m3_1 l=4 w=4
X43 a_2799_n9190# qn qp vss sky130_fd_pr__nfet_01v8_lvt ad=0.5775 pd=3.83 as=0.5775 ps=3.83 w=3.5 l=0.15
X44 a_6191_n850# b3 a_6099_n850# vss sky130_fd_pr__nfet_01v8_lvt ad=0.66 pd=4.33 as=0.66 ps=4.33 w=4 l=0.15
X45 a_2319_n11000# a_n8583_n10876# vss vss sky130_fd_pr__nfet_01v8 ad=0.6525 pd=4.79 as=0.6525 ps=4.79 w=4.5 l=0.35
X46 a_n8513_n10850# a_n2699_n11028# a_n4201_n9190# vss sky130_fd_pr__nfet_01v8_lvt ad=0.825 pd=5.33 as=0.825 ps=5.33 w=5 l=0.15
X47 vp vn vdd vdd sky130_fd_pr__pfet_01v8_lvt ad=0.58 pd=4.29 as=0.58 ps=4.29 w=4 l=0.35
X48 a_n7249_n850# b3 vss vss sky130_fd_pr__nfet_01v8 ad=0.29 pd=2.58 as=0.29 ps=2.58 w=1 l=0.5
X49 vp vn a_n19519_n3460# vss sky130_fd_pr__nfet_01v8_lvt ad=0.4125 pd=2.83 as=0.4125 ps=2.83 w=2.5 l=0.15
X50 vss a_n19619_n3730# a_n19519_n3460# vss sky130_fd_pr__nfet_01v8 ad=0.725 pd=5.29 as=0.725 ps=5.29 w=5 l=0.5
X51 vn a_n5569_n850# sky130_fd_pr__cap_mim_m3_1 l=4 w=4
X52 vn a_n8929_n850# sky130_fd_pr__cap_mim_m3_1 l=4 w=4
X53 a_2799_n9190# a_n18016_n12241# a_2319_n11000# vss sky130_fd_pr__nfet_01v8_lvt ad=0.825 pd=5.33 as=0.825 ps=5.33 w=5 l=0.15
X54 a_7779_n850# b3 a_7871_n850# vss sky130_fd_pr__nfet_01v8_lvt ad=0.66 pd=4.33 as=0.66 ps=4.33 w=4 l=0.15
X55 ip in a_n4201_n9190# vss sky130_fd_pr__nfet_01v8_lvt ad=0.5775 pd=3.83 as=1.085 ps=7.62 w=3.5 l=0.15
X56 vp a_n18016_n12241# sky130_fd_pr__cap_mim_m3_1 l=8 w=8
X57 a_n19519_n3460# vn vp vss sky130_fd_pr__nfet_01v8_lvt ad=0.4125 pd=2.83 as=0.4125 ps=2.83 w=2.5 l=0.15
X58 a_n12289_n850# b3 a_n12381_n850# vss sky130_fd_pr__nfet_01v8_lvt ad=0.66 pd=4.33 as=0.66 ps=4.33 w=4 l=0.15
X59 vdd qp vss sky130_fd_pr__res_high_po_2p85 l=5.6
X60 vp a_n2301_n850# sky130_fd_pr__cap_mim_m3_1 l=4 w=4
X61 vn vp a_n19519_n3460# vss sky130_fd_pr__nfet_01v8_lvt ad=0.4125 pd=2.83 as=0.4125 ps=2.83 w=2.5 l=0.15
X62 a_n5661_n850# b2 a_n5569_n850# vss sky130_fd_pr__nfet_01v8_lvt ad=1.24 pd=8.62 as=0.66 ps=4.33 w=4 l=0.15
X63 a_n4201_n9190# a_n2699_n11028# a_n8513_n10850# vss sky130_fd_pr__nfet_01v8_lvt ad=0.825 pd=5.33 as=0.825 ps=5.33 w=5 l=0.15
X64 a_n529_n850# b0 a_n621_n850# vss sky130_fd_pr__nfet_01v8_lvt ad=0.66 pd=4.33 as=1.24 ps=8.62 w=4 l=0.15
X65 a_n8513_n10850# a_n8583_n10876# vss vss sky130_fd_pr__nfet_01v8 ad=0.6525 pd=4.79 as=0.6525 ps=4.79 w=4.5 l=0.35
X66 vdd vn vp vdd sky130_fd_pr__pfet_01v8_lvt ad=0.58 pd=4.29 as=0.58 ps=4.29 w=4 l=0.35
X67 a_9459_n850# b3 vss vss sky130_fd_pr__nfet_01v8 ad=0.29 pd=2.58 as=0.29 ps=2.58 w=1 l=0.5
X68 a_n19519_n3460# a_n19619_n3730# vss vss sky130_fd_pr__nfet_01v8 ad=0.725 pd=5.29 as=0.725 ps=5.29 w=5 l=0.5
X69 a_n19519_n3460# vp vn vss sky130_fd_pr__nfet_01v8_lvt ad=0.4125 pd=2.83 as=0.4125 ps=2.83 w=2.5 l=0.15
X70 a_n8929_n850# b3 a_n9021_n850# vss sky130_fd_pr__nfet_01v8_lvt ad=0.66 pd=4.33 as=1.24 ps=8.62 w=4 l=0.15
X71 a_2319_n11000# a_n18016_n12241# a_2799_n9190# vss sky130_fd_pr__nfet_01v8_lvt ad=0.825 pd=5.33 as=0.825 ps=5.33 w=5 l=0.15
X72 in ip a_n4201_n9190# vss sky130_fd_pr__nfet_01v8_lvt ad=0.5775 pd=3.83 as=1.085 ps=7.62 w=3.5 l=0.15
X73 vdd vp vn vdd sky130_fd_pr__pfet_01v8_lvt ad=0.58 pd=4.29 as=0.58 ps=4.29 w=4 l=0.35
X74 a_4419_n850# b2 a_4511_n850# vss sky130_fd_pr__nfet_01v8_lvt ad=0.66 pd=4.33 as=0.66 ps=4.33 w=4 l=0.15
X75 vp vctrl vss sky130_fd_pr__cap_var_lvt w=5.2 l=0.5
X76 vdd vn vp vdd sky130_fd_pr__pfet_01v8_lvt ad=0.58 pd=4.29 as=0.58 ps=4.29 w=4 l=0.35
X77 vn vctrl vss sky130_fd_pr__cap_var_lvt w=5.2 l=0.5
X78 a_n7341_n850# b3 a_n7249_n850# vss sky130_fd_pr__nfet_01v8_lvt ad=1.24 pd=8.62 as=0.66 ps=4.33 w=4 l=0.15
X79 vdd vp vn vdd sky130_fd_pr__pfet_01v8_lvt ad=0.58 pd=4.29 as=0.58 ps=4.29 w=4 l=0.35
X80 a_7779_n850# b3 vss vss sky130_fd_pr__nfet_01v8 ad=0.29 pd=2.58 as=0.29 ps=2.58 w=1 l=0.5
X81 a_11139_n850# b3 vdd vdd sky130_fd_pr__pfet_01v8 ad=0.29 pd=2.58 as=0.29 ps=2.58 w=1 l=0.5
X82 vp vctrl vss sky130_fd_pr__cap_var_lvt w=5.2 l=0.5
X83 vp vn a_n19519_n3460# vss sky130_fd_pr__nfet_01v8_lvt ad=0.4125 pd=2.83 as=0.4125 ps=2.83 w=2.5 l=0.15
X84 a_n5569_n850# b2 a_n5661_n850# vss sky130_fd_pr__nfet_01v8_lvt ad=0.66 pd=4.33 as=1.24 ps=8.62 w=4 l=0.15
X85 a_n8513_n10850# a_n8583_n10876# vss vss sky130_fd_pr__nfet_01v8 ad=0.6525 pd=4.79 as=0.6525 ps=4.79 w=4.5 l=0.35
X86 a_n19619_n3730# a_14859_1604# vss sky130_fd_pr__res_high_po_1p41 l=10
X87 vn a_n2209_n850# sky130_fd_pr__cap_mim_m3_1 l=4 w=4
X88 vp a_1059_n850# sky130_fd_pr__cap_mim_m3_1 l=4 w=4
X89 a_7871_n850# b3 a_7779_n850# vss sky130_fd_pr__nfet_01v8_lvt ad=0.66 pd=4.33 as=0.66 ps=4.33 w=4 l=0.15
X90 vss a_n8583_n10876# a_2319_n11000# vss sky130_fd_pr__nfet_01v8 ad=0.6525 pd=4.79 as=0.6525 ps=4.79 w=4.5 l=0.35
X91 a_2831_n850# b2 a_2739_n850# vss sky130_fd_pr__nfet_01v8_lvt ad=0.66 pd=4.33 as=1.24 ps=8.62 w=4 l=0.15
X92 a_4419_n850# b2 vss vss sky130_fd_pr__nfet_01v8 ad=0.29 pd=2.58 as=0.29 ps=2.58 w=1 l=0.5
X93 a_11231_n850# b3 a_11139_n850# vss sky130_fd_pr__nfet_01v8_lvt ad=0.66 pd=4.33 as=0.66 ps=4.33 w=4 l=0.15
X94 a_n18016_n12241# a_n1616_n13041# vss sky130_fd_pr__res_high_po_1p41 l=80
X95 vn vp vdd vdd sky130_fd_pr__pfet_01v8_lvt ad=0.58 pd=4.29 as=0.58 ps=4.29 w=4 l=0.35
X96 vn a_7871_n850# sky130_fd_pr__cap_mim_m3_1 l=4 w=4
X97 qn in a_1759_n9240# vss sky130_fd_pr__nfet_01v8_lvt ad=0.66 pd=4.33 as=0.66 ps=4.33 w=4 l=0.15
X98 a_n621_n850# b0 vss vss sky130_fd_pr__nfet_01v8 ad=0.29 pd=2.58 as=0.29 ps=2.58 w=1 l=0.5
X99 a_1059_n850# b1 a_1151_n850# vss sky130_fd_pr__nfet_01v8_lvt ad=1.24 pd=8.62 as=0.66 ps=4.33 w=4 l=0.15
X100 a_9459_n850# b3 a_9551_n850# vss sky130_fd_pr__nfet_01v8_lvt ad=0.66 pd=4.33 as=0.66 ps=4.33 w=4 l=0.15
X101 vp a_n621_n850# sky130_fd_pr__cap_mim_m3_1 l=4 w=4
X102 a_1759_n9240# in qn vss sky130_fd_pr__nfet_01v8_lvt ad=0.66 pd=4.33 as=0.66 ps=4.33 w=4 l=0.15
X103 a_n10701_n850# b3 vdd vdd sky130_fd_pr__pfet_01v8 ad=0.29 pd=2.58 as=0.29 ps=2.58 w=1 l=0.5
X104 vdd qn vss sky130_fd_pr__res_high_po_2p85 l=5.6
X105 vn vp vdd vdd sky130_fd_pr__pfet_01v8_lvt ad=0.58 pd=4.29 as=0.58 ps=4.29 w=4 l=0.35
X106 vn vp a_n19519_n3460# vss sky130_fd_pr__nfet_01v8_lvt ad=0.4125 pd=2.83 as=0.4125 ps=2.83 w=2.5 l=0.15
X107 vdd qn vss sky130_fd_pr__res_high_po_2p85 l=5.6
X108 vp a_2739_n850# sky130_fd_pr__cap_mim_m3_1 l=4 w=4
X109 a_n10609_n850# b3 a_n10701_n850# vss sky130_fd_pr__nfet_01v8_lvt ad=0.66 pd=4.33 as=1.24 ps=8.62 w=4 l=0.15
X110 vp a_n9021_n850# sky130_fd_pr__cap_mim_m3_1 l=4 w=4
X111 vss a_n8583_n10876# a_2319_n11000# vss sky130_fd_pr__nfet_01v8 ad=0.6525 pd=4.79 as=0.6525 ps=4.79 w=4.5 l=0.35
X112 vp vn vdd vdd sky130_fd_pr__pfet_01v8_lvt ad=0.58 pd=4.29 as=0.58 ps=4.29 w=4 l=0.35
X113 a_n3981_n850# b2 a_n3889_n850# vss sky130_fd_pr__nfet_01v8_lvt ad=0.66 pd=4.33 as=0.66 ps=4.33 w=4 l=0.15
X114 a_n19519_n3460# vp vn vss sky130_fd_pr__nfet_01v8_lvt ad=0.4125 pd=2.83 as=0.4125 ps=2.83 w=2.5 l=0.15
X115 a_1759_n9240# a_n2699_n11028# a_2319_n11000# vss sky130_fd_pr__nfet_01v8_lvt ad=0.825 pd=5.33 as=1.55 ps=10.62 w=5 l=0.15
X116 qp ip a_1759_n9240# vss sky130_fd_pr__nfet_01v8_lvt ad=0.66 pd=4.33 as=0.66 ps=4.33 w=4 l=0.15
X117 a_1759_n9240# ip qp vss sky130_fd_pr__nfet_01v8_lvt ad=0.66 pd=4.33 as=0.66 ps=4.33 w=4 l=0.15
X118 a_6099_n850# b3 a_6191_n850# vss sky130_fd_pr__nfet_01v8_lvt ad=0.66 pd=4.33 as=0.66 ps=4.33 w=4 l=0.15
X119 vn a_n10609_n850# sky130_fd_pr__cap_mim_m3_1 l=4 w=4
X120 a_n8929_n850# b3 vdd vdd sky130_fd_pr__pfet_01v8 ad=0.29 pd=2.58 as=0.29 ps=2.58 w=1 l=0.5
X121 a_n19519_n3460# vn vp vss sky130_fd_pr__nfet_01v8_lvt ad=0.775 pd=5.62 as=0.4125 ps=2.83 w=2.5 l=0.15
X122 a_n621_n850# b0 a_n529_n850# vss sky130_fd_pr__nfet_01v8_lvt ad=1.24 pd=8.62 as=0.66 ps=4.33 w=4 l=0.15
X123 a_n529_n850# b0 vdd vdd sky130_fd_pr__pfet_01v8 ad=0.29 pd=2.58 as=0.29 ps=2.58 w=1 l=0.5
X124 a_11231_n850# b3 vdd vdd sky130_fd_pr__pfet_01v8 ad=0.29 pd=2.58 as=0.29 ps=2.58 w=1 l=0.5
X125 vn a_n2699_n11028# sky130_fd_pr__cap_mim_m3_1 l=8 w=8
X126 a_n8513_n10850# a_n18016_n12241# a_n5241_n9240# vss sky130_fd_pr__nfet_01v8_lvt ad=0.825 pd=5.33 as=0.825 ps=5.33 w=5 l=0.15
X127 vss a_n8583_n10876# a_n8513_n10850# vss sky130_fd_pr__nfet_01v8 ad=1.305 pd=9.58 as=0.6525 ps=4.79 w=4.5 l=0.35
X128 a_n9021_n850# b3 a_n8929_n850# vss sky130_fd_pr__nfet_01v8_lvt ad=1.24 pd=8.62 as=0.66 ps=4.33 w=4 l=0.15
X129 ip qn a_n5241_n9240# vss sky130_fd_pr__nfet_01v8_lvt ad=0.66 pd=4.33 as=1.24 ps=8.62 w=4 l=0.15
X130 vss a_n8583_n10876# a_n8513_n10850# vss sky130_fd_pr__nfet_01v8 ad=0.6525 pd=4.79 as=0.6525 ps=4.79 w=4.5 l=0.35
X131 a_n19519_n3460# vp vn vss sky130_fd_pr__nfet_01v8_lvt ad=0.4125 pd=2.83 as=0.4125 ps=2.83 w=2.5 l=0.15
X132 a_n7249_n850# b3 a_n7341_n850# vss sky130_fd_pr__nfet_01v8_lvt ad=0.66 pd=4.33 as=1.24 ps=8.62 w=4 l=0.15
X133 a_2319_n11000# a_n8583_n10876# vss vss sky130_fd_pr__nfet_01v8 ad=0.6525 pd=4.79 as=1.305 ps=9.58 w=4.5 l=0.35
X134 vdd vp vn vdd sky130_fd_pr__pfet_01v8_lvt ad=0.58 pd=4.29 as=0.58 ps=4.29 w=4 l=0.35
X135 a_9459_n850# b3 vdd vdd sky130_fd_pr__pfet_01v8 ad=0.29 pd=2.58 as=0.29 ps=2.58 w=1 l=0.5
X136 vn a_4511_n850# sky130_fd_pr__cap_mim_m3_1 l=4 w=4
X137 vn a_1151_n850# sky130_fd_pr__cap_mim_m3_1 l=4 w=4
X138 vn vp a_n19519_n3460# vss sky130_fd_pr__nfet_01v8_lvt ad=0.4125 pd=2.83 as=0.4125 ps=2.83 w=2.5 l=0.15
X139 vp a_7779_n850# sky130_fd_pr__cap_mim_m3_1 l=4 w=4
X140 in qp a_n5241_n9240# vss sky130_fd_pr__nfet_01v8_lvt ad=0.66 pd=4.33 as=1.24 ps=8.62 w=4 l=0.15
X141 a_n5241_n9240# a_n18016_n12241# a_n8513_n10850# vss sky130_fd_pr__nfet_01v8_lvt ad=0.825 pd=5.33 as=0.825 ps=5.33 w=5 l=0.15
X142 a_2799_n9190# qp qn vss sky130_fd_pr__nfet_01v8_lvt ad=1.085 pd=7.62 as=0.5775 ps=3.83 w=3.5 l=0.15
X143 vdd vp vn vdd sky130_fd_pr__pfet_01v8_lvt ad=0.58 pd=4.29 as=0.58 ps=4.29 w=4 l=0.35
X144 a_n12381_n850# b3 vdd vdd sky130_fd_pr__pfet_01v8 ad=0.29 pd=2.58 as=0.29 ps=2.58 w=1 l=0.5
X145 vp vn a_n19519_n3460# vss sky130_fd_pr__nfet_01v8_lvt ad=0.4125 pd=2.83 as=0.4125 ps=2.83 w=2.5 l=0.15
X146 vp a_n10701_n850# sky130_fd_pr__cap_mim_m3_1 l=4 w=4
X147 a_n4201_n9190# in ip vss sky130_fd_pr__nfet_01v8_lvt ad=1.085 pd=7.62 as=0.5775 ps=3.83 w=3.5 l=0.15
X148 a_n8513_n10850# a_n8583_n10876# vss vss sky130_fd_pr__nfet_01v8 ad=0.6525 pd=4.79 as=0.6525 ps=4.79 w=4.5 l=0.35
X149 a_n2301_n850# b1 vss vss sky130_fd_pr__nfet_01v8 ad=0.29 pd=2.58 as=0.29 ps=2.58 w=1 l=0.5
X150 vss a_n19619_n3730# a_n19519_n3460# vss sky130_fd_pr__nfet_01v8 ad=0.725 pd=5.29 as=0.725 ps=5.29 w=5 l=0.5
X151 a_n19519_n3460# vn vp vss sky130_fd_pr__nfet_01v8_lvt ad=0.4125 pd=2.83 as=0.4125 ps=2.83 w=2.5 l=0.15
X152 a_n12289_n850# b3 vss vss sky130_fd_pr__nfet_01v8 ad=0.29 pd=2.58 as=0.29 ps=2.58 w=1 l=0.5
X153 vp a_4419_n850# sky130_fd_pr__cap_mim_m3_1 l=4 w=4
X154 vp vctrl vss sky130_fd_pr__cap_var_lvt w=5.2 l=0.5
X155 a_n12289_n850# b3 a_n12381_n850# vss sky130_fd_pr__nfet_01v8_lvt ad=0.66 pd=4.33 as=1.24 ps=8.62 w=4 l=0.15
X156 vss a_n19619_n3730# a_n19519_n3460# vss sky130_fd_pr__nfet_01v8 ad=0.725 pd=5.29 as=0.725 ps=5.29 w=5 l=0.5
X157 a_2799_n9190# a_n18016_n12241# a_2319_n11000# vss sky130_fd_pr__nfet_01v8_lvt ad=0.825 pd=5.33 as=1.55 ps=10.62 w=5 l=0.15
X158 a_2799_n9190# qn qp vss sky130_fd_pr__nfet_01v8_lvt ad=1.085 pd=7.62 as=0.5775 ps=3.83 w=3.5 l=0.15
X159 vdd vn vp vdd sky130_fd_pr__pfet_01v8_lvt ad=0.58 pd=4.29 as=0.58 ps=4.29 w=4 l=0.35
X160 a_n5661_n850# b2 a_n5569_n850# vss sky130_fd_pr__nfet_01v8_lvt ad=0.66 pd=4.33 as=0.66 ps=4.33 w=4 l=0.15
X161 a_1151_n850# b1 a_1059_n850# vss sky130_fd_pr__nfet_01v8_lvt ad=0.66 pd=4.33 as=1.24 ps=8.62 w=4 l=0.15
X162 a_n9021_n850# b3 vdd vdd sky130_fd_pr__pfet_01v8 ad=0.29 pd=2.58 as=0.29 ps=2.58 w=1 l=0.5
X163 vn a_n3889_n850# sky130_fd_pr__cap_mim_m3_1 l=4 w=4
X164 vdd ip vss sky130_fd_pr__res_high_po_2p85 l=5.6
X165 a_n4201_n9190# ip in vss sky130_fd_pr__nfet_01v8_lvt ad=1.085 pd=7.62 as=0.5775 ps=3.83 w=3.5 l=0.15
X166 vn vctrl vss sky130_fd_pr__cap_var_lvt w=5.2 l=0.5
X167 a_n19519_n3460# vp vn vss sky130_fd_pr__nfet_01v8_lvt ad=0.775 pd=5.62 as=0.4125 ps=2.83 w=2.5 l=0.15
X168 a_n10701_n850# b3 a_n10609_n850# vss sky130_fd_pr__nfet_01v8_lvt ad=1.24 pd=8.62 as=0.66 ps=4.33 w=4 l=0.15
X169 a_4419_n850# b2 a_4511_n850# vss sky130_fd_pr__nfet_01v8_lvt ad=1.24 pd=8.62 as=0.66 ps=4.33 w=4 l=0.15
X170 a_7779_n850# b3 vdd vdd sky130_fd_pr__pfet_01v8 ad=0.29 pd=2.58 as=0.29 ps=2.58 w=1 l=0.5
X171 a_n19519_n3460# a_n19619_n3730# vss vss sky130_fd_pr__nfet_01v8 ad=0.725 pd=5.29 as=0.725 ps=5.29 w=5 l=0.5
X172 vdd vn vp vdd sky130_fd_pr__pfet_01v8_lvt ad=0.58 pd=4.29 as=0.58 ps=4.29 w=4 l=0.35
X173 a_11139_n850# b3 a_11231_n850# vss sky130_fd_pr__nfet_01v8_lvt ad=0.66 pd=4.33 as=0.66 ps=4.33 w=4 l=0.15
X174 vdd qp vss sky130_fd_pr__res_high_po_2p85 l=5.6
X175 vp a_n7341_n850# sky130_fd_pr__cap_mim_m3_1 l=4 w=4
X176 a_2319_n11000# a_n8583_n10876# vss vss sky130_fd_pr__nfet_01v8 ad=0.6525 pd=4.79 as=0.6525 ps=4.79 w=4.5 l=0.35
X177 a_2319_n11000# a_n2699_n11028# a_1759_n9240# vss sky130_fd_pr__nfet_01v8_lvt ad=1.55 pd=10.62 as=0.825 ps=5.33 w=5 l=0.15
X178 vp vctrl vss sky130_fd_pr__cap_var_lvt w=5.2 l=0.5
X179 a_n19519_n3460# vn vp vss sky130_fd_pr__nfet_01v8_lvt ad=0.4125 pd=2.83 as=0.4125 ps=2.83 w=2.5 l=0.15
X180 a_n2301_n850# b1 a_n2209_n850# vss sky130_fd_pr__nfet_01v8_lvt ad=0.66 pd=4.33 as=0.66 ps=4.33 w=4 l=0.15
X181 a_n7249_n850# b3 vdd vdd sky130_fd_pr__pfet_01v8 ad=0.29 pd=2.58 as=0.29 ps=2.58 w=1 l=0.5
X182 a_4511_n850# b2 vdd vdd sky130_fd_pr__pfet_01v8 ad=0.29 pd=2.58 as=0.29 ps=2.58 w=1 l=0.5
X183 a_n19519_n3460# a_n19619_n3730# vss vss sky130_fd_pr__nfet_01v8 ad=0.725 pd=5.29 as=1.45 ps=10.58 w=5 l=0.5
X184 vn vp vdd vdd sky130_fd_pr__pfet_01v8_lvt ad=0.58 pd=4.29 as=0.58 ps=4.29 w=4 l=0.35
X185 vp vn a_n19519_n3460# vss sky130_fd_pr__nfet_01v8_lvt ad=0.4125 pd=2.83 as=0.4125 ps=2.83 w=2.5 l=0.15
X186 a_n3889_n850# b2 a_n3981_n850# vss sky130_fd_pr__nfet_01v8_lvt ad=0.66 pd=4.33 as=0.66 ps=4.33 w=4 l=0.15
X187 a_2831_n850# b2 vss vss sky130_fd_pr__nfet_01v8 ad=0.29 pd=2.58 as=0.29 ps=2.58 w=1 l=0.5
X188 vp a_9459_n850# sky130_fd_pr__cap_mim_m3_1 l=4 w=4
X189 vp vn vdd vdd sky130_fd_pr__pfet_01v8_lvt ad=0.58 pd=4.29 as=0.58 ps=4.29 w=4 l=0.35
X190 a_n3981_n850# b2 vdd vdd sky130_fd_pr__pfet_01v8 ad=0.29 pd=2.58 as=0.29 ps=2.58 w=1 l=0.5
X191 a_n8513_n10850# a_n2699_n11028# a_n4201_n9190# vss sky130_fd_pr__nfet_01v8_lvt ad=1.55 pd=10.62 as=0.825 ps=5.33 w=5 l=0.15
X192 a_n8513_n10850# a_n8583_n10876# vss vss sky130_fd_pr__nfet_01v8 ad=0.6525 pd=4.79 as=1.305 ps=9.58 w=4.5 l=0.35
X193 vn vp vdd vdd sky130_fd_pr__pfet_01v8_lvt ad=0.58 pd=4.29 as=1.16 ps=8.58 w=4 l=0.35
X194 vn a_11231_n850# sky130_fd_pr__cap_mim_m3_1 l=4 w=4
X195 vn vp vdd vdd sky130_fd_pr__pfet_01v8_lvt ad=0.58 pd=4.29 as=0.58 ps=4.29 w=4 l=0.35
X196 a_n1616_n13041# vss vss sky130_fd_pr__res_high_po_1p41 l=96
X197 vss a_n8583_n10876# a_2319_n11000# vss sky130_fd_pr__nfet_01v8 ad=0.6525 pd=4.79 as=0.6525 ps=4.79 w=4.5 l=0.35
X198 a_2739_n850# b2 vdd vdd sky130_fd_pr__pfet_01v8 ad=0.29 pd=2.58 as=0.29 ps=2.58 w=1 l=0.5
X199 vp a_n12381_n850# sky130_fd_pr__cap_mim_m3_1 l=4 w=4
X200 vss a_n8583_n10876# a_2319_n11000# vss sky130_fd_pr__nfet_01v8 ad=1.305 pd=9.58 as=0.6525 ps=4.79 w=4.5 l=0.35
X201 vn vp vdd vdd sky130_fd_pr__pfet_01v8_lvt ad=0.58 pd=4.29 as=0.58 ps=4.29 w=4 l=0.35
X202 a_n3981_n850# b2 vss vss sky130_fd_pr__nfet_01v8 ad=0.29 pd=2.58 as=0.29 ps=2.58 w=1 l=0.5
X203 a_9459_n850# b3 a_9551_n850# vss sky130_fd_pr__nfet_01v8_lvt ad=1.24 pd=8.62 as=0.66 ps=4.33 w=4 l=0.15
X204 vp a_6099_n850# sky130_fd_pr__cap_mim_m3_1 l=4 w=4
X205 vn vp a_n19519_n3460# vss sky130_fd_pr__nfet_01v8_lvt ad=0.4125 pd=2.83 as=0.4125 ps=2.83 w=2.5 l=0.15
X206 a_n2209_n850# b1 vdd vdd sky130_fd_pr__pfet_01v8 ad=0.29 pd=2.58 as=0.29 ps=2.58 w=1 l=0.5
X207 a_n19519_n3460# a_n19619_n3730# vss vss sky130_fd_pr__nfet_01v8 ad=0.725 pd=5.29 as=0.725 ps=5.29 w=5 l=0.5
X208 vn a_n529_n850# sky130_fd_pr__cap_mim_m3_1 l=4 w=4
X209 a_7871_n850# b3 a_7779_n850# vss sky130_fd_pr__nfet_01v8_lvt ad=0.66 pd=4.33 as=1.24 ps=8.62 w=4 l=0.15
X210 vss a_n8583_n10876# a_n8513_n10850# vss sky130_fd_pr__nfet_01v8 ad=0.6525 pd=4.79 as=0.6525 ps=4.79 w=4.5 l=0.35
X211 a_n12381_n850# b3 a_n12289_n850# vss sky130_fd_pr__nfet_01v8_lvt ad=1.24 pd=8.62 as=0.66 ps=4.33 w=4 l=0.15
X212 a_6099_n850# b3 a_6191_n850# vss sky130_fd_pr__nfet_01v8_lvt ad=1.24 pd=8.62 as=0.66 ps=4.33 w=4 l=0.15
X213 a_9551_n850# b3 vdd vdd sky130_fd_pr__pfet_01v8 ad=0.29 pd=2.58 as=0.29 ps=2.58 w=1 l=0.5
X214 a_1759_n9240# in qn vss sky130_fd_pr__nfet_01v8_lvt ad=1.24 pd=8.62 as=0.66 ps=4.33 w=4 l=0.15
X215 a_n19519_n3460# vn vp vss sky130_fd_pr__nfet_01v8_lvt ad=0.4125 pd=2.83 as=0.4125 ps=2.83 w=2.5 l=0.15
X216 a_n5661_n850# b2 vss vss sky130_fd_pr__nfet_01v8 ad=0.29 pd=2.58 as=0.29 ps=2.58 w=1 l=0.5
X217 a_n621_n850# b0 a_n529_n850# vss sky130_fd_pr__nfet_01v8_lvt ad=0.66 pd=4.33 as=0.66 ps=4.33 w=4 l=0.15
X218 vss a_n19619_n3730# a_n19519_n3460# vss sky130_fd_pr__nfet_01v8 ad=0.725 pd=5.29 as=0.725 ps=5.29 w=5 l=0.5
X219 a_n5241_n9240# qn ip vss sky130_fd_pr__nfet_01v8_lvt ad=1.24 pd=8.62 as=0.66 ps=4.33 w=4 l=0.15
X220 vp vn a_n19519_n3460# vss sky130_fd_pr__nfet_01v8_lvt ad=0.4125 pd=2.83 as=0.4125 ps=2.83 w=2.5 l=0.15
X221 a_n9021_n850# b3 a_n8929_n850# vss sky130_fd_pr__nfet_01v8_lvt ad=0.66 pd=4.33 as=0.66 ps=4.33 w=4 l=0.15
X222 a_4511_n850# b2 a_4419_n850# vss sky130_fd_pr__nfet_01v8_lvt ad=0.66 pd=4.33 as=1.24 ps=8.62 w=4 l=0.15
X223 vdd in vss sky130_fd_pr__res_high_po_2p85 l=5.6
X224 a_1759_n9240# ip qp vss sky130_fd_pr__nfet_01v8_lvt ad=1.24 pd=8.62 as=0.66 ps=4.33 w=4 l=0.15
X225 vdd vp vn vdd sky130_fd_pr__pfet_01v8_lvt ad=1.16 pd=8.58 as=0.58 ps=4.29 w=4 l=0.35
X226 a_n19519_n3460# vp vn vss sky130_fd_pr__nfet_01v8_lvt ad=0.4125 pd=2.83 as=0.4125 ps=2.83 w=2.5 l=0.15
X227 a_n5569_n850# b2 a_n5661_n850# vss sky130_fd_pr__nfet_01v8_lvt ad=0.66 pd=4.33 as=0.66 ps=4.33 w=4 l=0.15
X228 a_2739_n850# b2 a_2831_n850# vss sky130_fd_pr__nfet_01v8_lvt ad=1.24 pd=8.62 as=0.66 ps=4.33 w=4 l=0.15
X229 vdd in vss sky130_fd_pr__res_high_po_2p85 l=5.6
X230 vdd vn vp vdd sky130_fd_pr__pfet_01v8_lvt ad=0.58 pd=4.29 as=0.58 ps=4.29 w=4 l=0.35
X231 a_4511_n850# b2 vss vss sky130_fd_pr__nfet_01v8 ad=0.29 pd=2.58 as=0.29 ps=2.58 w=1 l=0.5
X232 a_n8583_n10876# a_n8583_n10876# vss vss sky130_fd_pr__nfet_01v8 ad=0.435 pd=3.29 as=0.87 ps=6.58 w=3 l=0.35
X233 qn qp a_2799_n9190# vss sky130_fd_pr__nfet_01v8_lvt ad=0.5775 pd=3.83 as=1.085 ps=7.62 w=3.5 l=0.15
X234 a_n5241_n9240# qp in vss sky130_fd_pr__nfet_01v8_lvt ad=1.24 pd=8.62 as=0.66 ps=4.33 w=4 l=0.15
X235 vn vp a_n19519_n3460# vss sky130_fd_pr__nfet_01v8_lvt ad=0.4125 pd=2.83 as=0.4125 ps=2.83 w=2.5 l=0.15
X236 vdd vn vp vdd sky130_fd_pr__pfet_01v8_lvt ad=1.16 pd=8.58 as=0.58 ps=4.29 w=4 l=0.35
X237 vdd vp vn vdd sky130_fd_pr__pfet_01v8_lvt ad=0.58 pd=4.29 as=0.58 ps=4.29 w=4 l=0.35
X238 vn vctrl vss sky130_fd_pr__cap_var_lvt w=5.2 l=0.5
X239 a_11231_n850# b3 a_11139_n850# vss sky130_fd_pr__nfet_01v8_lvt ad=0.66 pd=4.33 as=1.24 ps=8.62 w=4 l=0.15
X240 vss a_n8583_n10876# a_n8583_n10876# vss sky130_fd_pr__nfet_01v8 ad=0.87 pd=6.58 as=0.435 ps=3.29 w=3 l=0.35
X241 vp vn a_n19519_n3460# vss sky130_fd_pr__nfet_01v8_lvt ad=0.4125 pd=2.83 as=0.4125 ps=2.83 w=2.5 l=0.15
X242 a_n2209_n850# b1 a_n2301_n850# vss sky130_fd_pr__nfet_01v8_lvt ad=0.66 pd=4.33 as=0.66 ps=4.33 w=4 l=0.15
X243 a_1059_n850# b1 vss vss sky130_fd_pr__nfet_01v8 ad=0.29 pd=2.58 as=0.29 ps=2.58 w=1 l=0.5
X244 a_n8583_n10876# vdd vss sky130_fd_pr__res_high_po_1p41 l=14
X245 a_7871_n850# b3 vdd vdd sky130_fd_pr__pfet_01v8 ad=0.29 pd=2.58 as=0.29 ps=2.58 w=1 l=0.5
X246 vp vctrl vss sky130_fd_pr__cap_var_lvt w=5.2 l=0.5
X247 a_1151_n850# b1 vss vss sky130_fd_pr__nfet_01v8 ad=0.29 pd=2.58 as=0.29 ps=2.58 w=1 l=0.5
X248 vn a_2831_n850# sky130_fd_pr__cap_mim_m3_1 l=4 w=4
X249 a_2319_n11000# a_n18016_n12241# a_2799_n9190# vss sky130_fd_pr__nfet_01v8_lvt ad=1.55 pd=10.62 as=0.825 ps=5.33 w=5 l=0.15
X250 a_n10701_n850# b3 vss vss sky130_fd_pr__nfet_01v8 ad=0.29 pd=2.58 as=0.29 ps=2.58 w=1 l=0.5
X251 a_n19519_n3460# vn vp vss sky130_fd_pr__nfet_01v8_lvt ad=0.4125 pd=2.83 as=0.4125 ps=2.83 w=2.5 l=0.15
X252 a_n7341_n850# b3 vdd vdd sky130_fd_pr__pfet_01v8 ad=0.29 pd=2.58 as=0.29 ps=2.58 w=1 l=0.5
X253 vp a_11139_n850# sky130_fd_pr__cap_mim_m3_1 l=4 w=4
X254 qp qn a_2799_n9190# vss sky130_fd_pr__nfet_01v8_lvt ad=0.5775 pd=3.83 as=1.085 ps=7.62 w=3.5 l=0.15
X255 a_14859_1604# a_14859_1604# vss vss sky130_fd_pr__nfet_01v8 ad=0.435 pd=3.29 as=0.87 ps=6.58 w=3 l=0.5
X256 a_1151_n850# b1 a_1059_n850# vss sky130_fd_pr__nfet_01v8_lvt ad=0.66 pd=4.33 as=0.66 ps=4.33 w=4 l=0.15
X257 a_9551_n850# b3 a_9459_n850# vss sky130_fd_pr__nfet_01v8_lvt ad=0.66 pd=4.33 as=1.24 ps=8.62 w=4 l=0.15
X258 a_2319_n11000# a_n8583_n10876# vss vss sky130_fd_pr__nfet_01v8 ad=0.6525 pd=4.79 as=0.6525 ps=4.79 w=4.5 l=0.35
X259 vn vctrl vss sky130_fd_pr__cap_var_lvt w=5.2 l=0.5
X260 a_n2209_n850# b1 vss vss sky130_fd_pr__nfet_01v8 ad=0.29 pd=2.58 as=0.29 ps=2.58 w=1 l=0.5
X261 a_6099_n850# b3 vdd vdd sky130_fd_pr__pfet_01v8 ad=0.29 pd=2.58 as=0.29 ps=2.58 w=1 l=0.5
X262 a_n19519_n3460# vp vn vss sky130_fd_pr__nfet_01v8_lvt ad=0.4125 pd=2.83 as=0.4125 ps=2.83 w=2.5 l=0.15
X263 a_7779_n850# b3 a_7871_n850# vss sky130_fd_pr__nfet_01v8_lvt ad=1.24 pd=8.62 as=0.66 ps=4.33 w=4 l=0.15
X264 a_n4201_n9190# in ip vss sky130_fd_pr__nfet_01v8_lvt ad=0.5775 pd=3.83 as=0.5775 ps=3.83 w=3.5 l=0.15
X265 a_n10701_n850# b3 a_n10609_n850# vss sky130_fd_pr__nfet_01v8_lvt ad=0.66 pd=4.33 as=0.66 ps=4.33 w=4 l=0.15
X266 a_n19619_n3730# vss sky130_fd_pr__cap_mim_m3_1 l=22 w=22
X267 ip in a_n4201_n9190# vss sky130_fd_pr__nfet_01v8_lvt ad=0.5775 pd=3.83 as=0.5775 ps=3.83 w=3.5 l=0.15
X268 a_n7341_n850# b3 vss vss sky130_fd_pr__nfet_01v8 ad=0.29 pd=2.58 as=0.29 ps=2.58 w=1 l=0.5
X269 a_11139_n850# b3 a_11231_n850# vss sky130_fd_pr__nfet_01v8_lvt ad=1.24 pd=8.62 as=0.66 ps=4.33 w=4 l=0.15
X270 vn vp a_n19519_n3460# vss sky130_fd_pr__nfet_01v8_lvt ad=0.4125 pd=2.83 as=0.4125 ps=2.83 w=2.5 l=0.15
X271 a_n5569_n850# b2 vdd vdd sky130_fd_pr__pfet_01v8 ad=0.29 pd=2.58 as=0.29 ps=2.58 w=1 l=0.5
X272 a_n8513_n10850# a_n18016_n12241# a_n5241_n9240# vss sky130_fd_pr__nfet_01v8_lvt ad=1.55 pd=10.62 as=0.825 ps=5.33 w=5 l=0.15
X273 vp vn vdd vdd sky130_fd_pr__pfet_01v8_lvt ad=0.58 pd=4.29 as=0.58 ps=4.29 w=4 l=0.35
X274 a_6191_n850# b3 a_6099_n850# vss sky130_fd_pr__nfet_01v8_lvt ad=0.66 pd=4.33 as=1.24 ps=8.62 w=4 l=0.15
X275 a_2831_n850# b2 vdd vdd sky130_fd_pr__pfet_01v8 ad=0.29 pd=2.58 as=0.29 ps=2.58 w=1 l=0.5
X276 vss a_14859_1604# a_14859_1604# vss sky130_fd_pr__nfet_01v8 ad=0.87 pd=6.58 as=0.435 ps=3.29 w=3 l=0.5
X277 a_2831_n850# b2 a_2739_n850# vss sky130_fd_pr__nfet_01v8_lvt ad=0.66 pd=4.33 as=0.66 ps=4.33 w=4 l=0.15
X278 vdd ip vss sky130_fd_pr__res_high_po_2p85 l=5.6
X279 vp vn vdd vdd sky130_fd_pr__pfet_01v8_lvt ad=0.58 pd=4.29 as=0.58 ps=4.29 w=4 l=0.35
X280 vp vn a_n19519_n3460# vss sky130_fd_pr__nfet_01v8_lvt ad=0.4125 pd=2.83 as=0.775 ps=5.62 w=2.5 l=0.15
X281 a_n3889_n850# b2 vss vss sky130_fd_pr__nfet_01v8 ad=0.29 pd=2.58 as=0.29 ps=2.58 w=1 l=0.5
X282 a_n4201_n9190# a_n2699_n11028# a_n8513_n10850# vss sky130_fd_pr__nfet_01v8_lvt ad=0.825 pd=5.33 as=1.55 ps=10.62 w=5 l=0.15
X283 in ip a_n4201_n9190# vss sky130_fd_pr__nfet_01v8_lvt ad=0.5775 pd=3.83 as=0.5775 ps=3.83 w=3.5 l=0.15
X284 a_n4201_n9190# ip in vss sky130_fd_pr__nfet_01v8_lvt ad=0.5775 pd=3.83 as=0.5775 ps=3.83 w=3.5 l=0.15
X285 vp vn vdd vdd sky130_fd_pr__pfet_01v8_lvt ad=0.58 pd=4.29 as=1.16 ps=8.58 w=4 l=0.35
X286 a_n3889_n850# b2 a_n3981_n850# vss sky130_fd_pr__nfet_01v8_lvt ad=0.66 pd=4.33 as=1.24 ps=8.62 w=4 l=0.15
X287 a_n12289_n850# b3 vdd vdd sky130_fd_pr__pfet_01v8 ad=0.29 pd=2.58 as=0.29 ps=2.58 w=1 l=0.5
X288 a_n2301_n850# b1 vdd vdd sky130_fd_pr__pfet_01v8 ad=0.29 pd=2.58 as=0.29 ps=2.58 w=1 l=0.5
X289 a_n19519_n3460# a_n19619_n3730# vss vss sky130_fd_pr__nfet_01v8 ad=0.725 pd=5.29 as=0.725 ps=5.29 w=5 l=0.5
X290 vn vp vdd vdd sky130_fd_pr__pfet_01v8_lvt ad=0.58 pd=4.29 as=0.58 ps=4.29 w=4 l=0.35
X291 a_9551_n850# b3 vss vss sky130_fd_pr__nfet_01v8 ad=0.29 pd=2.58 as=0.29 ps=2.58 w=1 l=0.5
X292 a_n7341_n850# b3 a_n7249_n850# vss sky130_fd_pr__nfet_01v8_lvt ad=0.66 pd=4.33 as=0.66 ps=4.33 w=4 l=0.15
X293 a_1059_n850# b1 vdd vdd sky130_fd_pr__pfet_01v8 ad=0.29 pd=2.58 as=0.29 ps=2.58 w=1 l=0.5
X294 vp vn vdd vdd sky130_fd_pr__pfet_01v8_lvt ad=0.58 pd=4.29 as=0.58 ps=4.29 w=4 l=0.35
X295 a_n529_n850# b0 a_n621_n850# vss sky130_fd_pr__nfet_01v8_lvt ad=0.66 pd=4.33 as=0.66 ps=4.33 w=4 l=0.15
X296 vdd vss sky130_fd_pr__cap_mim_m3_1 l=32 w=32
X297 a_n12381_n850# b3 vss vss sky130_fd_pr__nfet_01v8 ad=0.29 pd=2.58 as=0.29 ps=2.58 w=1 l=0.5
X298 a_n2301_n850# b1 a_n2209_n850# vss sky130_fd_pr__nfet_01v8_lvt ad=1.24 pd=8.62 as=0.66 ps=4.33 w=4 l=0.15
X299 a_2739_n850# b2 vss vss sky130_fd_pr__nfet_01v8 ad=0.29 pd=2.58 as=0.29 ps=2.58 w=1 l=0.5
X300 a_n19519_n3460# vp vn vss sky130_fd_pr__nfet_01v8_lvt ad=0.4125 pd=2.83 as=0.4125 ps=2.83 w=2.5 l=0.15
X301 a_1759_n9240# a_n2699_n11028# a_2319_n11000# vss sky130_fd_pr__nfet_01v8_lvt ad=0.825 pd=5.33 as=0.825 ps=5.33 w=5 l=0.15
X302 a_n8929_n850# b3 a_n9021_n850# vss sky130_fd_pr__nfet_01v8_lvt ad=0.66 pd=4.33 as=0.66 ps=4.33 w=4 l=0.15
X303 a_7871_n850# b3 vss vss sky130_fd_pr__nfet_01v8 ad=0.29 pd=2.58 as=0.29 ps=2.58 w=1 l=0.5
X304 vss a_n19619_n3730# a_n19519_n3460# vss sky130_fd_pr__nfet_01v8 ad=0.725 pd=5.29 as=0.725 ps=5.29 w=5 l=0.5
X305 a_6191_n850# b3 vdd vdd sky130_fd_pr__pfet_01v8 ad=0.29 pd=2.58 as=0.29 ps=2.58 w=1 l=0.5
X306 vn a_n7249_n850# sky130_fd_pr__cap_mim_m3_1 l=4 w=4
X307 vdd vp vn vdd sky130_fd_pr__pfet_01v8_lvt ad=0.58 pd=4.29 as=0.58 ps=4.29 w=4 l=0.35
X308 a_n8929_n850# b3 vss vss sky130_fd_pr__nfet_01v8 ad=0.29 pd=2.58 as=0.29 ps=2.58 w=1 l=0.5
X309 vdd vp vn vdd sky130_fd_pr__pfet_01v8_lvt ad=0.58 pd=4.29 as=0.58 ps=4.29 w=4 l=0.35
X310 a_n12381_n850# b3 a_n12289_n850# vss sky130_fd_pr__nfet_01v8_lvt ad=0.66 pd=4.33 as=0.66 ps=4.33 w=4 l=0.15
X311 vn a_9551_n850# sky130_fd_pr__cap_mim_m3_1 l=4 w=4
X312 a_2319_n11000# a_n2699_n11028# a_1759_n9240# vss sky130_fd_pr__nfet_01v8_lvt ad=0.825 pd=5.33 as=0.825 ps=5.33 w=5 l=0.15
X313 qn in a_1759_n9240# vss sky130_fd_pr__nfet_01v8_lvt ad=0.66 pd=4.33 as=1.24 ps=8.62 w=4 l=0.15
X314 a_n9021_n850# b3 vss vss sky130_fd_pr__nfet_01v8 ad=0.29 pd=2.58 as=0.29 ps=2.58 w=1 l=0.5
X315 a_n19519_n3460# vn vp vss sky130_fd_pr__nfet_01v8_lvt ad=0.4125 pd=2.83 as=0.4125 ps=2.83 w=2.5 l=0.15
X316 a_4419_n850# b2 vdd vdd sky130_fd_pr__pfet_01v8 ad=0.29 pd=2.58 as=0.29 ps=2.58 w=1 l=0.5
X317 a_n529_n850# b0 vss vss sky130_fd_pr__nfet_01v8 ad=0.29 pd=2.58 as=0.29 ps=2.58 w=1 l=0.5
X318 vp a_n3981_n850# sky130_fd_pr__cap_mim_m3_1 l=4 w=4
X319 a_4511_n850# b2 a_4419_n850# vss sky130_fd_pr__nfet_01v8_lvt ad=0.66 pd=4.33 as=0.66 ps=4.33 w=4 l=0.15
X320 vdd a_14859_1604# vss sky130_fd_pr__res_high_po_1p41 l=9.8
X321 a_n5569_n850# b2 vss vss sky130_fd_pr__nfet_01v8 ad=0.29 pd=2.58 as=0.29 ps=2.58 w=1 l=0.5
X322 a_n5241_n9240# a_n18016_n12241# a_n8513_n10850# vss sky130_fd_pr__nfet_01v8_lvt ad=0.825 pd=5.33 as=1.55 ps=10.62 w=5 l=0.15
X323 qp ip a_1759_n9240# vss sky130_fd_pr__nfet_01v8_lvt ad=0.66 pd=4.33 as=1.24 ps=8.62 w=4 l=0.15
X324 vdd vn vp vdd sky130_fd_pr__pfet_01v8_lvt ad=0.58 pd=4.29 as=0.58 ps=4.29 w=4 l=0.35
.ends
