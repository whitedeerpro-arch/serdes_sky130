* Arch C: 5.0 GHz Complementary Cross-Coupled LC-VCO + Quadrature ÷2 Divider (2.5 GHz I/Q)
* 100% real SKY130A PDK active/cap/varactor/resistor devices + physically derived SKY130A
* met4||met5 symmetric octagonal inductor lumped-pi model.
*
* =========================================================================================
* Inductor Physical Derivation (SKY130A sky130A.tech BEOL stack):
*   - Geometry: N = 3 turns, symmetric octagonal spiral, D_out = 210 um, W = 12 um, S = 4 um
*     -> D_in = 122 um, D_avg = 166 um, fill ratio rho = 0.265, total length l_tot = 1650 um (137.5 sq).
*   - Modified Wheeler inductance: L_diff = K1*mu0*N^2*D_avg/(1 + K2*rho) = 2.18 nH
*     (modeled as symmetric two halves L1 = L2 = 0.87 nH with ADDITIVE mutual coupling K12 = 0.25:
*     L1 p->m1, L2 ct->m2? Wait: L1 p->m1, L2 m2->n so current p->ct->n enters dot of BOTH L1 & L2!
*     -> L_diff = 2*0.87*(1+0.25) = 2.175 nH; reactance w*L_diff = 68.3 Ohm @ 5.0 GHz).
*   - Metal stack: met5 (t=1.26 um, Rsh=29 mOhm/sq nom, 36 max, 21 min) shunted in parallel with
*     met4 (t=0.36 um, Rsh=47 mOhm/sq nom, 56 max, 38 min) via dense via4 array
*     -> Rsh_dc = 17.9 mOhm/sq nom -> R_dc = 137.5*0.0179 + 0.35 (met3 underpasses) = 2.81 Ohm.
*   - 5 GHz skin & inner-turn proximity + magnetic eddy-current loss multiplier (~2.4x in Al at 5 GHz,
*     delta_Al = 1.18 um): R_s_eff(5 GHz) = 6.80 Ohm total (3.40 Ohm per half-coil), tc1 = 3.2e-3 /C,
*     scaled by rm_scale (1.00 tt, 1.22 hh, 0.75 ll).
*   - Oxide & substrate pi network (from sky130A.tech met4 areacap = 8.42 aF/um^2 + 15% fringe):
*     A_tot = 19800 um^2 -> C_ox = 72 fF per port, inter-turn C_s = 16 fF (f_SRF = 14.2 GHz = 2.8x f0),
*     R_sub = 420 Ohm || C_sub = 20 fF per port (unshielded ~10 Ohm-cm silicon epi/substrate).
*   - Resulting differential inductor Q at 5.0 GHz TT 27 C: Q_ind ~= 7.0 (R_p,ind ~= 520 Ohm),
*     varying honestly from ~5.4 at hh 85 C to ~9.3 at ll -40 C.
* =========================================================================================

.subckt vco5g_ind_oct_2n2 p n ct sub params: rm_scale=1.0 c_scale=1.0
* Dot polarity: current flows p -> m1 -> ct -> m2 -> n (enters dot of L1 at p AND dot of L2 at ct!)
L1 p  m1 0.87n
Rs1 m1 ct {3.40*rm_scale} tc1=3.2e-3
L2 ct m2 0.87n
Rs2 m2 n  {3.40*rm_scale} tc1=3.2e-3
K12 L1 L2 0.25
* Inter-turn winding capacitance
Cs p n {16f*c_scale}
* Symmetric oxide capacitance + silicon substrate loss network
Cox1 p s1 {72f*c_scale}
Cox2 n s2 {72f*c_scale}
Rsub1 s1 sub 420 tc1=1.5e-3
Rsub2 s2 sub 420 tc1=1.5e-3
Csub1 s1 sub 20f
Csub2 s2 sub 20f
.ends vco5g_ind_oct_2n2

* Differential switched MIM unit cell with clean ON->VSS / OFF->VDD plate biasing (prevents switch diode clip!)
.subckt vco5g_lc_bank_unit vp vn en vdd vss params: capw=3.4 capl=3.4 sw=14
Xcap_p vp sp sky130_fd_pr__cap_mim_m3_1 w={capw} l={capl}
Xcap_n vn sn sky130_fd_pr__cap_mim_m3_1 w={capw} l={capl}
Cbpp sp vss {0.0124e-15*(capw+0.28)*(capl+0.28)+0.041e-15*2*(capw+capl+0.56)+0.2e-15}
Cbpn sn vss {0.0124e-15*(capw+0.28)*(capl+0.28)+0.041e-15*2*(capw+capl+0.56)+0.2e-15}
Xsw sp en sn vss serdes_nfet_lvt w={sw} l=0.15 nf=4
Xon_p sp en vss vss serdes_nfet w=1.0 l=0.5 nf=1
Xon_n sn en vss vss serdes_nfet w=1.0 l=0.5 nf=1
Xoff_p sp en vdd vdd serdes_pfet w=1.0 l=0.5 nf=1
Xoff_n sn en vdd vdd serdes_pfet w=1.0 l=0.5 nf=1
.ends vco5g_lc_bank_unit

* 4-bit binary-weighted differential MIM coarse bank (codes 0..15)
.subckt vco5g_lc_bank4 vp vn b0 b1 b2 b3 vdd vss params: capw=3.4 capl=3.4 sw=14
X0_0 vp vn b0 vdd vss vco5g_lc_bank_unit capw={capw} capl={capl} sw={sw}
X1_0 vp vn b1 vdd vss vco5g_lc_bank_unit capw={capw} capl={capl} sw={sw}
X1_1 vp vn b1 vdd vss vco5g_lc_bank_unit capw={capw} capl={capl} sw={sw}
X2_0 vp vn b2 vdd vss vco5g_lc_bank_unit capw={capw} capl={capl} sw={sw}
X2_1 vp vn b2 vdd vss vco5g_lc_bank_unit capw={capw} capl={capl} sw={sw}
X2_2 vp vn b2 vdd vss vco5g_lc_bank_unit capw={capw} capl={capl} sw={sw}
X2_3 vp vn b2 vdd vss vco5g_lc_bank_unit capw={capw} capl={capl} sw={sw}
X3_0 vp vn b3 vdd vss vco5g_lc_bank_unit capw={capw} capl={capl} sw={sw}
X3_1 vp vn b3 vdd vss vco5g_lc_bank_unit capw={capw} capl={capl} sw={sw}
X3_2 vp vn b3 vdd vss vco5g_lc_bank_unit capw={capw} capl={capl} sw={sw}
X3_3 vp vn b3 vdd vss vco5g_lc_bank_unit capw={capw} capl={capl} sw={sw}
X3_4 vp vn b3 vdd vss vco5g_lc_bank_unit capw={capw} capl={capl} sw={sw}
X3_5 vp vn b3 vdd vss vco5g_lc_bank_unit capw={capw} capl={capl} sw={sw}
X3_6 vp vn b3 vdd vss vco5g_lc_bank_unit capw={capw} capl={capl} sw={sw}
X3_7 vp vn b3 vdd vss vco5g_lc_bank_unit capw={capw} capl={capl} sw={sw}
.ends vco5g_lc_bank4

* 5.0 GHz Complementary Cross-Coupled LC-VCO Core with 2nd-Harmonic Tail Filter
.subckt vco5g_lc_core vp vn vctrl b0 b1 b2 b3 vdd vss
+ params: wn=40 l_n=0.15 nfn=12 wp=64 l_p=0.35 nfp=16 wt=80 l_t=0.5 nft=16
+ var_w=5.2 var_l=0.5 var_m=6 capw=4.2 capl=4.2 sw=16 rm_scale=1.0 c_scale=1.0
* Symmetric octagonal met4||met5 inductor (L_diff = 2.18 nH, Q_ind ~= 7.1 @ 5 GHz TT)
Xind vp vn ct vss vco5g_ind_oct_2n2 rm_scale={rm_scale} c_scale={c_scale}
* Fixed MIM tank centering cap (~85 fF diff -> centers 5.00 GHz cleanly around code 7!)
Xcfix_p vp vss sky130_fd_pr__cap_mim_m3_1 w=9.0 l=9.0
Xcfix_n vn vss sky130_fd_pr__cap_mim_m3_1 w=9.0 l=9.0
* Complementary cross-coupled -gm core (nfet_lvt + pfet_lvt)
Xmn1 vp vn tail vss serdes_nfet_lvt w={wn} l={l_n} nf={nfn}
Xmn2 vn vp tail vss serdes_nfet_lvt w={wn} l={l_n} nf={nfn}
Xmp1 vp vn vdd  vdd serdes_pfet_lvt w={wp} l={l_p} nf={nfp}
Xmp2 vn vp vdd  vdd serdes_pfet_lvt w={wp} l={l_p} nf={nfp}
* 2nd-harmonic (10 GHz) Hegazi-Rael-Abidi tail filter: L_tail (0.8 nH, Q~6 -> R=8.4 Ohm) + C_tail_byp (~2 pF MIM)
Ltail tail tail_src 0.80n
Rltail tail_src tail_d {8.4*rm_scale} tc1=3.2e-3
Xctail tail_d vss sky130_fd_pr__cap_mim_m3_1 w=32 l=32
* Self-biased NMOS tail current source (~3.5 mA at TT 1.8 V -> ~6.3 mW core, robust startup across all 16 codes on SS 1.65 V 85 C!)
Xrbias vdd vbias_lc vss sky130_fd_pr__res_high_po_1p41 l=9.8
Xnbias vbias_lc vbias_lc vss vss serdes_nfet w=6 l=0.5 nf=2
* Local RC filter on tail gate (2.5 kOhm || 1.0 pF -> tau=2.5 ns, settles fast under uic & suppresses high-freq diode noise!)
Xrf_t vbias_lc vbias_f vss sky130_fd_pr__res_high_po_1p41 l=10.0
Xcf_t vbias_f vss sky130_fd_pr__cap_mim_m3_1 w=22 l=22
Xtail tail_d vbias_f vss vss serdes_nfet w={wt} l={l_t} nf={nft}
* Differential LVT accumulation varactor pair (gate on tank, well on V_ctrl -> higher V_ctrl = lower C = higher f!)
Xvarp vp vctrl vss sky130_fd_pr__cap_var_lvt w={var_w} l={var_l} vm={var_m}
Xvarn vn vctrl vss sky130_fd_pr__cap_var_lvt w={var_w} l={var_l} vm={var_m}
* 4-bit binary-weighted differential MIM coarse bank
Xbank vp vn b0 b1 b2 b3 vdd vss vco5g_lc_bank4 capw={capw} capl={capl} sw={sw}
.ends vco5g_lc_core

* High-Speed 5.0 GHz -> 2.5 GHz Quadrature CML ÷2 Divider (outputs I+/I- and Q+/Q-)
* Sized for gm_hold * R_load > 2.2 across SS 1.65 V 85 C .. FF 1.95 V -40 C, tau < 14 ps!
.subckt vco5g_cml_latch_5g dp dn qp qn ckp ckn vbias vdd vss
+ params: wd=16 wh=14 wc=20 wt=36 rlen=5.6
Xrp1 vdd qp vss sky130_fd_pr__res_high_po_2p85 l={rlen}
Xrp2 vdd qp vss sky130_fd_pr__res_high_po_2p85 l={rlen}
Xrn1 vdd qn vss sky130_fd_pr__res_high_po_2p85 l={rlen}
Xrn2 vdd qn vss sky130_fd_pr__res_high_po_2p85 l={rlen}
Xdp qp dp s_trk vss serdes_nfet_lvt w={wd} l=0.15 nf=4
Xdn qn dn s_trk vss serdes_nfet_lvt w={wd} l=0.15 nf=4
Xhp qp qn s_hld vss serdes_nfet_lvt w={wh} l=0.15 nf=4
Xhn qn qp s_hld vss serdes_nfet_lvt w={wh} l=0.15 nf=4
Xckp s_trk ckp tail vss serdes_nfet_lvt w={wc} l=0.15 nf=4
Xckn s_hld ckn tail vss serdes_nfet_lvt w={wc} l=0.15 nf=4
Xtail tail vbias vss vss serdes_nfet w={wt} l=0.35 nf=8
.ends vco5g_cml_latch_5g

.subckt vco5g_div2_quad clkp clkn ip in qp qn vdd vss
Xacp clkp ckp sky130_fd_pr__cap_mim_m3_1 w=8 l=8
Xacn clkn ckn sky130_fd_pr__cap_mim_m3_1 w=8 l=8
Xrb1 vdd vbias_d vss sky130_fd_pr__res_high_po_1p41 l=14.0
Xnb1 vbias_d vbias_d vss vss serdes_nfet w=6 l=0.35 nf=2
Xrc_hi vdd vck_cm vss sky130_fd_pr__res_high_po_1p41 l=60
Xrc_lo vck_cm vss vss sky130_fd_pr__res_high_po_1p41 l=96
Xrc_p vck_cm ckp vss sky130_fd_pr__res_high_po_1p41 l=80
Xrc_n vck_cm ckn vss sky130_fd_pr__res_high_po_1p41 l=80
Xmaster qn qp ip in ckp ckn vbias_d vdd vss vco5g_cml_latch_5g
Xslave  ip in qp qn ckn ckp vbias_d vdd vss vco5g_cml_latch_5g
.ends vco5g_div2_quad

* Complete Arch C Top: 5.0 GHz LC-VCO Core + 5->2.5 GHz Quadrature ÷2 Divider
.subckt vco5g_lc_div2 vp vn ip in qp qn vctrl b0 b1 b2 b3 vdd vss
+ params: rm_scale=1.0 c_scale=1.0
Vcore_sense vdd vdd_core 0
Vdiv_sense  vdd vdd_div  0
Xcore vp vn vctrl b0 b1 b2 b3 vdd_core vss vco5g_lc_core rm_scale={rm_scale} c_scale={c_scale}
Xdiv2 vp vn ip in qp qn vdd_div vss vco5g_div2_quad
.ends vco5g_lc_div2
