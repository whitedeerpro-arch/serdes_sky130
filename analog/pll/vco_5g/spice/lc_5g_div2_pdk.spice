* 5.0 GHz LC-VCO + Quadrature /2 Divider (2.5 GHz I/Q) — Real Extracted PDK Spiral Inductor Model
* SKY130A, 1.8 V, 100% real SKY130A PDK active/cap/varactor/resistor devices + Magic DRC=0 / CPEX
* extracted parameters for `vco5g_ind_sym_2n2_pdk` (analog/pll/vco_5g/layout/variants/ind_sym_2n2_pdk/summary.json).
*
* =========================================================================================
* Extracted Physical Inductor Parameters (`vco5g_ind_sym_2n2_pdk`, Magic drc_total=0):
*   - Geometry: N = 3 turns, symmetric met4||met5 spiral, D_out = 210 um, D_in = 122 um,
*     W = 12 um, S = 4 um, bbox = 248 x 248 um^2 (61,504 um^2), trace len = 2,018 um,
*     2,905 via4 cuts + 676 via3 cuts.
*   - Inductance: L_diff = 2.541 nH -> L1 = L2 = 1.016 nH, K12 = 0.25 -> 2*1.016*(1+0.25) = 2.540 nH.
*     Dot polarity: p -> m1 -> ct -> m2 -> n (differential current enters dot of L1 at p and L2 at ct -> aiding!).
*   - Resistance: R_dc = 3.248 Ohm total (1.624 Ohm/half); at 5 GHz with Al skin+proximity (~2.4x):
*     Rs1 = Rs2 = {3.90*rm_scale} tc1=3.2e-3.
*   - Magic CPEX total substrate capacitance: C_sub,total = 396.51 fF
*     -> Cox1 = {132f*c_scale} (p->s1), Cox2 = {132f*c_scale} (n->s2), Cox_ct = {132f*c_scale} (ct->sct),
*        each via Rsub = 420 Ohm || Csub = 30 fF to sub, plus inter-turn Cs = {18f*c_scale}.
* =========================================================================================
* Dependencies: sky130_primitives.spice, sky130_pfet_lvt.spice.

.subckt vco5g_ind_sym_2n2_pdk p n ct sub params: rm_scale=1.0 c_scale=1.0
* Dot polarity: current flows p -> m1 -> ct -> m2 -> n (enters dot of L1 at p AND dot of L2 at ct!)
L1  p  m1 1.016n
Rs1 m1 ct {3.90*rm_scale} tc1=3.2e-3
L2  ct m2 1.016n
Rs2 m2 n  {3.90*rm_scale} tc1=3.2e-3
K12 L1 L2 0.25
* Inter-turn winding capacitance
Cs p n {18f*c_scale}
* Symmetric Magic CPEX oxide capacitance (3 x 132 fF = 396 fF) + silicon substrate loss network
Cox1   p  s1  {132f*c_scale}
Cox2   n  s2  {132f*c_scale}
Cox_ct ct sct {132f*c_scale}
Rsub1   s1  sub 420 tc1=1.5e-3
Rsub2   s2  sub 420 tc1=1.5e-3
Rsub_ct sct sub 420 tc1=1.5e-3
Csub1   s1  sub 30f
Csub2   s2  sub 30f
Csub_ct sct sub 30f
.ends vco5g_ind_sym_2n2_pdk

* Differential switched MIM unit cell with clean ON->VSS / OFF->VDD plate biasing (prevents switch diode clip!)
.subckt vco5g_pdk_bank_unit vp vn en vdd vss params: capw=4.0 capl=4.0 sw=16
Xcap_p vp sp sky130_fd_pr__cap_mim_m3_1 w={capw} l={capl}
Xcap_n vn sn sky130_fd_pr__cap_mim_m3_1 w={capw} l={capl}
Cbpp sp vss {0.0124e-15*(capw+0.28)*(capl+0.28)+0.041e-15*2*(capw+capl+0.56)+0.2e-15}
Cbpn sn vss {0.0124e-15*(capw+0.28)*(capl+0.28)+0.041e-15*2*(capw+capl+0.56)+0.2e-15}
Xsw sp en sn vss serdes_nfet_lvt w={sw} l=0.15 nf=4
Xon_p sp en vss vss serdes_nfet w=1.0 l=0.5 nf=1
Xon_n sn en vss vss serdes_nfet w=1.0 l=0.5 nf=1
Xoff_p sp en vdd vdd serdes_pfet w=1.0 l=0.5 nf=1
Xoff_n sn en vdd vdd serdes_pfet w=1.0 l=0.5 nf=1
.ends vco5g_pdk_bank_unit

* 4-bit binary-weighted differential MIM coarse bank (codes 0..15)
.subckt vco5g_pdk_bank4 vp vn b0 b1 b2 b3 vdd vss params: capw=4.0 capl=4.0 sw=16
X0_0 vp vn b0 vdd vss vco5g_pdk_bank_unit capw={capw} capl={capl} sw={sw}
X1_0 vp vn b1 vdd vss vco5g_pdk_bank_unit capw={capw} capl={capl} sw={sw}
X1_1 vp vn b1 vdd vss vco5g_pdk_bank_unit capw={capw} capl={capl} sw={sw}
X2_0 vp vn b2 vdd vss vco5g_pdk_bank_unit capw={capw} capl={capl} sw={sw}
X2_1 vp vn b2 vdd vss vco5g_pdk_bank_unit capw={capw} capl={capl} sw={sw}
X2_2 vp vn b2 vdd vss vco5g_pdk_bank_unit capw={capw} capl={capl} sw={sw}
X2_3 vp vn b2 vdd vss vco5g_pdk_bank_unit capw={capw} capl={capl} sw={sw}
X3_0 vp vn b3 vdd vss vco5g_pdk_bank_unit capw={capw} capl={capl} sw={sw}
X3_1 vp vn b3 vdd vss vco5g_pdk_bank_unit capw={capw} capl={capl} sw={sw}
X3_2 vp vn b3 vdd vss vco5g_pdk_bank_unit capw={capw} capl={capl} sw={sw}
X3_3 vp vn b3 vdd vss vco5g_pdk_bank_unit capw={capw} capl={capl} sw={sw}
X3_4 vp vn b3 vdd vss vco5g_pdk_bank_unit capw={capw} capl={capl} sw={sw}
X3_5 vp vn b3 vdd vss vco5g_pdk_bank_unit capw={capw} capl={capl} sw={sw}
X3_6 vp vn b3 vdd vss vco5g_pdk_bank_unit capw={capw} capl={capl} sw={sw}
X3_7 vp vn b3 vdd vss vco5g_pdk_bank_unit capw={capw} capl={capl} sw={sw}
.ends vco5g_pdk_bank4

* 5.0 GHz Complementary Cross-Coupled LC-VCO Core with Real Extracted 2.541 nH Inductor
* Fixed MIM Xcfix removed to compensate L_diff (+16.6%) and CPEX Cox (72->132 fF) -> centers 5.000 GHz mid-bank!
.subckt vco5g_lc_core_pdk vp vn vctrl b0 b1 b2 b3 vdd vss
+ params: wn=40 l_n=0.15 nfn=12 wp=64 l_p=0.35 nfp=16 wt=48 l_t=0.5 nft=10
+ var_w=5.2 var_l=0.5 var_m=6 capw=4.0 capl=4.0 sw=16 rm_scale=1.0 c_scale=1.0
* Real extracted symmetric met4||met5 inductor (L_diff = 2.541 nH, R_dc = 3.248 Ohm, C_sub = 396.51 fF)
Xind vp vn ct vss vco5g_ind_sym_2n2_pdk rm_scale={rm_scale} c_scale={c_scale}
* Complementary cross-coupled -gm core (nfet_lvt + pfet_lvt)
Xmn1 vp vn tail vss serdes_nfet_lvt w={wn} l={l_n} nf={nfn}
Xmn2 vn vp tail vss serdes_nfet_lvt w={wn} l={l_n} nf={nfn}
Xmp1 vp vn vdd  vdd serdes_pfet_lvt w={wp} l={l_p} nf={nfp}
Xmp2 vn vp vdd  vdd serdes_pfet_lvt w={wp} l={l_p} nf={nfp}
* 2nd-harmonic (10 GHz) Hegazi-Rael-Abidi tail filter
Ltail tail tail_src 0.80n
Rltail tail_src tail_d {8.4*rm_scale} tc1=3.2e-3
Xctail tail_d vss sky130_fd_pr__cap_mim_m3_1 w=32 l=32
* Self-biased NMOS tail current source (~3.5 mA at TT 1.8 V)
Xrbias vdd vbias_lc vss sky130_fd_pr__res_high_po_1p41 l=9.8
Xnbias vbias_lc vbias_lc vss vss serdes_nfet w=6 l=0.5 nf=2
* Local RC filter on tail gate
Xrf_t vbias_lc vbias_f vss sky130_fd_pr__res_high_po_1p41 l=10.0
Xcf_t vbias_f vss sky130_fd_pr__cap_mim_m3_1 w=22 l=22
Xtail tail_d vbias_f vss vss serdes_nfet w={wt} l={l_t} nf={nft}
* Differential LVT accumulation varactor pair (gate on tank, well on V_ctrl -> higher V_ctrl = lower C = higher f!)
Xvarp vp vctrl vss sky130_fd_pr__cap_var_lvt w={var_w} l={var_l} vm={var_m}
Xvarn vn vctrl vss sky130_fd_pr__cap_var_lvt w={var_w} l={var_l} vm={var_m}
* 4-bit binary-weighted differential MIM coarse bank
Xbank vp vn b0 b1 b2 b3 vdd vss vco5g_pdk_bank4 capw={capw} capl={capl} sw={sw}
.ends vco5g_lc_core_pdk

* High-Speed 5.0 GHz -> 2.5 GHz Quadrature CML /2 Divider (outputs I+/I- and Q+/Q-)
.subckt vco5g_pdk_cml_latch_5g dp dn qp qn ckp ckn vbias vdd vss
+ params: wd=16 wh=14 wc=20 wt=36 rlen=5.6
Xrp1 vdd qp vss sky130_fd_pr__res_high_po_2p85 l={rlen}
Xrp2 vdd qp vss sky130_fd_pr__res_high_po_2p85 l={rlen}
Xrn1 vdd qn vss sky130_fd_pr__res_high_po_2p85 l={rlen}
Xrn2 vdd qn vss sky130_fd_pr__res_high_po_2p85 l={rlen}
Xdp qp dp s_trk vss serdes_nfet_lvt w={wd} l=0.15 nf=4
Xdn qn dn s_trk vss serdes_nfet_lvt w={wd} l=0.15 nf=4
Xhp qp qn s_hld vss serdes_nfet_lvt w={wh} l=0.15 nf=4
Xhn qn qp s_hld vss serdes_nfet_lvt w={wh} l=0.15 nf=4
Xckp s_trk ckp tail vss serdes_nfet_lvt w={wc} l=0.15 nf=4
Xckn s_hld ckn tail vss serdes_nfet_lvt w={wc} l=0.15 nf=4
Xtail tail vbias vss vss serdes_nfet w={wt} l=0.35 nf=8
.ends vco5g_pdk_cml_latch_5g

.subckt vco5g_pdk_div2_quad clkp clkn ip in qp qn vdd vss
Xacp clkp ckp sky130_fd_pr__cap_mim_m3_1 w=8 l=8
Xacn clkn ckn sky130_fd_pr__cap_mim_m3_1 w=8 l=8
Xrb1 vdd vbias_d vss sky130_fd_pr__res_high_po_1p41 l=14.0
Xnb1 vbias_d vbias_d vss vss serdes_nfet w=6 l=0.35 nf=2
Xrc_hi vdd vck_cm vss sky130_fd_pr__res_high_po_1p41 l=60
Xrc_lo vck_cm vss vss sky130_fd_pr__res_high_po_1p41 l=96
Xrc_p vck_cm ckp vss sky130_fd_pr__res_high_po_1p41 l=80
Xrc_n vck_cm ckn vss sky130_fd_pr__res_high_po_1p41 l=80
Xmaster qn qp ip in ckp ckn vbias_d vdd vss vco5g_pdk_cml_latch_5g
Xslave  ip in qp qn ckn ckp vbias_d vdd vss vco5g_pdk_cml_latch_5g
.ends vco5g_pdk_div2_quad

* Complete 5.0 GHz LC-VCO + 5->2.5 GHz Quadrature /2 Divider Top (Real Extracted PDK Spiral)
.subckt vco5g_lc_div2_pdk vp vn ip in qp qn vctrl b0 b1 b2 b3 vdd vss
+ params: rm_scale=1.0 c_scale=1.0 capw=4.0 capl=4.0
Vcore_sense vdd vdd_core 0
Vdiv_sense  vdd vdd_div  0
Xcore vp vn vctrl b0 b1 b2 b3 vdd_core vss vco5g_lc_core_pdk
+ capw={capw} capl={capl} rm_scale={rm_scale} c_scale={c_scale}
Xdiv2 vp vn ip in qp qn vdd_div vss vco5g_pdk_div2_quad
.ends vco5g_lc_div2_pdk
