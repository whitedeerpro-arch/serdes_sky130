* Arch B: 2.5 GHz Maneatis Self-Biased Symmetric-Load Ring VCO (4-stage / 8-phase)
* 100% real SKY130A PDK devices (nfet_01v8_lvt, pfet_01v8_lvt, nfet_01v8, pfet_01v8, cap_mim_m3_1, res_high_po_1p41).
*
* Architecture (J. G. Maneatis, JSSC Nov 1996):
*   - 4-stage differential delay cell (vco5g_maneatis_cell):
*     Symmetric active load per output = equal-sized diode-connected pfet_lvt (P1) || Vbp-biased pfet_lvt (P2).
*     NMOS LVT differential input pair (W=22/0.15) + NMOS tail current source (W=56/0.25) gated by Vbn.
*     Note: SKY130A pfet_01v8_lvt has minimum L = 0.35 um and low |Vth| (~0.30-0.35 V), critical for
*     1.65 V headroom since low-level swing clamps to Vbp and NMOS pair + tail sit below Vbp.
*   - Half-replica bias servo OTA (vco5g_maneatis_bias):
*     1:2 scaled half-stage replica (P1||P2 load + ON NMOS input + NMOS tail) regulated by a 5T
*     nfet_lvt-input / pfet_lvt-mirror OTA (input CM range up to VDD - 0.12 V!) so v_rep = vbp across
*     all PVT and supply voltages (1.65-1.95 V), setting Vbn automatically so low swing equals Vbp.
*   - Control voltage is Vbp (lower Vbp -> larger VDD-Vbp swing & tail current -> higher frequency;
*     Kvco = df/dVbp < 0).

.subckt vco5g_maneatis_cell inp inn outp outn vbp vbn vdd vss
+ params: wn=22 l_n=0.15 nfn=8 wp=32 l_p=0.35 nfp=8 wt=64 l_t=0.25 nft=16 cwire=12f
* Symmetric pfet_lvt loads: diode-connected P1 || Vbp-biased P2
Xp1p outp outp vdd vdd serdes_pfet_lvt w={wp} l={l_p} nf={nfp}
Xp2p outp vbp  vdd vdd serdes_pfet_lvt w={wp} l={l_p} nf={nfp}
Xp1n outn outn vdd vdd serdes_pfet_lvt w={wp} l={l_p} nf={nfp}
Xp2n outn vbp  vdd vdd serdes_pfet_lvt w={wp} l={l_p} nf={nfp}
* Differential LVT NMOS input pair
Xmp outp inp tail vss serdes_nfet_lvt w={wn} l={l_n} nf={nfn}
Xmn outn inn tail vss serdes_nfet_lvt w={wn} l={l_n} nf={nfn}
* Tail NMOS current source (Vbn generated by replica-bias servo)
Xtail tail vbn vss vss serdes_nfet w={wt} l={l_t} nf={nft}
* Realistic 12 fF/node interconnect parasitic budget
Cwp outp vss {cwire}
Cwn outn vss {cwire}
.ends vco5g_maneatis_cell

* Half-replica bias generator with wide-CM servo OTA (forces v_rep = vbp via vbn)
* Scaled 1:2 relative to delay cell to cut bias power overhead while matching Vgs/Vds ratios exactly.
.subckt vco5g_maneatis_bias vbp vbn vdd vss
+ params: wn=22 l_n=0.15 nfn=8 wp=32 l_p=0.35 nfp=8 wt=64 l_t=0.25 nft=16
* 1:2 scaled replica half-cell: single symmetric load (wp/2 each), input NMOS (wn/2) tied to VDD, tail (wt/2)
Xrp1 vrep vrep vdd vdd serdes_pfet_lvt w={wp/2} l={l_p} nf={nfp/2}
Xrp2 vrep vbp  vdd vdd serdes_pfet_lvt w={wp/2} l={l_p} nf={nfp/2}
Xrmn vrep vdd rtail vss serdes_nfet_lvt w={wn/2} l={l_n} nf={nfn/2}
Xrtail rtail vbn vss vss serdes_nfet w={wt/2} l={l_t} nf={nft/2}
* Self-biased OTA tail current (~140 uA) using real SKY130 high_po_1p41 (~7 kOhm)
Xrbo vdd obias vss sky130_fd_pr__res_high_po_1p41 l=29.3
Xnbo obias obias vss vss serdes_nfet w=10 l=0.5 nf=4
* 5T servo OTA: nfet_lvt input + pfet_lvt mirror (L=0.5 um for high DC gain > 40 dB & low offset!)
Xotail otail obias vss vss serdes_nfet w=16 l=0.5 nf=4
Xin_p n_diode vrep otail vss serdes_nfet_lvt w=48 l=0.5 nf=12
Xin_n vbn     vbp  otail vss serdes_nfet_lvt w=48 l=0.5 nf=12
Xom1 n_diode n_diode vdd vdd serdes_pfet_lvt w=48 l=0.5 nf=12
Xom2 vbn     n_diode vdd vdd serdes_pfet_lvt w=48 l=0.5 nf=12
* Compensation & noise-filtering MIM capacitor on Vbn (~2.0 pF)
Xcbn vbn vss sky130_fd_pr__cap_mim_m3_1 w=32 l=32
.ends vco5g_maneatis_bias

* Differential resistive-load CML output buffer (light input cap ~9 fF on ring phase node, 30 fF/pin load)
.subckt vco5g_man_buf inp inn outp outn vbn vdd vss
Xrp1 vdd outp vss sky130_fd_pr__res_high_po_2p85 l=5.5
Xrn1 vdd outn vss sky130_fd_pr__res_high_po_2p85 l=5.5
Xmp outp inp tail vss serdes_nfet_lvt w=8 l=0.15 nf=4
Xmn outn inn tail vss serdes_nfet_lvt w=8 l=0.15 nf=4
Xtail tail vbn vss vss serdes_nfet w=8 l=0.25 nf=4
.ends vco5g_man_buf

* Complete Arch B Top: Replica Bias + 4-stage Maneatis Ring + 4 Buffers
.subckt vco5g_ring_maneatis v0p v0n v1p v1n v2p v2n v3p v3n b0p b0n b1p b1n b2p b2n b3p b3n vbp vbn vdd vss
+ params: wn=22 l_n=0.15 nfn=8 wp=32 l_p=0.35 nfp=8 wt=64 l_t=0.25 nft=16 cwire=12f
Vcore_sense vdd vdd_core 0
Vbias_sense vdd vdd_bias 0
Vbuf_sense  vdd vdd_buf  0
Xbias vbp vbn vdd_bias vss vco5g_maneatis_bias wn={wn} l_n={l_n} nfn={nfn} wp={wp} l_p={l_p} nfp={nfp} wt={wt} l_t={l_t} nft={nft}
X0 v3n v3p v0p v0n vbp vbn vdd_core vss vco5g_maneatis_cell wn={wn} l_n={l_n} nfn={nfn} wp={wp} l_p={l_p} nfp={nfp} wt={wt} l_t={l_t} nft={nft} cwire={cwire}
X1 v0p v0n v1p v1n vbp vbn vdd_core vss vco5g_maneatis_cell wn={wn} l_n={l_n} nfn={nfn} wp={wp} l_p={l_p} nfp={nfp} wt={wt} l_t={l_t} nft={nft} cwire={cwire}
X2 v1p v1n v2p v2n vbp vbn vdd_core vss vco5g_maneatis_cell wn={wn} l_n={l_n} nfn={nfn} wp={wp} l_p={l_p} nfp={nfp} wt={wt} l_t={l_t} nft={nft} cwire={cwire}
X3 v2p v2n v3p v3n vbp vbn vdd_core vss vco5g_maneatis_cell wn={wn} l_n={l_n} nfn={nfn} wp={wp} l_p={l_p} nfp={nfp} wt={wt} l_t={l_t} nft={nft} cwire={cwire}
Xb0 v0p v0n b0p b0n vbn vdd_buf vss vco5g_man_buf
Xb1 v1p v1n b1p b1n vbn vdd_buf vss vco5g_man_buf
Xb2 v2p v2n b2p b2n vbn vdd_buf vss vco5g_man_buf
Xb3 v3p v3n b3p b3n vbn vdd_buf vss vco5g_man_buf
.ends vco5g_ring_maneatis
