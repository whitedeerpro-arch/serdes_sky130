* NGSPICE file created from serdes_rx_ctle_shunt_5g_compact_pdk_open.ext - technology: sky130A

.subckt serdes_rx_ctle_shunt_5g_compact_pdk_open inp inn outp outn eq0 eq1 vbias vdd
+ vss lp_mid ln_mid
X0 a_n3772_2670# eq1 vdd vdd sky130_fd_pr__pfet_01v8 ad=0.58 pd=4.58 as=0.58 ps=4.58 w=2 l=0.18
X1 outn inp a_n3290_4138# vss sky130_fd_pr__nfet_01v8_lvt ad=0.495 pd=3.33 as=0.93 ps=6.62 w=3 l=0.15
X2 a_n3290_4138# a_n2902_2642# a_n2866_2670# vss sky130_fd_pr__nfet_01v8 ad=0.1218 pd=1.42 as=0.1218 ps=1.42 w=0.42 l=0.5
X3 outp lp_mid vss sky130_fd_pr__res_high_po_2p85 l=3.2
X4 a_n3290_4138# inp outn vss sky130_fd_pr__nfet_01v8_lvt ad=0.495 pd=3.33 as=0.495 ps=3.33 w=3 l=0.15
X5 outn inp a_n3290_4138# vss sky130_fd_pr__nfet_01v8_lvt ad=0.495 pd=3.33 as=0.495 ps=3.33 w=3 l=0.15
X6 a_n3290_4138# vbias vss vss sky130_fd_pr__nfet_01v8_lvt ad=0.87 pd=6.29 as=0.87 ps=6.29 w=6 l=0.5
X7 outp inn a_n3561_2670# vss sky130_fd_pr__nfet_01v8_lvt ad=0.495 pd=3.33 as=0.93 ps=6.62 w=3 l=0.15
X8 a_n3290_4138# inp outn vss sky130_fd_pr__nfet_01v8_lvt ad=0.93 pd=6.62 as=0.495 ps=3.33 w=3 l=0.15
X9 a_n3290_4138# a_n3466_2670# sky130_fd_pr__cap_mim_m3_1 l=9.81 w=9.81
X10 vss vbias a_n3290_4138# vss sky130_fd_pr__nfet_01v8_lvt ad=0.87 pd=6.29 as=0.87 ps=6.29 w=6 l=0.5
X11 outn inp a_n3290_4138# vss sky130_fd_pr__nfet_01v8_lvt ad=0.495 pd=3.33 as=0.93 ps=6.62 w=3 l=0.15
X12 a_n3561_2670# inn outp vss sky130_fd_pr__nfet_01v8_lvt ad=0.93 pd=6.62 as=0.495 ps=3.33 w=3 l=0.15
X13 a_n3290_4138# a_n3466_2670# sky130_fd_pr__cap_mim_m3_1 l=9.81 w=9.81
X14 a_n3561_2670# a_n3772_2670# a_n3466_2670# vdd sky130_fd_pr__pfet_01v8 ad=0.59 pd=4.59 as=0.3 ps=2.3 w=2 l=0.18
X15 vss vbias a_n3290_4138# vss sky130_fd_pr__nfet_01v8_lvt ad=0.87 pd=6.29 as=0.87 ps=6.29 w=6 l=0.5
X16 a_n3561_2670# inn outp vss sky130_fd_pr__nfet_01v8_lvt ad=0.495 pd=3.33 as=0.495 ps=3.33 w=3 l=0.15
X17 outp inn a_n3561_2670# vss sky130_fd_pr__nfet_01v8_lvt ad=0.495 pd=3.33 as=0.495 ps=3.33 w=3 l=0.15
X18 a_n3290_4138# vbias vss vss sky130_fd_pr__nfet_01v8_lvt ad=0.87 pd=6.29 as=0.87 ps=6.29 w=6 l=0.5
X19 a_n3290_4138# vbias vss vss sky130_fd_pr__nfet_01v8_lvt ad=0.87 pd=6.29 as=0.87 ps=6.29 w=6 l=0.5
X20 outp inn a_n3561_2670# vss sky130_fd_pr__nfet_01v8_lvt ad=0.495 pd=3.33 as=0.93 ps=6.62 w=3 l=0.15
X21 a_n3466_2670# a_n3772_2670# a_n3561_2670# vdd sky130_fd_pr__pfet_01v8 ad=0.3 pd=2.3 as=0.59 ps=4.59 w=2 l=0.18
X22 a_n3561_2670# a_n2902_2642# a_n2866_2670# vdd sky130_fd_pr__pfet_01v8 ad=0.59 pd=4.59 as=0.3 ps=2.3 w=2 l=0.18
X23 vss vbias a_n3561_2670# vss sky130_fd_pr__nfet_01v8_lvt ad=0.87 pd=6.29 as=0.87 ps=6.29 w=6 l=0.5
X24 vss vbias a_n3290_4138# vss sky130_fd_pr__nfet_01v8_lvt ad=0.87 pd=6.29 as=0.87 ps=6.29 w=6 l=0.5
X25 a_n3290_4138# vbias vss vss sky130_fd_pr__nfet_01v8_lvt ad=0.87 pd=6.29 as=0.87 ps=6.29 w=6 l=0.5
X26 a_n3290_4138# inp outn vss sky130_fd_pr__nfet_01v8_lvt ad=0.93 pd=6.62 as=0.495 ps=3.33 w=3 l=0.15
X27 a_n3290_4138# a_n2866_2670# sky130_fd_pr__cap_mim_m3_1 l=9.81 w=9.81
X28 outp inn a_n3561_2670# vss sky130_fd_pr__nfet_01v8_lvt ad=0.495 pd=3.33 as=0.495 ps=3.33 w=3 l=0.15
X29 a_n2866_2670# a_n2902_2642# a_n3561_2670# vdd sky130_fd_pr__pfet_01v8 ad=0.3 pd=2.3 as=0.59 ps=4.59 w=2 l=0.18
X30 vss vbias a_n3561_2670# vss sky130_fd_pr__nfet_01v8_lvt ad=0.87 pd=6.29 as=0.87 ps=6.29 w=6 l=0.5
X31 a_n3561_2670# a_n3772_2670# a_n3466_2670# vdd sky130_fd_pr__pfet_01v8 ad=0.3 pd=2.3 as=0.3 ps=2.3 w=2 l=0.18
X32 a_n3561_2670# vbias vss vss sky130_fd_pr__nfet_01v8_lvt ad=0.87 pd=6.29 as=0.87 ps=6.29 w=6 l=0.5
X33 a_n3561_2670# vbias vss vss sky130_fd_pr__nfet_01v8_lvt ad=0.87 pd=6.29 as=0.87 ps=6.29 w=6 l=0.5
X34 a_n3290_4138# vbias vss vss sky130_fd_pr__nfet_01v8_lvt ad=0.87 pd=6.29 as=1.74 ps=12.58 w=6 l=0.5
X35 vss vbias a_n3290_4138# vss sky130_fd_pr__nfet_01v8_lvt ad=1.74 pd=12.58 as=0.87 ps=6.29 w=6 l=0.5
X36 a_n3561_2670# inn outp vss sky130_fd_pr__nfet_01v8_lvt ad=0.495 pd=3.33 as=0.495 ps=3.33 w=3 l=0.15
X37 outn ln_mid vss sky130_fd_pr__res_high_po_2p85 l=3.2
X38 a_n3561_2670# a_n2902_2642# a_n2866_2670# vdd sky130_fd_pr__pfet_01v8 ad=0.3 pd=2.3 as=0.3 ps=2.3 w=2 l=0.18
X39 vss vbias a_n3561_2670# vss sky130_fd_pr__nfet_01v8_lvt ad=0.87 pd=6.29 as=0.87 ps=6.29 w=6 l=0.5
X40 a_n3466_2670# eq1 a_n3561_2670# vss sky130_fd_pr__nfet_01v8 ad=0.3 pd=2.3 as=0.59 ps=4.59 w=2 l=0.18
X41 a_n3561_2670# vbias vss vss sky130_fd_pr__nfet_01v8_lvt ad=0.87 pd=6.29 as=0.87 ps=6.29 w=6 l=0.5
X42 a_n3561_2670# vbias vss vss sky130_fd_pr__nfet_01v8_lvt ad=0.87 pd=6.29 as=0.87 ps=6.29 w=6 l=0.5
X43 a_n3290_4138# inp outn vss sky130_fd_pr__nfet_01v8_lvt ad=0.495 pd=3.33 as=0.495 ps=3.33 w=3 l=0.15
X44 a_n3561_2670# a_n3290_4138# vss sky130_fd_pr__res_high_po_2p85 l=4.14
X45 vss eq0 a_n2902_2642# vss sky130_fd_pr__nfet_01v8 ad=0.29 pd=2.58 as=0.29 ps=2.58 w=1 l=0.18
X46 a_n3466_2670# a_n3772_2670# a_n3561_2670# vdd sky130_fd_pr__pfet_01v8 ad=0.3 pd=2.3 as=0.3 ps=2.3 w=2 l=0.18
X47 vss vbias a_n3290_4138# vss sky130_fd_pr__nfet_01v8_lvt ad=0.87 pd=6.29 as=0.87 ps=6.29 w=6 l=0.5
X48 vss vbias a_n3561_2670# vss sky130_fd_pr__nfet_01v8_lvt ad=0.87 pd=6.29 as=0.87 ps=6.29 w=6 l=0.5
X49 a_n2866_2670# eq0 a_n3561_2670# vss sky130_fd_pr__nfet_01v8 ad=0.3 pd=2.3 as=0.59 ps=4.59 w=2 l=0.18
X50 a_n2866_2670# a_n2902_2642# a_n3561_2670# vdd sky130_fd_pr__pfet_01v8 ad=0.3 pd=2.3 as=0.3 ps=2.3 w=2 l=0.18
X51 vss vbias a_n3561_2670# vss sky130_fd_pr__nfet_01v8_lvt ad=0.87 pd=6.29 as=0.87 ps=6.29 w=6 l=0.5
X52 a_n3772_2670# eq1 vss vss sky130_fd_pr__nfet_01v8 ad=0.29 pd=2.58 as=0.29 ps=2.58 w=1 l=0.18
X53 a_n3561_2670# eq1 a_n3466_2670# vss sky130_fd_pr__nfet_01v8 ad=0.59 pd=4.59 as=0.3 ps=2.3 w=2 l=0.18
X54 vdd eq0 a_n2902_2642# vdd sky130_fd_pr__pfet_01v8 ad=0.58 pd=4.58 as=0.58 ps=4.58 w=2 l=0.18
X55 a_n3561_2670# vbias vss vss sky130_fd_pr__nfet_01v8_lvt ad=0.87 pd=6.29 as=0.87 ps=6.29 w=6 l=0.5
X56 outn inp a_n3290_4138# vss sky130_fd_pr__nfet_01v8_lvt ad=0.495 pd=3.33 as=0.495 ps=3.33 w=3 l=0.15
X57 a_n3561_2670# inn outp vss sky130_fd_pr__nfet_01v8_lvt ad=0.93 pd=6.62 as=0.495 ps=3.33 w=3 l=0.15
X58 a_n3290_4138# a_n3772_2670# a_n3466_2670# vss sky130_fd_pr__nfet_01v8 ad=0.1218 pd=1.42 as=0.1218 ps=1.42 w=0.42 l=0.5
X59 a_n3561_2670# eq0 a_n2866_2670# vss sky130_fd_pr__nfet_01v8 ad=0.59 pd=4.59 as=0.3 ps=2.3 w=2 l=0.18
C0 vdd a_n3290_4138# 0.18712f
C1 eq0 a_n2902_2642# 0.32857f
C2 outn a_n3466_2670# 0.02602f
C3 a_n2902_2642# a_n3561_2670# 0.33804f
C4 vdd eq0 0.67788f
C5 outp eq1 0
C6 outp vbias 0
C7 vdd a_n3561_2670# 0.52077f
C8 inp vdd 0.00429f
C9 eq1 a_n3466_2670# 1.16131f
C10 vbias a_n3466_2670# 0.45808f
C11 outn inn 0.61284f
C12 a_n3290_4138# a_n2866_2670# 11.7836f
C13 vdd ln_mid 0.67102f
C14 a_n3772_2670# eq1 0.39688f
C15 eq0 a_n2866_2670# 0.16203f
C16 outp a_n2902_2642# 0
C17 a_n2866_2670# a_n3561_2670# 3.47477f
C18 inp a_n2866_2670# 0.04881f
C19 vbias inn 0.00138f
C20 a_n2902_2642# a_n3466_2670# 0.40591f
C21 outp vdd 0.13432f
C22 vbias outn 0
C23 lp_mid a_n3290_4138# 0
C24 a_n3772_2670# a_n2902_2642# 0.02273f
C25 vdd a_n3466_2670# 0.77714f
C26 lp_mid eq0 0
C27 a_n3772_2670# vdd 0.46077f
C28 lp_mid a_n3561_2670# 0.09214f
C29 outp a_n2866_2670# 0.02754f
C30 vdd inn 0.00429f
C31 lp_mid ln_mid 0.07736f
C32 a_n2866_2670# a_n3466_2670# 1.97802f
C33 vdd outn 0.23236f
C34 a_n3772_2670# a_n2866_2670# 0.00241f
C35 eq1 a_n2902_2642# 0
C36 a_n3290_4138# eq0 0.11624f
C37 a_n3290_4138# a_n3561_2670# 2.33536f
C38 inp a_n3290_4138# 0.51033f
C39 outp lp_mid 0.31588f
C40 vdd eq1 0.14576f
C41 a_n2866_2670# inn 0.01238f
C42 lp_mid a_n3466_2670# 0
C43 a_n2866_2670# outn 0.0066f
C44 eq0 a_n3561_2670# 0.26787f
C45 a_n3290_4138# ln_mid 0.09729f
C46 inp a_n3561_2670# 0.03163f
C47 ln_mid a_n3561_2670# 0
C48 vdd a_n2902_2642# 0.46387f
C49 inp ln_mid 0.01118f
C50 eq1 a_n2866_2670# 0.00252f
C51 vbias a_n2866_2670# 1.32448f
C52 lp_mid inn 0.00267f
C53 outp a_n3290_4138# 0.33061f
C54 lp_mid outn 0.0934f
C55 a_n3290_4138# a_n3466_2670# 21.0622f
C56 outp eq0 0.03975f
C57 outp a_n3561_2670# 2.76586f
C58 inp outp 0.34822f
C59 a_n3772_2670# a_n3290_4138# 0.02003f
C60 eq0 a_n3466_2670# 0.98633f
C61 a_n2866_2670# a_n2902_2642# 0.28885f
C62 a_n3561_2670# a_n3466_2670# 5.41997f
C63 inp a_n3466_2670# 0.07015f
C64 a_n3772_2670# eq0 0.00806f
C65 a_n3290_4138# inn 0.12579f
C66 vdd a_n2866_2670# 0.10885f
C67 a_n3772_2670# a_n3561_2670# 0.23039f
C68 a_n3290_4138# outn 2.79263f
C69 inn a_n3561_2670# 0.39545f
C70 inp inn 1.61024f
C71 eq0 outn 0.00379f
C72 outn a_n3561_2670# 0.14681f
C73 inp outn 0.65987f
C74 eq1 a_n3290_4138# 0.00235f
C75 vbias a_n3290_4138# 2.58994f
C76 ln_mid inn 0.03856f
C77 lp_mid vdd 0.67316f
C78 outp a_n3466_2670# 0.03769f
C79 ln_mid outn 0.31196f
C80 eq1 eq0 0.0157f
C81 a_n3772_2670# outp 0
C82 eq1 a_n3561_2670# 0.11555f
C83 vbias a_n3561_2670# 2.86471f
C84 inp vbias 0.00223f
C85 a_n3772_2670# a_n3466_2670# 0.68607f
C86 outp inn 0.50817f
C87 a_n3290_4138# a_n2902_2642# 0.1463f
C88 outp outn 1.17251f
C89 ln_mid vss 2.5475f
C90 outn vss 2.72957f
C91 inn vss 2.06903f
C92 inp vss 2.02518f
C93 lp_mid vss 2.4835f
C94 outp vss 3.02386f
C95 vbias vss 12.0757f
C96 eq0 vss 2.19255f
C97 eq1 vss 2.42905f
C98 vdd vss 16.3967f
C99 a_n3561_2670# vss 10.1623f
C100 a_n2866_2670# vss 5.74507f
C101 a_n3290_4138# vss 12.589f
C102 a_n3466_2670# vss 10.6954f
C103 a_n2902_2642# vss 0.88271f
C104 a_n3772_2670# vss 0.99479f
.ends
