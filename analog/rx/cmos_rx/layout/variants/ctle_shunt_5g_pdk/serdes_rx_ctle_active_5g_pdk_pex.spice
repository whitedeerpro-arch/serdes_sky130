* NGSPICE file created from serdes_rx_ctle_active_5g_pdk.ext - technology: sky130A

.subckt serdes_rx_ctle_active_5g_pdk inp inn outp outn lp_mid ln_mid eq0 eq1 vbias
+ vdd vss
X0 a_n3772_2670# eq1 vdd vdd sky130_fd_pr__pfet_01v8 ad=0.58 pd=4.58 as=0.58 ps=4.58 w=2 l=0.18
X1 outn inp a_n3290_4138# vss sky130_fd_pr__nfet_01v8_lvt ad=0.495 pd=3.33 as=0.93 ps=6.62 w=3 l=0.15
X2 a_n3290_4138# a_n2902_2642# a_n2866_2670# vss sky130_fd_pr__nfet_01v8 ad=0.1218 pd=1.42 as=0.1218 ps=1.42 w=0.42 l=0.5
X3 outp lp_mid vss sky130_fd_pr__res_high_po_2p85 l=3.2
X4 a_n3290_4138# inp outn vss sky130_fd_pr__nfet_01v8_lvt ad=0.495 pd=3.33 as=0.495 ps=3.33 w=3 l=0.15
X5 outn inp a_n3290_4138# vss sky130_fd_pr__nfet_01v8_lvt ad=0.495 pd=3.33 as=0.495 ps=3.33 w=3 l=0.15
X6 a_n3290_4138# vbias vss vss sky130_fd_pr__nfet_01v8_lvt ad=0.87 pd=6.29 as=0.87 ps=6.29 w=6 l=0.5
X7 outp inn a_n3561_2670# vss sky130_fd_pr__nfet_01v8_lvt ad=0.495 pd=3.33 as=0.93 ps=6.62 w=3 l=0.15
X8 a_n3290_4138# inp outn vss sky130_fd_pr__nfet_01v8_lvt ad=0.93 pd=6.62 as=0.495 ps=3.33 w=3 l=0.15
X9 a_n3290_4138# a_n3466_2670# sky130_fd_pr__cap_mim_m3_1 l=9.81 w=9.81
X10 vss vbias a_n3290_4138# vss sky130_fd_pr__nfet_01v8_lvt ad=0.87 pd=6.29 as=0.87 ps=6.29 w=6 l=0.5
X11 outn inp a_n3290_4138# vss sky130_fd_pr__nfet_01v8_lvt ad=0.495 pd=3.33 as=0.93 ps=6.62 w=3 l=0.15
X12 a_n3561_2670# inn outp vss sky130_fd_pr__nfet_01v8_lvt ad=0.93 pd=6.62 as=0.495 ps=3.33 w=3 l=0.15
X13 a_n3290_4138# a_n3466_2670# sky130_fd_pr__cap_mim_m3_1 l=9.81 w=9.81
X14 a_n3561_2670# a_n3772_2670# a_n3466_2670# vdd sky130_fd_pr__pfet_01v8 ad=0.59 pd=4.59 as=0.3 ps=2.3 w=2 l=0.18
X15 vss vbias a_n3290_4138# vss sky130_fd_pr__nfet_01v8_lvt ad=0.87 pd=6.29 as=0.87 ps=6.29 w=6 l=0.5
X16 a_n3561_2670# inn outp vss sky130_fd_pr__nfet_01v8_lvt ad=0.495 pd=3.33 as=0.495 ps=3.33 w=3 l=0.15
X17 outp inn a_n3561_2670# vss sky130_fd_pr__nfet_01v8_lvt ad=0.495 pd=3.33 as=0.495 ps=3.33 w=3 l=0.15
X18 a_n3290_4138# vbias vss vss sky130_fd_pr__nfet_01v8_lvt ad=0.87 pd=6.29 as=0.87 ps=6.29 w=6 l=0.5
X19 a_n3290_4138# vbias vss vss sky130_fd_pr__nfet_01v8_lvt ad=0.87 pd=6.29 as=0.87 ps=6.29 w=6 l=0.5
X20 outp inn a_n3561_2670# vss sky130_fd_pr__nfet_01v8_lvt ad=0.495 pd=3.33 as=0.93 ps=6.62 w=3 l=0.15
X21 a_n3466_2670# a_n3772_2670# a_n3561_2670# vdd sky130_fd_pr__pfet_01v8 ad=0.3 pd=2.3 as=0.59 ps=4.59 w=2 l=0.18
X22 a_n3561_2670# a_n2902_2642# a_n2866_2670# vdd sky130_fd_pr__pfet_01v8 ad=0.59 pd=4.59 as=0.3 ps=2.3 w=2 l=0.18
X23 vss vbias a_n3561_2670# vss sky130_fd_pr__nfet_01v8_lvt ad=0.87 pd=6.29 as=0.87 ps=6.29 w=6 l=0.5
X24 vss vbias a_n3290_4138# vss sky130_fd_pr__nfet_01v8_lvt ad=0.87 pd=6.29 as=0.87 ps=6.29 w=6 l=0.5
X25 a_n3290_4138# vbias vss vss sky130_fd_pr__nfet_01v8_lvt ad=0.87 pd=6.29 as=0.87 ps=6.29 w=6 l=0.5
X26 a_n3290_4138# inp outn vss sky130_fd_pr__nfet_01v8_lvt ad=0.93 pd=6.62 as=0.495 ps=3.33 w=3 l=0.15
X27 a_n3290_4138# a_n2866_2670# sky130_fd_pr__cap_mim_m3_1 l=9.81 w=9.81
X28 outp inn a_n3561_2670# vss sky130_fd_pr__nfet_01v8_lvt ad=0.495 pd=3.33 as=0.495 ps=3.33 w=3 l=0.15
X29 a_n2866_2670# a_n2902_2642# a_n3561_2670# vdd sky130_fd_pr__pfet_01v8 ad=0.3 pd=2.3 as=0.59 ps=4.59 w=2 l=0.18
X30 vss vbias a_n3561_2670# vss sky130_fd_pr__nfet_01v8_lvt ad=0.87 pd=6.29 as=0.87 ps=6.29 w=6 l=0.5
X31 a_n3561_2670# a_n3772_2670# a_n3466_2670# vdd sky130_fd_pr__pfet_01v8 ad=0.3 pd=2.3 as=0.3 ps=2.3 w=2 l=0.18
X32 a_n3561_2670# vbias vss vss sky130_fd_pr__nfet_01v8_lvt ad=0.87 pd=6.29 as=0.87 ps=6.29 w=6 l=0.5
X33 a_n3561_2670# vbias vss vss sky130_fd_pr__nfet_01v8_lvt ad=0.87 pd=6.29 as=0.87 ps=6.29 w=6 l=0.5
X34 a_n3290_4138# vbias vss vss sky130_fd_pr__nfet_01v8_lvt ad=0.87 pd=6.29 as=1.74 ps=12.58 w=6 l=0.5
X35 vss vbias a_n3290_4138# vss sky130_fd_pr__nfet_01v8_lvt ad=1.74 pd=12.58 as=0.87 ps=6.29 w=6 l=0.5
X36 a_n3561_2670# inn outp vss sky130_fd_pr__nfet_01v8_lvt ad=0.495 pd=3.33 as=0.495 ps=3.33 w=3 l=0.15
X37 outn ln_mid vss sky130_fd_pr__res_high_po_2p85 l=3.2
X38 a_n3561_2670# a_n2902_2642# a_n2866_2670# vdd sky130_fd_pr__pfet_01v8 ad=0.3 pd=2.3 as=0.3 ps=2.3 w=2 l=0.18
X39 vss vbias a_n3561_2670# vss sky130_fd_pr__nfet_01v8_lvt ad=0.87 pd=6.29 as=0.87 ps=6.29 w=6 l=0.5
X40 a_n3466_2670# eq1 a_n3561_2670# vss sky130_fd_pr__nfet_01v8 ad=0.3 pd=2.3 as=0.59 ps=4.59 w=2 l=0.18
X41 a_n3561_2670# vbias vss vss sky130_fd_pr__nfet_01v8_lvt ad=0.87 pd=6.29 as=0.87 ps=6.29 w=6 l=0.5
X42 a_n3561_2670# vbias vss vss sky130_fd_pr__nfet_01v8_lvt ad=0.87 pd=6.29 as=0.87 ps=6.29 w=6 l=0.5
X43 a_n3290_4138# inp outn vss sky130_fd_pr__nfet_01v8_lvt ad=0.495 pd=3.33 as=0.495 ps=3.33 w=3 l=0.15
X44 a_n3561_2670# a_n3290_4138# vss sky130_fd_pr__res_high_po_2p85 l=4.14
X45 vss eq0 a_n2902_2642# vss sky130_fd_pr__nfet_01v8 ad=0.29 pd=2.58 as=0.29 ps=2.58 w=1 l=0.18
X46 a_n3466_2670# a_n3772_2670# a_n3561_2670# vdd sky130_fd_pr__pfet_01v8 ad=0.3 pd=2.3 as=0.3 ps=2.3 w=2 l=0.18
X47 vss vbias a_n3290_4138# vss sky130_fd_pr__nfet_01v8_lvt ad=0.87 pd=6.29 as=0.87 ps=6.29 w=6 l=0.5
X48 vss vbias a_n3561_2670# vss sky130_fd_pr__nfet_01v8_lvt ad=0.87 pd=6.29 as=0.87 ps=6.29 w=6 l=0.5
X49 a_n2866_2670# eq0 a_n3561_2670# vss sky130_fd_pr__nfet_01v8 ad=0.3 pd=2.3 as=0.59 ps=4.59 w=2 l=0.18
X50 a_n2866_2670# a_n2902_2642# a_n3561_2670# vdd sky130_fd_pr__pfet_01v8 ad=0.3 pd=2.3 as=0.3 ps=2.3 w=2 l=0.18
X51 vss vbias a_n3561_2670# vss sky130_fd_pr__nfet_01v8_lvt ad=0.87 pd=6.29 as=0.87 ps=6.29 w=6 l=0.5
X52 a_n3772_2670# eq1 vss vss sky130_fd_pr__nfet_01v8 ad=0.29 pd=2.58 as=0.29 ps=2.58 w=1 l=0.18
X53 a_n3561_2670# eq1 a_n3466_2670# vss sky130_fd_pr__nfet_01v8 ad=0.59 pd=4.59 as=0.3 ps=2.3 w=2 l=0.18
X54 vdd eq0 a_n2902_2642# vdd sky130_fd_pr__pfet_01v8 ad=0.58 pd=4.58 as=0.58 ps=4.58 w=2 l=0.18
X55 a_n3561_2670# vbias vss vss sky130_fd_pr__nfet_01v8_lvt ad=0.87 pd=6.29 as=0.87 ps=6.29 w=6 l=0.5
X56 outn inp a_n3290_4138# vss sky130_fd_pr__nfet_01v8_lvt ad=0.495 pd=3.33 as=0.495 ps=3.33 w=3 l=0.15
X57 a_n3561_2670# inn outp vss sky130_fd_pr__nfet_01v8_lvt ad=0.93 pd=6.62 as=0.495 ps=3.33 w=3 l=0.15
X58 a_n3290_4138# a_n3772_2670# a_n3466_2670# vss sky130_fd_pr__nfet_01v8 ad=0.1218 pd=1.42 as=0.1218 ps=1.42 w=0.42 l=0.5
X59 a_n3561_2670# eq0 a_n2866_2670# vss sky130_fd_pr__nfet_01v8 ad=0.59 pd=4.59 as=0.3 ps=2.3 w=2 l=0.18
C0 inp a_n3290_4138# 0.51033f
C1 outp a_n3772_2670# 0
C2 vbias inp 0.00223f
C3 a_n2866_2670# eq1 0.00251f
C4 outp a_n3466_2670# 0.03769f
C5 a_n3290_4138# a_n2902_2642# 0.1463f
C6 a_n3561_2670# a_n2866_2670# 3.47477f
C7 eq0 lp_mid 0
C8 vdd lp_mid 0.00214f
C9 outn lp_mid 0.08366f
C10 a_n2866_2670# inn 0.01238f
C11 eq0 vdd 0.66547f
C12 eq0 outn 0.00215f
C13 a_n2866_2670# outp 0.02754f
C14 vdd outn 0.04691f
C15 vbias a_n3290_4138# 2.58994f
C16 inp a_n3466_2670# 0.07015f
C17 a_n3561_2670# lp_mid 0.08326f
C18 a_n3772_2670# a_n2902_2642# 0.02273f
C19 eq0 eq1 0.0157f
C20 vdd eq1 0.14576f
C21 eq0 a_n3561_2670# 0.26787f
C22 a_n3466_2670# a_n2902_2642# 0.40591f
C23 vdd a_n3561_2670# 0.51323f
C24 inn lp_mid 0
C25 outn a_n3561_2670# 0.14681f
C26 a_n3290_4138# a_n3772_2670# 0.02003f
C27 inp a_n2866_2670# 0.04881f
C28 lp_mid outp 0.31276f
C29 ln_mid lp_mid 0.00909f
C30 a_n3290_4138# a_n3466_2670# 21.0622f
C31 a_n3561_2670# eq1 0.11555f
C32 outn inn 0.61284f
C33 eq0 outp 0.02918f
C34 a_n2866_2670# a_n2902_2642# 0.28885f
C35 vdd outp 0.09206f
C36 vbias a_n3466_2670# 0.45808f
C37 outn outp 1.03507f
C38 ln_mid outn 0.30848f
C39 a_n2866_2670# a_n3290_4138# 11.7836f
C40 outp eq1 0
C41 a_n3561_2670# inn 0.39545f
C42 a_n3561_2670# outp 2.76586f
C43 a_n3466_2670# a_n3772_2670# 0.68607f
C44 vbias a_n2866_2670# 1.32448f
C45 ln_mid a_n3561_2670# 0
C46 inp outn 0.65987f
C47 inn outp 0.50817f
C48 eq0 a_n2902_2642# 0.32857f
C49 ln_mid inn 0.03767f
C50 a_n3290_4138# lp_mid 0
C51 vdd a_n2902_2642# 0.46387f
C52 a_n2866_2670# a_n3772_2670# 0.00241f
C53 inp a_n3561_2670# 0.03163f
C54 eq0 a_n3290_4138# 0.11589f
C55 a_n2866_2670# a_n3466_2670# 1.97802f
C56 vdd a_n3290_4138# 0.17944f
C57 eq1 a_n2902_2642# 0
C58 outn a_n3290_4138# 2.79263f
C59 inp inn 1.27706f
C60 a_n3561_2670# a_n2902_2642# 0.33804f
C61 vbias outn 0
C62 inp outp 0.34822f
C63 ln_mid inp 0.00795f
C64 a_n3290_4138# eq1 0.00235f
C65 a_n3561_2670# a_n3290_4138# 2.33536f
C66 lp_mid a_n3466_2670# 0
C67 eq0 a_n3772_2670# 0.00806f
C68 outp a_n2902_2642# 0
C69 vdd a_n3772_2670# 0.46077f
C70 vbias a_n3561_2670# 2.86471f
C71 eq0 a_n3466_2670# 0.98633f
C72 a_n3290_4138# inn 0.12579f
C73 vdd a_n3466_2670# 0.77714f
C74 outn a_n3466_2670# 0.02602f
C75 a_n3290_4138# outp 0.33061f
C76 ln_mid a_n3290_4138# 0.0877f
C77 eq1 a_n3772_2670# 0.39688f
C78 vbias inn 0.00138f
C79 a_n3561_2670# a_n3772_2670# 0.23039f
C80 vbias outp 0
C81 eq1 a_n3466_2670# 1.15525f
C82 eq0 a_n2866_2670# 0.16203f
C83 a_n3561_2670# a_n3466_2670# 5.41997f
C84 vdd a_n2866_2670# 0.10885f
C85 outn a_n2866_2670# 0.0066f
C86 ln_mid vss 2.00534f
C87 outn vss 2.78248f
C88 inn vss 1.66917f
C89 inp vss 1.62532f
C90 lp_mid vss 1.96197f
C91 outp vss 2.68075f
C92 vbias vss 11.3212f
C93 eq0 vss 1.22486f
C94 eq1 vss 1.44841f
C95 vdd vss 6.27886f
C96 a_n3561_2670# vss 10.1671f
C97 a_n2866_2670# vss 5.87614f
C98 a_n3290_4138# vss 12.6099f
C99 a_n3466_2670# vss 10.2452f
C100 a_n2902_2642# vss 0.88234f
C101 a_n3772_2670# vss 0.98499f
.ends
