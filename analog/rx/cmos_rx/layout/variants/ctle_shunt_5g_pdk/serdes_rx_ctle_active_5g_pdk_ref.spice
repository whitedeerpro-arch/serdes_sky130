* Exact flattened LVS reference netlist for serdes_rx_ctle_active_5g_pdk
* Source: analog/rx/cmos_rx/spice/rx_ctle_shunt_5g_pdk.spice (shunt_480_5g active core)
.subckt serdes_rx_ctle_active_5g_pdk inp inn outp outn lp_mid ln_mid eq0 eq1 vbias vdd vss
X1 lp_mid outp vss sky130_fd_pr__res_high_po_2p85 l=3.2
X2 ln_mid outn vss sky130_fd_pr__res_high_po_2p85 l=3.2
X3 outn inp t_sp vss sky130_fd_pr__nfet_01v8_lvt w=24 l=0.15
X4 outp inn t_sn vss sky130_fd_pr__nfet_01v8_lvt w=24 l=0.15
X5 t_sp vbias vss vss sky130_fd_pr__nfet_01v8_lvt w=60 l=0.5
X6 t_sn vbias vss vss sky130_fd_pr__nfet_01v8_lvt w=60 l=0.5
X7 t_sp t_sn vss sky130_fd_pr__res_high_po_2p85 l=4.14
X8 t_eq0_b eq0 vss vss sky130_fd_pr__nfet_01v8 w=1 l=0.18
X9 t_eq0_b eq0 vdd vdd sky130_fd_pr__pfet_01v8 w=2 l=0.18
X10 t_eq1_b eq1 vss vss sky130_fd_pr__nfet_01v8 w=1 l=0.18
X11 t_eq1_b eq1 vdd vdd sky130_fd_pr__pfet_01v8 w=2 l=0.18
X12 t_sp t_cap0 sky130_fd_pr__cap_mim_m3_1 w=9.81 l=9.81
X13 t_sp t_cap1 sky130_fd_pr__cap_mim_m3_1 w=9.81 l=9.81
X14 t_sp t_cap1 sky130_fd_pr__cap_mim_m3_1 w=9.81 l=9.81
X15 t_cap0 eq0 t_sn vss sky130_fd_pr__nfet_01v8 w=4 l=0.18
X16 t_cap0 t_eq0_b t_sn vdd sky130_fd_pr__pfet_01v8 w=8 l=0.18
X17 t_cap1 eq1 t_sn vss sky130_fd_pr__nfet_01v8 w=4 l=0.18
X18 t_cap1 t_eq1_b t_sn vdd sky130_fd_pr__pfet_01v8 w=8 l=0.18
X19 t_cap0 t_eq0_b t_sp vss sky130_fd_pr__nfet_01v8 w=0.42 l=0.5
X20 t_cap1 t_eq1_b t_sp vss sky130_fd_pr__nfet_01v8 w=0.42 l=0.5
.ends serdes_rx_ctle_active_5g_pdk
