* Authoritative reference netlist for integrated 5G shunt-peaked RX CTLE (serdes_rx_ctle_shunt_5g_pdk)
* Source: analog/rx/cmos_rx/spice/rx_ctle_shunt_5g_pdk.spice (shunt_480_5g defaults)

.subckt rx_ctle_ind_6n5_pdk pa pb ct sub
+ params: lhalf=2.845n kmut=0.45 rs=24.74 csub=35f rsub=500 cw=10f rm_scale=1.0 c_scale=1.0
* Left half (pa <-> ct)
Rsa1 pa  na1 {0.5*rs*rm_scale} tc1=3.2e-3
La   na1 na2 {lhalf}
Rsa2 na2 ct  {0.5*rs*rm_scale} tc1=3.2e-3
Cwa  pa  ct  {cw*c_scale}
Csa  pa  sa  {csub*c_scale}
Rsub_a sa sub {rsub} tc1=1.5e-3
* Right half (ct <-> pb) — dot convention: differential current enters pa & exits pb -> aiding flux!
Rsb1 ct  nb1 {0.5*rs*rm_scale} tc1=3.2e-3
Lb   nb1 nb2 {lhalf}
Rsb2 nb2 pb  {0.5*rs*rm_scale} tc1=3.2e-3
Cwb  ct  pb  {cw*c_scale}
Csb  pb  sb  {csub*c_scale}
Rsub_b sb sub {rsub} tc1=1.5e-3
* Center-tap substrate capacitance (AC-shorted to VDD in CTLE)
Cs_ct   ct  sct {csub*c_scale}
Rsub_ct sct sub {rsub} tc1=1.5e-3
* Differential mutual coupling (aiding for differential, opposing for common-mode)
Kab La Lb {kmut}
.ends rx_ctle_ind_6n5_pdk

.subckt serdes_rx_ctle_shunt_5g_pdk inp inn outp outn eq0 eq1 vbias vdd vss
Xind lp_mid ln_mid vdd vss rx_ctle_ind_6n5_pdk
X1 lp_mid outp vss sky130_fd_pr__res_high_po_2p85 l=3.2
X2 ln_mid outn vss sky130_fd_pr__res_high_po_2p85 l=3.2
X3 outn inp t_sp vss sky130_fd_pr__nfet_01v8_lvt w=24 l=0.15
X4 outp inn t_sn vss sky130_fd_pr__nfet_01v8_lvt w=24 l=0.15
X5 t_sp vbias vss vss sky130_fd_pr__nfet_01v8_lvt w=60 l=0.5
X6 t_sn vbias vss vss sky130_fd_pr__nfet_01v8_lvt w=60 l=0.5
X7 t_sp t_sn vss sky130_fd_pr__res_high_po_2p85 l=4.14
X8 t_eq0_b eq0 vss vss sky130_fd_pr__nfet_01v8 w=1 l=0.18
X9 t_eq0_b eq0 vdd vdd sky130_fd_pr__pfet_01v8 w=2 l=0.18
X10 t_eq1_b eq1 vss vss sky130_fd_pr__nfet_01v8 w=1 l=0.18
X11 t_eq1_b eq1 vdd vdd sky130_fd_pr__pfet_01v8 w=2 l=0.18
X12 t_sp t_cap0 sky130_fd_pr__cap_mim_m3_1 w=9.81 l=9.81
X13 t_sp t_cap1 sky130_fd_pr__cap_mim_m3_1 w=9.81 l=9.81
X14 t_sp t_cap1 sky130_fd_pr__cap_mim_m3_1 w=9.81 l=9.81
X15 t_cap0 eq0 t_sn vss sky130_fd_pr__nfet_01v8 w=4 l=0.18
X16 t_cap0 t_eq0_b t_sn vdd sky130_fd_pr__pfet_01v8 w=8 l=0.18
X17 t_cap1 eq1 t_sn vss sky130_fd_pr__nfet_01v8 w=4 l=0.18
X18 t_cap1 t_eq1_b t_sn vdd sky130_fd_pr__pfet_01v8 w=8 l=0.18
X19 t_cap0 t_eq0_b t_sp vss sky130_fd_pr__nfet_01v8 w=0.42 l=0.5
X20 t_cap1 t_eq1_b t_sp vss sky130_fd_pr__nfet_01v8 w=0.42 l=0.5
.ends serdes_rx_ctle_shunt_5g_pdk
