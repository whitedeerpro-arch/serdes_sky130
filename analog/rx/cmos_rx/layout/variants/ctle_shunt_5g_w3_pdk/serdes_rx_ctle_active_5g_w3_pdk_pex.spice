* NGSPICE file created from serdes_rx_ctle_active_5g_w3_pdk.ext - technology: sky130A

.subckt serdes_rx_ctle_active_5g_w3_pdk inp inn outp outn lp_mid ln_mid eq0 eq1 vbias
+ vdd vss
X0 a_n3561_2630# eq0 a_n2866_2630# vss sky130_fd_pr__nfet_01v8 ad=1.18 pd=8.59 as=0.6 ps=4.3 w=4 l=0.18
X1 a_n2866_2630# a_n2902_2602# a_n3561_2630# vdd sky130_fd_pr__pfet_01v8 ad=0.6 pd=4.3 as=0.6 ps=4.3 w=4 l=0.18
X2 vss vbias a_n3561_2630# vss sky130_fd_pr__nfet_01v8_lvt ad=1.305 pd=9.29 as=1.305 ps=9.29 w=9 l=0.5
X3 a_n3290_4908# vbias vss vss sky130_fd_pr__nfet_01v8_lvt ad=1.305 pd=9.29 as=1.305 ps=9.29 w=9 l=0.5
X4 outn inp a_n3290_4908# vss sky130_fd_pr__nfet_01v8_lvt ad=0.396 pd=2.73 as=0.744 ps=5.42 w=2.4 l=0.15
X5 a_n3290_4908# a_n2866_2630# sky130_fd_pr__cap_mim_m3_1 l=6 w=6
X6 vss vbias a_n3290_4908# vss sky130_fd_pr__nfet_01v8_lvt ad=1.305 pd=9.29 as=1.305 ps=9.29 w=9 l=0.5
X7 outn ln_mid vss sky130_fd_pr__res_high_po_2p85 l=2.83
X8 outn inp a_n3290_4908# vss sky130_fd_pr__nfet_01v8_lvt ad=0.396 pd=2.73 as=0.744 ps=5.42 w=2.4 l=0.15
X9 vss vbias a_n3561_2630# vss sky130_fd_pr__nfet_01v8_lvt ad=1.305 pd=9.29 as=1.305 ps=9.29 w=9 l=0.5
X10 a_n3290_4908# inp outn vss sky130_fd_pr__nfet_01v8_lvt ad=0.396 pd=2.73 as=0.396 ps=2.73 w=2.4 l=0.15
X11 outn inp a_n3290_4908# vss sky130_fd_pr__nfet_01v8_lvt ad=0.396 pd=2.73 as=0.396 ps=2.73 w=2.4 l=0.15
X12 vss eq0 a_n2902_2602# vss sky130_fd_pr__nfet_01v8 ad=0.29 pd=2.58 as=0.29 ps=2.58 w=1 l=0.18
X13 a_n3290_4908# inp outn vss sky130_fd_pr__nfet_01v8_lvt ad=0.744 pd=5.42 as=0.396 ps=2.73 w=2.4 l=0.15
X14 a_n3290_4908# inp outn vss sky130_fd_pr__nfet_01v8_lvt ad=0.744 pd=5.42 as=0.396 ps=2.73 w=2.4 l=0.15
X15 a_n3290_4908# a_n3466_2630# sky130_fd_pr__cap_mim_m3_1 l=6 w=6
X16 a_n3561_2630# vbias vss vss sky130_fd_pr__nfet_01v8_lvt ad=1.305 pd=9.29 as=1.305 ps=9.29 w=9 l=0.5
X17 a_n3561_2630# vbias vss vss sky130_fd_pr__nfet_01v8_lvt ad=1.305 pd=9.29 as=1.305 ps=9.29 w=9 l=0.5
X18 outp inn a_n3561_2630# vss sky130_fd_pr__nfet_01v8_lvt ad=0.396 pd=2.73 as=0.396 ps=2.73 w=2.4 l=0.15
X19 a_n3561_2630# inn outp vss sky130_fd_pr__nfet_01v8_lvt ad=0.744 pd=5.42 as=0.396 ps=2.73 w=2.4 l=0.15
X20 a_n3290_4908# vbias vss vss sky130_fd_pr__nfet_01v8_lvt ad=1.305 pd=9.29 as=2.61 ps=18.58 w=9 l=0.5
X21 vss vbias a_n3290_4908# vss sky130_fd_pr__nfet_01v8_lvt ad=2.61 pd=18.58 as=1.305 ps=9.29 w=9 l=0.5
X22 a_n3561_2630# inn outp vss sky130_fd_pr__nfet_01v8_lvt ad=0.396 pd=2.73 as=0.396 ps=2.73 w=2.4 l=0.15
X23 outp inn a_n3561_2630# vss sky130_fd_pr__nfet_01v8_lvt ad=0.396 pd=2.73 as=0.396 ps=2.73 w=2.4 l=0.15
X24 a_n3290_4908# a_n3772_2830# a_n3466_2630# vss sky130_fd_pr__nfet_01v8 ad=0.1218 pd=1.42 as=0.1218 ps=1.42 w=0.42 l=0.5
X25 a_n3772_2830# eq1 vss vss sky130_fd_pr__nfet_01v8 ad=0.29 pd=2.58 as=0.29 ps=2.58 w=1 l=0.18
X26 outp inn a_n3561_2630# vss sky130_fd_pr__nfet_01v8_lvt ad=0.396 pd=2.73 as=0.744 ps=5.42 w=2.4 l=0.15
X27 a_n3290_4908# a_n3466_2630# sky130_fd_pr__cap_mim_m3_1 l=6 w=6
X28 vss vbias a_n3561_2630# vss sky130_fd_pr__nfet_01v8_lvt ad=1.305 pd=9.29 as=1.305 ps=9.29 w=9 l=0.5
X29 a_n3561_2630# a_n3772_2830# a_n3466_2630# vdd sky130_fd_pr__pfet_01v8 ad=1.18 pd=8.59 as=0.6 ps=4.3 w=4 l=0.18
X30 a_n3561_2630# vbias vss vss sky130_fd_pr__nfet_01v8_lvt ad=1.305 pd=9.29 as=1.305 ps=9.29 w=9 l=0.5
X31 a_n3561_2630# vbias vss vss sky130_fd_pr__nfet_01v8_lvt ad=1.305 pd=9.29 as=1.305 ps=9.29 w=9 l=0.5
X32 a_n3290_4908# a_n2902_2602# a_n2866_2630# vss sky130_fd_pr__nfet_01v8 ad=0.1218 pd=1.42 as=0.1218 ps=1.42 w=0.42 l=0.5
X33 a_n3466_2630# a_n3772_2830# a_n3561_2630# vdd sky130_fd_pr__pfet_01v8 ad=0.6 pd=4.3 as=1.18 ps=8.59 w=4 l=0.18
X34 vdd eq0 a_n2902_2602# vdd sky130_fd_pr__pfet_01v8 ad=0.58 pd=4.58 as=0.58 ps=4.58 w=2 l=0.18
X35 a_n3561_2630# a_n2902_2602# a_n2866_2630# vdd sky130_fd_pr__pfet_01v8 ad=1.18 pd=8.59 as=0.6 ps=4.3 w=4 l=0.18
X36 vss vbias a_n3290_4908# vss sky130_fd_pr__nfet_01v8_lvt ad=1.305 pd=9.29 as=1.305 ps=9.29 w=9 l=0.5
X37 vss vbias a_n3561_2630# vss sky130_fd_pr__nfet_01v8_lvt ad=1.305 pd=9.29 as=1.305 ps=9.29 w=9 l=0.5
X38 a_n3561_2630# inn outp vss sky130_fd_pr__nfet_01v8_lvt ad=0.396 pd=2.73 as=0.396 ps=2.73 w=2.4 l=0.15
X39 outp lp_mid vss sky130_fd_pr__res_high_po_2p85 l=2.83
X40 a_n3290_4908# inp outn vss sky130_fd_pr__nfet_01v8_lvt ad=0.396 pd=2.73 as=0.396 ps=2.73 w=2.4 l=0.15
X41 a_n3772_2830# eq1 vdd vdd sky130_fd_pr__pfet_01v8 ad=0.58 pd=4.58 as=0.58 ps=4.58 w=2 l=0.18
X42 a_n2866_2630# a_n2902_2602# a_n3561_2630# vdd sky130_fd_pr__pfet_01v8 ad=0.6 pd=4.3 as=1.18 ps=8.59 w=4 l=0.18
X43 a_n3561_2630# vbias vss vss sky130_fd_pr__nfet_01v8_lvt ad=1.305 pd=9.29 as=1.305 ps=9.29 w=9 l=0.5
X44 vss vbias a_n3561_2630# vss sky130_fd_pr__nfet_01v8_lvt ad=1.305 pd=9.29 as=1.305 ps=9.29 w=9 l=0.5
X45 a_n3561_2630# a_n3772_2830# a_n3466_2630# vdd sky130_fd_pr__pfet_01v8 ad=0.6 pd=4.3 as=0.6 ps=4.3 w=4 l=0.18
X46 a_n3466_2630# eq1 a_n3561_2630# vss sky130_fd_pr__nfet_01v8 ad=0.6 pd=4.3 as=1.18 ps=8.59 w=4 l=0.18
X47 outn inp a_n3290_4908# vss sky130_fd_pr__nfet_01v8_lvt ad=0.396 pd=2.73 as=0.396 ps=2.73 w=2.4 l=0.15
X48 a_n3561_2630# a_n3290_4908# vss sky130_fd_pr__res_high_po_2p85 l=5.1
X49 a_n3561_2630# inn outp vss sky130_fd_pr__nfet_01v8_lvt ad=0.744 pd=5.42 as=0.396 ps=2.73 w=2.4 l=0.15
X50 a_n2866_2630# eq0 a_n3561_2630# vss sky130_fd_pr__nfet_01v8 ad=0.6 pd=4.3 as=1.18 ps=8.59 w=4 l=0.18
X51 a_n3561_2630# a_n2902_2602# a_n2866_2630# vdd sky130_fd_pr__pfet_01v8 ad=0.6 pd=4.3 as=0.6 ps=4.3 w=4 l=0.18
X52 a_n3290_4908# vbias vss vss sky130_fd_pr__nfet_01v8_lvt ad=1.305 pd=9.29 as=1.305 ps=9.29 w=9 l=0.5
X53 vss vbias a_n3290_4908# vss sky130_fd_pr__nfet_01v8_lvt ad=1.305 pd=9.29 as=1.305 ps=9.29 w=9 l=0.5
X54 a_n3466_2630# a_n3772_2830# a_n3561_2630# vdd sky130_fd_pr__pfet_01v8 ad=0.6 pd=4.3 as=0.6 ps=4.3 w=4 l=0.18
X55 a_n3561_2630# eq1 a_n3466_2630# vss sky130_fd_pr__nfet_01v8 ad=1.18 pd=8.59 as=0.6 ps=4.3 w=4 l=0.18
X56 vss vbias a_n3290_4908# vss sky130_fd_pr__nfet_01v8_lvt ad=1.305 pd=9.29 as=1.305 ps=9.29 w=9 l=0.5
X57 a_n3290_4908# vbias vss vss sky130_fd_pr__nfet_01v8_lvt ad=1.305 pd=9.29 as=1.305 ps=9.29 w=9 l=0.5
X58 a_n3290_4908# vbias vss vss sky130_fd_pr__nfet_01v8_lvt ad=1.305 pd=9.29 as=1.305 ps=9.29 w=9 l=0.5
X59 outp inn a_n3561_2630# vss sky130_fd_pr__nfet_01v8_lvt ad=0.396 pd=2.73 as=0.744 ps=5.42 w=2.4 l=0.15
C0 a_n3561_2630# a_n3466_2630# 5.61221f
C1 inp vbias 0.01361f
C2 a_n3772_2830# a_n3466_2630# 0.62263f
C3 a_n3290_4908# inn 0.11757f
C4 vdd a_n2866_2630# 0.15263f
C5 a_n3290_4908# outn 2.33237f
C6 inn a_n3561_2630# 0.31857f
C7 eq0 outn 0.00227f
C8 outn a_n3561_2630# 0.11792f
C9 eq1 a_n3290_4908# 0.0024f
C10 vbias a_n3290_4908# 3.94031f
C11 ln_mid inn 0.0459f
C12 lp_mid vdd 0.00215f
C13 outp a_n3466_2630# 0.01269f
C14 ln_mid outn 0.34815f
C15 eq1 eq0 0.0154f
C16 eq1 a_n3561_2630# 0.24955f
C17 vbias a_n3561_2630# 4.0144f
C18 a_n3772_2830# eq1 0.47412f
C19 outp inn 0.43437f
C20 a_n3290_4908# a_n2902_2602# 0.20418f
C21 outp outn 1.01349f
C22 inp a_n2866_2630# 0.00378f
C23 vdd a_n3290_4908# 0.31252f
C24 eq0 a_n2902_2602# 0.37262f
C25 outn a_n3466_2630# 0.00586f
C26 a_n2902_2602# a_n3561_2630# 0.57658f
C27 a_n3772_2830# a_n2902_2602# 0.0242f
C28 vdd eq0 0.83944f
C29 outp eq1 0
C30 outp vbias 0.00721f
C31 vdd a_n3561_2630# 0.95447f
C32 a_n3772_2830# vdd 0.50582f
C33 eq1 a_n3466_2630# 0.71212f
C34 vbias a_n3466_2630# 0.34713f
C35 outn inn 0.60402f
C36 a_n3290_4908# a_n2866_2630# 4.91161f
C37 eq0 a_n2866_2630# 0.2396f
C38 outp a_n2902_2602# 0.0016f
C39 a_n2866_2630# a_n3561_2630# 3.98588f
C40 vbias inn 0.00161f
C41 a_n3772_2830# a_n2866_2630# 0.00231f
C42 a_n2902_2602# a_n3466_2630# 0.34178f
C43 outp vdd 0.11604f
C44 vbias outn 0
C45 lp_mid a_n3290_4908# 0
C46 inp a_n3290_4908# 0.43567f
C47 vdd a_n3466_2630# 0.39582f
C48 lp_mid eq0 0
C49 lp_mid a_n3561_2630# 0.07874f
C50 inp a_n3561_2630# 0.02828f
C51 outp a_n2866_2630# 0.01464f
C52 lp_mid ln_mid 0.00909f
C53 inp ln_mid 0.00866f
C54 a_n2866_2630# a_n3466_2630# 1.38574f
C55 vdd outn 0.047f
C56 eq1 a_n2902_2602# 0.00104f
C57 vbias a_n2902_2602# 0
C58 a_n3290_4908# eq0 0.15866f
C59 a_n3290_4908# a_n3561_2630# 2.8198f
C60 outp lp_mid 0.35165f
C61 inp outp 0.33752f
C62 vdd eq1 0.26224f
C63 a_n3772_2830# a_n3290_4908# 0.02312f
C64 a_n2866_2630# inn 0.00381f
C65 a_n2866_2630# outn 0.00188f
C66 eq0 a_n3561_2630# 0.41348f
C67 a_n3290_4908# ln_mid 0.08391f
C68 a_n3772_2830# eq0 0.00962f
C69 a_n3772_2830# a_n3561_2630# 0.45856f
C70 ln_mid a_n3561_2630# 0
C71 vdd a_n2902_2602# 0.50927f
C72 eq1 a_n2866_2630# 0.0024f
C73 vbias a_n2866_2630# 1.04707f
C74 lp_mid inn 0
C75 inp inn 1.26507f
C76 outp a_n3290_4908# 0.28959f
C77 lp_mid outn 0.08898f
C78 inp outn 0.59298f
C79 a_n3290_4908# a_n3466_2630# 8.10093f
C80 outp eq0 0.02991f
C81 outp a_n3561_2630# 2.32207f
C82 a_n3772_2830# outp 0.00295f
C83 eq0 a_n3466_2630# 0.69398f
C84 a_n2866_2630# a_n2902_2602# 0.42598f
C85 ln_mid vss 2.00347f
C86 outn vss 2.80128f
C87 inn vss 1.80742f
C88 inp vss 2.02767f
C89 lp_mid vss 1.96009f
C90 outp vss 2.73206f
C91 vbias vss 13.7714f
C92 eq0 vss 1.31379f
C93 eq1 vss 1.62967f
C94 vdd vss 8.64775f
C95 a_n3561_2630# vss 12.3032f
C96 a_n2866_2630# vss 3.50736f
C97 a_n3290_4908# vss 14.6389f
C98 a_n3466_2630# vss 6.43389f
C99 a_n2902_2602# vss 1.02186f
C100 a_n3772_2830# vss 1.16273f
.ends
