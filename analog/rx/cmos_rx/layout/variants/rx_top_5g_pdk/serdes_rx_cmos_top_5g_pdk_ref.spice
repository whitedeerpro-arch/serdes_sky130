* LVS reference netlist for serdes_rx_cmos_top_5g_pdk (inductor_open=False, pi_dir=v5g_4ph_v3_pdk)
* Exact flattened LVS reference netlist for serdes_rx_term_pdk
* Source subckt: serdes_rx_term_pdk (frozen analog/rx/cmos_rx/spice/*.spice)
.subckt serdes_rx_term_pdk inp inn vcm vss
X1 inp vcm vss sky130_fd_pr__res_high_po_5p73 l=2.34
X2 inp vcm vss sky130_fd_pr__res_high_po_5p73 l=2.34
X3 inp vcm vss sky130_fd_pr__res_high_po_5p73 l=2.34
X4 inp vcm vss sky130_fd_pr__res_high_po_5p73 l=2.34
X5 inn vcm vss sky130_fd_pr__res_high_po_5p73 l=2.34
X6 inn vcm vss sky130_fd_pr__res_high_po_5p73 l=2.34
X7 inn vcm vss sky130_fd_pr__res_high_po_5p73 l=2.34
X8 inn vcm vss sky130_fd_pr__res_high_po_5p73 l=2.34
.ends serdes_rx_term_pdk

.subckt serdes_bias_ctle_v2_pdk iin vss
Xm iin iin vss vss sky130_fd_pr__nfet_01v8_lvt w=8.0 l=0.5 nf=4
.ends serdes_bias_ctle_v2_pdk

.subckt serdes_rx_ctle_shunt_5g_dc inp inn outp outn eq0 eq1 vbias vdd vss
X1 vdd outp vss sky130_fd_pr__res_high_po_2p85 l=2.83
X2 vdd outn vss sky130_fd_pr__res_high_po_2p85 l=2.83
X3 outn inp t_sp vss sky130_fd_pr__nfet_01v8_lvt w=19.2 l=0.15
X4 outp inn t_sn vss sky130_fd_pr__nfet_01v8_lvt w=19.2 l=0.15
X5 t_sp vbias vss vss sky130_fd_pr__nfet_01v8_lvt w=90 l=0.5
X6 t_sn vbias vss vss sky130_fd_pr__nfet_01v8_lvt w=90 l=0.5
X7 t_sp t_sn vss sky130_fd_pr__res_high_po_2p85 l=5.1
X8 t_eq0_b eq0 vss vss sky130_fd_pr__nfet_01v8 w=1 l=0.18
X9 t_eq0_b eq0 vdd vdd sky130_fd_pr__pfet_01v8 w=2 l=0.18
X10 t_eq1_b eq1 vss vss sky130_fd_pr__nfet_01v8 w=1 l=0.18
X11 t_eq1_b eq1 vdd vdd sky130_fd_pr__pfet_01v8 w=2 l=0.18
X12 t_sp t_cap0 sky130_fd_pr__cap_mim_m3_1 w=6 l=6
X13 t_sp t_cap1 sky130_fd_pr__cap_mim_m3_1 w=6 l=6
X14 t_sp t_cap1 sky130_fd_pr__cap_mim_m3_1 w=6 l=6
X15 t_cap0 eq0 t_sn vss sky130_fd_pr__nfet_01v8 w=8 l=0.18
X16 t_cap0 t_eq0_b t_sn vdd sky130_fd_pr__pfet_01v8 w=16 l=0.18
X17 t_cap1 eq1 t_sn vss sky130_fd_pr__nfet_01v8 w=8 l=0.18
X18 t_cap1 t_eq1_b t_sn vdd sky130_fd_pr__pfet_01v8 w=16 l=0.18
X19 t_cap0 t_eq0_b t_sp vss sky130_fd_pr__nfet_01v8 w=0.42 l=0.5
X20 t_cap1 t_eq1_b t_sp vss sky130_fd_pr__nfet_01v8 w=0.42 l=0.5
.ends serdes_rx_ctle_shunt_5g_dc

* Exact flattened LVS reference netlist for serdes_rx_pi_4ph_5g_pdk
* Source subckt: serdes_rx_pi_4ph_iq_8ph (analog/rx/cmos_rx/spice/rx_pi_4ph_iq_5g_v3.spice)
.subckt serdes_rx_pi_4ph_5g_pdk ip qp in qn a0 a1 a2 a3 a4 a5 a6 a7 b0 b1 b2 b3 b4 b5 b6 b7 f0 f1 f2 f3 f4 f5 f6 f7 rst_n dp dn ep en ckd0 ckd1 ckd2 ckd3 cke0 cke1 cke2 cke3 vdd vss
X1 t_ab0 a0 vss vss sky130_fd_pr__nfet_01v8 w=0.45 l=0.18
X2 t_ab0 a0 vdd vdd sky130_fd_pr__pfet_01v8 w=0.9 l=0.18
X3 t_ab1 a1 vss vss sky130_fd_pr__nfet_01v8 w=0.45 l=0.18
X4 t_ab1 a1 vdd vdd sky130_fd_pr__pfet_01v8 w=0.9 l=0.18
X5 t_ab2 a2 vss vss sky130_fd_pr__nfet_01v8 w=0.45 l=0.18
X6 t_ab2 a2 vdd vdd sky130_fd_pr__pfet_01v8 w=0.9 l=0.18
X7 t_ab3 a3 vss vss sky130_fd_pr__nfet_01v8 w=0.45 l=0.18
X8 t_ab3 a3 vdd vdd sky130_fd_pr__pfet_01v8 w=0.9 l=0.18
X9 t_ab4 a4 vss vss sky130_fd_pr__nfet_01v8 w=0.45 l=0.18
X10 t_ab4 a4 vdd vdd sky130_fd_pr__pfet_01v8 w=0.9 l=0.18
X11 t_ab5 a5 vss vss sky130_fd_pr__nfet_01v8 w=0.45 l=0.18
X12 t_ab5 a5 vdd vdd sky130_fd_pr__pfet_01v8 w=0.9 l=0.18
X13 t_ab6 a6 vss vss sky130_fd_pr__nfet_01v8 w=0.45 l=0.18
X14 t_ab6 a6 vdd vdd sky130_fd_pr__pfet_01v8 w=0.9 l=0.18
X15 t_ab7 a7 vss vss sky130_fd_pr__nfet_01v8 w=0.45 l=0.18
X16 t_ab7 a7 vdd vdd sky130_fd_pr__pfet_01v8 w=0.9 l=0.18
X17 t_bb0 b0 vss vss sky130_fd_pr__nfet_01v8 w=0.45 l=0.18
X18 t_bb0 b0 vdd vdd sky130_fd_pr__pfet_01v8 w=0.9 l=0.18
X19 t_bb1 b1 vss vss sky130_fd_pr__nfet_01v8 w=0.45 l=0.18
X20 t_bb1 b1 vdd vdd sky130_fd_pr__pfet_01v8 w=0.9 l=0.18
X21 t_bb2 b2 vss vss sky130_fd_pr__nfet_01v8 w=0.45 l=0.18
X22 t_bb2 b2 vdd vdd sky130_fd_pr__pfet_01v8 w=0.9 l=0.18
X23 t_bb3 b3 vss vss sky130_fd_pr__nfet_01v8 w=0.45 l=0.18
X24 t_bb3 b3 vdd vdd sky130_fd_pr__pfet_01v8 w=0.9 l=0.18
X25 t_bb4 b4 vss vss sky130_fd_pr__nfet_01v8 w=0.45 l=0.18
X26 t_bb4 b4 vdd vdd sky130_fd_pr__pfet_01v8 w=0.9 l=0.18
X27 t_bb5 b5 vss vss sky130_fd_pr__nfet_01v8 w=0.45 l=0.18
X28 t_bb5 b5 vdd vdd sky130_fd_pr__pfet_01v8 w=0.9 l=0.18
X29 t_bb6 b6 vss vss sky130_fd_pr__nfet_01v8 w=0.45 l=0.18
X30 t_bb6 b6 vdd vdd sky130_fd_pr__pfet_01v8 w=0.9 l=0.18
X31 t_bb7 b7 vss vss sky130_fd_pr__nfet_01v8 w=0.45 l=0.18
X32 t_bb7 b7 vdd vdd sky130_fd_pr__pfet_01v8 w=0.9 l=0.18
X33 t_fb0 f0 vss vss sky130_fd_pr__nfet_01v8 w=0.45 l=0.18
X34 t_fb0 f0 vdd vdd sky130_fd_pr__pfet_01v8 w=0.9 l=0.18
X35 t_fb1 f1 vss vss sky130_fd_pr__nfet_01v8 w=0.45 l=0.18
X36 t_fb1 f1 vdd vdd sky130_fd_pr__pfet_01v8 w=0.9 l=0.18
X37 t_fb2 f2 vss vss sky130_fd_pr__nfet_01v8 w=0.45 l=0.18
X38 t_fb2 f2 vdd vdd sky130_fd_pr__pfet_01v8 w=0.9 l=0.18
X39 t_fb3 f3 vss vss sky130_fd_pr__nfet_01v8 w=0.45 l=0.18
X40 t_fb3 f3 vdd vdd sky130_fd_pr__pfet_01v8 w=0.9 l=0.18
X41 t_fb4 f4 vss vss sky130_fd_pr__nfet_01v8 w=0.45 l=0.18
X42 t_fb4 f4 vdd vdd sky130_fd_pr__pfet_01v8 w=0.9 l=0.18
X43 t_fb5 f5 vss vss sky130_fd_pr__nfet_01v8 w=0.45 l=0.18
X44 t_fb5 f5 vdd vdd sky130_fd_pr__pfet_01v8 w=0.9 l=0.18
X45 t_fb6 f6 vss vss sky130_fd_pr__nfet_01v8 w=0.45 l=0.18
X46 t_fb6 f6 vdd vdd sky130_fd_pr__pfet_01v8 w=0.9 l=0.18
X47 t_fb7 f7 vss vss sky130_fd_pr__nfet_01v8 w=0.45 l=0.18
X48 t_fb7 f7 vdd vdd sky130_fd_pr__pfet_01v8 w=0.9 l=0.18
X49 t_Xoct_ips ip vss vss sky130_fd_pr__nfet_01v8_lvt w=1.4 l=0.15
X50 t_Xoct_ips ip vdd vdd sky130_fd_pr__pfet_01v8_lvt w=5.6 l=0.35
X51 t_Xoct_qps qp vss vss sky130_fd_pr__nfet_01v8_lvt w=1.4 l=0.15
X52 t_Xoct_qps qp vdd vdd sky130_fd_pr__pfet_01v8_lvt w=5.6 l=0.35
X53 t_Xoct_ins in vss vss sky130_fd_pr__nfet_01v8_lvt w=1.4 l=0.15
X54 t_Xoct_ins in vdd vdd sky130_fd_pr__pfet_01v8_lvt w=5.6 l=0.35
X55 t_Xoct_qns qn vss vss sky130_fd_pr__nfet_01v8_lvt w=1.4 l=0.15
X56 t_Xoct_qns qn vdd vdd sky130_fd_pr__pfet_01v8_lvt w=5.6 l=0.35
X57 t_Xoct_ips vss sky130_fd_pr__cap_mim_m3_1 w=1.75 l=1.75
X58 t_Xoct_qps vss sky130_fd_pr__cap_mim_m3_1 w=1.75 l=1.75
X59 t_Xoct_ins vss sky130_fd_pr__cap_mim_m3_1 w=1.75 l=1.75
X60 t_Xoct_qns vss sky130_fd_pr__cap_mim_m3_1 w=1.75 l=1.75
X61 t_Xoct_Xo0_da t_Xoct_ips vss vss sky130_fd_pr__nfet_01v8_lvt w=1.1 l=0.15
X62 t_Xoct_Xo0_da t_Xoct_ips vdd vdd sky130_fd_pr__pfet_01v8_lvt w=4.4 l=0.35
X63 t_Xoct_Xo0_db t_Xoct_ips vss vss sky130_fd_pr__nfet_01v8_lvt w=1.1 l=0.15
X64 t_Xoct_Xo0_db t_Xoct_ips vdd vdd sky130_fd_pr__pfet_01v8_lvt w=4.4 l=0.35
X65 t_Xoct_Xo0_da t_Xoct_m0 vss sky130_fd_pr__res_high_po_0p69 l=1.5
X66 t_Xoct_Xo0_db t_Xoct_m0 vss sky130_fd_pr__res_high_po_0p69 l=1.5
X67 t_Xoct_Xo1_da t_Xoct_ips vss vss sky130_fd_pr__nfet_01v8_lvt w=1.1 l=0.15
X68 t_Xoct_Xo1_da t_Xoct_ips vdd vdd sky130_fd_pr__pfet_01v8_lvt w=4.4 l=0.35
X69 t_Xoct_Xo1_db t_Xoct_qps vss vss sky130_fd_pr__nfet_01v8_lvt w=1.1 l=0.15
X70 t_Xoct_Xo1_db t_Xoct_qps vdd vdd sky130_fd_pr__pfet_01v8_lvt w=4.4 l=0.35
X71 t_Xoct_Xo1_da t_Xoct_m1 vss sky130_fd_pr__res_high_po_0p69 l=1.5
X72 t_Xoct_Xo1_db t_Xoct_m1 vss sky130_fd_pr__res_high_po_0p69 l=1.5
X73 t_Xoct_Xo2_da t_Xoct_qps vss vss sky130_fd_pr__nfet_01v8_lvt w=1.1 l=0.15
X74 t_Xoct_Xo2_da t_Xoct_qps vdd vdd sky130_fd_pr__pfet_01v8_lvt w=4.4 l=0.35
X75 t_Xoct_Xo2_db t_Xoct_qps vss vss sky130_fd_pr__nfet_01v8_lvt w=1.1 l=0.15
X76 t_Xoct_Xo2_db t_Xoct_qps vdd vdd sky130_fd_pr__pfet_01v8_lvt w=4.4 l=0.35
X77 t_Xoct_Xo2_da t_Xoct_m2 vss sky130_fd_pr__res_high_po_0p69 l=1.5
X78 t_Xoct_Xo2_db t_Xoct_m2 vss sky130_fd_pr__res_high_po_0p69 l=1.5
X79 t_Xoct_Xo3_da t_Xoct_qps vss vss sky130_fd_pr__nfet_01v8_lvt w=1.1 l=0.15
X80 t_Xoct_Xo3_da t_Xoct_qps vdd vdd sky130_fd_pr__pfet_01v8_lvt w=4.4 l=0.35
X81 t_Xoct_Xo3_db t_Xoct_ins vss vss sky130_fd_pr__nfet_01v8_lvt w=1.1 l=0.15
X82 t_Xoct_Xo3_db t_Xoct_ins vdd vdd sky130_fd_pr__pfet_01v8_lvt w=4.4 l=0.35
X83 t_Xoct_Xo3_da t_Xoct_m3 vss sky130_fd_pr__res_high_po_0p69 l=1.5
X84 t_Xoct_Xo3_db t_Xoct_m3 vss sky130_fd_pr__res_high_po_0p69 l=1.5
X85 t_Xoct_Xo4_da t_Xoct_ins vss vss sky130_fd_pr__nfet_01v8_lvt w=1.1 l=0.15
X86 t_Xoct_Xo4_da t_Xoct_ins vdd vdd sky130_fd_pr__pfet_01v8_lvt w=4.4 l=0.35
X87 t_Xoct_Xo4_db t_Xoct_ins vss vss sky130_fd_pr__nfet_01v8_lvt w=1.1 l=0.15
X88 t_Xoct_Xo4_db t_Xoct_ins vdd vdd sky130_fd_pr__pfet_01v8_lvt w=4.4 l=0.35
X89 t_Xoct_Xo4_da t_Xoct_m4 vss sky130_fd_pr__res_high_po_0p69 l=1.5
X90 t_Xoct_Xo4_db t_Xoct_m4 vss sky130_fd_pr__res_high_po_0p69 l=1.5
X91 t_Xoct_Xo5_da t_Xoct_ins vss vss sky130_fd_pr__nfet_01v8_lvt w=1.1 l=0.15
X92 t_Xoct_Xo5_da t_Xoct_ins vdd vdd sky130_fd_pr__pfet_01v8_lvt w=4.4 l=0.35
X93 t_Xoct_Xo5_db t_Xoct_qns vss vss sky130_fd_pr__nfet_01v8_lvt w=1.1 l=0.15
X94 t_Xoct_Xo5_db t_Xoct_qns vdd vdd sky130_fd_pr__pfet_01v8_lvt w=4.4 l=0.35
X95 t_Xoct_Xo5_da t_Xoct_m5 vss sky130_fd_pr__res_high_po_0p69 l=1.5
X96 t_Xoct_Xo5_db t_Xoct_m5 vss sky130_fd_pr__res_high_po_0p69 l=1.5
X97 t_Xoct_Xo6_da t_Xoct_qns vss vss sky130_fd_pr__nfet_01v8_lvt w=1.1 l=0.15
X98 t_Xoct_Xo6_da t_Xoct_qns vdd vdd sky130_fd_pr__pfet_01v8_lvt w=4.4 l=0.35
X99 t_Xoct_Xo6_db t_Xoct_qns vss vss sky130_fd_pr__nfet_01v8_lvt w=1.1 l=0.15
X100 t_Xoct_Xo6_db t_Xoct_qns vdd vdd sky130_fd_pr__pfet_01v8_lvt w=4.4 l=0.35
X101 t_Xoct_Xo6_da t_Xoct_m6 vss sky130_fd_pr__res_high_po_0p69 l=1.5
X102 t_Xoct_Xo6_db t_Xoct_m6 vss sky130_fd_pr__res_high_po_0p69 l=1.5
X103 t_Xoct_Xo7_da t_Xoct_qns vss vss sky130_fd_pr__nfet_01v8_lvt w=1.1 l=0.15
X104 t_Xoct_Xo7_da t_Xoct_qns vdd vdd sky130_fd_pr__pfet_01v8_lvt w=4.4 l=0.35
X105 t_Xoct_Xo7_db t_Xoct_ips vss vss sky130_fd_pr__nfet_01v8_lvt w=1.1 l=0.15
X106 t_Xoct_Xo7_db t_Xoct_ips vdd vdd sky130_fd_pr__pfet_01v8_lvt w=4.4 l=0.35
X107 t_Xoct_Xo7_da t_Xoct_m7 vss sky130_fd_pr__res_high_po_0p69 l=1.5
X108 t_Xoct_Xo7_db t_Xoct_m7 vss sky130_fd_pr__res_high_po_0p69 l=1.5
X109 t_Xoct_Xrec04_acp t_Xoct_m0 sky130_fd_pr__cap_mim_m3_1 w=4.2 l=4.2
X110 t_Xoct_Xrec04_acn t_Xoct_m4 sky130_fd_pr__cap_mim_m3_1 w=4.2 l=4.2
X111 t_Xoct_Xrec04_acp t_Xoct_o0 vss sky130_fd_pr__res_high_po_0p35 l=9.5
X112 t_Xoct_Xrec04_acn t_Xoct_o4 vss sky130_fd_pr__res_high_po_0p35 l=9.5
X113 t_Xoct_o0 t_Xoct_Xrec04_acp vss vss sky130_fd_pr__nfet_01v8_lvt w=2.2 l=0.15
X114 t_Xoct_o0 t_Xoct_Xrec04_acp vdd vdd sky130_fd_pr__pfet_01v8_lvt w=8.4 l=0.35
X115 t_Xoct_o4 t_Xoct_Xrec04_acn vss vss sky130_fd_pr__nfet_01v8_lvt w=2.2 l=0.15
X116 t_Xoct_o4 t_Xoct_Xrec04_acn vdd vdd sky130_fd_pr__pfet_01v8_lvt w=8.4 l=0.35
X117 t_Xoct_Xrec15_acp t_Xoct_m1 sky130_fd_pr__cap_mim_m3_1 w=4.2 l=4.2
X118 t_Xoct_Xrec15_acn t_Xoct_m5 sky130_fd_pr__cap_mim_m3_1 w=4.2 l=4.2
X119 t_Xoct_Xrec15_acp t_Xoct_o1 vss sky130_fd_pr__res_high_po_0p35 l=9.5
X120 t_Xoct_Xrec15_acn t_Xoct_o5 vss sky130_fd_pr__res_high_po_0p35 l=9.5
X121 t_Xoct_o1 t_Xoct_Xrec15_acp vss vss sky130_fd_pr__nfet_01v8_lvt w=2.2 l=0.15
X122 t_Xoct_o1 t_Xoct_Xrec15_acp vdd vdd sky130_fd_pr__pfet_01v8_lvt w=8.4 l=0.35
X123 t_Xoct_o5 t_Xoct_Xrec15_acn vss vss sky130_fd_pr__nfet_01v8_lvt w=2.2 l=0.15
X124 t_Xoct_o5 t_Xoct_Xrec15_acn vdd vdd sky130_fd_pr__pfet_01v8_lvt w=8.4 l=0.35
X125 t_Xoct_Xrec26_acp t_Xoct_m2 sky130_fd_pr__cap_mim_m3_1 w=4.2 l=4.2
X126 t_Xoct_Xrec26_acn t_Xoct_m6 sky130_fd_pr__cap_mim_m3_1 w=4.2 l=4.2
X127 t_Xoct_Xrec26_acp t_Xoct_o2 vss sky130_fd_pr__res_high_po_0p35 l=9.5
X128 t_Xoct_Xrec26_acn t_Xoct_o6 vss sky130_fd_pr__res_high_po_0p35 l=9.5
X129 t_Xoct_o2 t_Xoct_Xrec26_acp vss vss sky130_fd_pr__nfet_01v8_lvt w=2.2 l=0.15
X130 t_Xoct_o2 t_Xoct_Xrec26_acp vdd vdd sky130_fd_pr__pfet_01v8_lvt w=8.4 l=0.35
X131 t_Xoct_o6 t_Xoct_Xrec26_acn vss vss sky130_fd_pr__nfet_01v8_lvt w=2.2 l=0.15
X132 t_Xoct_o6 t_Xoct_Xrec26_acn vdd vdd sky130_fd_pr__pfet_01v8_lvt w=8.4 l=0.35
X133 t_Xoct_Xrec37_acp t_Xoct_m3 sky130_fd_pr__cap_mim_m3_1 w=4.2 l=4.2
X134 t_Xoct_Xrec37_acn t_Xoct_m7 sky130_fd_pr__cap_mim_m3_1 w=4.2 l=4.2
X135 t_Xoct_Xrec37_acp t_Xoct_o3 vss sky130_fd_pr__res_high_po_0p35 l=9.5
X136 t_Xoct_Xrec37_acn t_Xoct_o7 vss sky130_fd_pr__res_high_po_0p35 l=9.5
X137 t_Xoct_o3 t_Xoct_Xrec37_acp vss vss sky130_fd_pr__nfet_01v8_lvt w=2.2 l=0.15
X138 t_Xoct_o3 t_Xoct_Xrec37_acp vdd vdd sky130_fd_pr__pfet_01v8_lvt w=8.4 l=0.35
X139 t_Xoct_o7 t_Xoct_Xrec37_acn vss vss sky130_fd_pr__nfet_01v8_lvt w=2.2 l=0.15
X140 t_Xoct_o7 t_Xoct_Xrec37_acn vdd vdd sky130_fd_pr__pfet_01v8_lvt w=8.4 l=0.35
X141 t_cb0 t_Xoct_o0 vss vss sky130_fd_pr__nfet_01v8_lvt w=3.4 l=0.15
X142 t_cb0 t_Xoct_o0 vdd vdd sky130_fd_pr__pfet_01v8_lvt w=12.6 l=0.35
X143 t_cb1 t_Xoct_o1 vss vss sky130_fd_pr__nfet_01v8_lvt w=3.4 l=0.15
X144 t_cb1 t_Xoct_o1 vdd vdd sky130_fd_pr__pfet_01v8_lvt w=12.6 l=0.35
X145 t_cb2 t_Xoct_o2 vss vss sky130_fd_pr__nfet_01v8_lvt w=3.4 l=0.15
X146 t_cb2 t_Xoct_o2 vdd vdd sky130_fd_pr__pfet_01v8_lvt w=12.6 l=0.35
X147 t_cb3 t_Xoct_o3 vss vss sky130_fd_pr__nfet_01v8_lvt w=3.4 l=0.15
X148 t_cb3 t_Xoct_o3 vdd vdd sky130_fd_pr__pfet_01v8_lvt w=12.6 l=0.35
X149 t_cb4 t_Xoct_o4 vss vss sky130_fd_pr__nfet_01v8_lvt w=3.4 l=0.15
X150 t_cb4 t_Xoct_o4 vdd vdd sky130_fd_pr__pfet_01v8_lvt w=12.6 l=0.35
X151 t_cb5 t_Xoct_o5 vss vss sky130_fd_pr__nfet_01v8_lvt w=3.4 l=0.15
X152 t_cb5 t_Xoct_o5 vdd vdd sky130_fd_pr__pfet_01v8_lvt w=12.6 l=0.35
X153 t_cb6 t_Xoct_o6 vss vss sky130_fd_pr__nfet_01v8_lvt w=3.4 l=0.15
X154 t_cb6 t_Xoct_o6 vdd vdd sky130_fd_pr__pfet_01v8_lvt w=12.6 l=0.35
X155 t_cb7 t_Xoct_o7 vss vss sky130_fd_pr__nfet_01v8_lvt w=3.4 l=0.15
X156 t_cb7 t_Xoct_o7 vdd vdd sky130_fd_pr__pfet_01v8_lvt w=12.6 l=0.35
X157 t_cb4 t_cb0 vss vss sky130_fd_pr__nfet_01v8_lvt w=0.45 l=0.15
X158 t_cb4 t_cb0 vdd vdd sky130_fd_pr__pfet_01v8_lvt w=2.1 l=0.35
X159 t_cb0 t_cb4 vss vss sky130_fd_pr__nfet_01v8_lvt w=0.45 l=0.15
X160 t_cb0 t_cb4 vdd vdd sky130_fd_pr__pfet_01v8_lvt w=2.1 l=0.35
X161 t_cb5 t_cb1 vss vss sky130_fd_pr__nfet_01v8_lvt w=0.45 l=0.15
X162 t_cb5 t_cb1 vdd vdd sky130_fd_pr__pfet_01v8_lvt w=2.1 l=0.35
X163 t_cb1 t_cb5 vss vss sky130_fd_pr__nfet_01v8_lvt w=0.45 l=0.15
X164 t_cb1 t_cb5 vdd vdd sky130_fd_pr__pfet_01v8_lvt w=2.1 l=0.35
X165 t_cb6 t_cb2 vss vss sky130_fd_pr__nfet_01v8_lvt w=0.45 l=0.15
X166 t_cb6 t_cb2 vdd vdd sky130_fd_pr__pfet_01v8_lvt w=2.1 l=0.35
X167 t_cb2 t_cb6 vss vss sky130_fd_pr__nfet_01v8_lvt w=0.45 l=0.15
X168 t_cb2 t_cb6 vdd vdd sky130_fd_pr__pfet_01v8_lvt w=2.1 l=0.35
X169 t_cb7 t_cb3 vss vss sky130_fd_pr__nfet_01v8_lvt w=0.45 l=0.15
X170 t_cb7 t_cb3 vdd vdd sky130_fd_pr__pfet_01v8_lvt w=2.1 l=0.35
X171 t_cb3 t_cb7 vss vss sky130_fd_pr__nfet_01v8_lvt w=0.45 l=0.15
X172 t_cb3 t_cb7 vdd vdd sky130_fd_pr__pfet_01v8_lvt w=2.1 l=0.35
X173 t_cb0 a0 t_Xch_d_Xmap_m vss sky130_fd_pr__nfet_01v8_lvt w=1.5 l=0.15
X174 t_cb0 t_ab0 t_Xch_d_Xmap_m vdd sky130_fd_pr__pfet_01v8_lvt w=4.6 l=0.35
X175 t_cb2 a2 t_Xch_d_Xmap_m vss sky130_fd_pr__nfet_01v8_lvt w=1.5 l=0.15
X176 t_cb2 t_ab2 t_Xch_d_Xmap_m vdd sky130_fd_pr__pfet_01v8_lvt w=4.6 l=0.35
X177 t_cb4 a4 t_Xch_d_Xmap_m vss sky130_fd_pr__nfet_01v8_lvt w=1.5 l=0.15
X178 t_cb4 t_ab4 t_Xch_d_Xmap_m vdd sky130_fd_pr__pfet_01v8_lvt w=4.6 l=0.35
X179 t_cb6 a6 t_Xch_d_Xmap_m vss sky130_fd_pr__nfet_01v8_lvt w=1.5 l=0.15
X180 t_cb6 t_ab6 t_Xch_d_Xmap_m vdd sky130_fd_pr__pfet_01v8_lvt w=4.6 l=0.35
X181 t_Xch_d_Xmap_ma t_Xch_d_Xmap_m sky130_fd_pr__cap_mim_m3_1 w=4.3 l=4.2
X182 t_Xch_d_Xmap_ma t_Xch_d_cap vss sky130_fd_pr__res_high_po_0p35 l=6.5
X183 t_Xch_d_cap t_Xch_d_Xmap_ma vss vss sky130_fd_pr__nfet_01v8_lvt w=3.4 l=0.15
X184 t_Xch_d_cap t_Xch_d_Xmap_ma vdd vdd sky130_fd_pr__pfet_01v8 w=11.2 l=0.15
X185 t_Xch_d_cap t_Xch_d_Xmap_ma vdd vdd sky130_fd_pr__pfet_01v8_lvt w=5.6 l=0.35
X186 t_cb4 a0 t_Xch_d_Xman_m vss sky130_fd_pr__nfet_01v8_lvt w=1.5 l=0.15
X187 t_cb4 t_ab0 t_Xch_d_Xman_m vdd sky130_fd_pr__pfet_01v8_lvt w=4.6 l=0.35
X188 t_cb6 a2 t_Xch_d_Xman_m vss sky130_fd_pr__nfet_01v8_lvt w=1.5 l=0.15
X189 t_cb6 t_ab2 t_Xch_d_Xman_m vdd sky130_fd_pr__pfet_01v8_lvt w=4.6 l=0.35
X190 t_cb0 a4 t_Xch_d_Xman_m vss sky130_fd_pr__nfet_01v8_lvt w=1.5 l=0.15
X191 t_cb0 t_ab4 t_Xch_d_Xman_m vdd sky130_fd_pr__pfet_01v8_lvt w=4.6 l=0.35
X192 t_cb2 a6 t_Xch_d_Xman_m vss sky130_fd_pr__nfet_01v8_lvt w=1.5 l=0.15
X193 t_cb2 t_ab6 t_Xch_d_Xman_m vdd sky130_fd_pr__pfet_01v8_lvt w=4.6 l=0.35
X194 t_Xch_d_Xman_ma t_Xch_d_Xman_m sky130_fd_pr__cap_mim_m3_1 w=4.3 l=4.2
X195 t_Xch_d_Xman_ma t_Xch_d_can vss sky130_fd_pr__res_high_po_0p35 l=6.5
X196 t_Xch_d_can t_Xch_d_Xman_ma vss vss sky130_fd_pr__nfet_01v8_lvt w=3.4 l=0.15
X197 t_Xch_d_can t_Xch_d_Xman_ma vdd vdd sky130_fd_pr__pfet_01v8 w=11.2 l=0.15
X198 t_Xch_d_can t_Xch_d_Xman_ma vdd vdd sky130_fd_pr__pfet_01v8_lvt w=5.6 l=0.35
X199 t_cb1 b1 t_Xch_d_Xmbp_m vss sky130_fd_pr__nfet_01v8_lvt w=1.5 l=0.15
X200 t_cb1 t_bb1 t_Xch_d_Xmbp_m vdd sky130_fd_pr__pfet_01v8_lvt w=4.6 l=0.35
X201 t_cb3 b3 t_Xch_d_Xmbp_m vss sky130_fd_pr__nfet_01v8_lvt w=1.5 l=0.15
X202 t_cb3 t_bb3 t_Xch_d_Xmbp_m vdd sky130_fd_pr__pfet_01v8_lvt w=4.6 l=0.35
X203 t_cb5 b5 t_Xch_d_Xmbp_m vss sky130_fd_pr__nfet_01v8_lvt w=1.5 l=0.15
X204 t_cb5 t_bb5 t_Xch_d_Xmbp_m vdd sky130_fd_pr__pfet_01v8_lvt w=4.6 l=0.35
X205 t_cb7 b7 t_Xch_d_Xmbp_m vss sky130_fd_pr__nfet_01v8_lvt w=1.5 l=0.15
X206 t_cb7 t_bb7 t_Xch_d_Xmbp_m vdd sky130_fd_pr__pfet_01v8_lvt w=4.6 l=0.35
X207 t_Xch_d_Xmbp_ma t_Xch_d_Xmbp_m sky130_fd_pr__cap_mim_m3_1 w=4.3 l=4.2
X208 t_Xch_d_Xmbp_ma t_Xch_d_cbp vss sky130_fd_pr__res_high_po_0p35 l=6.5
X209 t_Xch_d_cbp t_Xch_d_Xmbp_ma vss vss sky130_fd_pr__nfet_01v8_lvt w=3.4 l=0.15
X210 t_Xch_d_cbp t_Xch_d_Xmbp_ma vdd vdd sky130_fd_pr__pfet_01v8 w=11.2 l=0.15
X211 t_Xch_d_cbp t_Xch_d_Xmbp_ma vdd vdd sky130_fd_pr__pfet_01v8_lvt w=5.6 l=0.35
X212 t_cb5 b1 t_Xch_d_Xmbn_m vss sky130_fd_pr__nfet_01v8_lvt w=1.5 l=0.15
X213 t_cb5 t_bb1 t_Xch_d_Xmbn_m vdd sky130_fd_pr__pfet_01v8_lvt w=4.6 l=0.35
X214 t_cb7 b3 t_Xch_d_Xmbn_m vss sky130_fd_pr__nfet_01v8_lvt w=1.5 l=0.15
X215 t_cb7 t_bb3 t_Xch_d_Xmbn_m vdd sky130_fd_pr__pfet_01v8_lvt w=4.6 l=0.35
X216 t_cb1 b5 t_Xch_d_Xmbn_m vss sky130_fd_pr__nfet_01v8_lvt w=1.5 l=0.15
X217 t_cb1 t_bb5 t_Xch_d_Xmbn_m vdd sky130_fd_pr__pfet_01v8_lvt w=4.6 l=0.35
X218 t_cb3 b7 t_Xch_d_Xmbn_m vss sky130_fd_pr__nfet_01v8_lvt w=1.5 l=0.15
X219 t_cb3 t_bb7 t_Xch_d_Xmbn_m vdd sky130_fd_pr__pfet_01v8_lvt w=4.6 l=0.35
X220 t_Xch_d_Xmbn_ma t_Xch_d_Xmbn_m sky130_fd_pr__cap_mim_m3_1 w=4.3 l=4.2
X221 t_Xch_d_Xmbn_ma t_Xch_d_cbn vss sky130_fd_pr__res_high_po_0p35 l=6.5
X222 t_Xch_d_cbn t_Xch_d_Xmbn_ma vss vss sky130_fd_pr__nfet_01v8_lvt w=3.4 l=0.15
X223 t_Xch_d_cbn t_Xch_d_Xmbn_ma vdd vdd sky130_fd_pr__pfet_01v8 w=11.2 l=0.15
X224 t_Xch_d_cbn t_Xch_d_Xmbn_ma vdd vdd sky130_fd_pr__pfet_01v8_lvt w=5.6 l=0.35
X225 t_Xch_d_cap t_fb0 t_Xch_d_Xmixp_Xs0_sel vss sky130_fd_pr__nfet_01v8_lvt w=0.65 l=0.15
X226 t_Xch_d_cap f0 t_Xch_d_Xmixp_Xs0_sel vdd sky130_fd_pr__pfet_01v8_lvt w=2.1 l=0.35
X227 t_Xch_d_cbp f0 t_Xch_d_Xmixp_Xs0_sel vss sky130_fd_pr__nfet_01v8_lvt w=0.65 l=0.15
X228 t_Xch_d_cbp t_fb0 t_Xch_d_Xmixp_Xs0_sel vdd sky130_fd_pr__pfet_01v8_lvt w=2.1 l=0.35
X229 t_Xch_d_Xmixp_Xs0_drv t_Xch_d_Xmixp_Xs0_sel vss vss sky130_fd_pr__nfet_01v8_lvt w=0.7 l=0.15
X230 t_Xch_d_Xmixp_Xs0_drv t_Xch_d_Xmixp_Xs0_sel vdd vdd sky130_fd_pr__pfet_01v8 w=3.4 l=0.15
X231 t_Xch_d_Xmixp_Xs0_drv t_Xch_d_mixp vss sky130_fd_pr__res_high_po_0p69 l=2.2
X232 t_Xch_d_cap f0 t_Xch_d_Xmixp_Xs0_dum vss sky130_fd_pr__nfet_01v8_lvt w=0.65 l=0.15
X233 t_Xch_d_cap t_fb0 t_Xch_d_Xmixp_Xs0_dum vdd sky130_fd_pr__pfet_01v8_lvt w=2.1 l=0.35
X234 t_Xch_d_cbp t_fb0 t_Xch_d_Xmixp_Xs0_dum vss sky130_fd_pr__nfet_01v8_lvt w=0.65 l=0.15
X235 t_Xch_d_cbp f0 t_Xch_d_Xmixp_Xs0_dum vdd sky130_fd_pr__pfet_01v8_lvt w=2.1 l=0.35
X236 vss t_Xch_d_Xmixp_Xs0_dum vss vss sky130_fd_pr__nfet_01v8_lvt w=0.7 l=0.15
X237 vdd t_Xch_d_Xmixp_Xs0_dum vdd vdd sky130_fd_pr__pfet_01v8 w=3.4 l=0.15
X238 t_Xch_d_cap t_fb1 t_Xch_d_Xmixp_Xs1_sel vss sky130_fd_pr__nfet_01v8_lvt w=0.65 l=0.15
X239 t_Xch_d_cap f1 t_Xch_d_Xmixp_Xs1_sel vdd sky130_fd_pr__pfet_01v8_lvt w=2.1 l=0.35
X240 t_Xch_d_cbp f1 t_Xch_d_Xmixp_Xs1_sel vss sky130_fd_pr__nfet_01v8_lvt w=0.65 l=0.15
X241 t_Xch_d_cbp t_fb1 t_Xch_d_Xmixp_Xs1_sel vdd sky130_fd_pr__pfet_01v8_lvt w=2.1 l=0.35
X242 t_Xch_d_Xmixp_Xs1_drv t_Xch_d_Xmixp_Xs1_sel vss vss sky130_fd_pr__nfet_01v8_lvt w=0.7 l=0.15
X243 t_Xch_d_Xmixp_Xs1_drv t_Xch_d_Xmixp_Xs1_sel vdd vdd sky130_fd_pr__pfet_01v8 w=3.4 l=0.15
X244 t_Xch_d_Xmixp_Xs1_drv t_Xch_d_mixp vss sky130_fd_pr__res_high_po_0p69 l=2.2
X245 t_Xch_d_cap f1 t_Xch_d_Xmixp_Xs1_dum vss sky130_fd_pr__nfet_01v8_lvt w=0.65 l=0.15
X246 t_Xch_d_cap t_fb1 t_Xch_d_Xmixp_Xs1_dum vdd sky130_fd_pr__pfet_01v8_lvt w=2.1 l=0.35
X247 t_Xch_d_cbp t_fb1 t_Xch_d_Xmixp_Xs1_dum vss sky130_fd_pr__nfet_01v8_lvt w=0.65 l=0.15
X248 t_Xch_d_cbp f1 t_Xch_d_Xmixp_Xs1_dum vdd sky130_fd_pr__pfet_01v8_lvt w=2.1 l=0.35
X249 vss t_Xch_d_Xmixp_Xs1_dum vss vss sky130_fd_pr__nfet_01v8_lvt w=0.7 l=0.15
X250 vdd t_Xch_d_Xmixp_Xs1_dum vdd vdd sky130_fd_pr__pfet_01v8 w=3.4 l=0.15
X251 t_Xch_d_cap t_fb2 t_Xch_d_Xmixp_Xs2_sel vss sky130_fd_pr__nfet_01v8_lvt w=0.65 l=0.15
X252 t_Xch_d_cap f2 t_Xch_d_Xmixp_Xs2_sel vdd sky130_fd_pr__pfet_01v8_lvt w=2.1 l=0.35
X253 t_Xch_d_cbp f2 t_Xch_d_Xmixp_Xs2_sel vss sky130_fd_pr__nfet_01v8_lvt w=0.65 l=0.15
X254 t_Xch_d_cbp t_fb2 t_Xch_d_Xmixp_Xs2_sel vdd sky130_fd_pr__pfet_01v8_lvt w=2.1 l=0.35
X255 t_Xch_d_Xmixp_Xs2_drv t_Xch_d_Xmixp_Xs2_sel vss vss sky130_fd_pr__nfet_01v8_lvt w=0.7 l=0.15
X256 t_Xch_d_Xmixp_Xs2_drv t_Xch_d_Xmixp_Xs2_sel vdd vdd sky130_fd_pr__pfet_01v8 w=3.4 l=0.15
X257 t_Xch_d_Xmixp_Xs2_drv t_Xch_d_mixp vss sky130_fd_pr__res_high_po_0p69 l=2.2
X258 t_Xch_d_cap f2 t_Xch_d_Xmixp_Xs2_dum vss sky130_fd_pr__nfet_01v8_lvt w=0.65 l=0.15
X259 t_Xch_d_cap t_fb2 t_Xch_d_Xmixp_Xs2_dum vdd sky130_fd_pr__pfet_01v8_lvt w=2.1 l=0.35
X260 t_Xch_d_cbp t_fb2 t_Xch_d_Xmixp_Xs2_dum vss sky130_fd_pr__nfet_01v8_lvt w=0.65 l=0.15
X261 t_Xch_d_cbp f2 t_Xch_d_Xmixp_Xs2_dum vdd sky130_fd_pr__pfet_01v8_lvt w=2.1 l=0.35
X262 vss t_Xch_d_Xmixp_Xs2_dum vss vss sky130_fd_pr__nfet_01v8_lvt w=0.7 l=0.15
X263 vdd t_Xch_d_Xmixp_Xs2_dum vdd vdd sky130_fd_pr__pfet_01v8 w=3.4 l=0.15
X264 t_Xch_d_cap t_fb3 t_Xch_d_Xmixp_Xs3_sel vss sky130_fd_pr__nfet_01v8_lvt w=0.65 l=0.15
X265 t_Xch_d_cap f3 t_Xch_d_Xmixp_Xs3_sel vdd sky130_fd_pr__pfet_01v8_lvt w=2.1 l=0.35
X266 t_Xch_d_cbp f3 t_Xch_d_Xmixp_Xs3_sel vss sky130_fd_pr__nfet_01v8_lvt w=0.65 l=0.15
X267 t_Xch_d_cbp t_fb3 t_Xch_d_Xmixp_Xs3_sel vdd sky130_fd_pr__pfet_01v8_lvt w=2.1 l=0.35
X268 t_Xch_d_Xmixp_Xs3_drv t_Xch_d_Xmixp_Xs3_sel vss vss sky130_fd_pr__nfet_01v8_lvt w=0.7 l=0.15
X269 t_Xch_d_Xmixp_Xs3_drv t_Xch_d_Xmixp_Xs3_sel vdd vdd sky130_fd_pr__pfet_01v8 w=3.4 l=0.15
X270 t_Xch_d_Xmixp_Xs3_drv t_Xch_d_mixp vss sky130_fd_pr__res_high_po_0p69 l=2.2
X271 t_Xch_d_cap f3 t_Xch_d_Xmixp_Xs3_dum vss sky130_fd_pr__nfet_01v8_lvt w=0.65 l=0.15
X272 t_Xch_d_cap t_fb3 t_Xch_d_Xmixp_Xs3_dum vdd sky130_fd_pr__pfet_01v8_lvt w=2.1 l=0.35
X273 t_Xch_d_cbp t_fb3 t_Xch_d_Xmixp_Xs3_dum vss sky130_fd_pr__nfet_01v8_lvt w=0.65 l=0.15
X274 t_Xch_d_cbp f3 t_Xch_d_Xmixp_Xs3_dum vdd sky130_fd_pr__pfet_01v8_lvt w=2.1 l=0.35
X275 vss t_Xch_d_Xmixp_Xs3_dum vss vss sky130_fd_pr__nfet_01v8_lvt w=0.7 l=0.15
X276 vdd t_Xch_d_Xmixp_Xs3_dum vdd vdd sky130_fd_pr__pfet_01v8 w=3.4 l=0.15
X277 t_Xch_d_cap t_fb4 t_Xch_d_Xmixp_Xs4_sel vss sky130_fd_pr__nfet_01v8_lvt w=0.65 l=0.15
X278 t_Xch_d_cap f4 t_Xch_d_Xmixp_Xs4_sel vdd sky130_fd_pr__pfet_01v8_lvt w=2.1 l=0.35
X279 t_Xch_d_cbp f4 t_Xch_d_Xmixp_Xs4_sel vss sky130_fd_pr__nfet_01v8_lvt w=0.65 l=0.15
X280 t_Xch_d_cbp t_fb4 t_Xch_d_Xmixp_Xs4_sel vdd sky130_fd_pr__pfet_01v8_lvt w=2.1 l=0.35
X281 t_Xch_d_Xmixp_Xs4_drv t_Xch_d_Xmixp_Xs4_sel vss vss sky130_fd_pr__nfet_01v8_lvt w=0.7 l=0.15
X282 t_Xch_d_Xmixp_Xs4_drv t_Xch_d_Xmixp_Xs4_sel vdd vdd sky130_fd_pr__pfet_01v8 w=3.4 l=0.15
X283 t_Xch_d_Xmixp_Xs4_drv t_Xch_d_mixp vss sky130_fd_pr__res_high_po_0p69 l=2.2
X284 t_Xch_d_cap f4 t_Xch_d_Xmixp_Xs4_dum vss sky130_fd_pr__nfet_01v8_lvt w=0.65 l=0.15
X285 t_Xch_d_cap t_fb4 t_Xch_d_Xmixp_Xs4_dum vdd sky130_fd_pr__pfet_01v8_lvt w=2.1 l=0.35
X286 t_Xch_d_cbp t_fb4 t_Xch_d_Xmixp_Xs4_dum vss sky130_fd_pr__nfet_01v8_lvt w=0.65 l=0.15
X287 t_Xch_d_cbp f4 t_Xch_d_Xmixp_Xs4_dum vdd sky130_fd_pr__pfet_01v8_lvt w=2.1 l=0.35
X288 vss t_Xch_d_Xmixp_Xs4_dum vss vss sky130_fd_pr__nfet_01v8_lvt w=0.7 l=0.15
X289 vdd t_Xch_d_Xmixp_Xs4_dum vdd vdd sky130_fd_pr__pfet_01v8 w=3.4 l=0.15
X290 t_Xch_d_cap t_fb5 t_Xch_d_Xmixp_Xs5_sel vss sky130_fd_pr__nfet_01v8_lvt w=0.65 l=0.15
X291 t_Xch_d_cap f5 t_Xch_d_Xmixp_Xs5_sel vdd sky130_fd_pr__pfet_01v8_lvt w=2.1 l=0.35
X292 t_Xch_d_cbp f5 t_Xch_d_Xmixp_Xs5_sel vss sky130_fd_pr__nfet_01v8_lvt w=0.65 l=0.15
X293 t_Xch_d_cbp t_fb5 t_Xch_d_Xmixp_Xs5_sel vdd sky130_fd_pr__pfet_01v8_lvt w=2.1 l=0.35
X294 t_Xch_d_Xmixp_Xs5_drv t_Xch_d_Xmixp_Xs5_sel vss vss sky130_fd_pr__nfet_01v8_lvt w=0.7 l=0.15
X295 t_Xch_d_Xmixp_Xs5_drv t_Xch_d_Xmixp_Xs5_sel vdd vdd sky130_fd_pr__pfet_01v8 w=3.4 l=0.15
X296 t_Xch_d_Xmixp_Xs5_drv t_Xch_d_mixp vss sky130_fd_pr__res_high_po_0p69 l=2.2
X297 t_Xch_d_cap f5 t_Xch_d_Xmixp_Xs5_dum vss sky130_fd_pr__nfet_01v8_lvt w=0.65 l=0.15
X298 t_Xch_d_cap t_fb5 t_Xch_d_Xmixp_Xs5_dum vdd sky130_fd_pr__pfet_01v8_lvt w=2.1 l=0.35
X299 t_Xch_d_cbp t_fb5 t_Xch_d_Xmixp_Xs5_dum vss sky130_fd_pr__nfet_01v8_lvt w=0.65 l=0.15
X300 t_Xch_d_cbp f5 t_Xch_d_Xmixp_Xs5_dum vdd sky130_fd_pr__pfet_01v8_lvt w=2.1 l=0.35
X301 vss t_Xch_d_Xmixp_Xs5_dum vss vss sky130_fd_pr__nfet_01v8_lvt w=0.7 l=0.15
X302 vdd t_Xch_d_Xmixp_Xs5_dum vdd vdd sky130_fd_pr__pfet_01v8 w=3.4 l=0.15
X303 t_Xch_d_cap t_fb6 t_Xch_d_Xmixp_Xs6_sel vss sky130_fd_pr__nfet_01v8_lvt w=0.65 l=0.15
X304 t_Xch_d_cap f6 t_Xch_d_Xmixp_Xs6_sel vdd sky130_fd_pr__pfet_01v8_lvt w=2.1 l=0.35
X305 t_Xch_d_cbp f6 t_Xch_d_Xmixp_Xs6_sel vss sky130_fd_pr__nfet_01v8_lvt w=0.65 l=0.15
X306 t_Xch_d_cbp t_fb6 t_Xch_d_Xmixp_Xs6_sel vdd sky130_fd_pr__pfet_01v8_lvt w=2.1 l=0.35
X307 t_Xch_d_Xmixp_Xs6_drv t_Xch_d_Xmixp_Xs6_sel vss vss sky130_fd_pr__nfet_01v8_lvt w=0.7 l=0.15
X308 t_Xch_d_Xmixp_Xs6_drv t_Xch_d_Xmixp_Xs6_sel vdd vdd sky130_fd_pr__pfet_01v8 w=3.4 l=0.15
X309 t_Xch_d_Xmixp_Xs6_drv t_Xch_d_mixp vss sky130_fd_pr__res_high_po_0p69 l=2.2
X310 t_Xch_d_cap f6 t_Xch_d_Xmixp_Xs6_dum vss sky130_fd_pr__nfet_01v8_lvt w=0.65 l=0.15
X311 t_Xch_d_cap t_fb6 t_Xch_d_Xmixp_Xs6_dum vdd sky130_fd_pr__pfet_01v8_lvt w=2.1 l=0.35
X312 t_Xch_d_cbp t_fb6 t_Xch_d_Xmixp_Xs6_dum vss sky130_fd_pr__nfet_01v8_lvt w=0.65 l=0.15
X313 t_Xch_d_cbp f6 t_Xch_d_Xmixp_Xs6_dum vdd sky130_fd_pr__pfet_01v8_lvt w=2.1 l=0.35
X314 vss t_Xch_d_Xmixp_Xs6_dum vss vss sky130_fd_pr__nfet_01v8_lvt w=0.7 l=0.15
X315 vdd t_Xch_d_Xmixp_Xs6_dum vdd vdd sky130_fd_pr__pfet_01v8 w=3.4 l=0.15
X316 t_Xch_d_cap t_fb7 t_Xch_d_Xmixp_Xs7_sel vss sky130_fd_pr__nfet_01v8_lvt w=0.65 l=0.15
X317 t_Xch_d_cap f7 t_Xch_d_Xmixp_Xs7_sel vdd sky130_fd_pr__pfet_01v8_lvt w=2.1 l=0.35
X318 t_Xch_d_cbp f7 t_Xch_d_Xmixp_Xs7_sel vss sky130_fd_pr__nfet_01v8_lvt w=0.65 l=0.15
X319 t_Xch_d_cbp t_fb7 t_Xch_d_Xmixp_Xs7_sel vdd sky130_fd_pr__pfet_01v8_lvt w=2.1 l=0.35
X320 t_Xch_d_Xmixp_Xs7_drv t_Xch_d_Xmixp_Xs7_sel vss vss sky130_fd_pr__nfet_01v8_lvt w=0.7 l=0.15
X321 t_Xch_d_Xmixp_Xs7_drv t_Xch_d_Xmixp_Xs7_sel vdd vdd sky130_fd_pr__pfet_01v8 w=3.4 l=0.15
X322 t_Xch_d_Xmixp_Xs7_drv t_Xch_d_mixp vss sky130_fd_pr__res_high_po_0p69 l=2.2
X323 t_Xch_d_cap f7 t_Xch_d_Xmixp_Xs7_dum vss sky130_fd_pr__nfet_01v8_lvt w=0.65 l=0.15
X324 t_Xch_d_cap t_fb7 t_Xch_d_Xmixp_Xs7_dum vdd sky130_fd_pr__pfet_01v8_lvt w=2.1 l=0.35
X325 t_Xch_d_cbp t_fb7 t_Xch_d_Xmixp_Xs7_dum vss sky130_fd_pr__nfet_01v8_lvt w=0.65 l=0.15
X326 t_Xch_d_cbp f7 t_Xch_d_Xmixp_Xs7_dum vdd sky130_fd_pr__pfet_01v8_lvt w=2.1 l=0.35
X327 vss t_Xch_d_Xmixp_Xs7_dum vss vss sky130_fd_pr__nfet_01v8_lvt w=0.7 l=0.15
X328 vdd t_Xch_d_Xmixp_Xs7_dum vdd vdd sky130_fd_pr__pfet_01v8 w=3.4 l=0.15
X329 t_Xch_d_mixp vss sky130_fd_pr__cap_mim_m3_1 w=1.6 l=1.6
X330 t_Xch_d_can t_fb0 t_Xch_d_Xmixn_Xs0_sel vss sky130_fd_pr__nfet_01v8_lvt w=0.65 l=0.15
X331 t_Xch_d_can f0 t_Xch_d_Xmixn_Xs0_sel vdd sky130_fd_pr__pfet_01v8_lvt w=2.1 l=0.35
X332 t_Xch_d_cbn f0 t_Xch_d_Xmixn_Xs0_sel vss sky130_fd_pr__nfet_01v8_lvt w=0.65 l=0.15
X333 t_Xch_d_cbn t_fb0 t_Xch_d_Xmixn_Xs0_sel vdd sky130_fd_pr__pfet_01v8_lvt w=2.1 l=0.35
X334 t_Xch_d_Xmixn_Xs0_drv t_Xch_d_Xmixn_Xs0_sel vss vss sky130_fd_pr__nfet_01v8_lvt w=0.7 l=0.15
X335 t_Xch_d_Xmixn_Xs0_drv t_Xch_d_Xmixn_Xs0_sel vdd vdd sky130_fd_pr__pfet_01v8 w=3.4 l=0.15
X336 t_Xch_d_Xmixn_Xs0_drv t_Xch_d_mixn vss sky130_fd_pr__res_high_po_0p69 l=2.2
X337 t_Xch_d_can f0 t_Xch_d_Xmixn_Xs0_dum vss sky130_fd_pr__nfet_01v8_lvt w=0.65 l=0.15
X338 t_Xch_d_can t_fb0 t_Xch_d_Xmixn_Xs0_dum vdd sky130_fd_pr__pfet_01v8_lvt w=2.1 l=0.35
X339 t_Xch_d_cbn t_fb0 t_Xch_d_Xmixn_Xs0_dum vss sky130_fd_pr__nfet_01v8_lvt w=0.65 l=0.15
X340 t_Xch_d_cbn f0 t_Xch_d_Xmixn_Xs0_dum vdd sky130_fd_pr__pfet_01v8_lvt w=2.1 l=0.35
X341 vss t_Xch_d_Xmixn_Xs0_dum vss vss sky130_fd_pr__nfet_01v8_lvt w=0.7 l=0.15
X342 vdd t_Xch_d_Xmixn_Xs0_dum vdd vdd sky130_fd_pr__pfet_01v8 w=3.4 l=0.15
X343 t_Xch_d_can t_fb1 t_Xch_d_Xmixn_Xs1_sel vss sky130_fd_pr__nfet_01v8_lvt w=0.65 l=0.15
X344 t_Xch_d_can f1 t_Xch_d_Xmixn_Xs1_sel vdd sky130_fd_pr__pfet_01v8_lvt w=2.1 l=0.35
X345 t_Xch_d_cbn f1 t_Xch_d_Xmixn_Xs1_sel vss sky130_fd_pr__nfet_01v8_lvt w=0.65 l=0.15
X346 t_Xch_d_cbn t_fb1 t_Xch_d_Xmixn_Xs1_sel vdd sky130_fd_pr__pfet_01v8_lvt w=2.1 l=0.35
X347 t_Xch_d_Xmixn_Xs1_drv t_Xch_d_Xmixn_Xs1_sel vss vss sky130_fd_pr__nfet_01v8_lvt w=0.7 l=0.15
X348 t_Xch_d_Xmixn_Xs1_drv t_Xch_d_Xmixn_Xs1_sel vdd vdd sky130_fd_pr__pfet_01v8 w=3.4 l=0.15
X349 t_Xch_d_Xmixn_Xs1_drv t_Xch_d_mixn vss sky130_fd_pr__res_high_po_0p69 l=2.2
X350 t_Xch_d_can f1 t_Xch_d_Xmixn_Xs1_dum vss sky130_fd_pr__nfet_01v8_lvt w=0.65 l=0.15
X351 t_Xch_d_can t_fb1 t_Xch_d_Xmixn_Xs1_dum vdd sky130_fd_pr__pfet_01v8_lvt w=2.1 l=0.35
X352 t_Xch_d_cbn t_fb1 t_Xch_d_Xmixn_Xs1_dum vss sky130_fd_pr__nfet_01v8_lvt w=0.65 l=0.15
X353 t_Xch_d_cbn f1 t_Xch_d_Xmixn_Xs1_dum vdd sky130_fd_pr__pfet_01v8_lvt w=2.1 l=0.35
X354 vss t_Xch_d_Xmixn_Xs1_dum vss vss sky130_fd_pr__nfet_01v8_lvt w=0.7 l=0.15
X355 vdd t_Xch_d_Xmixn_Xs1_dum vdd vdd sky130_fd_pr__pfet_01v8 w=3.4 l=0.15
X356 t_Xch_d_can t_fb2 t_Xch_d_Xmixn_Xs2_sel vss sky130_fd_pr__nfet_01v8_lvt w=0.65 l=0.15
X357 t_Xch_d_can f2 t_Xch_d_Xmixn_Xs2_sel vdd sky130_fd_pr__pfet_01v8_lvt w=2.1 l=0.35
X358 t_Xch_d_cbn f2 t_Xch_d_Xmixn_Xs2_sel vss sky130_fd_pr__nfet_01v8_lvt w=0.65 l=0.15
X359 t_Xch_d_cbn t_fb2 t_Xch_d_Xmixn_Xs2_sel vdd sky130_fd_pr__pfet_01v8_lvt w=2.1 l=0.35
X360 t_Xch_d_Xmixn_Xs2_drv t_Xch_d_Xmixn_Xs2_sel vss vss sky130_fd_pr__nfet_01v8_lvt w=0.7 l=0.15
X361 t_Xch_d_Xmixn_Xs2_drv t_Xch_d_Xmixn_Xs2_sel vdd vdd sky130_fd_pr__pfet_01v8 w=3.4 l=0.15
X362 t_Xch_d_Xmixn_Xs2_drv t_Xch_d_mixn vss sky130_fd_pr__res_high_po_0p69 l=2.2
X363 t_Xch_d_can f2 t_Xch_d_Xmixn_Xs2_dum vss sky130_fd_pr__nfet_01v8_lvt w=0.65 l=0.15
X364 t_Xch_d_can t_fb2 t_Xch_d_Xmixn_Xs2_dum vdd sky130_fd_pr__pfet_01v8_lvt w=2.1 l=0.35
X365 t_Xch_d_cbn t_fb2 t_Xch_d_Xmixn_Xs2_dum vss sky130_fd_pr__nfet_01v8_lvt w=0.65 l=0.15
X366 t_Xch_d_cbn f2 t_Xch_d_Xmixn_Xs2_dum vdd sky130_fd_pr__pfet_01v8_lvt w=2.1 l=0.35
X367 vss t_Xch_d_Xmixn_Xs2_dum vss vss sky130_fd_pr__nfet_01v8_lvt w=0.7 l=0.15
X368 vdd t_Xch_d_Xmixn_Xs2_dum vdd vdd sky130_fd_pr__pfet_01v8 w=3.4 l=0.15
X369 t_Xch_d_can t_fb3 t_Xch_d_Xmixn_Xs3_sel vss sky130_fd_pr__nfet_01v8_lvt w=0.65 l=0.15
X370 t_Xch_d_can f3 t_Xch_d_Xmixn_Xs3_sel vdd sky130_fd_pr__pfet_01v8_lvt w=2.1 l=0.35
X371 t_Xch_d_cbn f3 t_Xch_d_Xmixn_Xs3_sel vss sky130_fd_pr__nfet_01v8_lvt w=0.65 l=0.15
X372 t_Xch_d_cbn t_fb3 t_Xch_d_Xmixn_Xs3_sel vdd sky130_fd_pr__pfet_01v8_lvt w=2.1 l=0.35
X373 t_Xch_d_Xmixn_Xs3_drv t_Xch_d_Xmixn_Xs3_sel vss vss sky130_fd_pr__nfet_01v8_lvt w=0.7 l=0.15
X374 t_Xch_d_Xmixn_Xs3_drv t_Xch_d_Xmixn_Xs3_sel vdd vdd sky130_fd_pr__pfet_01v8 w=3.4 l=0.15
X375 t_Xch_d_Xmixn_Xs3_drv t_Xch_d_mixn vss sky130_fd_pr__res_high_po_0p69 l=2.2
X376 t_Xch_d_can f3 t_Xch_d_Xmixn_Xs3_dum vss sky130_fd_pr__nfet_01v8_lvt w=0.65 l=0.15
X377 t_Xch_d_can t_fb3 t_Xch_d_Xmixn_Xs3_dum vdd sky130_fd_pr__pfet_01v8_lvt w=2.1 l=0.35
X378 t_Xch_d_cbn t_fb3 t_Xch_d_Xmixn_Xs3_dum vss sky130_fd_pr__nfet_01v8_lvt w=0.65 l=0.15
X379 t_Xch_d_cbn f3 t_Xch_d_Xmixn_Xs3_dum vdd sky130_fd_pr__pfet_01v8_lvt w=2.1 l=0.35
X380 vss t_Xch_d_Xmixn_Xs3_dum vss vss sky130_fd_pr__nfet_01v8_lvt w=0.7 l=0.15
X381 vdd t_Xch_d_Xmixn_Xs3_dum vdd vdd sky130_fd_pr__pfet_01v8 w=3.4 l=0.15
X382 t_Xch_d_can t_fb4 t_Xch_d_Xmixn_Xs4_sel vss sky130_fd_pr__nfet_01v8_lvt w=0.65 l=0.15
X383 t_Xch_d_can f4 t_Xch_d_Xmixn_Xs4_sel vdd sky130_fd_pr__pfet_01v8_lvt w=2.1 l=0.35
X384 t_Xch_d_cbn f4 t_Xch_d_Xmixn_Xs4_sel vss sky130_fd_pr__nfet_01v8_lvt w=0.65 l=0.15
X385 t_Xch_d_cbn t_fb4 t_Xch_d_Xmixn_Xs4_sel vdd sky130_fd_pr__pfet_01v8_lvt w=2.1 l=0.35
X386 t_Xch_d_Xmixn_Xs4_drv t_Xch_d_Xmixn_Xs4_sel vss vss sky130_fd_pr__nfet_01v8_lvt w=0.7 l=0.15
X387 t_Xch_d_Xmixn_Xs4_drv t_Xch_d_Xmixn_Xs4_sel vdd vdd sky130_fd_pr__pfet_01v8 w=3.4 l=0.15
X388 t_Xch_d_Xmixn_Xs4_drv t_Xch_d_mixn vss sky130_fd_pr__res_high_po_0p69 l=2.2
X389 t_Xch_d_can f4 t_Xch_d_Xmixn_Xs4_dum vss sky130_fd_pr__nfet_01v8_lvt w=0.65 l=0.15
X390 t_Xch_d_can t_fb4 t_Xch_d_Xmixn_Xs4_dum vdd sky130_fd_pr__pfet_01v8_lvt w=2.1 l=0.35
X391 t_Xch_d_cbn t_fb4 t_Xch_d_Xmixn_Xs4_dum vss sky130_fd_pr__nfet_01v8_lvt w=0.65 l=0.15
X392 t_Xch_d_cbn f4 t_Xch_d_Xmixn_Xs4_dum vdd sky130_fd_pr__pfet_01v8_lvt w=2.1 l=0.35
X393 vss t_Xch_d_Xmixn_Xs4_dum vss vss sky130_fd_pr__nfet_01v8_lvt w=0.7 l=0.15
X394 vdd t_Xch_d_Xmixn_Xs4_dum vdd vdd sky130_fd_pr__pfet_01v8 w=3.4 l=0.15
X395 t_Xch_d_can t_fb5 t_Xch_d_Xmixn_Xs5_sel vss sky130_fd_pr__nfet_01v8_lvt w=0.65 l=0.15
X396 t_Xch_d_can f5 t_Xch_d_Xmixn_Xs5_sel vdd sky130_fd_pr__pfet_01v8_lvt w=2.1 l=0.35
X397 t_Xch_d_cbn f5 t_Xch_d_Xmixn_Xs5_sel vss sky130_fd_pr__nfet_01v8_lvt w=0.65 l=0.15
X398 t_Xch_d_cbn t_fb5 t_Xch_d_Xmixn_Xs5_sel vdd sky130_fd_pr__pfet_01v8_lvt w=2.1 l=0.35
X399 t_Xch_d_Xmixn_Xs5_drv t_Xch_d_Xmixn_Xs5_sel vss vss sky130_fd_pr__nfet_01v8_lvt w=0.7 l=0.15
X400 t_Xch_d_Xmixn_Xs5_drv t_Xch_d_Xmixn_Xs5_sel vdd vdd sky130_fd_pr__pfet_01v8 w=3.4 l=0.15
X401 t_Xch_d_Xmixn_Xs5_drv t_Xch_d_mixn vss sky130_fd_pr__res_high_po_0p69 l=2.2
X402 t_Xch_d_can f5 t_Xch_d_Xmixn_Xs5_dum vss sky130_fd_pr__nfet_01v8_lvt w=0.65 l=0.15
X403 t_Xch_d_can t_fb5 t_Xch_d_Xmixn_Xs5_dum vdd sky130_fd_pr__pfet_01v8_lvt w=2.1 l=0.35
X404 t_Xch_d_cbn t_fb5 t_Xch_d_Xmixn_Xs5_dum vss sky130_fd_pr__nfet_01v8_lvt w=0.65 l=0.15
X405 t_Xch_d_cbn f5 t_Xch_d_Xmixn_Xs5_dum vdd sky130_fd_pr__pfet_01v8_lvt w=2.1 l=0.35
X406 vss t_Xch_d_Xmixn_Xs5_dum vss vss sky130_fd_pr__nfet_01v8_lvt w=0.7 l=0.15
X407 vdd t_Xch_d_Xmixn_Xs5_dum vdd vdd sky130_fd_pr__pfet_01v8 w=3.4 l=0.15
X408 t_Xch_d_can t_fb6 t_Xch_d_Xmixn_Xs6_sel vss sky130_fd_pr__nfet_01v8_lvt w=0.65 l=0.15
X409 t_Xch_d_can f6 t_Xch_d_Xmixn_Xs6_sel vdd sky130_fd_pr__pfet_01v8_lvt w=2.1 l=0.35
X410 t_Xch_d_cbn f6 t_Xch_d_Xmixn_Xs6_sel vss sky130_fd_pr__nfet_01v8_lvt w=0.65 l=0.15
X411 t_Xch_d_cbn t_fb6 t_Xch_d_Xmixn_Xs6_sel vdd sky130_fd_pr__pfet_01v8_lvt w=2.1 l=0.35
X412 t_Xch_d_Xmixn_Xs6_drv t_Xch_d_Xmixn_Xs6_sel vss vss sky130_fd_pr__nfet_01v8_lvt w=0.7 l=0.15
X413 t_Xch_d_Xmixn_Xs6_drv t_Xch_d_Xmixn_Xs6_sel vdd vdd sky130_fd_pr__pfet_01v8 w=3.4 l=0.15
X414 t_Xch_d_Xmixn_Xs6_drv t_Xch_d_mixn vss sky130_fd_pr__res_high_po_0p69 l=2.2
X415 t_Xch_d_can f6 t_Xch_d_Xmixn_Xs6_dum vss sky130_fd_pr__nfet_01v8_lvt w=0.65 l=0.15
X416 t_Xch_d_can t_fb6 t_Xch_d_Xmixn_Xs6_dum vdd sky130_fd_pr__pfet_01v8_lvt w=2.1 l=0.35
X417 t_Xch_d_cbn t_fb6 t_Xch_d_Xmixn_Xs6_dum vss sky130_fd_pr__nfet_01v8_lvt w=0.65 l=0.15
X418 t_Xch_d_cbn f6 t_Xch_d_Xmixn_Xs6_dum vdd sky130_fd_pr__pfet_01v8_lvt w=2.1 l=0.35
X419 vss t_Xch_d_Xmixn_Xs6_dum vss vss sky130_fd_pr__nfet_01v8_lvt w=0.7 l=0.15
X420 vdd t_Xch_d_Xmixn_Xs6_dum vdd vdd sky130_fd_pr__pfet_01v8 w=3.4 l=0.15
X421 t_Xch_d_can t_fb7 t_Xch_d_Xmixn_Xs7_sel vss sky130_fd_pr__nfet_01v8_lvt w=0.65 l=0.15
X422 t_Xch_d_can f7 t_Xch_d_Xmixn_Xs7_sel vdd sky130_fd_pr__pfet_01v8_lvt w=2.1 l=0.35
X423 t_Xch_d_cbn f7 t_Xch_d_Xmixn_Xs7_sel vss sky130_fd_pr__nfet_01v8_lvt w=0.65 l=0.15
X424 t_Xch_d_cbn t_fb7 t_Xch_d_Xmixn_Xs7_sel vdd sky130_fd_pr__pfet_01v8_lvt w=2.1 l=0.35
X425 t_Xch_d_Xmixn_Xs7_drv t_Xch_d_Xmixn_Xs7_sel vss vss sky130_fd_pr__nfet_01v8_lvt w=0.7 l=0.15
X426 t_Xch_d_Xmixn_Xs7_drv t_Xch_d_Xmixn_Xs7_sel vdd vdd sky130_fd_pr__pfet_01v8 w=3.4 l=0.15
X427 t_Xch_d_Xmixn_Xs7_drv t_Xch_d_mixn vss sky130_fd_pr__res_high_po_0p69 l=2.2
X428 t_Xch_d_can f7 t_Xch_d_Xmixn_Xs7_dum vss sky130_fd_pr__nfet_01v8_lvt w=0.65 l=0.15
X429 t_Xch_d_can t_fb7 t_Xch_d_Xmixn_Xs7_dum vdd sky130_fd_pr__pfet_01v8_lvt w=2.1 l=0.35
X430 t_Xch_d_cbn t_fb7 t_Xch_d_Xmixn_Xs7_dum vss sky130_fd_pr__nfet_01v8_lvt w=0.65 l=0.15
X431 t_Xch_d_cbn f7 t_Xch_d_Xmixn_Xs7_dum vdd sky130_fd_pr__pfet_01v8_lvt w=2.1 l=0.35
X432 vss t_Xch_d_Xmixn_Xs7_dum vss vss sky130_fd_pr__nfet_01v8_lvt w=0.7 l=0.15
X433 vdd t_Xch_d_Xmixn_Xs7_dum vdd vdd sky130_fd_pr__pfet_01v8 w=3.4 l=0.15
X434 t_Xch_d_mixn vss sky130_fd_pr__cap_mim_m3_1 w=1.6 l=1.6
X435 t_Xch_d_Xrec_ac1p t_Xch_d_mixp sky130_fd_pr__cap_mim_m3_1 w=4.8 l=4.8
X436 t_Xch_d_Xrec_ac1n t_Xch_d_mixn sky130_fd_pr__cap_mim_m3_1 w=4.8 l=4.8
X437 t_Xch_d_Xrec_ac1p t_Xch_d_Xrec_r1n vss sky130_fd_pr__res_high_po_0p35 l=6.5
X438 t_Xch_d_Xrec_ac1n t_Xch_d_Xrec_r1p vss sky130_fd_pr__res_high_po_0p35 l=6.5
X439 t_Xch_d_Xrec_r1n t_Xch_d_Xrec_ac1p t_Xch_d_Xrec_tail1 vss sky130_fd_pr__nfet_01v8_lvt w=7.2 l=0.15
X440 t_Xch_d_Xrec_r1p t_Xch_d_Xrec_ac1n t_Xch_d_Xrec_tail1 vss sky130_fd_pr__nfet_01v8_lvt w=7.2 l=0.15
X441 t_Xch_d_Xrec_tail1 vdd vss vss sky130_fd_pr__nfet_01v8 w=4.6 l=0.2
X442 t_Xch_d_Xrec_r1n vss vdd vdd sky130_fd_pr__pfet_01v8 w=3.8 l=0.15
X443 t_Xch_d_Xrec_r1p vss vdd vdd sky130_fd_pr__pfet_01v8 w=3.8 l=0.15
X444 t_Xch_d_Xrec_r1n t_Xch_d_Xrec_r1p vdd vdd sky130_fd_pr__pfet_01v8 w=2.88 l=0.15
X445 t_Xch_d_Xrec_r1p t_Xch_d_Xrec_r1n vdd vdd sky130_fd_pr__pfet_01v8 w=2.88 l=0.15
X446 t_Xch_d_Xrec_r2n t_Xch_d_Xrec_r1p t_Xch_d_Xrec_tail2 vss sky130_fd_pr__nfet_01v8_lvt w=12 l=0.15
X447 t_Xch_d_Xrec_r2p t_Xch_d_Xrec_r1n t_Xch_d_Xrec_tail2 vss sky130_fd_pr__nfet_01v8_lvt w=12 l=0.15
X448 t_Xch_d_Xrec_tail2 vdd vss vss sky130_fd_pr__nfet_01v8 w=9.8 l=0.2
X449 t_Xch_d_Xrec_r2n vss vdd vdd sky130_fd_pr__pfet_01v8 w=6.3 l=0.15
X450 t_Xch_d_Xrec_r2p vss vdd vdd sky130_fd_pr__pfet_01v8 w=6.3 l=0.15
X451 t_Xch_d_Xrec_r2n t_Xch_d_Xrec_r2p vdd vdd sky130_fd_pr__pfet_01v8 w=5.04 l=0.15
X452 t_Xch_d_Xrec_r2p t_Xch_d_Xrec_r2n vdd vdd sky130_fd_pr__pfet_01v8 w=5.04 l=0.15
X453 dp t_Xch_d_Xrec_r2n vss vss sky130_fd_pr__nfet_01v8_lvt w=4.2 l=0.15
X454 dp t_Xch_d_Xrec_r2n vdd vdd sky130_fd_pr__pfet_01v8 w=18 l=0.15
X455 dp t_Xch_d_Xrec_r2n vdd vdd sky130_fd_pr__pfet_01v8_lvt w=5.6 l=0.35
X456 dn t_Xch_d_Xrec_r2p vss vss sky130_fd_pr__nfet_01v8_lvt w=4.2 l=0.15
X457 dn t_Xch_d_Xrec_r2p vdd vdd sky130_fd_pr__pfet_01v8 w=18 l=0.15
X458 dn t_Xch_d_Xrec_r2p vdd vdd sky130_fd_pr__pfet_01v8_lvt w=5.6 l=0.35
X459 dn dp vss vss sky130_fd_pr__nfet_01v8_lvt w=0.9 l=0.15
X460 dn dp vdd vdd sky130_fd_pr__pfet_01v8 w=3.8 l=0.15
X461 dp dn vss vss sky130_fd_pr__nfet_01v8_lvt w=0.9 l=0.15
X462 dp dn vdd vdd sky130_fd_pr__pfet_01v8 w=3.8 l=0.15
X463 t_cb2 a0 t_Xch_e_Xmap_m vss sky130_fd_pr__nfet_01v8_lvt w=1.5 l=0.15
X464 t_cb2 t_ab0 t_Xch_e_Xmap_m vdd sky130_fd_pr__pfet_01v8_lvt w=4.6 l=0.35
X465 t_cb4 a2 t_Xch_e_Xmap_m vss sky130_fd_pr__nfet_01v8_lvt w=1.5 l=0.15
X466 t_cb4 t_ab2 t_Xch_e_Xmap_m vdd sky130_fd_pr__pfet_01v8_lvt w=4.6 l=0.35
X467 t_cb6 a4 t_Xch_e_Xmap_m vss sky130_fd_pr__nfet_01v8_lvt w=1.5 l=0.15
X468 t_cb6 t_ab4 t_Xch_e_Xmap_m vdd sky130_fd_pr__pfet_01v8_lvt w=4.6 l=0.35
X469 t_cb0 a6 t_Xch_e_Xmap_m vss sky130_fd_pr__nfet_01v8_lvt w=1.5 l=0.15
X470 t_cb0 t_ab6 t_Xch_e_Xmap_m vdd sky130_fd_pr__pfet_01v8_lvt w=4.6 l=0.35
X471 t_Xch_e_Xmap_ma t_Xch_e_Xmap_m sky130_fd_pr__cap_mim_m3_1 w=4.3 l=4.2
X472 t_Xch_e_Xmap_ma t_Xch_e_cap vss sky130_fd_pr__res_high_po_0p35 l=6.5
X473 t_Xch_e_cap t_Xch_e_Xmap_ma vss vss sky130_fd_pr__nfet_01v8_lvt w=3.4 l=0.15
X474 t_Xch_e_cap t_Xch_e_Xmap_ma vdd vdd sky130_fd_pr__pfet_01v8 w=11.2 l=0.15
X475 t_Xch_e_cap t_Xch_e_Xmap_ma vdd vdd sky130_fd_pr__pfet_01v8_lvt w=5.6 l=0.35
X476 t_cb6 a0 t_Xch_e_Xman_m vss sky130_fd_pr__nfet_01v8_lvt w=1.5 l=0.15
X477 t_cb6 t_ab0 t_Xch_e_Xman_m vdd sky130_fd_pr__pfet_01v8_lvt w=4.6 l=0.35
X478 t_cb0 a2 t_Xch_e_Xman_m vss sky130_fd_pr__nfet_01v8_lvt w=1.5 l=0.15
X479 t_cb0 t_ab2 t_Xch_e_Xman_m vdd sky130_fd_pr__pfet_01v8_lvt w=4.6 l=0.35
X480 t_cb2 a4 t_Xch_e_Xman_m vss sky130_fd_pr__nfet_01v8_lvt w=1.5 l=0.15
X481 t_cb2 t_ab4 t_Xch_e_Xman_m vdd sky130_fd_pr__pfet_01v8_lvt w=4.6 l=0.35
X482 t_cb4 a6 t_Xch_e_Xman_m vss sky130_fd_pr__nfet_01v8_lvt w=1.5 l=0.15
X483 t_cb4 t_ab6 t_Xch_e_Xman_m vdd sky130_fd_pr__pfet_01v8_lvt w=4.6 l=0.35
X484 t_Xch_e_Xman_ma t_Xch_e_Xman_m sky130_fd_pr__cap_mim_m3_1 w=4.3 l=4.2
X485 t_Xch_e_Xman_ma t_Xch_e_can vss sky130_fd_pr__res_high_po_0p35 l=6.5
X486 t_Xch_e_can t_Xch_e_Xman_ma vss vss sky130_fd_pr__nfet_01v8_lvt w=3.4 l=0.15
X487 t_Xch_e_can t_Xch_e_Xman_ma vdd vdd sky130_fd_pr__pfet_01v8 w=11.2 l=0.15
X488 t_Xch_e_can t_Xch_e_Xman_ma vdd vdd sky130_fd_pr__pfet_01v8_lvt w=5.6 l=0.35
X489 t_cb3 b1 t_Xch_e_Xmbp_m vss sky130_fd_pr__nfet_01v8_lvt w=1.5 l=0.15
X490 t_cb3 t_bb1 t_Xch_e_Xmbp_m vdd sky130_fd_pr__pfet_01v8_lvt w=4.6 l=0.35
X491 t_cb5 b3 t_Xch_e_Xmbp_m vss sky130_fd_pr__nfet_01v8_lvt w=1.5 l=0.15
X492 t_cb5 t_bb3 t_Xch_e_Xmbp_m vdd sky130_fd_pr__pfet_01v8_lvt w=4.6 l=0.35
X493 t_cb7 b5 t_Xch_e_Xmbp_m vss sky130_fd_pr__nfet_01v8_lvt w=1.5 l=0.15
X494 t_cb7 t_bb5 t_Xch_e_Xmbp_m vdd sky130_fd_pr__pfet_01v8_lvt w=4.6 l=0.35
X495 t_cb1 b7 t_Xch_e_Xmbp_m vss sky130_fd_pr__nfet_01v8_lvt w=1.5 l=0.15
X496 t_cb1 t_bb7 t_Xch_e_Xmbp_m vdd sky130_fd_pr__pfet_01v8_lvt w=4.6 l=0.35
X497 t_Xch_e_Xmbp_ma t_Xch_e_Xmbp_m sky130_fd_pr__cap_mim_m3_1 w=4.3 l=4.2
X498 t_Xch_e_Xmbp_ma t_Xch_e_cbp vss sky130_fd_pr__res_high_po_0p35 l=6.5
X499 t_Xch_e_cbp t_Xch_e_Xmbp_ma vss vss sky130_fd_pr__nfet_01v8_lvt w=3.4 l=0.15
X500 t_Xch_e_cbp t_Xch_e_Xmbp_ma vdd vdd sky130_fd_pr__pfet_01v8 w=11.2 l=0.15
X501 t_Xch_e_cbp t_Xch_e_Xmbp_ma vdd vdd sky130_fd_pr__pfet_01v8_lvt w=5.6 l=0.35
X502 t_cb7 b1 t_Xch_e_Xmbn_m vss sky130_fd_pr__nfet_01v8_lvt w=1.5 l=0.15
X503 t_cb7 t_bb1 t_Xch_e_Xmbn_m vdd sky130_fd_pr__pfet_01v8_lvt w=4.6 l=0.35
X504 t_cb1 b3 t_Xch_e_Xmbn_m vss sky130_fd_pr__nfet_01v8_lvt w=1.5 l=0.15
X505 t_cb1 t_bb3 t_Xch_e_Xmbn_m vdd sky130_fd_pr__pfet_01v8_lvt w=4.6 l=0.35
X506 t_cb3 b5 t_Xch_e_Xmbn_m vss sky130_fd_pr__nfet_01v8_lvt w=1.5 l=0.15
X507 t_cb3 t_bb5 t_Xch_e_Xmbn_m vdd sky130_fd_pr__pfet_01v8_lvt w=4.6 l=0.35
X508 t_cb5 b7 t_Xch_e_Xmbn_m vss sky130_fd_pr__nfet_01v8_lvt w=1.5 l=0.15
X509 t_cb5 t_bb7 t_Xch_e_Xmbn_m vdd sky130_fd_pr__pfet_01v8_lvt w=4.6 l=0.35
X510 t_Xch_e_Xmbn_ma t_Xch_e_Xmbn_m sky130_fd_pr__cap_mim_m3_1 w=4.3 l=4.2
X511 t_Xch_e_Xmbn_ma t_Xch_e_cbn vss sky130_fd_pr__res_high_po_0p35 l=6.5
X512 t_Xch_e_cbn t_Xch_e_Xmbn_ma vss vss sky130_fd_pr__nfet_01v8_lvt w=3.4 l=0.15
X513 t_Xch_e_cbn t_Xch_e_Xmbn_ma vdd vdd sky130_fd_pr__pfet_01v8 w=11.2 l=0.15
X514 t_Xch_e_cbn t_Xch_e_Xmbn_ma vdd vdd sky130_fd_pr__pfet_01v8_lvt w=5.6 l=0.35
X515 t_Xch_e_cap t_fb0 t_Xch_e_Xmixp_Xs0_sel vss sky130_fd_pr__nfet_01v8_lvt w=0.65 l=0.15
X516 t_Xch_e_cap f0 t_Xch_e_Xmixp_Xs0_sel vdd sky130_fd_pr__pfet_01v8_lvt w=2.1 l=0.35
X517 t_Xch_e_cbp f0 t_Xch_e_Xmixp_Xs0_sel vss sky130_fd_pr__nfet_01v8_lvt w=0.65 l=0.15
X518 t_Xch_e_cbp t_fb0 t_Xch_e_Xmixp_Xs0_sel vdd sky130_fd_pr__pfet_01v8_lvt w=2.1 l=0.35
X519 t_Xch_e_Xmixp_Xs0_drv t_Xch_e_Xmixp_Xs0_sel vss vss sky130_fd_pr__nfet_01v8_lvt w=0.7 l=0.15
X520 t_Xch_e_Xmixp_Xs0_drv t_Xch_e_Xmixp_Xs0_sel vdd vdd sky130_fd_pr__pfet_01v8 w=3.4 l=0.15
X521 t_Xch_e_Xmixp_Xs0_drv t_Xch_e_mixp vss sky130_fd_pr__res_high_po_0p69 l=2.2
X522 t_Xch_e_cap f0 t_Xch_e_Xmixp_Xs0_dum vss sky130_fd_pr__nfet_01v8_lvt w=0.65 l=0.15
X523 t_Xch_e_cap t_fb0 t_Xch_e_Xmixp_Xs0_dum vdd sky130_fd_pr__pfet_01v8_lvt w=2.1 l=0.35
X524 t_Xch_e_cbp t_fb0 t_Xch_e_Xmixp_Xs0_dum vss sky130_fd_pr__nfet_01v8_lvt w=0.65 l=0.15
X525 t_Xch_e_cbp f0 t_Xch_e_Xmixp_Xs0_dum vdd sky130_fd_pr__pfet_01v8_lvt w=2.1 l=0.35
X526 vss t_Xch_e_Xmixp_Xs0_dum vss vss sky130_fd_pr__nfet_01v8_lvt w=0.7 l=0.15
X527 vdd t_Xch_e_Xmixp_Xs0_dum vdd vdd sky130_fd_pr__pfet_01v8 w=3.4 l=0.15
X528 t_Xch_e_cap t_fb1 t_Xch_e_Xmixp_Xs1_sel vss sky130_fd_pr__nfet_01v8_lvt w=0.65 l=0.15
X529 t_Xch_e_cap f1 t_Xch_e_Xmixp_Xs1_sel vdd sky130_fd_pr__pfet_01v8_lvt w=2.1 l=0.35
X530 t_Xch_e_cbp f1 t_Xch_e_Xmixp_Xs1_sel vss sky130_fd_pr__nfet_01v8_lvt w=0.65 l=0.15
X531 t_Xch_e_cbp t_fb1 t_Xch_e_Xmixp_Xs1_sel vdd sky130_fd_pr__pfet_01v8_lvt w=2.1 l=0.35
X532 t_Xch_e_Xmixp_Xs1_drv t_Xch_e_Xmixp_Xs1_sel vss vss sky130_fd_pr__nfet_01v8_lvt w=0.7 l=0.15
X533 t_Xch_e_Xmixp_Xs1_drv t_Xch_e_Xmixp_Xs1_sel vdd vdd sky130_fd_pr__pfet_01v8 w=3.4 l=0.15
X534 t_Xch_e_Xmixp_Xs1_drv t_Xch_e_mixp vss sky130_fd_pr__res_high_po_0p69 l=2.2
X535 t_Xch_e_cap f1 t_Xch_e_Xmixp_Xs1_dum vss sky130_fd_pr__nfet_01v8_lvt w=0.65 l=0.15
X536 t_Xch_e_cap t_fb1 t_Xch_e_Xmixp_Xs1_dum vdd sky130_fd_pr__pfet_01v8_lvt w=2.1 l=0.35
X537 t_Xch_e_cbp t_fb1 t_Xch_e_Xmixp_Xs1_dum vss sky130_fd_pr__nfet_01v8_lvt w=0.65 l=0.15
X538 t_Xch_e_cbp f1 t_Xch_e_Xmixp_Xs1_dum vdd sky130_fd_pr__pfet_01v8_lvt w=2.1 l=0.35
X539 vss t_Xch_e_Xmixp_Xs1_dum vss vss sky130_fd_pr__nfet_01v8_lvt w=0.7 l=0.15
X540 vdd t_Xch_e_Xmixp_Xs1_dum vdd vdd sky130_fd_pr__pfet_01v8 w=3.4 l=0.15
X541 t_Xch_e_cap t_fb2 t_Xch_e_Xmixp_Xs2_sel vss sky130_fd_pr__nfet_01v8_lvt w=0.65 l=0.15
X542 t_Xch_e_cap f2 t_Xch_e_Xmixp_Xs2_sel vdd sky130_fd_pr__pfet_01v8_lvt w=2.1 l=0.35
X543 t_Xch_e_cbp f2 t_Xch_e_Xmixp_Xs2_sel vss sky130_fd_pr__nfet_01v8_lvt w=0.65 l=0.15
X544 t_Xch_e_cbp t_fb2 t_Xch_e_Xmixp_Xs2_sel vdd sky130_fd_pr__pfet_01v8_lvt w=2.1 l=0.35
X545 t_Xch_e_Xmixp_Xs2_drv t_Xch_e_Xmixp_Xs2_sel vss vss sky130_fd_pr__nfet_01v8_lvt w=0.7 l=0.15
X546 t_Xch_e_Xmixp_Xs2_drv t_Xch_e_Xmixp_Xs2_sel vdd vdd sky130_fd_pr__pfet_01v8 w=3.4 l=0.15
X547 t_Xch_e_Xmixp_Xs2_drv t_Xch_e_mixp vss sky130_fd_pr__res_high_po_0p69 l=2.2
X548 t_Xch_e_cap f2 t_Xch_e_Xmixp_Xs2_dum vss sky130_fd_pr__nfet_01v8_lvt w=0.65 l=0.15
X549 t_Xch_e_cap t_fb2 t_Xch_e_Xmixp_Xs2_dum vdd sky130_fd_pr__pfet_01v8_lvt w=2.1 l=0.35
X550 t_Xch_e_cbp t_fb2 t_Xch_e_Xmixp_Xs2_dum vss sky130_fd_pr__nfet_01v8_lvt w=0.65 l=0.15
X551 t_Xch_e_cbp f2 t_Xch_e_Xmixp_Xs2_dum vdd sky130_fd_pr__pfet_01v8_lvt w=2.1 l=0.35
X552 vss t_Xch_e_Xmixp_Xs2_dum vss vss sky130_fd_pr__nfet_01v8_lvt w=0.7 l=0.15
X553 vdd t_Xch_e_Xmixp_Xs2_dum vdd vdd sky130_fd_pr__pfet_01v8 w=3.4 l=0.15
X554 t_Xch_e_cap t_fb3 t_Xch_e_Xmixp_Xs3_sel vss sky130_fd_pr__nfet_01v8_lvt w=0.65 l=0.15
X555 t_Xch_e_cap f3 t_Xch_e_Xmixp_Xs3_sel vdd sky130_fd_pr__pfet_01v8_lvt w=2.1 l=0.35
X556 t_Xch_e_cbp f3 t_Xch_e_Xmixp_Xs3_sel vss sky130_fd_pr__nfet_01v8_lvt w=0.65 l=0.15
X557 t_Xch_e_cbp t_fb3 t_Xch_e_Xmixp_Xs3_sel vdd sky130_fd_pr__pfet_01v8_lvt w=2.1 l=0.35
X558 t_Xch_e_Xmixp_Xs3_drv t_Xch_e_Xmixp_Xs3_sel vss vss sky130_fd_pr__nfet_01v8_lvt w=0.7 l=0.15
X559 t_Xch_e_Xmixp_Xs3_drv t_Xch_e_Xmixp_Xs3_sel vdd vdd sky130_fd_pr__pfet_01v8 w=3.4 l=0.15
X560 t_Xch_e_Xmixp_Xs3_drv t_Xch_e_mixp vss sky130_fd_pr__res_high_po_0p69 l=2.2
X561 t_Xch_e_cap f3 t_Xch_e_Xmixp_Xs3_dum vss sky130_fd_pr__nfet_01v8_lvt w=0.65 l=0.15
X562 t_Xch_e_cap t_fb3 t_Xch_e_Xmixp_Xs3_dum vdd sky130_fd_pr__pfet_01v8_lvt w=2.1 l=0.35
X563 t_Xch_e_cbp t_fb3 t_Xch_e_Xmixp_Xs3_dum vss sky130_fd_pr__nfet_01v8_lvt w=0.65 l=0.15
X564 t_Xch_e_cbp f3 t_Xch_e_Xmixp_Xs3_dum vdd sky130_fd_pr__pfet_01v8_lvt w=2.1 l=0.35
X565 vss t_Xch_e_Xmixp_Xs3_dum vss vss sky130_fd_pr__nfet_01v8_lvt w=0.7 l=0.15
X566 vdd t_Xch_e_Xmixp_Xs3_dum vdd vdd sky130_fd_pr__pfet_01v8 w=3.4 l=0.15
X567 t_Xch_e_cap t_fb4 t_Xch_e_Xmixp_Xs4_sel vss sky130_fd_pr__nfet_01v8_lvt w=0.65 l=0.15
X568 t_Xch_e_cap f4 t_Xch_e_Xmixp_Xs4_sel vdd sky130_fd_pr__pfet_01v8_lvt w=2.1 l=0.35
X569 t_Xch_e_cbp f4 t_Xch_e_Xmixp_Xs4_sel vss sky130_fd_pr__nfet_01v8_lvt w=0.65 l=0.15
X570 t_Xch_e_cbp t_fb4 t_Xch_e_Xmixp_Xs4_sel vdd sky130_fd_pr__pfet_01v8_lvt w=2.1 l=0.35
X571 t_Xch_e_Xmixp_Xs4_drv t_Xch_e_Xmixp_Xs4_sel vss vss sky130_fd_pr__nfet_01v8_lvt w=0.7 l=0.15
X572 t_Xch_e_Xmixp_Xs4_drv t_Xch_e_Xmixp_Xs4_sel vdd vdd sky130_fd_pr__pfet_01v8 w=3.4 l=0.15
X573 t_Xch_e_Xmixp_Xs4_drv t_Xch_e_mixp vss sky130_fd_pr__res_high_po_0p69 l=2.2
X574 t_Xch_e_cap f4 t_Xch_e_Xmixp_Xs4_dum vss sky130_fd_pr__nfet_01v8_lvt w=0.65 l=0.15
X575 t_Xch_e_cap t_fb4 t_Xch_e_Xmixp_Xs4_dum vdd sky130_fd_pr__pfet_01v8_lvt w=2.1 l=0.35
X576 t_Xch_e_cbp t_fb4 t_Xch_e_Xmixp_Xs4_dum vss sky130_fd_pr__nfet_01v8_lvt w=0.65 l=0.15
X577 t_Xch_e_cbp f4 t_Xch_e_Xmixp_Xs4_dum vdd sky130_fd_pr__pfet_01v8_lvt w=2.1 l=0.35
X578 vss t_Xch_e_Xmixp_Xs4_dum vss vss sky130_fd_pr__nfet_01v8_lvt w=0.7 l=0.15
X579 vdd t_Xch_e_Xmixp_Xs4_dum vdd vdd sky130_fd_pr__pfet_01v8 w=3.4 l=0.15
X580 t_Xch_e_cap t_fb5 t_Xch_e_Xmixp_Xs5_sel vss sky130_fd_pr__nfet_01v8_lvt w=0.65 l=0.15
X581 t_Xch_e_cap f5 t_Xch_e_Xmixp_Xs5_sel vdd sky130_fd_pr__pfet_01v8_lvt w=2.1 l=0.35
X582 t_Xch_e_cbp f5 t_Xch_e_Xmixp_Xs5_sel vss sky130_fd_pr__nfet_01v8_lvt w=0.65 l=0.15
X583 t_Xch_e_cbp t_fb5 t_Xch_e_Xmixp_Xs5_sel vdd sky130_fd_pr__pfet_01v8_lvt w=2.1 l=0.35
X584 t_Xch_e_Xmixp_Xs5_drv t_Xch_e_Xmixp_Xs5_sel vss vss sky130_fd_pr__nfet_01v8_lvt w=0.7 l=0.15
X585 t_Xch_e_Xmixp_Xs5_drv t_Xch_e_Xmixp_Xs5_sel vdd vdd sky130_fd_pr__pfet_01v8 w=3.4 l=0.15
X586 t_Xch_e_Xmixp_Xs5_drv t_Xch_e_mixp vss sky130_fd_pr__res_high_po_0p69 l=2.2
X587 t_Xch_e_cap f5 t_Xch_e_Xmixp_Xs5_dum vss sky130_fd_pr__nfet_01v8_lvt w=0.65 l=0.15
X588 t_Xch_e_cap t_fb5 t_Xch_e_Xmixp_Xs5_dum vdd sky130_fd_pr__pfet_01v8_lvt w=2.1 l=0.35
X589 t_Xch_e_cbp t_fb5 t_Xch_e_Xmixp_Xs5_dum vss sky130_fd_pr__nfet_01v8_lvt w=0.65 l=0.15
X590 t_Xch_e_cbp f5 t_Xch_e_Xmixp_Xs5_dum vdd sky130_fd_pr__pfet_01v8_lvt w=2.1 l=0.35
X591 vss t_Xch_e_Xmixp_Xs5_dum vss vss sky130_fd_pr__nfet_01v8_lvt w=0.7 l=0.15
X592 vdd t_Xch_e_Xmixp_Xs5_dum vdd vdd sky130_fd_pr__pfet_01v8 w=3.4 l=0.15
X593 t_Xch_e_cap t_fb6 t_Xch_e_Xmixp_Xs6_sel vss sky130_fd_pr__nfet_01v8_lvt w=0.65 l=0.15
X594 t_Xch_e_cap f6 t_Xch_e_Xmixp_Xs6_sel vdd sky130_fd_pr__pfet_01v8_lvt w=2.1 l=0.35
X595 t_Xch_e_cbp f6 t_Xch_e_Xmixp_Xs6_sel vss sky130_fd_pr__nfet_01v8_lvt w=0.65 l=0.15
X596 t_Xch_e_cbp t_fb6 t_Xch_e_Xmixp_Xs6_sel vdd sky130_fd_pr__pfet_01v8_lvt w=2.1 l=0.35
X597 t_Xch_e_Xmixp_Xs6_drv t_Xch_e_Xmixp_Xs6_sel vss vss sky130_fd_pr__nfet_01v8_lvt w=0.7 l=0.15
X598 t_Xch_e_Xmixp_Xs6_drv t_Xch_e_Xmixp_Xs6_sel vdd vdd sky130_fd_pr__pfet_01v8 w=3.4 l=0.15
X599 t_Xch_e_Xmixp_Xs6_drv t_Xch_e_mixp vss sky130_fd_pr__res_high_po_0p69 l=2.2
X600 t_Xch_e_cap f6 t_Xch_e_Xmixp_Xs6_dum vss sky130_fd_pr__nfet_01v8_lvt w=0.65 l=0.15
X601 t_Xch_e_cap t_fb6 t_Xch_e_Xmixp_Xs6_dum vdd sky130_fd_pr__pfet_01v8_lvt w=2.1 l=0.35
X602 t_Xch_e_cbp t_fb6 t_Xch_e_Xmixp_Xs6_dum vss sky130_fd_pr__nfet_01v8_lvt w=0.65 l=0.15
X603 t_Xch_e_cbp f6 t_Xch_e_Xmixp_Xs6_dum vdd sky130_fd_pr__pfet_01v8_lvt w=2.1 l=0.35
X604 vss t_Xch_e_Xmixp_Xs6_dum vss vss sky130_fd_pr__nfet_01v8_lvt w=0.7 l=0.15
X605 vdd t_Xch_e_Xmixp_Xs6_dum vdd vdd sky130_fd_pr__pfet_01v8 w=3.4 l=0.15
X606 t_Xch_e_cap t_fb7 t_Xch_e_Xmixp_Xs7_sel vss sky130_fd_pr__nfet_01v8_lvt w=0.65 l=0.15
X607 t_Xch_e_cap f7 t_Xch_e_Xmixp_Xs7_sel vdd sky130_fd_pr__pfet_01v8_lvt w=2.1 l=0.35
X608 t_Xch_e_cbp f7 t_Xch_e_Xmixp_Xs7_sel vss sky130_fd_pr__nfet_01v8_lvt w=0.65 l=0.15
X609 t_Xch_e_cbp t_fb7 t_Xch_e_Xmixp_Xs7_sel vdd sky130_fd_pr__pfet_01v8_lvt w=2.1 l=0.35
X610 t_Xch_e_Xmixp_Xs7_drv t_Xch_e_Xmixp_Xs7_sel vss vss sky130_fd_pr__nfet_01v8_lvt w=0.7 l=0.15
X611 t_Xch_e_Xmixp_Xs7_drv t_Xch_e_Xmixp_Xs7_sel vdd vdd sky130_fd_pr__pfet_01v8 w=3.4 l=0.15
X612 t_Xch_e_Xmixp_Xs7_drv t_Xch_e_mixp vss sky130_fd_pr__res_high_po_0p69 l=2.2
X613 t_Xch_e_cap f7 t_Xch_e_Xmixp_Xs7_dum vss sky130_fd_pr__nfet_01v8_lvt w=0.65 l=0.15
X614 t_Xch_e_cap t_fb7 t_Xch_e_Xmixp_Xs7_dum vdd sky130_fd_pr__pfet_01v8_lvt w=2.1 l=0.35
X615 t_Xch_e_cbp t_fb7 t_Xch_e_Xmixp_Xs7_dum vss sky130_fd_pr__nfet_01v8_lvt w=0.65 l=0.15
X616 t_Xch_e_cbp f7 t_Xch_e_Xmixp_Xs7_dum vdd sky130_fd_pr__pfet_01v8_lvt w=2.1 l=0.35
X617 vss t_Xch_e_Xmixp_Xs7_dum vss vss sky130_fd_pr__nfet_01v8_lvt w=0.7 l=0.15
X618 vdd t_Xch_e_Xmixp_Xs7_dum vdd vdd sky130_fd_pr__pfet_01v8 w=3.4 l=0.15
X619 t_Xch_e_mixp vss sky130_fd_pr__cap_mim_m3_1 w=1.6 l=1.6
X620 t_Xch_e_can t_fb0 t_Xch_e_Xmixn_Xs0_sel vss sky130_fd_pr__nfet_01v8_lvt w=0.65 l=0.15
X621 t_Xch_e_can f0 t_Xch_e_Xmixn_Xs0_sel vdd sky130_fd_pr__pfet_01v8_lvt w=2.1 l=0.35
X622 t_Xch_e_cbn f0 t_Xch_e_Xmixn_Xs0_sel vss sky130_fd_pr__nfet_01v8_lvt w=0.65 l=0.15
X623 t_Xch_e_cbn t_fb0 t_Xch_e_Xmixn_Xs0_sel vdd sky130_fd_pr__pfet_01v8_lvt w=2.1 l=0.35
X624 t_Xch_e_Xmixn_Xs0_drv t_Xch_e_Xmixn_Xs0_sel vss vss sky130_fd_pr__nfet_01v8_lvt w=0.7 l=0.15
X625 t_Xch_e_Xmixn_Xs0_drv t_Xch_e_Xmixn_Xs0_sel vdd vdd sky130_fd_pr__pfet_01v8 w=3.4 l=0.15
X626 t_Xch_e_Xmixn_Xs0_drv t_Xch_e_mixn vss sky130_fd_pr__res_high_po_0p69 l=2.2
X627 t_Xch_e_can f0 t_Xch_e_Xmixn_Xs0_dum vss sky130_fd_pr__nfet_01v8_lvt w=0.65 l=0.15
X628 t_Xch_e_can t_fb0 t_Xch_e_Xmixn_Xs0_dum vdd sky130_fd_pr__pfet_01v8_lvt w=2.1 l=0.35
X629 t_Xch_e_cbn t_fb0 t_Xch_e_Xmixn_Xs0_dum vss sky130_fd_pr__nfet_01v8_lvt w=0.65 l=0.15
X630 t_Xch_e_cbn f0 t_Xch_e_Xmixn_Xs0_dum vdd sky130_fd_pr__pfet_01v8_lvt w=2.1 l=0.35
X631 vss t_Xch_e_Xmixn_Xs0_dum vss vss sky130_fd_pr__nfet_01v8_lvt w=0.7 l=0.15
X632 vdd t_Xch_e_Xmixn_Xs0_dum vdd vdd sky130_fd_pr__pfet_01v8 w=3.4 l=0.15
X633 t_Xch_e_can t_fb1 t_Xch_e_Xmixn_Xs1_sel vss sky130_fd_pr__nfet_01v8_lvt w=0.65 l=0.15
X634 t_Xch_e_can f1 t_Xch_e_Xmixn_Xs1_sel vdd sky130_fd_pr__pfet_01v8_lvt w=2.1 l=0.35
X635 t_Xch_e_cbn f1 t_Xch_e_Xmixn_Xs1_sel vss sky130_fd_pr__nfet_01v8_lvt w=0.65 l=0.15
X636 t_Xch_e_cbn t_fb1 t_Xch_e_Xmixn_Xs1_sel vdd sky130_fd_pr__pfet_01v8_lvt w=2.1 l=0.35
X637 t_Xch_e_Xmixn_Xs1_drv t_Xch_e_Xmixn_Xs1_sel vss vss sky130_fd_pr__nfet_01v8_lvt w=0.7 l=0.15
X638 t_Xch_e_Xmixn_Xs1_drv t_Xch_e_Xmixn_Xs1_sel vdd vdd sky130_fd_pr__pfet_01v8 w=3.4 l=0.15
X639 t_Xch_e_Xmixn_Xs1_drv t_Xch_e_mixn vss sky130_fd_pr__res_high_po_0p69 l=2.2
X640 t_Xch_e_can f1 t_Xch_e_Xmixn_Xs1_dum vss sky130_fd_pr__nfet_01v8_lvt w=0.65 l=0.15
X641 t_Xch_e_can t_fb1 t_Xch_e_Xmixn_Xs1_dum vdd sky130_fd_pr__pfet_01v8_lvt w=2.1 l=0.35
X642 t_Xch_e_cbn t_fb1 t_Xch_e_Xmixn_Xs1_dum vss sky130_fd_pr__nfet_01v8_lvt w=0.65 l=0.15
X643 t_Xch_e_cbn f1 t_Xch_e_Xmixn_Xs1_dum vdd sky130_fd_pr__pfet_01v8_lvt w=2.1 l=0.35
X644 vss t_Xch_e_Xmixn_Xs1_dum vss vss sky130_fd_pr__nfet_01v8_lvt w=0.7 l=0.15
X645 vdd t_Xch_e_Xmixn_Xs1_dum vdd vdd sky130_fd_pr__pfet_01v8 w=3.4 l=0.15
X646 t_Xch_e_can t_fb2 t_Xch_e_Xmixn_Xs2_sel vss sky130_fd_pr__nfet_01v8_lvt w=0.65 l=0.15
X647 t_Xch_e_can f2 t_Xch_e_Xmixn_Xs2_sel vdd sky130_fd_pr__pfet_01v8_lvt w=2.1 l=0.35
X648 t_Xch_e_cbn f2 t_Xch_e_Xmixn_Xs2_sel vss sky130_fd_pr__nfet_01v8_lvt w=0.65 l=0.15
X649 t_Xch_e_cbn t_fb2 t_Xch_e_Xmixn_Xs2_sel vdd sky130_fd_pr__pfet_01v8_lvt w=2.1 l=0.35
X650 t_Xch_e_Xmixn_Xs2_drv t_Xch_e_Xmixn_Xs2_sel vss vss sky130_fd_pr__nfet_01v8_lvt w=0.7 l=0.15
X651 t_Xch_e_Xmixn_Xs2_drv t_Xch_e_Xmixn_Xs2_sel vdd vdd sky130_fd_pr__pfet_01v8 w=3.4 l=0.15
X652 t_Xch_e_Xmixn_Xs2_drv t_Xch_e_mixn vss sky130_fd_pr__res_high_po_0p69 l=2.2
X653 t_Xch_e_can f2 t_Xch_e_Xmixn_Xs2_dum vss sky130_fd_pr__nfet_01v8_lvt w=0.65 l=0.15
X654 t_Xch_e_can t_fb2 t_Xch_e_Xmixn_Xs2_dum vdd sky130_fd_pr__pfet_01v8_lvt w=2.1 l=0.35
X655 t_Xch_e_cbn t_fb2 t_Xch_e_Xmixn_Xs2_dum vss sky130_fd_pr__nfet_01v8_lvt w=0.65 l=0.15
X656 t_Xch_e_cbn f2 t_Xch_e_Xmixn_Xs2_dum vdd sky130_fd_pr__pfet_01v8_lvt w=2.1 l=0.35
X657 vss t_Xch_e_Xmixn_Xs2_dum vss vss sky130_fd_pr__nfet_01v8_lvt w=0.7 l=0.15
X658 vdd t_Xch_e_Xmixn_Xs2_dum vdd vdd sky130_fd_pr__pfet_01v8 w=3.4 l=0.15
X659 t_Xch_e_can t_fb3 t_Xch_e_Xmixn_Xs3_sel vss sky130_fd_pr__nfet_01v8_lvt w=0.65 l=0.15
X660 t_Xch_e_can f3 t_Xch_e_Xmixn_Xs3_sel vdd sky130_fd_pr__pfet_01v8_lvt w=2.1 l=0.35
X661 t_Xch_e_cbn f3 t_Xch_e_Xmixn_Xs3_sel vss sky130_fd_pr__nfet_01v8_lvt w=0.65 l=0.15
X662 t_Xch_e_cbn t_fb3 t_Xch_e_Xmixn_Xs3_sel vdd sky130_fd_pr__pfet_01v8_lvt w=2.1 l=0.35
X663 t_Xch_e_Xmixn_Xs3_drv t_Xch_e_Xmixn_Xs3_sel vss vss sky130_fd_pr__nfet_01v8_lvt w=0.7 l=0.15
X664 t_Xch_e_Xmixn_Xs3_drv t_Xch_e_Xmixn_Xs3_sel vdd vdd sky130_fd_pr__pfet_01v8 w=3.4 l=0.15
X665 t_Xch_e_Xmixn_Xs3_drv t_Xch_e_mixn vss sky130_fd_pr__res_high_po_0p69 l=2.2
X666 t_Xch_e_can f3 t_Xch_e_Xmixn_Xs3_dum vss sky130_fd_pr__nfet_01v8_lvt w=0.65 l=0.15
X667 t_Xch_e_can t_fb3 t_Xch_e_Xmixn_Xs3_dum vdd sky130_fd_pr__pfet_01v8_lvt w=2.1 l=0.35
X668 t_Xch_e_cbn t_fb3 t_Xch_e_Xmixn_Xs3_dum vss sky130_fd_pr__nfet_01v8_lvt w=0.65 l=0.15
X669 t_Xch_e_cbn f3 t_Xch_e_Xmixn_Xs3_dum vdd sky130_fd_pr__pfet_01v8_lvt w=2.1 l=0.35
X670 vss t_Xch_e_Xmixn_Xs3_dum vss vss sky130_fd_pr__nfet_01v8_lvt w=0.7 l=0.15
X671 vdd t_Xch_e_Xmixn_Xs3_dum vdd vdd sky130_fd_pr__pfet_01v8 w=3.4 l=0.15
X672 t_Xch_e_can t_fb4 t_Xch_e_Xmixn_Xs4_sel vss sky130_fd_pr__nfet_01v8_lvt w=0.65 l=0.15
X673 t_Xch_e_can f4 t_Xch_e_Xmixn_Xs4_sel vdd sky130_fd_pr__pfet_01v8_lvt w=2.1 l=0.35
X674 t_Xch_e_cbn f4 t_Xch_e_Xmixn_Xs4_sel vss sky130_fd_pr__nfet_01v8_lvt w=0.65 l=0.15
X675 t_Xch_e_cbn t_fb4 t_Xch_e_Xmixn_Xs4_sel vdd sky130_fd_pr__pfet_01v8_lvt w=2.1 l=0.35
X676 t_Xch_e_Xmixn_Xs4_drv t_Xch_e_Xmixn_Xs4_sel vss vss sky130_fd_pr__nfet_01v8_lvt w=0.7 l=0.15
X677 t_Xch_e_Xmixn_Xs4_drv t_Xch_e_Xmixn_Xs4_sel vdd vdd sky130_fd_pr__pfet_01v8 w=3.4 l=0.15
X678 t_Xch_e_Xmixn_Xs4_drv t_Xch_e_mixn vss sky130_fd_pr__res_high_po_0p69 l=2.2
X679 t_Xch_e_can f4 t_Xch_e_Xmixn_Xs4_dum vss sky130_fd_pr__nfet_01v8_lvt w=0.65 l=0.15
X680 t_Xch_e_can t_fb4 t_Xch_e_Xmixn_Xs4_dum vdd sky130_fd_pr__pfet_01v8_lvt w=2.1 l=0.35
X681 t_Xch_e_cbn t_fb4 t_Xch_e_Xmixn_Xs4_dum vss sky130_fd_pr__nfet_01v8_lvt w=0.65 l=0.15
X682 t_Xch_e_cbn f4 t_Xch_e_Xmixn_Xs4_dum vdd sky130_fd_pr__pfet_01v8_lvt w=2.1 l=0.35
X683 vss t_Xch_e_Xmixn_Xs4_dum vss vss sky130_fd_pr__nfet_01v8_lvt w=0.7 l=0.15
X684 vdd t_Xch_e_Xmixn_Xs4_dum vdd vdd sky130_fd_pr__pfet_01v8 w=3.4 l=0.15
X685 t_Xch_e_can t_fb5 t_Xch_e_Xmixn_Xs5_sel vss sky130_fd_pr__nfet_01v8_lvt w=0.65 l=0.15
X686 t_Xch_e_can f5 t_Xch_e_Xmixn_Xs5_sel vdd sky130_fd_pr__pfet_01v8_lvt w=2.1 l=0.35
X687 t_Xch_e_cbn f5 t_Xch_e_Xmixn_Xs5_sel vss sky130_fd_pr__nfet_01v8_lvt w=0.65 l=0.15
X688 t_Xch_e_cbn t_fb5 t_Xch_e_Xmixn_Xs5_sel vdd sky130_fd_pr__pfet_01v8_lvt w=2.1 l=0.35
X689 t_Xch_e_Xmixn_Xs5_drv t_Xch_e_Xmixn_Xs5_sel vss vss sky130_fd_pr__nfet_01v8_lvt w=0.7 l=0.15
X690 t_Xch_e_Xmixn_Xs5_drv t_Xch_e_Xmixn_Xs5_sel vdd vdd sky130_fd_pr__pfet_01v8 w=3.4 l=0.15
X691 t_Xch_e_Xmixn_Xs5_drv t_Xch_e_mixn vss sky130_fd_pr__res_high_po_0p69 l=2.2
X692 t_Xch_e_can f5 t_Xch_e_Xmixn_Xs5_dum vss sky130_fd_pr__nfet_01v8_lvt w=0.65 l=0.15
X693 t_Xch_e_can t_fb5 t_Xch_e_Xmixn_Xs5_dum vdd sky130_fd_pr__pfet_01v8_lvt w=2.1 l=0.35
X694 t_Xch_e_cbn t_fb5 t_Xch_e_Xmixn_Xs5_dum vss sky130_fd_pr__nfet_01v8_lvt w=0.65 l=0.15
X695 t_Xch_e_cbn f5 t_Xch_e_Xmixn_Xs5_dum vdd sky130_fd_pr__pfet_01v8_lvt w=2.1 l=0.35
X696 vss t_Xch_e_Xmixn_Xs5_dum vss vss sky130_fd_pr__nfet_01v8_lvt w=0.7 l=0.15
X697 vdd t_Xch_e_Xmixn_Xs5_dum vdd vdd sky130_fd_pr__pfet_01v8 w=3.4 l=0.15
X698 t_Xch_e_can t_fb6 t_Xch_e_Xmixn_Xs6_sel vss sky130_fd_pr__nfet_01v8_lvt w=0.65 l=0.15
X699 t_Xch_e_can f6 t_Xch_e_Xmixn_Xs6_sel vdd sky130_fd_pr__pfet_01v8_lvt w=2.1 l=0.35
X700 t_Xch_e_cbn f6 t_Xch_e_Xmixn_Xs6_sel vss sky130_fd_pr__nfet_01v8_lvt w=0.65 l=0.15
X701 t_Xch_e_cbn t_fb6 t_Xch_e_Xmixn_Xs6_sel vdd sky130_fd_pr__pfet_01v8_lvt w=2.1 l=0.35
X702 t_Xch_e_Xmixn_Xs6_drv t_Xch_e_Xmixn_Xs6_sel vss vss sky130_fd_pr__nfet_01v8_lvt w=0.7 l=0.15
X703 t_Xch_e_Xmixn_Xs6_drv t_Xch_e_Xmixn_Xs6_sel vdd vdd sky130_fd_pr__pfet_01v8 w=3.4 l=0.15
X704 t_Xch_e_Xmixn_Xs6_drv t_Xch_e_mixn vss sky130_fd_pr__res_high_po_0p69 l=2.2
X705 t_Xch_e_can f6 t_Xch_e_Xmixn_Xs6_dum vss sky130_fd_pr__nfet_01v8_lvt w=0.65 l=0.15
X706 t_Xch_e_can t_fb6 t_Xch_e_Xmixn_Xs6_dum vdd sky130_fd_pr__pfet_01v8_lvt w=2.1 l=0.35
X707 t_Xch_e_cbn t_fb6 t_Xch_e_Xmixn_Xs6_dum vss sky130_fd_pr__nfet_01v8_lvt w=0.65 l=0.15
X708 t_Xch_e_cbn f6 t_Xch_e_Xmixn_Xs6_dum vdd sky130_fd_pr__pfet_01v8_lvt w=2.1 l=0.35
X709 vss t_Xch_e_Xmixn_Xs6_dum vss vss sky130_fd_pr__nfet_01v8_lvt w=0.7 l=0.15
X710 vdd t_Xch_e_Xmixn_Xs6_dum vdd vdd sky130_fd_pr__pfet_01v8 w=3.4 l=0.15
X711 t_Xch_e_can t_fb7 t_Xch_e_Xmixn_Xs7_sel vss sky130_fd_pr__nfet_01v8_lvt w=0.65 l=0.15
X712 t_Xch_e_can f7 t_Xch_e_Xmixn_Xs7_sel vdd sky130_fd_pr__pfet_01v8_lvt w=2.1 l=0.35
X713 t_Xch_e_cbn f7 t_Xch_e_Xmixn_Xs7_sel vss sky130_fd_pr__nfet_01v8_lvt w=0.65 l=0.15
X714 t_Xch_e_cbn t_fb7 t_Xch_e_Xmixn_Xs7_sel vdd sky130_fd_pr__pfet_01v8_lvt w=2.1 l=0.35
X715 t_Xch_e_Xmixn_Xs7_drv t_Xch_e_Xmixn_Xs7_sel vss vss sky130_fd_pr__nfet_01v8_lvt w=0.7 l=0.15
X716 t_Xch_e_Xmixn_Xs7_drv t_Xch_e_Xmixn_Xs7_sel vdd vdd sky130_fd_pr__pfet_01v8 w=3.4 l=0.15
X717 t_Xch_e_Xmixn_Xs7_drv t_Xch_e_mixn vss sky130_fd_pr__res_high_po_0p69 l=2.2
X718 t_Xch_e_can f7 t_Xch_e_Xmixn_Xs7_dum vss sky130_fd_pr__nfet_01v8_lvt w=0.65 l=0.15
X719 t_Xch_e_can t_fb7 t_Xch_e_Xmixn_Xs7_dum vdd sky130_fd_pr__pfet_01v8_lvt w=2.1 l=0.35
X720 t_Xch_e_cbn t_fb7 t_Xch_e_Xmixn_Xs7_dum vss sky130_fd_pr__nfet_01v8_lvt w=0.65 l=0.15
X721 t_Xch_e_cbn f7 t_Xch_e_Xmixn_Xs7_dum vdd sky130_fd_pr__pfet_01v8_lvt w=2.1 l=0.35
X722 vss t_Xch_e_Xmixn_Xs7_dum vss vss sky130_fd_pr__nfet_01v8_lvt w=0.7 l=0.15
X723 vdd t_Xch_e_Xmixn_Xs7_dum vdd vdd sky130_fd_pr__pfet_01v8 w=3.4 l=0.15
X724 t_Xch_e_mixn vss sky130_fd_pr__cap_mim_m3_1 w=1.6 l=1.6
X725 t_Xch_e_Xrec_ac1p t_Xch_e_mixp sky130_fd_pr__cap_mim_m3_1 w=4.8 l=4.8
X726 t_Xch_e_Xrec_ac1n t_Xch_e_mixn sky130_fd_pr__cap_mim_m3_1 w=4.8 l=4.8
X727 t_Xch_e_Xrec_ac1p t_Xch_e_Xrec_r1n vss sky130_fd_pr__res_high_po_0p35 l=6.5
X728 t_Xch_e_Xrec_ac1n t_Xch_e_Xrec_r1p vss sky130_fd_pr__res_high_po_0p35 l=6.5
X729 t_Xch_e_Xrec_r1n t_Xch_e_Xrec_ac1p t_Xch_e_Xrec_tail1 vss sky130_fd_pr__nfet_01v8_lvt w=7.2 l=0.15
X730 t_Xch_e_Xrec_r1p t_Xch_e_Xrec_ac1n t_Xch_e_Xrec_tail1 vss sky130_fd_pr__nfet_01v8_lvt w=7.2 l=0.15
X731 t_Xch_e_Xrec_tail1 vdd vss vss sky130_fd_pr__nfet_01v8 w=4.6 l=0.2
X732 t_Xch_e_Xrec_r1n vss vdd vdd sky130_fd_pr__pfet_01v8 w=3.8 l=0.15
X733 t_Xch_e_Xrec_r1p vss vdd vdd sky130_fd_pr__pfet_01v8 w=3.8 l=0.15
X734 t_Xch_e_Xrec_r1n t_Xch_e_Xrec_r1p vdd vdd sky130_fd_pr__pfet_01v8 w=2.88 l=0.15
X735 t_Xch_e_Xrec_r1p t_Xch_e_Xrec_r1n vdd vdd sky130_fd_pr__pfet_01v8 w=2.88 l=0.15
X736 t_Xch_e_Xrec_r2n t_Xch_e_Xrec_r1p t_Xch_e_Xrec_tail2 vss sky130_fd_pr__nfet_01v8_lvt w=12 l=0.15
X737 t_Xch_e_Xrec_r2p t_Xch_e_Xrec_r1n t_Xch_e_Xrec_tail2 vss sky130_fd_pr__nfet_01v8_lvt w=12 l=0.15
X738 t_Xch_e_Xrec_tail2 vdd vss vss sky130_fd_pr__nfet_01v8 w=9.8 l=0.2
X739 t_Xch_e_Xrec_r2n vss vdd vdd sky130_fd_pr__pfet_01v8 w=6.3 l=0.15
X740 t_Xch_e_Xrec_r2p vss vdd vdd sky130_fd_pr__pfet_01v8 w=6.3 l=0.15
X741 t_Xch_e_Xrec_r2n t_Xch_e_Xrec_r2p vdd vdd sky130_fd_pr__pfet_01v8 w=5.04 l=0.15
X742 t_Xch_e_Xrec_r2p t_Xch_e_Xrec_r2n vdd vdd sky130_fd_pr__pfet_01v8 w=5.04 l=0.15
X743 ep t_Xch_e_Xrec_r2n vss vss sky130_fd_pr__nfet_01v8_lvt w=4.2 l=0.15
X744 ep t_Xch_e_Xrec_r2n vdd vdd sky130_fd_pr__pfet_01v8 w=18 l=0.15
X745 ep t_Xch_e_Xrec_r2n vdd vdd sky130_fd_pr__pfet_01v8_lvt w=5.6 l=0.35
X746 en t_Xch_e_Xrec_r2p vss vss sky130_fd_pr__nfet_01v8_lvt w=4.2 l=0.15
X747 en t_Xch_e_Xrec_r2p vdd vdd sky130_fd_pr__pfet_01v8 w=18 l=0.15
X748 en t_Xch_e_Xrec_r2p vdd vdd sky130_fd_pr__pfet_01v8_lvt w=5.6 l=0.35
X749 en ep vss vss sky130_fd_pr__nfet_01v8_lvt w=0.9 l=0.15
X750 en ep vdd vdd sky130_fd_pr__pfet_01v8 w=3.8 l=0.15
X751 ep en vss vss sky130_fd_pr__nfet_01v8_lvt w=0.9 l=0.15
X752 ep en vdd vdd sky130_fd_pr__pfet_01v8 w=3.8 l=0.15
X753 t_Xdiv_rst rst_n vss vss sky130_fd_pr__nfet_01v8_lvt w=2 l=0.15
X754 t_Xdiv_rst rst_n vdd vdd sky130_fd_pr__pfet_01v8_lvt w=6 l=0.35
X755 t_Xdiv_rst_n_lat t_Xdiv_rst vss vss sky130_fd_pr__nfet_01v8 w=0.65 l=0.35
X756 t_Xdiv_rst_n_lat t_Xdiv_rst vdd vdd sky130_fd_pr__pfet_01v8_lvt w=1.6 l=0.35
X757 t_Xdiv_rst_lat t_Xdiv_rst_n_lat vss vss sky130_fd_pr__nfet_01v8_lvt w=2.2 l=0.15
X758 t_Xdiv_rst_lat t_Xdiv_rst_n_lat vdd vdd sky130_fd_pr__pfet_01v8_lvt w=5.4 l=0.35
X759 t_Xdiv_Xlock_v_lpf t_Xdiv_d2 t_Xdiv_Xlock_sp1 vdd sky130_fd_pr__pfet_01v8_lvt w=2.2 l=0.35
X760 t_Xdiv_Xlock_sp1 t_Xdiv_e0 vdd vdd sky130_fd_pr__pfet_01v8_lvt w=2.2 l=0.35
X761 t_Xdiv_Xlock_v_lpf t_Xdiv_d0 t_Xdiv_Xlock_sp2 vdd sky130_fd_pr__pfet_01v8_lvt w=2.2 l=0.35
X762 t_Xdiv_Xlock_sp2 t_Xdiv_e2 vdd vdd sky130_fd_pr__pfet_01v8_lvt w=2.2 l=0.35
X763 t_Xdiv_Xlock_v_lpf t_Xdiv_d2 t_Xdiv_Xlock_sn1 vss sky130_fd_pr__nfet_01v8 w=0.85 l=0.35
X764 t_Xdiv_Xlock_sn1 t_Xdiv_e2 vss vss sky130_fd_pr__nfet_01v8 w=0.85 l=0.35
X765 t_Xdiv_Xlock_v_lpf t_Xdiv_d0 t_Xdiv_Xlock_sn2 vss sky130_fd_pr__nfet_01v8 w=0.85 l=0.35
X766 t_Xdiv_Xlock_sn2 t_Xdiv_e0 vss vss sky130_fd_pr__nfet_01v8 w=0.85 l=0.35
X767 t_Xdiv_Xlock_v_lpf t_Xdiv_rst_lat vss vss sky130_fd_pr__nfet_01v8 w=1 l=0.18
X768 vss t_Xdiv_Xlock_v_lpf vss vss sky130_fd_pr__nfet_01v8 w=0.95 l=0.95
X769 t_Xdiv_inj_en t_Xdiv_Xlock_v_lpf vss vss sky130_fd_pr__nfet_01v8 w=2.8 l=0.18
X770 t_Xdiv_inj_en t_Xdiv_Xlock_v_lpf vdd vdd sky130_fd_pr__pfet_01v8_lvt w=2 l=0.35
X771 dp rst_n t_Xdiv_Xg_dpb_ck_g vss sky130_fd_pr__nfet_01v8_lvt w=2.6 l=0.15
X772 dp t_Xdiv_rst t_Xdiv_Xg_dpb_ck_g vdd sky130_fd_pr__pfet_01v8_lvt w=6.8 l=0.35
X773 t_Xdiv_Xg_dpb_ck_g t_Xdiv_rst vss vss sky130_fd_pr__nfet_01v8 w=0.8 l=0.18
X774 t_Xdiv_dp_ckb t_Xdiv_Xg_dpb_ck_g vss vss sky130_fd_pr__nfet_01v8_lvt w=2.5 l=0.15
X775 t_Xdiv_dp_ckb t_Xdiv_Xg_dpb_ck_g vdd vdd sky130_fd_pr__pfet_01v8 w=7 l=0.15
X776 t_Xdiv_dp_ckb t_Xdiv_Xg_dpb_ck_g vdd vdd sky130_fd_pr__pfet_01v8_lvt w=3.5 l=0.35
X777 dn rst_n t_Xdiv_Xg_dnb_ck_g vss sky130_fd_pr__nfet_01v8_lvt w=2.6 l=0.15
X778 dn t_Xdiv_rst t_Xdiv_Xg_dnb_ck_g vdd sky130_fd_pr__pfet_01v8_lvt w=6.8 l=0.35
X779 t_Xdiv_Xg_dnb_ck_g rst_n vdd vdd sky130_fd_pr__pfet_01v8 w=1.6 l=0.18
X780 t_Xdiv_dn_ckb t_Xdiv_Xg_dnb_ck_g vss vss sky130_fd_pr__nfet_01v8_lvt w=2.5 l=0.15
X781 t_Xdiv_dn_ckb t_Xdiv_Xg_dnb_ck_g vdd vdd sky130_fd_pr__pfet_01v8 w=7 l=0.15
X782 t_Xdiv_dn_ckb t_Xdiv_Xg_dnb_ck_g vdd vdd sky130_fd_pr__pfet_01v8_lvt w=3.5 l=0.35
X783 ep rst_n t_Xdiv_Xg_epb_ck_g vss sky130_fd_pr__nfet_01v8_lvt w=2.6 l=0.15
X784 ep t_Xdiv_rst t_Xdiv_Xg_epb_ck_g vdd sky130_fd_pr__pfet_01v8_lvt w=6.8 l=0.35
X785 t_Xdiv_Xg_epb_ck_g t_Xdiv_rst vss vss sky130_fd_pr__nfet_01v8 w=0.8 l=0.18
X786 t_Xdiv_ep_ckb t_Xdiv_Xg_epb_ck_g vss vss sky130_fd_pr__nfet_01v8_lvt w=2.5 l=0.15
X787 t_Xdiv_ep_ckb t_Xdiv_Xg_epb_ck_g vdd vdd sky130_fd_pr__pfet_01v8 w=7 l=0.15
X788 t_Xdiv_ep_ckb t_Xdiv_Xg_epb_ck_g vdd vdd sky130_fd_pr__pfet_01v8_lvt w=3.5 l=0.35
X789 en rst_n t_Xdiv_Xg_enb_ck_g vss sky130_fd_pr__nfet_01v8_lvt w=2.6 l=0.15
X790 en t_Xdiv_rst t_Xdiv_Xg_enb_ck_g vdd sky130_fd_pr__pfet_01v8_lvt w=6.8 l=0.35
X791 t_Xdiv_Xg_enb_ck_g rst_n vdd vdd sky130_fd_pr__pfet_01v8 w=1.6 l=0.18
X792 t_Xdiv_en_ckb t_Xdiv_Xg_enb_ck_g vss vss sky130_fd_pr__nfet_01v8_lvt w=2.5 l=0.15
X793 t_Xdiv_en_ckb t_Xdiv_Xg_enb_ck_g vdd vdd sky130_fd_pr__pfet_01v8 w=7 l=0.15
X794 t_Xdiv_en_ckb t_Xdiv_Xg_enb_ck_g vdd vdd sky130_fd_pr__pfet_01v8_lvt w=3.5 l=0.35
X795 t_Xdiv_dp_ck t_Xdiv_dp_ckb vss vss sky130_fd_pr__nfet_01v8_lvt w=3.5 l=0.15
X796 t_Xdiv_dp_ck t_Xdiv_dp_ckb vdd vdd sky130_fd_pr__pfet_01v8 w=14 l=0.15
X797 t_Xdiv_dp_ck t_Xdiv_dp_ckb vdd vdd sky130_fd_pr__pfet_01v8_lvt w=3.5 l=0.35
X798 t_Xdiv_dn_ck t_Xdiv_dn_ckb vss vss sky130_fd_pr__nfet_01v8_lvt w=3.5 l=0.15
X799 t_Xdiv_dn_ck t_Xdiv_dn_ckb vdd vdd sky130_fd_pr__pfet_01v8 w=14 l=0.15
X800 t_Xdiv_dn_ck t_Xdiv_dn_ckb vdd vdd sky130_fd_pr__pfet_01v8_lvt w=3.5 l=0.35
X801 t_Xdiv_ep_ck t_Xdiv_ep_ckb vss vss sky130_fd_pr__nfet_01v8_lvt w=3.5 l=0.15
X802 t_Xdiv_ep_ck t_Xdiv_ep_ckb vdd vdd sky130_fd_pr__pfet_01v8 w=14 l=0.15
X803 t_Xdiv_ep_ck t_Xdiv_ep_ckb vdd vdd sky130_fd_pr__pfet_01v8_lvt w=3.5 l=0.35
X804 t_Xdiv_en_ck t_Xdiv_en_ckb vss vss sky130_fd_pr__nfet_01v8_lvt w=3.5 l=0.15
X805 t_Xdiv_en_ck t_Xdiv_en_ckb vdd vdd sky130_fd_pr__pfet_01v8 w=14 l=0.15
X806 t_Xdiv_en_ck t_Xdiv_en_ckb vdd vdd sky130_fd_pr__pfet_01v8_lvt w=3.5 l=0.35
X807 t_Xdiv_dn_ck t_Xdiv_dp_ck vss vss sky130_fd_pr__nfet_01v8_lvt w=0.45 l=0.15
X808 t_Xdiv_dn_ck t_Xdiv_dp_ck vdd vdd sky130_fd_pr__pfet_01v8_lvt w=2.3 l=0.35
X809 t_Xdiv_dp_ck t_Xdiv_dn_ck vss vss sky130_fd_pr__nfet_01v8_lvt w=0.45 l=0.15
X810 t_Xdiv_dp_ck t_Xdiv_dn_ck vdd vdd sky130_fd_pr__pfet_01v8_lvt w=2.3 l=0.35
X811 t_Xdiv_en_ck t_Xdiv_ep_ck vss vss sky130_fd_pr__nfet_01v8_lvt w=0.45 l=0.15
X812 t_Xdiv_en_ck t_Xdiv_ep_ck vdd vdd sky130_fd_pr__pfet_01v8_lvt w=2.3 l=0.35
X813 t_Xdiv_ep_ck t_Xdiv_en_ck vss vss sky130_fd_pr__nfet_01v8_lvt w=0.45 l=0.15
X814 t_Xdiv_ep_ck t_Xdiv_en_ck vdd vdd sky130_fd_pr__pfet_01v8_lvt w=2.3 l=0.35
X815 t_Xdiv_d3 t_Xdiv_dp_ck t_Xdiv_Xld0_int_p vss sky130_fd_pr__nfet_01v8_lvt w=2.9 l=0.15
X816 t_Xdiv_d3 t_Xdiv_dn_ck t_Xdiv_Xld0_int_p vdd sky130_fd_pr__pfet_01v8 w=5.6 l=0.15
X817 t_Xdiv_d3 t_Xdiv_dn_ck t_Xdiv_Xld0_int_p vdd sky130_fd_pr__pfet_01v8_lvt w=2.25 l=0.35
X818 t_Xdiv_d1 t_Xdiv_dp_ck t_Xdiv_Xld0_int_n vss sky130_fd_pr__nfet_01v8_lvt w=2.9 l=0.15
X819 t_Xdiv_d1 t_Xdiv_dn_ck t_Xdiv_Xld0_int_n vdd sky130_fd_pr__pfet_01v8 w=5.6 l=0.15
X820 t_Xdiv_d1 t_Xdiv_dn_ck t_Xdiv_Xld0_int_n vdd sky130_fd_pr__pfet_01v8_lvt w=2.25 l=0.35
X821 t_Xdiv_Xld0_int_p t_Xdiv_Xld0_int_n vdd vdd sky130_fd_pr__pfet_01v8_lvt w=0.6 l=0.35
X822 t_Xdiv_Xld0_int_p t_Xdiv_Xld0_int_n vss vss sky130_fd_pr__nfet_01v8 w=0.6 l=0.28
X823 t_Xdiv_Xld0_int_n t_Xdiv_Xld0_int_p vdd vdd sky130_fd_pr__pfet_01v8_lvt w=0.6 l=0.35
X824 t_Xdiv_Xld0_int_n t_Xdiv_Xld0_int_p vss vss sky130_fd_pr__nfet_01v8 w=0.6 l=0.28
X825 t_Xdiv_Xld0_int_p t_Xdiv_rst_lat vss vss sky130_fd_pr__nfet_01v8 w=1 l=0.18
X826 t_Xdiv_Xld0_int_n t_Xdiv_rst_n_lat vdd vdd sky130_fd_pr__pfet_01v8 w=1.8 l=0.18
X827 t_Xdiv_d0 t_Xdiv_Xld0_int_n vss vss sky130_fd_pr__nfet_01v8_lvt w=3.8 l=0.15
X828 t_Xdiv_d0 t_Xdiv_Xld0_int_n vdd vdd sky130_fd_pr__pfet_01v8 w=10.5 l=0.15
X829 t_Xdiv_d0 t_Xdiv_Xld0_int_n vdd vdd sky130_fd_pr__pfet_01v8_lvt w=3.5 l=0.35
X830 t_Xdiv_d2 t_Xdiv_Xld0_int_p vss vss sky130_fd_pr__nfet_01v8_lvt w=3.8 l=0.15
X831 t_Xdiv_d2 t_Xdiv_Xld0_int_p vdd vdd sky130_fd_pr__pfet_01v8 w=10.5 l=0.15
X832 t_Xdiv_d2 t_Xdiv_Xld0_int_p vdd vdd sky130_fd_pr__pfet_01v8_lvt w=3.5 l=0.35
X833 t_Xdiv_d2 t_Xdiv_d0 vss vss sky130_fd_pr__nfet_01v8_lvt w=0.65 l=0.15
X834 t_Xdiv_d2 t_Xdiv_d0 vdd vdd sky130_fd_pr__pfet_01v8_lvt w=2.1 l=0.35
X835 t_Xdiv_d0 t_Xdiv_d2 vss vss sky130_fd_pr__nfet_01v8_lvt w=0.65 l=0.15
X836 t_Xdiv_d0 t_Xdiv_d2 vdd vdd sky130_fd_pr__pfet_01v8_lvt w=2.1 l=0.35
X837 t_Xdiv_d0 t_Xdiv_dn_ck t_Xdiv_Xld1_int_p vss sky130_fd_pr__nfet_01v8_lvt w=2.9 l=0.15
X838 t_Xdiv_d0 t_Xdiv_dp_ck t_Xdiv_Xld1_int_p vdd sky130_fd_pr__pfet_01v8 w=5.6 l=0.15
X839 t_Xdiv_d0 t_Xdiv_dp_ck t_Xdiv_Xld1_int_p vdd sky130_fd_pr__pfet_01v8_lvt w=2.25 l=0.35
X840 t_Xdiv_d2 t_Xdiv_dn_ck t_Xdiv_Xld1_int_n vss sky130_fd_pr__nfet_01v8_lvt w=2.9 l=0.15
X841 t_Xdiv_d2 t_Xdiv_dp_ck t_Xdiv_Xld1_int_n vdd sky130_fd_pr__pfet_01v8 w=5.6 l=0.15
X842 t_Xdiv_d2 t_Xdiv_dp_ck t_Xdiv_Xld1_int_n vdd sky130_fd_pr__pfet_01v8_lvt w=2.25 l=0.35
X843 t_Xdiv_Xld1_int_p t_Xdiv_Xld1_int_n vdd vdd sky130_fd_pr__pfet_01v8_lvt w=0.6 l=0.35
X844 t_Xdiv_Xld1_int_p t_Xdiv_Xld1_int_n vss vss sky130_fd_pr__nfet_01v8 w=0.6 l=0.28
X845 t_Xdiv_Xld1_int_n t_Xdiv_Xld1_int_p vdd vdd sky130_fd_pr__pfet_01v8_lvt w=0.6 l=0.35
X846 t_Xdiv_Xld1_int_n t_Xdiv_Xld1_int_p vss vss sky130_fd_pr__nfet_01v8 w=0.6 l=0.28
X847 t_Xdiv_Xld1_int_p t_Xdiv_rst_lat vss vss sky130_fd_pr__nfet_01v8 w=1 l=0.18
X848 t_Xdiv_Xld1_int_n t_Xdiv_rst_n_lat vdd vdd sky130_fd_pr__pfet_01v8 w=1.8 l=0.18
X849 t_Xdiv_d1 t_Xdiv_Xld1_int_n vss vss sky130_fd_pr__nfet_01v8_lvt w=3.8 l=0.15
X850 t_Xdiv_d1 t_Xdiv_Xld1_int_n vdd vdd sky130_fd_pr__pfet_01v8 w=10.5 l=0.15
X851 t_Xdiv_d1 t_Xdiv_Xld1_int_n vdd vdd sky130_fd_pr__pfet_01v8_lvt w=3.5 l=0.35
X852 t_Xdiv_d3 t_Xdiv_Xld1_int_p vss vss sky130_fd_pr__nfet_01v8_lvt w=3.8 l=0.15
X853 t_Xdiv_d3 t_Xdiv_Xld1_int_p vdd vdd sky130_fd_pr__pfet_01v8 w=10.5 l=0.15
X854 t_Xdiv_d3 t_Xdiv_Xld1_int_p vdd vdd sky130_fd_pr__pfet_01v8_lvt w=3.5 l=0.35
X855 t_Xdiv_d3 t_Xdiv_d1 vss vss sky130_fd_pr__nfet_01v8_lvt w=0.65 l=0.15
X856 t_Xdiv_d3 t_Xdiv_d1 vdd vdd sky130_fd_pr__pfet_01v8_lvt w=2.1 l=0.35
X857 t_Xdiv_d1 t_Xdiv_d3 vss vss sky130_fd_pr__nfet_01v8_lvt w=0.65 l=0.15
X858 t_Xdiv_d1 t_Xdiv_d3 vdd vdd sky130_fd_pr__pfet_01v8_lvt w=2.1 l=0.35
X859 t_Xdiv_e3 t_Xdiv_ep_ck t_Xdiv_e0_intp vss sky130_fd_pr__nfet_01v8_lvt w=4 l=0.15
X860 t_Xdiv_e3 t_Xdiv_en_ck t_Xdiv_e0_intp vdd sky130_fd_pr__pfet_01v8 w=7 l=0.15
X861 t_Xdiv_e3 t_Xdiv_en_ck t_Xdiv_e0_intp vdd sky130_fd_pr__pfet_01v8_lvt w=3.2 l=0.35
X862 t_Xdiv_e1 t_Xdiv_ep_ck t_Xdiv_e0_intn vss sky130_fd_pr__nfet_01v8_lvt w=4 l=0.15
X863 t_Xdiv_e1 t_Xdiv_en_ck t_Xdiv_e0_intn vdd sky130_fd_pr__pfet_01v8 w=7 l=0.15
X864 t_Xdiv_e1 t_Xdiv_en_ck t_Xdiv_e0_intn vdd sky130_fd_pr__pfet_01v8_lvt w=3.2 l=0.35
X865 t_Xdiv_e0_intp t_Xdiv_e0_intn vdd vdd sky130_fd_pr__pfet_01v8_lvt w=0.6 l=0.35
X866 t_Xdiv_e0_intp t_Xdiv_e0_intn vss vss sky130_fd_pr__nfet_01v8 w=0.6 l=0.28
X867 t_Xdiv_e0_intn t_Xdiv_e0_intp vdd vdd sky130_fd_pr__pfet_01v8_lvt w=0.6 l=0.35
X868 t_Xdiv_e0_intn t_Xdiv_e0_intp vss vss sky130_fd_pr__nfet_01v8 w=0.6 l=0.28
X869 t_Xdiv_e0_intp t_Xdiv_rst_lat vss vss sky130_fd_pr__nfet_01v8 w=1 l=0.18
X870 t_Xdiv_e0_intn t_Xdiv_rst_n_lat vdd vdd sky130_fd_pr__pfet_01v8 w=1.8 l=0.18
X871 t_Xdiv_e0 t_Xdiv_e0_intn vss vss sky130_fd_pr__nfet_01v8_lvt w=3.8 l=0.15
X872 t_Xdiv_e0 t_Xdiv_e0_intn vdd vdd sky130_fd_pr__pfet_01v8 w=10.5 l=0.15
X873 t_Xdiv_e0 t_Xdiv_e0_intn vdd vdd sky130_fd_pr__pfet_01v8_lvt w=3.5 l=0.35
X874 t_Xdiv_e2 t_Xdiv_e0_intp vss vss sky130_fd_pr__nfet_01v8_lvt w=3.8 l=0.15
X875 t_Xdiv_e2 t_Xdiv_e0_intp vdd vdd sky130_fd_pr__pfet_01v8 w=10.5 l=0.15
X876 t_Xdiv_e2 t_Xdiv_e0_intp vdd vdd sky130_fd_pr__pfet_01v8_lvt w=3.5 l=0.35
X877 t_Xdiv_e2 t_Xdiv_e0 vss vss sky130_fd_pr__nfet_01v8_lvt w=0.65 l=0.15
X878 t_Xdiv_e2 t_Xdiv_e0 vdd vdd sky130_fd_pr__pfet_01v8_lvt w=2.1 l=0.35
X879 t_Xdiv_e0 t_Xdiv_e2 vss vss sky130_fd_pr__nfet_01v8_lvt w=0.65 l=0.15
X880 t_Xdiv_e0 t_Xdiv_e2 vdd vdd sky130_fd_pr__pfet_01v8_lvt w=2.1 l=0.35
X881 t_Xdiv_e0 t_Xdiv_en_ck t_Xdiv_e1_intp vss sky130_fd_pr__nfet_01v8_lvt w=4 l=0.15
X882 t_Xdiv_e0 t_Xdiv_ep_ck t_Xdiv_e1_intp vdd sky130_fd_pr__pfet_01v8 w=7 l=0.15
X883 t_Xdiv_e0 t_Xdiv_ep_ck t_Xdiv_e1_intp vdd sky130_fd_pr__pfet_01v8_lvt w=3.2 l=0.35
X884 t_Xdiv_e2 t_Xdiv_en_ck t_Xdiv_e1_intn vss sky130_fd_pr__nfet_01v8_lvt w=4 l=0.15
X885 t_Xdiv_e2 t_Xdiv_ep_ck t_Xdiv_e1_intn vdd sky130_fd_pr__pfet_01v8 w=7 l=0.15
X886 t_Xdiv_e2 t_Xdiv_ep_ck t_Xdiv_e1_intn vdd sky130_fd_pr__pfet_01v8_lvt w=3.2 l=0.35
X887 t_Xdiv_e1_intp t_Xdiv_e1_intn vdd vdd sky130_fd_pr__pfet_01v8_lvt w=0.6 l=0.35
X888 t_Xdiv_e1_intp t_Xdiv_e1_intn vss vss sky130_fd_pr__nfet_01v8 w=0.6 l=0.28
X889 t_Xdiv_e1_intn t_Xdiv_e1_intp vdd vdd sky130_fd_pr__pfet_01v8_lvt w=0.6 l=0.35
X890 t_Xdiv_e1_intn t_Xdiv_e1_intp vss vss sky130_fd_pr__nfet_01v8 w=0.6 l=0.28
X891 t_Xdiv_e1_intp t_Xdiv_rst_lat vss vss sky130_fd_pr__nfet_01v8 w=1 l=0.18
X892 t_Xdiv_e1_intn t_Xdiv_rst_n_lat vdd vdd sky130_fd_pr__pfet_01v8 w=1.8 l=0.18
X893 t_Xdiv_e1 t_Xdiv_e1_intn vss vss sky130_fd_pr__nfet_01v8_lvt w=3.8 l=0.15
X894 t_Xdiv_e1 t_Xdiv_e1_intn vdd vdd sky130_fd_pr__pfet_01v8 w=10.5 l=0.15
X895 t_Xdiv_e1 t_Xdiv_e1_intn vdd vdd sky130_fd_pr__pfet_01v8_lvt w=3.5 l=0.35
X896 t_Xdiv_e3 t_Xdiv_e1_intp vss vss sky130_fd_pr__nfet_01v8_lvt w=3.8 l=0.15
X897 t_Xdiv_e3 t_Xdiv_e1_intp vdd vdd sky130_fd_pr__pfet_01v8 w=10.5 l=0.15
X898 t_Xdiv_e3 t_Xdiv_e1_intp vdd vdd sky130_fd_pr__pfet_01v8_lvt w=3.5 l=0.35
X899 t_Xdiv_e3 t_Xdiv_e1 vss vss sky130_fd_pr__nfet_01v8_lvt w=0.65 l=0.15
X900 t_Xdiv_e3 t_Xdiv_e1 vdd vdd sky130_fd_pr__pfet_01v8_lvt w=2.1 l=0.35
X901 t_Xdiv_e1 t_Xdiv_e3 vss vss sky130_fd_pr__nfet_01v8_lvt w=0.65 l=0.15
X902 t_Xdiv_e1 t_Xdiv_e3 vdd vdd sky130_fd_pr__pfet_01v8_lvt w=2.1 l=0.35
X903 t_Xdiv_e0_intn t_Xdiv_inj_en t_Xdiv_Xinj_e0n_sn vss sky130_fd_pr__nfet_01v8_lvt w=3 l=0.15
X904 t_Xdiv_Xinj_e0n_sn t_Xdiv_d2 vss vss sky130_fd_pr__nfet_01v8_lvt w=3 l=0.15
X905 t_Xdiv_e0_intp t_Xdiv_inj_en t_Xdiv_Xinj_e0p_sn vss sky130_fd_pr__nfet_01v8_lvt w=3 l=0.15
X906 t_Xdiv_Xinj_e0p_sn t_Xdiv_d0 vss vss sky130_fd_pr__nfet_01v8_lvt w=3 l=0.15
X907 t_Xdiv_e1_intn t_Xdiv_inj_en t_Xdiv_Xinj_e1n_sn vss sky130_fd_pr__nfet_01v8_lvt w=3 l=0.15
X908 t_Xdiv_Xinj_e1n_sn t_Xdiv_d3 vss vss sky130_fd_pr__nfet_01v8_lvt w=3 l=0.15
X909 t_Xdiv_e1_intp t_Xdiv_inj_en t_Xdiv_Xinj_e1p_sn vss sky130_fd_pr__nfet_01v8_lvt w=3 l=0.15
X910 t_Xdiv_Xinj_e1p_sn t_Xdiv_d1 vss vss sky130_fd_pr__nfet_01v8_lvt w=3 l=0.15
X911 vdd t_Xdiv_d1 vdd vdd sky130_fd_pr__pfet_01v8_lvt w=2.2 l=0.35
X912 vss t_Xdiv_d1 vss vss sky130_fd_pr__nfet_01v8 w=0.85 l=0.35
X913 vdd t_Xdiv_d3 vdd vdd sky130_fd_pr__pfet_01v8_lvt w=2.2 l=0.35
X914 vss t_Xdiv_d3 vss vss sky130_fd_pr__nfet_01v8 w=0.85 l=0.35
X915 vdd t_Xdiv_e1 vdd vdd sky130_fd_pr__pfet_01v8_lvt w=2.2 l=0.35
X916 vss t_Xdiv_e1 vss vss sky130_fd_pr__nfet_01v8 w=0.85 l=0.35
X917 vdd t_Xdiv_e3 vdd vdd sky130_fd_pr__pfet_01v8_lvt w=2.2 l=0.35
X918 vss t_Xdiv_e3 vss vss sky130_fd_pr__nfet_01v8 w=0.85 l=0.35
X919 vdd t_Xdiv_e1 vdd vdd sky130_fd_pr__pfet_01v8 w=1.4 l=0.15
X920 vss t_Xdiv_e1 vss vss sky130_fd_pr__nfet_01v8_lvt w=0.42 l=0.15
X921 vdd t_Xdiv_e3 vdd vdd sky130_fd_pr__pfet_01v8 w=1.4 l=0.15
X922 vss t_Xdiv_e3 vss vss sky130_fd_pr__nfet_01v8_lvt w=0.42 l=0.15
X923 ckd0 t_Xdiv_d2 vss vss sky130_fd_pr__nfet_01v8_lvt w=2.6 l=0.15
X924 ckd0 t_Xdiv_d2 vdd vdd sky130_fd_pr__pfet_01v8 w=9 l=0.15
X925 ckd0 t_Xdiv_d2 vdd vdd sky130_fd_pr__pfet_01v8_lvt w=3 l=0.35
X926 ckd2 t_Xdiv_d0 vss vss sky130_fd_pr__nfet_01v8_lvt w=2.6 l=0.15
X927 ckd2 t_Xdiv_d0 vdd vdd sky130_fd_pr__pfet_01v8 w=9 l=0.15
X928 ckd2 t_Xdiv_d0 vdd vdd sky130_fd_pr__pfet_01v8_lvt w=3 l=0.35
X929 ckd1 t_Xdiv_d3 vss vss sky130_fd_pr__nfet_01v8_lvt w=2.6 l=0.15
X930 ckd1 t_Xdiv_d3 vdd vdd sky130_fd_pr__pfet_01v8 w=9 l=0.15
X931 ckd1 t_Xdiv_d3 vdd vdd sky130_fd_pr__pfet_01v8_lvt w=3 l=0.35
X932 ckd3 t_Xdiv_d1 vss vss sky130_fd_pr__nfet_01v8_lvt w=2.6 l=0.15
X933 ckd3 t_Xdiv_d1 vdd vdd sky130_fd_pr__pfet_01v8 w=9 l=0.15
X934 ckd3 t_Xdiv_d1 vdd vdd sky130_fd_pr__pfet_01v8_lvt w=3 l=0.35
X935 cke0 t_Xdiv_e0 vss vss sky130_fd_pr__nfet_01v8_lvt w=2.6 l=0.15
X936 cke0 t_Xdiv_e0 vdd vdd sky130_fd_pr__pfet_01v8 w=9 l=0.15
X937 cke0 t_Xdiv_e0 vdd vdd sky130_fd_pr__pfet_01v8_lvt w=3 l=0.35
X938 cke2 t_Xdiv_e2 vss vss sky130_fd_pr__nfet_01v8_lvt w=2.6 l=0.15
X939 cke2 t_Xdiv_e2 vdd vdd sky130_fd_pr__pfet_01v8 w=9 l=0.15
X940 cke2 t_Xdiv_e2 vdd vdd sky130_fd_pr__pfet_01v8_lvt w=3 l=0.35
X941 cke1 t_Xdiv_e1 vss vss sky130_fd_pr__nfet_01v8_lvt w=2.6 l=0.15
X942 cke1 t_Xdiv_e1 vdd vdd sky130_fd_pr__pfet_01v8 w=9 l=0.15
X943 cke1 t_Xdiv_e1 vdd vdd sky130_fd_pr__pfet_01v8_lvt w=3 l=0.35
X944 cke3 t_Xdiv_e3 vss vss sky130_fd_pr__nfet_01v8_lvt w=2.6 l=0.15
X945 cke3 t_Xdiv_e3 vdd vdd sky130_fd_pr__pfet_01v8 w=9 l=0.15
X946 cke3 t_Xdiv_e3 vdd vdd sky130_fd_pr__pfet_01v8_lvt w=3 l=0.35
X947 ckd2 ckd0 vss vss sky130_fd_pr__nfet_01v8_lvt w=0.45 l=0.15
X948 ckd2 ckd0 vdd vdd sky130_fd_pr__pfet_01v8_lvt w=1.4 l=0.35
X949 ckd0 ckd2 vss vss sky130_fd_pr__nfet_01v8_lvt w=0.45 l=0.15
X950 ckd0 ckd2 vdd vdd sky130_fd_pr__pfet_01v8_lvt w=1.4 l=0.35
X951 ckd3 ckd1 vss vss sky130_fd_pr__nfet_01v8_lvt w=0.45 l=0.15
X952 ckd3 ckd1 vdd vdd sky130_fd_pr__pfet_01v8_lvt w=1.4 l=0.35
X953 ckd1 ckd3 vss vss sky130_fd_pr__nfet_01v8_lvt w=0.45 l=0.15
X954 ckd1 ckd3 vdd vdd sky130_fd_pr__pfet_01v8_lvt w=1.4 l=0.35
X955 cke2 cke0 vss vss sky130_fd_pr__nfet_01v8_lvt w=0.45 l=0.15
X956 cke2 cke0 vdd vdd sky130_fd_pr__pfet_01v8_lvt w=1.4 l=0.35
X957 cke0 cke2 vss vss sky130_fd_pr__nfet_01v8_lvt w=0.45 l=0.15
X958 cke0 cke2 vdd vdd sky130_fd_pr__pfet_01v8_lvt w=1.4 l=0.35
X959 cke3 cke1 vss vss sky130_fd_pr__nfet_01v8_lvt w=0.45 l=0.15
X960 cke3 cke1 vdd vdd sky130_fd_pr__pfet_01v8_lvt w=1.4 l=0.35
X961 cke1 cke3 vss vss sky130_fd_pr__nfet_01v8_lvt w=0.45 l=0.15
X962 cke1 cke3 vdd vdd sky130_fd_pr__pfet_01v8_lvt w=1.4 l=0.35
.ends serdes_rx_pi_4ph_5g_pdk

* Exact flattened LVS reference netlist for serdes_rx_dt_slicer_5g_pdk
* Source subckt: serdes_rx_dt_slicer_5g (analog/rx/cmos_rx/spice/rx_dt_sampler_5g.spice)
.subckt serdes_rx_dt_slicer_5g_pdk inp inn clk qp qn t5 t4 t3 t2 t1 t0 vdd vss
X1 t_Xcomp_Xtrim_tb0 t0 vss vss sky130_fd_pr__nfet_01v8 w=1 l=0.18
X2 t_Xcomp_Xtrim_tb0 t0 vdd vdd sky130_fd_pr__pfet_01v8 w=2 l=0.18
X3 t_Xcomp_Xtrim_tb1 t1 vss vss sky130_fd_pr__nfet_01v8 w=1 l=0.18
X4 t_Xcomp_Xtrim_tb1 t1 vdd vdd sky130_fd_pr__pfet_01v8 w=2 l=0.18
X5 t_Xcomp_Xtrim_tb2 t2 vss vss sky130_fd_pr__nfet_01v8 w=1 l=0.18
X6 t_Xcomp_Xtrim_tb2 t2 vdd vdd sky130_fd_pr__pfet_01v8 w=2 l=0.18
X7 t_Xcomp_Xtrim_tb3 t3 vss vss sky130_fd_pr__nfet_01v8 w=2 l=0.18
X8 t_Xcomp_Xtrim_tb3 t3 vdd vdd sky130_fd_pr__pfet_01v8 w=4 l=0.18
X9 t_Xcomp_Xtrim_tb4 t4 vss vss sky130_fd_pr__nfet_01v8 w=4 l=0.18
X10 t_Xcomp_Xtrim_tb4 t4 vdd vdd sky130_fd_pr__pfet_01v8 w=8 l=0.18
X11 t_Xcomp_Xtrim_tb5 t5 vss vss sky130_fd_pr__nfet_01v8 w=8 l=0.18
X12 t_Xcomp_Xtrim_tb5 t5 vdd vdd sky130_fd_pr__pfet_01v8 w=16 l=0.18
X13 t_Xcomp_Xtrim_td1 t_Xcomp_Xtrim_tb1 vss vss sky130_fd_pr__nfet_01v8 w=1 l=0.18
X14 t_Xcomp_Xtrim_td1 t_Xcomp_Xtrim_tb1 vdd vdd sky130_fd_pr__pfet_01v8 w=2 l=0.18
X15 t_Xcomp_Xtrim_td2 t_Xcomp_Xtrim_tb2 vss vss sky130_fd_pr__nfet_01v8 w=1 l=0.18
X16 t_Xcomp_Xtrim_td2 t_Xcomp_Xtrim_tb2 vdd vdd sky130_fd_pr__pfet_01v8 w=2 l=0.18
X17 t_Xcomp_Xtrim_td3 t_Xcomp_Xtrim_tb3 vss vss sky130_fd_pr__nfet_01v8 w=2 l=0.18
X18 t_Xcomp_Xtrim_td3 t_Xcomp_Xtrim_tb3 vdd vdd sky130_fd_pr__pfet_01v8 w=4 l=0.18
X19 t_Xcomp_Xtrim_td4 t_Xcomp_Xtrim_tb4 vss vss sky130_fd_pr__nfet_01v8 w=4 l=0.18
X20 t_Xcomp_Xtrim_td4 t_Xcomp_Xtrim_tb4 vdd vdd sky130_fd_pr__pfet_01v8 w=8 l=0.18
X21 t_Xcomp_Xtrim_td5 t_Xcomp_Xtrim_tb5 vss vss sky130_fd_pr__nfet_01v8 w=8 l=0.18
X22 t_Xcomp_Xtrim_td5 t_Xcomp_Xtrim_tb5 vdd vdd sky130_fd_pr__pfet_01v8 w=16 l=0.18
X23 t_Xcomp_Xtrim_r_on vdd vss vss sky130_fd_pr__nfet_01v8 w=1 l=0.18
X24 t_Xcomp_Xtrim_r_on vdd vdd vdd sky130_fd_pr__pfet_01v8 w=2 l=0.18
X25 t_Xcomp_Xtrim_tb0 t_Xcomp_fn t_Xcomp_Xtrim_tb0 vss sky130_fd_pr__nfet_01v8 w=0.45 l=0.18
X26 t_Xcomp_Xtrim_tb1 t_Xcomp_fn t_Xcomp_Xtrim_tb1 vss sky130_fd_pr__nfet_01v8 w=0.45 l=0.18
X27 t_Xcomp_Xtrim_tb2 t_Xcomp_fn t_Xcomp_Xtrim_tb2 vss sky130_fd_pr__nfet_01v8 w=0.9 l=0.18
X28 t_Xcomp_Xtrim_tb3 t_Xcomp_fn t_Xcomp_Xtrim_tb3 vss sky130_fd_pr__nfet_01v8 w=1.8 l=0.18
X29 t_Xcomp_Xtrim_tb4 t_Xcomp_fn t_Xcomp_Xtrim_tb4 vss sky130_fd_pr__nfet_01v8 w=3.6 l=0.18
X30 t_Xcomp_Xtrim_tb5 t_Xcomp_fn t_Xcomp_Xtrim_tb5 vss sky130_fd_pr__nfet_01v8 w=7.2 l=0.18
X31 t_Xcomp_Xtrim_r_on t_Xcomp_fp t_Xcomp_Xtrim_r_on vss sky130_fd_pr__nfet_01v8 w=0.45 l=0.18
X32 t_Xcomp_Xtrim_td1 t_Xcomp_fp t_Xcomp_Xtrim_td1 vss sky130_fd_pr__nfet_01v8 w=0.45 l=0.18
X33 t_Xcomp_Xtrim_td2 t_Xcomp_fp t_Xcomp_Xtrim_td2 vss sky130_fd_pr__nfet_01v8 w=0.9 l=0.18
X34 t_Xcomp_Xtrim_td3 t_Xcomp_fp t_Xcomp_Xtrim_td3 vss sky130_fd_pr__nfet_01v8 w=1.8 l=0.18
X35 t_Xcomp_Xtrim_td4 t_Xcomp_fp t_Xcomp_Xtrim_td4 vss sky130_fd_pr__nfet_01v8 w=3.6 l=0.18
X36 t_Xcomp_Xtrim_td5 t_Xcomp_fp t_Xcomp_Xtrim_td5 vss sky130_fd_pr__nfet_01v8 w=7.2 l=0.18
X37 t_Xcomp_tail clk vss vss sky130_fd_pr__nfet_01v8_lvt w=24 l=0.15
X38 t_Xcomp_fn inp t_Xcomp_tail vss sky130_fd_pr__nfet_01v8_lvt w=14 l=0.15
X39 t_Xcomp_fp inn t_Xcomp_tail vss sky130_fd_pr__nfet_01v8_lvt w=14 l=0.15
X40 t_Xcomp_fn clk vdd vdd sky130_fd_pr__pfet_01v8 w=6.3 l=0.15
X41 t_Xcomp_fp clk vdd vdd sky130_fd_pr__pfet_01v8 w=6.3 l=0.15
X42 t_Xcomp_fn clk t_Xcomp_fp vdd sky130_fd_pr__pfet_01v8 w=4.8 l=0.15
X43 t_outp_b t_outn_b t_Xcomp_fn vss sky130_fd_pr__nfet_01v8_lvt w=14.4 l=0.15
X44 t_outn_b t_outp_b t_Xcomp_fp vss sky130_fd_pr__nfet_01v8_lvt w=14.4 l=0.15
X45 t_outp_b t_outn_b vdd vdd sky130_fd_pr__pfet_01v8 w=8.4 l=0.15
X46 t_outp_b t_outn_b vdd vdd sky130_fd_pr__pfet_01v8_lvt w=3.2 l=0.35
X47 t_outn_b t_outp_b vdd vdd sky130_fd_pr__pfet_01v8 w=8.4 l=0.15
X48 t_outn_b t_outp_b vdd vdd sky130_fd_pr__pfet_01v8_lvt w=3.2 l=0.35
X49 t_outp_b clk vdd vdd sky130_fd_pr__pfet_01v8 w=6.3 l=0.15
X50 t_outn_b clk vdd vdd sky130_fd_pr__pfet_01v8 w=6.3 l=0.15
X51 t_outp_b clk t_outn_b vdd sky130_fd_pr__pfet_01v8 w=4.8 l=0.15
X52 t_Xsr_sp t_outp_b vss vss sky130_fd_pr__nfet_01v8_lvt w=2.4 l=0.15
X53 t_Xsr_sp t_outp_b vdd vdd sky130_fd_pr__pfet_01v8 w=6 l=0.15
X54 t_Xsr_sp t_outp_b vdd vdd sky130_fd_pr__pfet_01v8_lvt w=2.1 l=0.35
X55 t_Xsr_sn t_outn_b vss vss sky130_fd_pr__nfet_01v8_lvt w=2.4 l=0.15
X56 t_Xsr_sn t_outn_b vdd vdd sky130_fd_pr__pfet_01v8 w=6 l=0.15
X57 t_Xsr_sn t_outn_b vdd vdd sky130_fd_pr__pfet_01v8_lvt w=2.1 l=0.35
X58 qn t_Xsr_sp vss vss sky130_fd_pr__nfet_01v8_lvt w=5 l=0.15
X59 qp t_Xsr_sn vss vss sky130_fd_pr__nfet_01v8_lvt w=5 l=0.15
X60 vdd t_Xsr_sp qp vss sky130_fd_pr__nfet_01v8_lvt w=5 l=0.15
X61 vdd t_Xsr_sn qn vss sky130_fd_pr__nfet_01v8_lvt w=5 l=0.15
X62 qp qn vss vss sky130_fd_pr__nfet_01v8_lvt w=0.8 l=0.15
X63 qn qp vss vss sky130_fd_pr__nfet_01v8_lvt w=0.8 l=0.15
X64 qp qn vdd vdd sky130_fd_pr__pfet_01v8 w=2.4 l=0.15
X65 qp qn vdd vdd sky130_fd_pr__pfet_01v8_lvt w=1 l=0.35
X66 qn qp vdd vdd sky130_fd_pr__pfet_01v8 w=2.4 l=0.15
X67 qn qp vdd vdd sky130_fd_pr__pfet_01v8_lvt w=1 l=0.35
.ends serdes_rx_dt_slicer_5g_pdk

* Exact flattened LVS reference netlist for serdes_rx_cmos_deser16_pdk
* Source subckt: serdes_rx_cmos_deser16 (frozen analog/rx/cmos_rx/spice/*.spice)
.subckt serdes_rx_cmos_deser16_pdk d0 d1 d2 d3 e0 e1 e2 e3 ckd0 ckd1 ckd2 ckd3 cke0 cke1 cke2 cke3 rst_n wd0 wd1 wd2 wd3 wd4 wd5 wd6 wd7 wd8 wd9 wd10 wd11 wd12 wd13 wd14 wd15 we0 we1 we2 we3 we4 we5 we6 we7 we8 we9 we10 we11 we12 we13 we14 we15 wclk vdd vss
X1 t_ck0_1 ckd2 vss vss sky130_fd_pr__nfet_01v8_lvt w=1.2 l=0.15
X2 t_ck0_1 ckd2 vdd vdd sky130_fd_pr__pfet_01v8 w=4.8 l=0.15
X3 t_ck2_1 ckd0 vss vss sky130_fd_pr__nfet_01v8_lvt w=1.2 l=0.15
X4 t_ck2_1 ckd0 vdd vdd sky130_fd_pr__pfet_01v8 w=4.8 l=0.15
X5 t_ck2_1 t_ck0_1 vss vss sky130_fd_pr__nfet_01v8_lvt w=0.42 l=0.15
X6 t_ck2_1 t_ck0_1 vdd vdd sky130_fd_pr__pfet_01v8 w=1.4 l=0.15
X7 t_ck0_1 t_ck2_1 vss vss sky130_fd_pr__nfet_01v8_lvt w=0.42 l=0.15
X8 t_ck0_1 t_ck2_1 vdd vdd sky130_fd_pr__pfet_01v8 w=1.4 l=0.15
X9 t_ck0_2a t_ck0_1 vss vss sky130_fd_pr__nfet_01v8_lvt w=2.4 l=0.15
X10 t_ck0_2a t_ck0_1 vdd vdd sky130_fd_pr__pfet_01v8 w=9.6 l=0.15
X11 t_ck2_2a t_ck2_1 vss vss sky130_fd_pr__nfet_01v8_lvt w=2.4 l=0.15
X12 t_ck2_2a t_ck2_1 vdd vdd sky130_fd_pr__pfet_01v8 w=9.6 l=0.15
X13 t_ck0a t_ck0_2a vss vss sky130_fd_pr__nfet_01v8_lvt w=9.6 l=0.15
X14 t_ck0a t_ck0_2a vdd vdd sky130_fd_pr__pfet_01v8 w=38.4 l=0.15
X15 t_ck0ba t_ck2_2a vss vss sky130_fd_pr__nfet_01v8_lvt w=9.6 l=0.15
X16 t_ck0ba t_ck2_2a vdd vdd sky130_fd_pr__pfet_01v8 w=38.4 l=0.15
X17 t_ck0ba t_ck0a vss vss sky130_fd_pr__nfet_01v8_lvt w=0.45 l=0.15
X18 t_ck0ba t_ck0a vdd vdd sky130_fd_pr__pfet_01v8 w=1.6 l=0.15
X19 t_ck0a t_ck0ba vss vss sky130_fd_pr__nfet_01v8_lvt w=0.45 l=0.15
X20 t_ck0a t_ck0ba vdd vdd sky130_fd_pr__pfet_01v8 w=1.6 l=0.15
X21 t_ck0_2b t_ck0_1 vss vss sky130_fd_pr__nfet_01v8_lvt w=2.4 l=0.15
X22 t_ck0_2b t_ck0_1 vdd vdd sky130_fd_pr__pfet_01v8 w=9.6 l=0.15
X23 t_ck2_2b t_ck2_1 vss vss sky130_fd_pr__nfet_01v8_lvt w=2.4 l=0.15
X24 t_ck2_2b t_ck2_1 vdd vdd sky130_fd_pr__pfet_01v8 w=9.6 l=0.15
X25 t_ck0b t_ck0_2b vss vss sky130_fd_pr__nfet_01v8_lvt w=9.6 l=0.15
X26 t_ck0b t_ck0_2b vdd vdd sky130_fd_pr__pfet_01v8 w=38.4 l=0.15
X27 t_ck0bb t_ck2_2b vss vss sky130_fd_pr__nfet_01v8_lvt w=9.6 l=0.15
X28 t_ck0bb t_ck2_2b vdd vdd sky130_fd_pr__pfet_01v8 w=38.4 l=0.15
X29 t_ck0bb t_ck0b vss vss sky130_fd_pr__nfet_01v8_lvt w=0.45 l=0.15
X30 t_ck0bb t_ck0b vdd vdd sky130_fd_pr__pfet_01v8 w=1.6 l=0.15
X31 t_ck0b t_ck0bb vss vss sky130_fd_pr__nfet_01v8_lvt w=0.45 l=0.15
X32 t_ck0b t_ck0bb vdd vdd sky130_fd_pr__pfet_01v8 w=1.6 l=0.15
X33 vss ckd1 vss vss sky130_fd_pr__nfet_01v8_lvt w=1.2 l=0.15
X34 vdd ckd1 vdd vdd sky130_fd_pr__pfet_01v8 w=4.8 l=0.15
X35 vss ckd3 vss vss sky130_fd_pr__nfet_01v8_lvt w=1.2 l=0.15
X36 vdd ckd3 vdd vdd sky130_fd_pr__pfet_01v8 w=4.8 l=0.15
X37 vss cke0 vss vss sky130_fd_pr__nfet_01v8_lvt w=1.2 l=0.15
X38 vdd cke0 vdd vdd sky130_fd_pr__pfet_01v8 w=4.8 l=0.15
X39 vss cke1 vss vss sky130_fd_pr__nfet_01v8_lvt w=1.2 l=0.15
X40 vdd cke1 vdd vdd sky130_fd_pr__pfet_01v8 w=4.8 l=0.15
X41 vss cke2 vss vss sky130_fd_pr__nfet_01v8_lvt w=1.2 l=0.15
X42 vdd cke2 vdd vdd sky130_fd_pr__pfet_01v8 w=4.8 l=0.15
X43 vss cke3 vss vss sky130_fd_pr__nfet_01v8_lvt w=1.2 l=0.15
X44 vdd cke3 vdd vdd sky130_fd_pr__pfet_01v8 w=4.8 l=0.15
X45 d0 t_ck0a t_Xd0_a_m1 vss sky130_fd_pr__nfet_01v8_lvt w=0.65 l=0.15
X46 d0 t_ck0ba t_Xd0_a_m1 vdd sky130_fd_pr__pfet_01v8 w=2.2 l=0.15
X47 t_Xd0_a_m2 t_Xd0_a_m1 t_Xd0_a_Xm2_mid vss sky130_fd_pr__nfet_01v8_lvt w=1 l=0.15
X48 t_Xd0_a_Xm2_mid rst_n vss vss sky130_fd_pr__nfet_01v8_lvt w=1 l=0.15
X49 t_Xd0_a_m2 t_Xd0_a_m1 vdd vdd sky130_fd_pr__pfet_01v8 w=2 l=0.15
X50 t_Xd0_a_m2 rst_n vdd vdd sky130_fd_pr__pfet_01v8 w=2 l=0.15
X51 t_Xd0_a_m3 t_Xd0_a_m2 vss vss sky130_fd_pr__nfet_01v8_lvt w=0.45 l=0.15
X52 t_Xd0_a_m3 t_Xd0_a_m2 vdd vdd sky130_fd_pr__pfet_01v8 w=1.15 l=0.15
X53 t_Xd0_a_m3 t_ck0ba t_Xd0_a_m1 vss sky130_fd_pr__nfet_01v8_lvt w=0.45 l=0.15
X54 t_Xd0_a_m3 t_ck0a t_Xd0_a_m1 vdd sky130_fd_pr__pfet_01v8 w=1.05 l=0.15
X55 t_Xd0_a_m2 t_ck0ba t_Xd0_a_s1 vss sky130_fd_pr__nfet_01v8_lvt w=0.65 l=0.15
X56 t_Xd0_a_m2 t_ck0a t_Xd0_a_s1 vdd sky130_fd_pr__pfet_01v8 w=2.2 l=0.15
X57 t_Xd0_a_qi t_Xd0_a_s1 vss vss sky130_fd_pr__nfet_01v8_lvt w=0.65 l=0.15
X58 t_Xd0_a_qi t_Xd0_a_s1 vdd vdd sky130_fd_pr__pfet_01v8 w=1.65 l=0.15
X59 t_Xd0_a_s2 t_Xd0_a_qi t_Xd0_a_Xsfb_mid vss sky130_fd_pr__nfet_01v8_lvt w=0.8 l=0.15
X60 t_Xd0_a_Xsfb_mid rst_n vss vss sky130_fd_pr__nfet_01v8_lvt w=0.8 l=0.15
X61 t_Xd0_a_s2 t_Xd0_a_qi vdd vdd sky130_fd_pr__pfet_01v8 w=1.4 l=0.15
X62 t_Xd0_a_s2 rst_n vdd vdd sky130_fd_pr__pfet_01v8 w=1.4 l=0.15
X63 t_Xd0_a_s2 t_ck0a t_Xd0_a_s1 vss sky130_fd_pr__nfet_01v8_lvt w=0.45 l=0.15
X64 t_Xd0_a_s2 t_ck0ba t_Xd0_a_s1 vdd sky130_fd_pr__pfet_01v8 w=1.05 l=0.15
X65 t_d0_a t_Xd0_a_s1 vss vss sky130_fd_pr__nfet_01v8_lvt w=0.8 l=0.15
X66 t_d0_a t_Xd0_a_s1 vdd vdd sky130_fd_pr__pfet_01v8 w=2.4 l=0.15
X67 t_d0_ab t_d0_a vss vss sky130_fd_pr__nfet_01v8_lvt w=0.55 l=0.15
X68 t_d0_ab t_d0_a vdd vdd sky130_fd_pr__pfet_01v8 w=1.4 l=0.15
X69 t_d0_a t_ck0ba t_Xd0_p_m1 vss sky130_fd_pr__nfet_01v8_lvt w=0.65 l=0.15
X70 t_d0_a t_ck0a t_Xd0_p_m1 vdd sky130_fd_pr__pfet_01v8 w=2.2 l=0.15
X71 t_Xd0_p_m2 t_Xd0_p_m1 t_Xd0_p_Xm2_mid vss sky130_fd_pr__nfet_01v8_lvt w=1 l=0.15
X72 t_Xd0_p_Xm2_mid rst_n vss vss sky130_fd_pr__nfet_01v8_lvt w=1 l=0.15
X73 t_Xd0_p_m2 t_Xd0_p_m1 vdd vdd sky130_fd_pr__pfet_01v8 w=2 l=0.15
X74 t_Xd0_p_m2 rst_n vdd vdd sky130_fd_pr__pfet_01v8 w=2 l=0.15
X75 t_Xd0_p_m3 t_Xd0_p_m2 vss vss sky130_fd_pr__nfet_01v8_lvt w=0.45 l=0.15
X76 t_Xd0_p_m3 t_Xd0_p_m2 vdd vdd sky130_fd_pr__pfet_01v8 w=1.15 l=0.15
X77 t_Xd0_p_m3 t_ck0a t_Xd0_p_m1 vss sky130_fd_pr__nfet_01v8_lvt w=0.45 l=0.15
X78 t_Xd0_p_m3 t_ck0ba t_Xd0_p_m1 vdd sky130_fd_pr__pfet_01v8 w=1.05 l=0.15
X79 t_Xd0_p_m2 t_ck0a t_Xd0_p_s1 vss sky130_fd_pr__nfet_01v8_lvt w=0.65 l=0.15
X80 t_Xd0_p_m2 t_ck0ba t_Xd0_p_s1 vdd sky130_fd_pr__pfet_01v8 w=2.2 l=0.15
X81 t_Xd0_p_qi t_Xd0_p_s1 vss vss sky130_fd_pr__nfet_01v8_lvt w=0.65 l=0.15
X82 t_Xd0_p_qi t_Xd0_p_s1 vdd vdd sky130_fd_pr__pfet_01v8 w=1.65 l=0.15
X83 t_Xd0_p_s2 t_Xd0_p_qi t_Xd0_p_Xsfb_mid vss sky130_fd_pr__nfet_01v8_lvt w=0.8 l=0.15
X84 t_Xd0_p_Xsfb_mid rst_n vss vss sky130_fd_pr__nfet_01v8_lvt w=0.8 l=0.15
X85 t_Xd0_p_s2 t_Xd0_p_qi vdd vdd sky130_fd_pr__pfet_01v8 w=1.4 l=0.15
X86 t_Xd0_p_s2 rst_n vdd vdd sky130_fd_pr__pfet_01v8 w=1.4 l=0.15
X87 t_Xd0_p_s2 t_ck0ba t_Xd0_p_s1 vss sky130_fd_pr__nfet_01v8_lvt w=0.45 l=0.15
X88 t_Xd0_p_s2 t_ck0a t_Xd0_p_s1 vdd sky130_fd_pr__pfet_01v8 w=1.05 l=0.15
X89 t_d0_p t_Xd0_p_s1 vss vss sky130_fd_pr__nfet_01v8_lvt w=0.8 l=0.15
X90 t_d0_p t_Xd0_p_s1 vdd vdd sky130_fd_pr__pfet_01v8 w=2.4 l=0.15
X91 t_d0_pb t_d0_p vss vss sky130_fd_pr__nfet_01v8_lvt w=0.55 l=0.15
X92 t_d0_pb t_d0_p vdd vdd sky130_fd_pr__pfet_01v8 w=1.4 l=0.15
X93 d1 t_ck0ba t_Xd1_p_m1 vss sky130_fd_pr__nfet_01v8_lvt w=0.65 l=0.15
X94 d1 t_ck0a t_Xd1_p_m1 vdd sky130_fd_pr__pfet_01v8 w=2.2 l=0.15
X95 t_Xd1_p_m2 t_Xd1_p_m1 t_Xd1_p_Xm2_mid vss sky130_fd_pr__nfet_01v8_lvt w=1 l=0.15
X96 t_Xd1_p_Xm2_mid rst_n vss vss sky130_fd_pr__nfet_01v8_lvt w=1 l=0.15
X97 t_Xd1_p_m2 t_Xd1_p_m1 vdd vdd sky130_fd_pr__pfet_01v8 w=2 l=0.15
X98 t_Xd1_p_m2 rst_n vdd vdd sky130_fd_pr__pfet_01v8 w=2 l=0.15
X99 t_Xd1_p_m3 t_Xd1_p_m2 vss vss sky130_fd_pr__nfet_01v8_lvt w=0.45 l=0.15
X100 t_Xd1_p_m3 t_Xd1_p_m2 vdd vdd sky130_fd_pr__pfet_01v8 w=1.15 l=0.15
X101 t_Xd1_p_m3 t_ck0a t_Xd1_p_m1 vss sky130_fd_pr__nfet_01v8_lvt w=0.45 l=0.15
X102 t_Xd1_p_m3 t_ck0ba t_Xd1_p_m1 vdd sky130_fd_pr__pfet_01v8 w=1.05 l=0.15
X103 t_Xd1_p_m2 t_ck0a t_Xd1_p_s1 vss sky130_fd_pr__nfet_01v8_lvt w=0.65 l=0.15
X104 t_Xd1_p_m2 t_ck0ba t_Xd1_p_s1 vdd sky130_fd_pr__pfet_01v8 w=2.2 l=0.15
X105 t_Xd1_p_qi t_Xd1_p_s1 vss vss sky130_fd_pr__nfet_01v8_lvt w=0.65 l=0.15
X106 t_Xd1_p_qi t_Xd1_p_s1 vdd vdd sky130_fd_pr__pfet_01v8 w=1.65 l=0.15
X107 t_Xd1_p_s2 t_Xd1_p_qi t_Xd1_p_Xsfb_mid vss sky130_fd_pr__nfet_01v8_lvt w=0.8 l=0.15
X108 t_Xd1_p_Xsfb_mid rst_n vss vss sky130_fd_pr__nfet_01v8_lvt w=0.8 l=0.15
X109 t_Xd1_p_s2 t_Xd1_p_qi vdd vdd sky130_fd_pr__pfet_01v8 w=1.4 l=0.15
X110 t_Xd1_p_s2 rst_n vdd vdd sky130_fd_pr__pfet_01v8 w=1.4 l=0.15
X111 t_Xd1_p_s2 t_ck0ba t_Xd1_p_s1 vss sky130_fd_pr__nfet_01v8_lvt w=0.45 l=0.15
X112 t_Xd1_p_s2 t_ck0a t_Xd1_p_s1 vdd sky130_fd_pr__pfet_01v8 w=1.05 l=0.15
X113 t_d1_p t_Xd1_p_s1 vss vss sky130_fd_pr__nfet_01v8_lvt w=0.8 l=0.15
X114 t_d1_p t_Xd1_p_s1 vdd vdd sky130_fd_pr__pfet_01v8 w=2.4 l=0.15
X115 t_d1_pb t_d1_p vss vss sky130_fd_pr__nfet_01v8_lvt w=0.55 l=0.15
X116 t_d1_pb t_d1_p vdd vdd sky130_fd_pr__pfet_01v8 w=1.4 l=0.15
X117 d2 t_ck0ba t_Xd2_p_m1 vss sky130_fd_pr__nfet_01v8_lvt w=0.65 l=0.15
X118 d2 t_ck0a t_Xd2_p_m1 vdd sky130_fd_pr__pfet_01v8 w=2.2 l=0.15
X119 t_Xd2_p_m2 t_Xd2_p_m1 t_Xd2_p_Xm2_mid vss sky130_fd_pr__nfet_01v8_lvt w=1 l=0.15
X120 t_Xd2_p_Xm2_mid rst_n vss vss sky130_fd_pr__nfet_01v8_lvt w=1 l=0.15
X121 t_Xd2_p_m2 t_Xd2_p_m1 vdd vdd sky130_fd_pr__pfet_01v8 w=2 l=0.15
X122 t_Xd2_p_m2 rst_n vdd vdd sky130_fd_pr__pfet_01v8 w=2 l=0.15
X123 t_Xd2_p_m3 t_Xd2_p_m2 vss vss sky130_fd_pr__nfet_01v8_lvt w=0.45 l=0.15
X124 t_Xd2_p_m3 t_Xd2_p_m2 vdd vdd sky130_fd_pr__pfet_01v8 w=1.15 l=0.15
X125 t_Xd2_p_m3 t_ck0a t_Xd2_p_m1 vss sky130_fd_pr__nfet_01v8_lvt w=0.45 l=0.15
X126 t_Xd2_p_m3 t_ck0ba t_Xd2_p_m1 vdd sky130_fd_pr__pfet_01v8 w=1.05 l=0.15
X127 t_Xd2_p_m2 t_ck0a t_Xd2_p_s1 vss sky130_fd_pr__nfet_01v8_lvt w=0.65 l=0.15
X128 t_Xd2_p_m2 t_ck0ba t_Xd2_p_s1 vdd sky130_fd_pr__pfet_01v8 w=2.2 l=0.15
X129 t_Xd2_p_qi t_Xd2_p_s1 vss vss sky130_fd_pr__nfet_01v8_lvt w=0.65 l=0.15
X130 t_Xd2_p_qi t_Xd2_p_s1 vdd vdd sky130_fd_pr__pfet_01v8 w=1.65 l=0.15
X131 t_Xd2_p_s2 t_Xd2_p_qi t_Xd2_p_Xsfb_mid vss sky130_fd_pr__nfet_01v8_lvt w=0.8 l=0.15
X132 t_Xd2_p_Xsfb_mid rst_n vss vss sky130_fd_pr__nfet_01v8_lvt w=0.8 l=0.15
X133 t_Xd2_p_s2 t_Xd2_p_qi vdd vdd sky130_fd_pr__pfet_01v8 w=1.4 l=0.15
X134 t_Xd2_p_s2 rst_n vdd vdd sky130_fd_pr__pfet_01v8 w=1.4 l=0.15
X135 t_Xd2_p_s2 t_ck0ba t_Xd2_p_s1 vss sky130_fd_pr__nfet_01v8_lvt w=0.45 l=0.15
X136 t_Xd2_p_s2 t_ck0a t_Xd2_p_s1 vdd sky130_fd_pr__pfet_01v8 w=1.05 l=0.15
X137 t_d2_p t_Xd2_p_s1 vss vss sky130_fd_pr__nfet_01v8_lvt w=0.8 l=0.15
X138 t_d2_p t_Xd2_p_s1 vdd vdd sky130_fd_pr__pfet_01v8 w=2.4 l=0.15
X139 t_d2_pb t_d2_p vss vss sky130_fd_pr__nfet_01v8_lvt w=0.55 l=0.15
X140 t_d2_pb t_d2_p vdd vdd sky130_fd_pr__pfet_01v8 w=1.4 l=0.15
X141 e0 t_ck0b t_Xe0_a_m1 vss sky130_fd_pr__nfet_01v8_lvt w=0.65 l=0.15
X142 e0 t_ck0bb t_Xe0_a_m1 vdd sky130_fd_pr__pfet_01v8 w=2.2 l=0.15
X143 t_Xe0_a_m2 t_Xe0_a_m1 t_Xe0_a_Xm2_mid vss sky130_fd_pr__nfet_01v8_lvt w=1 l=0.15
X144 t_Xe0_a_Xm2_mid rst_n vss vss sky130_fd_pr__nfet_01v8_lvt w=1 l=0.15
X145 t_Xe0_a_m2 t_Xe0_a_m1 vdd vdd sky130_fd_pr__pfet_01v8 w=2 l=0.15
X146 t_Xe0_a_m2 rst_n vdd vdd sky130_fd_pr__pfet_01v8 w=2 l=0.15
X147 t_Xe0_a_m3 t_Xe0_a_m2 vss vss sky130_fd_pr__nfet_01v8_lvt w=0.45 l=0.15
X148 t_Xe0_a_m3 t_Xe0_a_m2 vdd vdd sky130_fd_pr__pfet_01v8 w=1.15 l=0.15
X149 t_Xe0_a_m3 t_ck0bb t_Xe0_a_m1 vss sky130_fd_pr__nfet_01v8_lvt w=0.45 l=0.15
X150 t_Xe0_a_m3 t_ck0b t_Xe0_a_m1 vdd sky130_fd_pr__pfet_01v8 w=1.05 l=0.15
X151 t_Xe0_a_m2 t_ck0bb t_Xe0_a_s1 vss sky130_fd_pr__nfet_01v8_lvt w=0.65 l=0.15
X152 t_Xe0_a_m2 t_ck0b t_Xe0_a_s1 vdd sky130_fd_pr__pfet_01v8 w=2.2 l=0.15
X153 t_Xe0_a_qi t_Xe0_a_s1 vss vss sky130_fd_pr__nfet_01v8_lvt w=0.65 l=0.15
X154 t_Xe0_a_qi t_Xe0_a_s1 vdd vdd sky130_fd_pr__pfet_01v8 w=1.65 l=0.15
X155 t_Xe0_a_s2 t_Xe0_a_qi t_Xe0_a_Xsfb_mid vss sky130_fd_pr__nfet_01v8_lvt w=0.8 l=0.15
X156 t_Xe0_a_Xsfb_mid rst_n vss vss sky130_fd_pr__nfet_01v8_lvt w=0.8 l=0.15
X157 t_Xe0_a_s2 t_Xe0_a_qi vdd vdd sky130_fd_pr__pfet_01v8 w=1.4 l=0.15
X158 t_Xe0_a_s2 rst_n vdd vdd sky130_fd_pr__pfet_01v8 w=1.4 l=0.15
X159 t_Xe0_a_s2 t_ck0b t_Xe0_a_s1 vss sky130_fd_pr__nfet_01v8_lvt w=0.45 l=0.15
X160 t_Xe0_a_s2 t_ck0bb t_Xe0_a_s1 vdd sky130_fd_pr__pfet_01v8 w=1.05 l=0.15
X161 t_e0_a t_Xe0_a_s1 vss vss sky130_fd_pr__nfet_01v8_lvt w=0.8 l=0.15
X162 t_e0_a t_Xe0_a_s1 vdd vdd sky130_fd_pr__pfet_01v8 w=2.4 l=0.15
X163 t_e0_ab t_e0_a vss vss sky130_fd_pr__nfet_01v8_lvt w=0.55 l=0.15
X164 t_e0_ab t_e0_a vdd vdd sky130_fd_pr__pfet_01v8 w=1.4 l=0.15
X165 t_e0_a t_ck0bb t_Xe0_p_m1 vss sky130_fd_pr__nfet_01v8_lvt w=0.65 l=0.15
X166 t_e0_a t_ck0b t_Xe0_p_m1 vdd sky130_fd_pr__pfet_01v8 w=2.2 l=0.15
X167 t_Xe0_p_m2 t_Xe0_p_m1 t_Xe0_p_Xm2_mid vss sky130_fd_pr__nfet_01v8_lvt w=1 l=0.15
X168 t_Xe0_p_Xm2_mid rst_n vss vss sky130_fd_pr__nfet_01v8_lvt w=1 l=0.15
X169 t_Xe0_p_m2 t_Xe0_p_m1 vdd vdd sky130_fd_pr__pfet_01v8 w=2 l=0.15
X170 t_Xe0_p_m2 rst_n vdd vdd sky130_fd_pr__pfet_01v8 w=2 l=0.15
X171 t_Xe0_p_m3 t_Xe0_p_m2 vss vss sky130_fd_pr__nfet_01v8_lvt w=0.45 l=0.15
X172 t_Xe0_p_m3 t_Xe0_p_m2 vdd vdd sky130_fd_pr__pfet_01v8 w=1.15 l=0.15
X173 t_Xe0_p_m3 t_ck0b t_Xe0_p_m1 vss sky130_fd_pr__nfet_01v8_lvt w=0.45 l=0.15
X174 t_Xe0_p_m3 t_ck0bb t_Xe0_p_m1 vdd sky130_fd_pr__pfet_01v8 w=1.05 l=0.15
X175 t_Xe0_p_m2 t_ck0b t_Xe0_p_s1 vss sky130_fd_pr__nfet_01v8_lvt w=0.65 l=0.15
X176 t_Xe0_p_m2 t_ck0bb t_Xe0_p_s1 vdd sky130_fd_pr__pfet_01v8 w=2.2 l=0.15
X177 t_Xe0_p_qi t_Xe0_p_s1 vss vss sky130_fd_pr__nfet_01v8_lvt w=0.65 l=0.15
X178 t_Xe0_p_qi t_Xe0_p_s1 vdd vdd sky130_fd_pr__pfet_01v8 w=1.65 l=0.15
X179 t_Xe0_p_s2 t_Xe0_p_qi t_Xe0_p_Xsfb_mid vss sky130_fd_pr__nfet_01v8_lvt w=0.8 l=0.15
X180 t_Xe0_p_Xsfb_mid rst_n vss vss sky130_fd_pr__nfet_01v8_lvt w=0.8 l=0.15
X181 t_Xe0_p_s2 t_Xe0_p_qi vdd vdd sky130_fd_pr__pfet_01v8 w=1.4 l=0.15
X182 t_Xe0_p_s2 rst_n vdd vdd sky130_fd_pr__pfet_01v8 w=1.4 l=0.15
X183 t_Xe0_p_s2 t_ck0bb t_Xe0_p_s1 vss sky130_fd_pr__nfet_01v8_lvt w=0.45 l=0.15
X184 t_Xe0_p_s2 t_ck0b t_Xe0_p_s1 vdd sky130_fd_pr__pfet_01v8 w=1.05 l=0.15
X185 t_e0_p t_Xe0_p_s1 vss vss sky130_fd_pr__nfet_01v8_lvt w=0.8 l=0.15
X186 t_e0_p t_Xe0_p_s1 vdd vdd sky130_fd_pr__pfet_01v8 w=2.4 l=0.15
X187 t_e0_pb t_e0_p vss vss sky130_fd_pr__nfet_01v8_lvt w=0.55 l=0.15
X188 t_e0_pb t_e0_p vdd vdd sky130_fd_pr__pfet_01v8 w=1.4 l=0.15
X189 e1 t_ck0bb t_Xe1_p_m1 vss sky130_fd_pr__nfet_01v8_lvt w=0.65 l=0.15
X190 e1 t_ck0b t_Xe1_p_m1 vdd sky130_fd_pr__pfet_01v8 w=2.2 l=0.15
X191 t_Xe1_p_m2 t_Xe1_p_m1 t_Xe1_p_Xm2_mid vss sky130_fd_pr__nfet_01v8_lvt w=1 l=0.15
X192 t_Xe1_p_Xm2_mid rst_n vss vss sky130_fd_pr__nfet_01v8_lvt w=1 l=0.15
X193 t_Xe1_p_m2 t_Xe1_p_m1 vdd vdd sky130_fd_pr__pfet_01v8 w=2 l=0.15
X194 t_Xe1_p_m2 rst_n vdd vdd sky130_fd_pr__pfet_01v8 w=2 l=0.15
X195 t_Xe1_p_m3 t_Xe1_p_m2 vss vss sky130_fd_pr__nfet_01v8_lvt w=0.45 l=0.15
X196 t_Xe1_p_m3 t_Xe1_p_m2 vdd vdd sky130_fd_pr__pfet_01v8 w=1.15 l=0.15
X197 t_Xe1_p_m3 t_ck0b t_Xe1_p_m1 vss sky130_fd_pr__nfet_01v8_lvt w=0.45 l=0.15
X198 t_Xe1_p_m3 t_ck0bb t_Xe1_p_m1 vdd sky130_fd_pr__pfet_01v8 w=1.05 l=0.15
X199 t_Xe1_p_m2 t_ck0b t_Xe1_p_s1 vss sky130_fd_pr__nfet_01v8_lvt w=0.65 l=0.15
X200 t_Xe1_p_m2 t_ck0bb t_Xe1_p_s1 vdd sky130_fd_pr__pfet_01v8 w=2.2 l=0.15
X201 t_Xe1_p_qi t_Xe1_p_s1 vss vss sky130_fd_pr__nfet_01v8_lvt w=0.65 l=0.15
X202 t_Xe1_p_qi t_Xe1_p_s1 vdd vdd sky130_fd_pr__pfet_01v8 w=1.65 l=0.15
X203 t_Xe1_p_s2 t_Xe1_p_qi t_Xe1_p_Xsfb_mid vss sky130_fd_pr__nfet_01v8_lvt w=0.8 l=0.15
X204 t_Xe1_p_Xsfb_mid rst_n vss vss sky130_fd_pr__nfet_01v8_lvt w=0.8 l=0.15
X205 t_Xe1_p_s2 t_Xe1_p_qi vdd vdd sky130_fd_pr__pfet_01v8 w=1.4 l=0.15
X206 t_Xe1_p_s2 rst_n vdd vdd sky130_fd_pr__pfet_01v8 w=1.4 l=0.15
X207 t_Xe1_p_s2 t_ck0bb t_Xe1_p_s1 vss sky130_fd_pr__nfet_01v8_lvt w=0.45 l=0.15
X208 t_Xe1_p_s2 t_ck0b t_Xe1_p_s1 vdd sky130_fd_pr__pfet_01v8 w=1.05 l=0.15
X209 t_e1_p t_Xe1_p_s1 vss vss sky130_fd_pr__nfet_01v8_lvt w=0.8 l=0.15
X210 t_e1_p t_Xe1_p_s1 vdd vdd sky130_fd_pr__pfet_01v8 w=2.4 l=0.15
X211 t_e1_pb t_e1_p vss vss sky130_fd_pr__nfet_01v8_lvt w=0.55 l=0.15
X212 t_e1_pb t_e1_p vdd vdd sky130_fd_pr__pfet_01v8 w=1.4 l=0.15
X213 d3 t_ck0a t_Xd3_a_m1 vss sky130_fd_pr__nfet_01v8_lvt w=0.65 l=0.15
X214 d3 t_ck0ba t_Xd3_a_m1 vdd sky130_fd_pr__pfet_01v8 w=2.2 l=0.15
X215 t_Xd3_a_m2 t_Xd3_a_m1 t_Xd3_a_Xm2_mid vss sky130_fd_pr__nfet_01v8_lvt w=1 l=0.15
X216 t_Xd3_a_Xm2_mid rst_n vss vss sky130_fd_pr__nfet_01v8_lvt w=1 l=0.15
X217 t_Xd3_a_m2 t_Xd3_a_m1 vdd vdd sky130_fd_pr__pfet_01v8 w=2 l=0.15
X218 t_Xd3_a_m2 rst_n vdd vdd sky130_fd_pr__pfet_01v8 w=2 l=0.15
X219 t_Xd3_a_m3 t_Xd3_a_m2 vss vss sky130_fd_pr__nfet_01v8_lvt w=0.45 l=0.15
X220 t_Xd3_a_m3 t_Xd3_a_m2 vdd vdd sky130_fd_pr__pfet_01v8 w=1.15 l=0.15
X221 t_Xd3_a_m3 t_ck0ba t_Xd3_a_m1 vss sky130_fd_pr__nfet_01v8_lvt w=0.45 l=0.15
X222 t_Xd3_a_m3 t_ck0a t_Xd3_a_m1 vdd sky130_fd_pr__pfet_01v8 w=1.05 l=0.15
X223 t_Xd3_a_m2 t_ck0ba t_Xd3_a_s1 vss sky130_fd_pr__nfet_01v8_lvt w=0.65 l=0.15
X224 t_Xd3_a_m2 t_ck0a t_Xd3_a_s1 vdd sky130_fd_pr__pfet_01v8 w=2.2 l=0.15
X225 t_Xd3_a_qi t_Xd3_a_s1 vss vss sky130_fd_pr__nfet_01v8_lvt w=0.65 l=0.15
X226 t_Xd3_a_qi t_Xd3_a_s1 vdd vdd sky130_fd_pr__pfet_01v8 w=1.65 l=0.15
X227 t_Xd3_a_s2 t_Xd3_a_qi t_Xd3_a_Xsfb_mid vss sky130_fd_pr__nfet_01v8_lvt w=0.8 l=0.15
X228 t_Xd3_a_Xsfb_mid rst_n vss vss sky130_fd_pr__nfet_01v8_lvt w=0.8 l=0.15
X229 t_Xd3_a_s2 t_Xd3_a_qi vdd vdd sky130_fd_pr__pfet_01v8 w=1.4 l=0.15
X230 t_Xd3_a_s2 rst_n vdd vdd sky130_fd_pr__pfet_01v8 w=1.4 l=0.15
X231 t_Xd3_a_s2 t_ck0a t_Xd3_a_s1 vss sky130_fd_pr__nfet_01v8_lvt w=0.45 l=0.15
X232 t_Xd3_a_s2 t_ck0ba t_Xd3_a_s1 vdd sky130_fd_pr__pfet_01v8 w=1.05 l=0.15
X233 t_d3_a t_Xd3_a_s1 vss vss sky130_fd_pr__nfet_01v8_lvt w=0.8 l=0.15
X234 t_d3_a t_Xd3_a_s1 vdd vdd sky130_fd_pr__pfet_01v8 w=2.4 l=0.15
X235 t_d3_ab t_d3_a vss vss sky130_fd_pr__nfet_01v8_lvt w=0.55 l=0.15
X236 t_d3_ab t_d3_a vdd vdd sky130_fd_pr__pfet_01v8 w=1.4 l=0.15
X237 e2 t_ck0bb t_Xe2_p_m1 vss sky130_fd_pr__nfet_01v8_lvt w=0.65 l=0.15
X238 e2 t_ck0b t_Xe2_p_m1 vdd sky130_fd_pr__pfet_01v8 w=2.2 l=0.15
X239 t_Xe2_p_m2 t_Xe2_p_m1 t_Xe2_p_Xm2_mid vss sky130_fd_pr__nfet_01v8_lvt w=1 l=0.15
X240 t_Xe2_p_Xm2_mid rst_n vss vss sky130_fd_pr__nfet_01v8_lvt w=1 l=0.15
X241 t_Xe2_p_m2 t_Xe2_p_m1 vdd vdd sky130_fd_pr__pfet_01v8 w=2 l=0.15
X242 t_Xe2_p_m2 rst_n vdd vdd sky130_fd_pr__pfet_01v8 w=2 l=0.15
X243 t_Xe2_p_m3 t_Xe2_p_m2 vss vss sky130_fd_pr__nfet_01v8_lvt w=0.45 l=0.15
X244 t_Xe2_p_m3 t_Xe2_p_m2 vdd vdd sky130_fd_pr__pfet_01v8 w=1.15 l=0.15
X245 t_Xe2_p_m3 t_ck0b t_Xe2_p_m1 vss sky130_fd_pr__nfet_01v8_lvt w=0.45 l=0.15
X246 t_Xe2_p_m3 t_ck0bb t_Xe2_p_m1 vdd sky130_fd_pr__pfet_01v8 w=1.05 l=0.15
X247 t_Xe2_p_m2 t_ck0b t_Xe2_p_s1 vss sky130_fd_pr__nfet_01v8_lvt w=0.65 l=0.15
X248 t_Xe2_p_m2 t_ck0bb t_Xe2_p_s1 vdd sky130_fd_pr__pfet_01v8 w=2.2 l=0.15
X249 t_Xe2_p_qi t_Xe2_p_s1 vss vss sky130_fd_pr__nfet_01v8_lvt w=0.65 l=0.15
X250 t_Xe2_p_qi t_Xe2_p_s1 vdd vdd sky130_fd_pr__pfet_01v8 w=1.65 l=0.15
X251 t_Xe2_p_s2 t_Xe2_p_qi t_Xe2_p_Xsfb_mid vss sky130_fd_pr__nfet_01v8_lvt w=0.8 l=0.15
X252 t_Xe2_p_Xsfb_mid rst_n vss vss sky130_fd_pr__nfet_01v8_lvt w=0.8 l=0.15
X253 t_Xe2_p_s2 t_Xe2_p_qi vdd vdd sky130_fd_pr__pfet_01v8 w=1.4 l=0.15
X254 t_Xe2_p_s2 rst_n vdd vdd sky130_fd_pr__pfet_01v8 w=1.4 l=0.15
X255 t_Xe2_p_s2 t_ck0bb t_Xe2_p_s1 vss sky130_fd_pr__nfet_01v8_lvt w=0.45 l=0.15
X256 t_Xe2_p_s2 t_ck0b t_Xe2_p_s1 vdd sky130_fd_pr__pfet_01v8 w=1.05 l=0.15
X257 t_e2_p t_Xe2_p_s1 vss vss sky130_fd_pr__nfet_01v8_lvt w=0.8 l=0.15
X258 t_e2_p t_Xe2_p_s1 vdd vdd sky130_fd_pr__pfet_01v8 w=2.4 l=0.15
X259 t_e2_pb t_e2_p vss vss sky130_fd_pr__nfet_01v8_lvt w=0.55 l=0.15
X260 t_e2_pb t_e2_p vdd vdd sky130_fd_pr__pfet_01v8 w=1.4 l=0.15
X261 t_e2_p t_ck0b t_Xe2_a_m1 vss sky130_fd_pr__nfet_01v8_lvt w=0.65 l=0.15
X262 t_e2_p t_ck0bb t_Xe2_a_m1 vdd sky130_fd_pr__pfet_01v8 w=2.2 l=0.15
X263 t_Xe2_a_m2 t_Xe2_a_m1 t_Xe2_a_Xm2_mid vss sky130_fd_pr__nfet_01v8_lvt w=1 l=0.15
X264 t_Xe2_a_Xm2_mid rst_n vss vss sky130_fd_pr__nfet_01v8_lvt w=1 l=0.15
X265 t_Xe2_a_m2 t_Xe2_a_m1 vdd vdd sky130_fd_pr__pfet_01v8 w=2 l=0.15
X266 t_Xe2_a_m2 rst_n vdd vdd sky130_fd_pr__pfet_01v8 w=2 l=0.15
X267 t_Xe2_a_m3 t_Xe2_a_m2 vss vss sky130_fd_pr__nfet_01v8_lvt w=0.45 l=0.15
X268 t_Xe2_a_m3 t_Xe2_a_m2 vdd vdd sky130_fd_pr__pfet_01v8 w=1.15 l=0.15
X269 t_Xe2_a_m3 t_ck0bb t_Xe2_a_m1 vss sky130_fd_pr__nfet_01v8_lvt w=0.45 l=0.15
X270 t_Xe2_a_m3 t_ck0b t_Xe2_a_m1 vdd sky130_fd_pr__pfet_01v8 w=1.05 l=0.15
X271 t_Xe2_a_m2 t_ck0bb t_Xe2_a_s1 vss sky130_fd_pr__nfet_01v8_lvt w=0.65 l=0.15
X272 t_Xe2_a_m2 t_ck0b t_Xe2_a_s1 vdd sky130_fd_pr__pfet_01v8 w=2.2 l=0.15
X273 t_Xe2_a_qi t_Xe2_a_s1 vss vss sky130_fd_pr__nfet_01v8_lvt w=0.65 l=0.15
X274 t_Xe2_a_qi t_Xe2_a_s1 vdd vdd sky130_fd_pr__pfet_01v8 w=1.65 l=0.15
X275 t_Xe2_a_s2 t_Xe2_a_qi t_Xe2_a_Xsfb_mid vss sky130_fd_pr__nfet_01v8_lvt w=0.8 l=0.15
X276 t_Xe2_a_Xsfb_mid rst_n vss vss sky130_fd_pr__nfet_01v8_lvt w=0.8 l=0.15
X277 t_Xe2_a_s2 t_Xe2_a_qi vdd vdd sky130_fd_pr__pfet_01v8 w=1.4 l=0.15
X278 t_Xe2_a_s2 rst_n vdd vdd sky130_fd_pr__pfet_01v8 w=1.4 l=0.15
X279 t_Xe2_a_s2 t_ck0b t_Xe2_a_s1 vss sky130_fd_pr__nfet_01v8_lvt w=0.45 l=0.15
X280 t_Xe2_a_s2 t_ck0bb t_Xe2_a_s1 vdd sky130_fd_pr__pfet_01v8 w=1.05 l=0.15
X281 t_e2_a t_Xe2_a_s1 vss vss sky130_fd_pr__nfet_01v8_lvt w=0.8 l=0.15
X282 t_e2_a t_Xe2_a_s1 vdd vdd sky130_fd_pr__pfet_01v8 w=2.4 l=0.15
X283 t_e2_ab t_e2_a vss vss sky130_fd_pr__nfet_01v8_lvt w=0.55 l=0.15
X284 t_e2_ab t_e2_a vdd vdd sky130_fd_pr__pfet_01v8 w=1.4 l=0.15
X285 e3 t_ck0b t_Xe3_a_m1 vss sky130_fd_pr__nfet_01v8_lvt w=0.65 l=0.15
X286 e3 t_ck0bb t_Xe3_a_m1 vdd sky130_fd_pr__pfet_01v8 w=2.2 l=0.15
X287 t_Xe3_a_m2 t_Xe3_a_m1 t_Xe3_a_Xm2_mid vss sky130_fd_pr__nfet_01v8_lvt w=1 l=0.15
X288 t_Xe3_a_Xm2_mid rst_n vss vss sky130_fd_pr__nfet_01v8_lvt w=1 l=0.15
X289 t_Xe3_a_m2 t_Xe3_a_m1 vdd vdd sky130_fd_pr__pfet_01v8 w=2 l=0.15
X290 t_Xe3_a_m2 rst_n vdd vdd sky130_fd_pr__pfet_01v8 w=2 l=0.15
X291 t_Xe3_a_m3 t_Xe3_a_m2 vss vss sky130_fd_pr__nfet_01v8_lvt w=0.45 l=0.15
X292 t_Xe3_a_m3 t_Xe3_a_m2 vdd vdd sky130_fd_pr__pfet_01v8 w=1.15 l=0.15
X293 t_Xe3_a_m3 t_ck0bb t_Xe3_a_m1 vss sky130_fd_pr__nfet_01v8_lvt w=0.45 l=0.15
X294 t_Xe3_a_m3 t_ck0b t_Xe3_a_m1 vdd sky130_fd_pr__pfet_01v8 w=1.05 l=0.15
X295 t_Xe3_a_m2 t_ck0bb t_Xe3_a_s1 vss sky130_fd_pr__nfet_01v8_lvt w=0.65 l=0.15
X296 t_Xe3_a_m2 t_ck0b t_Xe3_a_s1 vdd sky130_fd_pr__pfet_01v8 w=2.2 l=0.15
X297 t_Xe3_a_qi t_Xe3_a_s1 vss vss sky130_fd_pr__nfet_01v8_lvt w=0.65 l=0.15
X298 t_Xe3_a_qi t_Xe3_a_s1 vdd vdd sky130_fd_pr__pfet_01v8 w=1.65 l=0.15
X299 t_Xe3_a_s2 t_Xe3_a_qi t_Xe3_a_Xsfb_mid vss sky130_fd_pr__nfet_01v8_lvt w=0.8 l=0.15
X300 t_Xe3_a_Xsfb_mid rst_n vss vss sky130_fd_pr__nfet_01v8_lvt w=0.8 l=0.15
X301 t_Xe3_a_s2 t_Xe3_a_qi vdd vdd sky130_fd_pr__pfet_01v8 w=1.4 l=0.15
X302 t_Xe3_a_s2 rst_n vdd vdd sky130_fd_pr__pfet_01v8 w=1.4 l=0.15
X303 t_Xe3_a_s2 t_ck0b t_Xe3_a_s1 vss sky130_fd_pr__nfet_01v8_lvt w=0.45 l=0.15
X304 t_Xe3_a_s2 t_ck0bb t_Xe3_a_s1 vdd sky130_fd_pr__pfet_01v8 w=1.05 l=0.15
X305 t_e3_a t_Xe3_a_s1 vss vss sky130_fd_pr__nfet_01v8_lvt w=0.8 l=0.15
X306 t_e3_a t_Xe3_a_s1 vdd vdd sky130_fd_pr__pfet_01v8 w=2.4 l=0.15
X307 t_e3_ab t_e3_a vss vss sky130_fd_pr__nfet_01v8_lvt w=0.55 l=0.15
X308 t_e3_ab t_e3_a vdd vdd sky130_fd_pr__pfet_01v8 w=1.4 l=0.15
X309 t_d0_p t_ck0ba t_Xsh_d0_Xf0_m1 vss sky130_fd_pr__nfet_01v8_lvt w=0.65 l=0.15
X310 t_d0_p t_ck0a t_Xsh_d0_Xf0_m1 vdd sky130_fd_pr__pfet_01v8 w=2.2 l=0.15
X311 t_Xsh_d0_Xf0_m2 t_Xsh_d0_Xf0_m1 t_Xsh_d0_Xf0_Xm2_mid vss sky130_fd_pr__nfet_01v8_lvt w=1 l=0.15
X312 t_Xsh_d0_Xf0_Xm2_mid rst_n vss vss sky130_fd_pr__nfet_01v8_lvt w=1 l=0.15
X313 t_Xsh_d0_Xf0_m2 t_Xsh_d0_Xf0_m1 vdd vdd sky130_fd_pr__pfet_01v8 w=2 l=0.15
X314 t_Xsh_d0_Xf0_m2 rst_n vdd vdd sky130_fd_pr__pfet_01v8 w=2 l=0.15
X315 t_Xsh_d0_Xf0_m3 t_Xsh_d0_Xf0_m2 vss vss sky130_fd_pr__nfet_01v8_lvt w=0.45 l=0.15
X316 t_Xsh_d0_Xf0_m3 t_Xsh_d0_Xf0_m2 vdd vdd sky130_fd_pr__pfet_01v8 w=1.15 l=0.15
X317 t_Xsh_d0_Xf0_m3 t_ck0a t_Xsh_d0_Xf0_m1 vss sky130_fd_pr__nfet_01v8_lvt w=0.45 l=0.15
X318 t_Xsh_d0_Xf0_m3 t_ck0ba t_Xsh_d0_Xf0_m1 vdd sky130_fd_pr__pfet_01v8 w=1.05 l=0.15
X319 t_Xsh_d0_Xf0_m2 t_ck0a t_Xsh_d0_Xf0_s1 vss sky130_fd_pr__nfet_01v8_lvt w=0.65 l=0.15
X320 t_Xsh_d0_Xf0_m2 t_ck0ba t_Xsh_d0_Xf0_s1 vdd sky130_fd_pr__pfet_01v8 w=2.2 l=0.15
X321 t_Xsh_d0_Xf0_qi t_Xsh_d0_Xf0_s1 vss vss sky130_fd_pr__nfet_01v8_lvt w=0.65 l=0.15
X322 t_Xsh_d0_Xf0_qi t_Xsh_d0_Xf0_s1 vdd vdd sky130_fd_pr__pfet_01v8 w=1.65 l=0.15
X323 t_Xsh_d0_Xf0_s2 t_Xsh_d0_Xf0_qi t_Xsh_d0_Xf0_Xsfb_mid vss sky130_fd_pr__nfet_01v8_lvt w=0.8 l=0.15
X324 t_Xsh_d0_Xf0_Xsfb_mid rst_n vss vss sky130_fd_pr__nfet_01v8_lvt w=0.8 l=0.15
X325 t_Xsh_d0_Xf0_s2 t_Xsh_d0_Xf0_qi vdd vdd sky130_fd_pr__pfet_01v8 w=1.4 l=0.15
X326 t_Xsh_d0_Xf0_s2 rst_n vdd vdd sky130_fd_pr__pfet_01v8 w=1.4 l=0.15
X327 t_Xsh_d0_Xf0_s2 t_ck0ba t_Xsh_d0_Xf0_s1 vss sky130_fd_pr__nfet_01v8_lvt w=0.45 l=0.15
X328 t_Xsh_d0_Xf0_s2 t_ck0a t_Xsh_d0_Xf0_s1 vdd sky130_fd_pr__pfet_01v8 w=1.05 l=0.15
X329 t_d0_0 t_Xsh_d0_Xf0_s1 vss vss sky130_fd_pr__nfet_01v8_lvt w=0.8 l=0.15
X330 t_d0_0 t_Xsh_d0_Xf0_s1 vdd vdd sky130_fd_pr__pfet_01v8 w=2.4 l=0.15
X331 t_Xsh_d0_s0b t_d0_0 vss vss sky130_fd_pr__nfet_01v8_lvt w=0.55 l=0.15
X332 t_Xsh_d0_s0b t_d0_0 vdd vdd sky130_fd_pr__pfet_01v8 w=1.4 l=0.15
X333 t_d0_0 t_ck0ba t_Xsh_d0_Xf1_m1 vss sky130_fd_pr__nfet_01v8_lvt w=0.65 l=0.15
X334 t_d0_0 t_ck0a t_Xsh_d0_Xf1_m1 vdd sky130_fd_pr__pfet_01v8 w=2.2 l=0.15
X335 t_Xsh_d0_Xf1_m2 t_Xsh_d0_Xf1_m1 t_Xsh_d0_Xf1_Xm2_mid vss sky130_fd_pr__nfet_01v8_lvt w=1 l=0.15
X336 t_Xsh_d0_Xf1_Xm2_mid rst_n vss vss sky130_fd_pr__nfet_01v8_lvt w=1 l=0.15
X337 t_Xsh_d0_Xf1_m2 t_Xsh_d0_Xf1_m1 vdd vdd sky130_fd_pr__pfet_01v8 w=2 l=0.15
X338 t_Xsh_d0_Xf1_m2 rst_n vdd vdd sky130_fd_pr__pfet_01v8 w=2 l=0.15
X339 t_Xsh_d0_Xf1_m3 t_Xsh_d0_Xf1_m2 vss vss sky130_fd_pr__nfet_01v8_lvt w=0.45 l=0.15
X340 t_Xsh_d0_Xf1_m3 t_Xsh_d0_Xf1_m2 vdd vdd sky130_fd_pr__pfet_01v8 w=1.15 l=0.15
X341 t_Xsh_d0_Xf1_m3 t_ck0a t_Xsh_d0_Xf1_m1 vss sky130_fd_pr__nfet_01v8_lvt w=0.45 l=0.15
X342 t_Xsh_d0_Xf1_m3 t_ck0ba t_Xsh_d0_Xf1_m1 vdd sky130_fd_pr__pfet_01v8 w=1.05 l=0.15
X343 t_Xsh_d0_Xf1_m2 t_ck0a t_Xsh_d0_Xf1_s1 vss sky130_fd_pr__nfet_01v8_lvt w=0.65 l=0.15
X344 t_Xsh_d0_Xf1_m2 t_ck0ba t_Xsh_d0_Xf1_s1 vdd sky130_fd_pr__pfet_01v8 w=2.2 l=0.15
X345 t_Xsh_d0_Xf1_qi t_Xsh_d0_Xf1_s1 vss vss sky130_fd_pr__nfet_01v8_lvt w=0.65 l=0.15
X346 t_Xsh_d0_Xf1_qi t_Xsh_d0_Xf1_s1 vdd vdd sky130_fd_pr__pfet_01v8 w=1.65 l=0.15
X347 t_Xsh_d0_Xf1_s2 t_Xsh_d0_Xf1_qi t_Xsh_d0_Xf1_Xsfb_mid vss sky130_fd_pr__nfet_01v8_lvt w=0.8 l=0.15
X348 t_Xsh_d0_Xf1_Xsfb_mid rst_n vss vss sky130_fd_pr__nfet_01v8_lvt w=0.8 l=0.15
X349 t_Xsh_d0_Xf1_s2 t_Xsh_d0_Xf1_qi vdd vdd sky130_fd_pr__pfet_01v8 w=1.4 l=0.15
X350 t_Xsh_d0_Xf1_s2 rst_n vdd vdd sky130_fd_pr__pfet_01v8 w=1.4 l=0.15
X351 t_Xsh_d0_Xf1_s2 t_ck0ba t_Xsh_d0_Xf1_s1 vss sky130_fd_pr__nfet_01v8_lvt w=0.45 l=0.15
X352 t_Xsh_d0_Xf1_s2 t_ck0a t_Xsh_d0_Xf1_s1 vdd sky130_fd_pr__pfet_01v8 w=1.05 l=0.15
X353 t_d0_1 t_Xsh_d0_Xf1_s1 vss vss sky130_fd_pr__nfet_01v8_lvt w=0.8 l=0.15
X354 t_d0_1 t_Xsh_d0_Xf1_s1 vdd vdd sky130_fd_pr__pfet_01v8 w=2.4 l=0.15
X355 t_Xsh_d0_s1b t_d0_1 vss vss sky130_fd_pr__nfet_01v8_lvt w=0.55 l=0.15
X356 t_Xsh_d0_s1b t_d0_1 vdd vdd sky130_fd_pr__pfet_01v8 w=1.4 l=0.15
X357 t_d0_1 t_ck0ba t_Xsh_d0_Xf2_m1 vss sky130_fd_pr__nfet_01v8_lvt w=0.65 l=0.15
X358 t_d0_1 t_ck0a t_Xsh_d0_Xf2_m1 vdd sky130_fd_pr__pfet_01v8 w=2.2 l=0.15
X359 t_Xsh_d0_Xf2_m2 t_Xsh_d0_Xf2_m1 t_Xsh_d0_Xf2_Xm2_mid vss sky130_fd_pr__nfet_01v8_lvt w=1 l=0.15
X360 t_Xsh_d0_Xf2_Xm2_mid rst_n vss vss sky130_fd_pr__nfet_01v8_lvt w=1 l=0.15
X361 t_Xsh_d0_Xf2_m2 t_Xsh_d0_Xf2_m1 vdd vdd sky130_fd_pr__pfet_01v8 w=2 l=0.15
X362 t_Xsh_d0_Xf2_m2 rst_n vdd vdd sky130_fd_pr__pfet_01v8 w=2 l=0.15
X363 t_Xsh_d0_Xf2_m3 t_Xsh_d0_Xf2_m2 vss vss sky130_fd_pr__nfet_01v8_lvt w=0.45 l=0.15
X364 t_Xsh_d0_Xf2_m3 t_Xsh_d0_Xf2_m2 vdd vdd sky130_fd_pr__pfet_01v8 w=1.15 l=0.15
X365 t_Xsh_d0_Xf2_m3 t_ck0a t_Xsh_d0_Xf2_m1 vss sky130_fd_pr__nfet_01v8_lvt w=0.45 l=0.15
X366 t_Xsh_d0_Xf2_m3 t_ck0ba t_Xsh_d0_Xf2_m1 vdd sky130_fd_pr__pfet_01v8 w=1.05 l=0.15
X367 t_Xsh_d0_Xf2_m2 t_ck0a t_Xsh_d0_Xf2_s1 vss sky130_fd_pr__nfet_01v8_lvt w=0.65 l=0.15
X368 t_Xsh_d0_Xf2_m2 t_ck0ba t_Xsh_d0_Xf2_s1 vdd sky130_fd_pr__pfet_01v8 w=2.2 l=0.15
X369 t_Xsh_d0_Xf2_qi t_Xsh_d0_Xf2_s1 vss vss sky130_fd_pr__nfet_01v8_lvt w=0.65 l=0.15
X370 t_Xsh_d0_Xf2_qi t_Xsh_d0_Xf2_s1 vdd vdd sky130_fd_pr__pfet_01v8 w=1.65 l=0.15
X371 t_Xsh_d0_Xf2_s2 t_Xsh_d0_Xf2_qi t_Xsh_d0_Xf2_Xsfb_mid vss sky130_fd_pr__nfet_01v8_lvt w=0.8 l=0.15
X372 t_Xsh_d0_Xf2_Xsfb_mid rst_n vss vss sky130_fd_pr__nfet_01v8_lvt w=0.8 l=0.15
X373 t_Xsh_d0_Xf2_s2 t_Xsh_d0_Xf2_qi vdd vdd sky130_fd_pr__pfet_01v8 w=1.4 l=0.15
X374 t_Xsh_d0_Xf2_s2 rst_n vdd vdd sky130_fd_pr__pfet_01v8 w=1.4 l=0.15
X375 t_Xsh_d0_Xf2_s2 t_ck0ba t_Xsh_d0_Xf2_s1 vss sky130_fd_pr__nfet_01v8_lvt w=0.45 l=0.15
X376 t_Xsh_d0_Xf2_s2 t_ck0a t_Xsh_d0_Xf2_s1 vdd sky130_fd_pr__pfet_01v8 w=1.05 l=0.15
X377 t_d0_2 t_Xsh_d0_Xf2_s1 vss vss sky130_fd_pr__nfet_01v8_lvt w=0.8 l=0.15
X378 t_d0_2 t_Xsh_d0_Xf2_s1 vdd vdd sky130_fd_pr__pfet_01v8 w=2.4 l=0.15
X379 t_Xsh_d0_s2b t_d0_2 vss vss sky130_fd_pr__nfet_01v8_lvt w=0.55 l=0.15
X380 t_Xsh_d0_s2b t_d0_2 vdd vdd sky130_fd_pr__pfet_01v8 w=1.4 l=0.15
X381 t_d0_2 t_ck0ba t_Xsh_d0_Xf3_m1 vss sky130_fd_pr__nfet_01v8_lvt w=0.65 l=0.15
X382 t_d0_2 t_ck0a t_Xsh_d0_Xf3_m1 vdd sky130_fd_pr__pfet_01v8 w=2.2 l=0.15
X383 t_Xsh_d0_Xf3_m2 t_Xsh_d0_Xf3_m1 t_Xsh_d0_Xf3_Xm2_mid vss sky130_fd_pr__nfet_01v8_lvt w=1 l=0.15
X384 t_Xsh_d0_Xf3_Xm2_mid rst_n vss vss sky130_fd_pr__nfet_01v8_lvt w=1 l=0.15
X385 t_Xsh_d0_Xf3_m2 t_Xsh_d0_Xf3_m1 vdd vdd sky130_fd_pr__pfet_01v8 w=2 l=0.15
X386 t_Xsh_d0_Xf3_m2 rst_n vdd vdd sky130_fd_pr__pfet_01v8 w=2 l=0.15
X387 t_Xsh_d0_Xf3_m3 t_Xsh_d0_Xf3_m2 vss vss sky130_fd_pr__nfet_01v8_lvt w=0.45 l=0.15
X388 t_Xsh_d0_Xf3_m3 t_Xsh_d0_Xf3_m2 vdd vdd sky130_fd_pr__pfet_01v8 w=1.15 l=0.15
X389 t_Xsh_d0_Xf3_m3 t_ck0a t_Xsh_d0_Xf3_m1 vss sky130_fd_pr__nfet_01v8_lvt w=0.45 l=0.15
X390 t_Xsh_d0_Xf3_m3 t_ck0ba t_Xsh_d0_Xf3_m1 vdd sky130_fd_pr__pfet_01v8 w=1.05 l=0.15
X391 t_Xsh_d0_Xf3_m2 t_ck0a t_Xsh_d0_Xf3_s1 vss sky130_fd_pr__nfet_01v8_lvt w=0.65 l=0.15
X392 t_Xsh_d0_Xf3_m2 t_ck0ba t_Xsh_d0_Xf3_s1 vdd sky130_fd_pr__pfet_01v8 w=2.2 l=0.15
X393 t_Xsh_d0_Xf3_qi t_Xsh_d0_Xf3_s1 vss vss sky130_fd_pr__nfet_01v8_lvt w=0.65 l=0.15
X394 t_Xsh_d0_Xf3_qi t_Xsh_d0_Xf3_s1 vdd vdd sky130_fd_pr__pfet_01v8 w=1.65 l=0.15
X395 t_Xsh_d0_Xf3_s2 t_Xsh_d0_Xf3_qi t_Xsh_d0_Xf3_Xsfb_mid vss sky130_fd_pr__nfet_01v8_lvt w=0.8 l=0.15
X396 t_Xsh_d0_Xf3_Xsfb_mid rst_n vss vss sky130_fd_pr__nfet_01v8_lvt w=0.8 l=0.15
X397 t_Xsh_d0_Xf3_s2 t_Xsh_d0_Xf3_qi vdd vdd sky130_fd_pr__pfet_01v8 w=1.4 l=0.15
X398 t_Xsh_d0_Xf3_s2 rst_n vdd vdd sky130_fd_pr__pfet_01v8 w=1.4 l=0.15
X399 t_Xsh_d0_Xf3_s2 t_ck0ba t_Xsh_d0_Xf3_s1 vss sky130_fd_pr__nfet_01v8_lvt w=0.45 l=0.15
X400 t_Xsh_d0_Xf3_s2 t_ck0a t_Xsh_d0_Xf3_s1 vdd sky130_fd_pr__pfet_01v8 w=1.05 l=0.15
X401 t_d0_3 t_Xsh_d0_Xf3_s1 vss vss sky130_fd_pr__nfet_01v8_lvt w=0.8 l=0.15
X402 t_d0_3 t_Xsh_d0_Xf3_s1 vdd vdd sky130_fd_pr__pfet_01v8 w=2.4 l=0.15
X403 t_Xsh_d0_s3b t_d0_3 vss vss sky130_fd_pr__nfet_01v8_lvt w=0.55 l=0.15
X404 t_Xsh_d0_s3b t_d0_3 vdd vdd sky130_fd_pr__pfet_01v8 w=1.4 l=0.15
X405 t_d1_p t_ck0ba t_Xsh_d1_Xf0_m1 vss sky130_fd_pr__nfet_01v8_lvt w=0.65 l=0.15
X406 t_d1_p t_ck0a t_Xsh_d1_Xf0_m1 vdd sky130_fd_pr__pfet_01v8 w=2.2 l=0.15
X407 t_Xsh_d1_Xf0_m2 t_Xsh_d1_Xf0_m1 t_Xsh_d1_Xf0_Xm2_mid vss sky130_fd_pr__nfet_01v8_lvt w=1 l=0.15
X408 t_Xsh_d1_Xf0_Xm2_mid rst_n vss vss sky130_fd_pr__nfet_01v8_lvt w=1 l=0.15
X409 t_Xsh_d1_Xf0_m2 t_Xsh_d1_Xf0_m1 vdd vdd sky130_fd_pr__pfet_01v8 w=2 l=0.15
X410 t_Xsh_d1_Xf0_m2 rst_n vdd vdd sky130_fd_pr__pfet_01v8 w=2 l=0.15
X411 t_Xsh_d1_Xf0_m3 t_Xsh_d1_Xf0_m2 vss vss sky130_fd_pr__nfet_01v8_lvt w=0.45 l=0.15
X412 t_Xsh_d1_Xf0_m3 t_Xsh_d1_Xf0_m2 vdd vdd sky130_fd_pr__pfet_01v8 w=1.15 l=0.15
X413 t_Xsh_d1_Xf0_m3 t_ck0a t_Xsh_d1_Xf0_m1 vss sky130_fd_pr__nfet_01v8_lvt w=0.45 l=0.15
X414 t_Xsh_d1_Xf0_m3 t_ck0ba t_Xsh_d1_Xf0_m1 vdd sky130_fd_pr__pfet_01v8 w=1.05 l=0.15
X415 t_Xsh_d1_Xf0_m2 t_ck0a t_Xsh_d1_Xf0_s1 vss sky130_fd_pr__nfet_01v8_lvt w=0.65 l=0.15
X416 t_Xsh_d1_Xf0_m2 t_ck0ba t_Xsh_d1_Xf0_s1 vdd sky130_fd_pr__pfet_01v8 w=2.2 l=0.15
X417 t_Xsh_d1_Xf0_qi t_Xsh_d1_Xf0_s1 vss vss sky130_fd_pr__nfet_01v8_lvt w=0.65 l=0.15
X418 t_Xsh_d1_Xf0_qi t_Xsh_d1_Xf0_s1 vdd vdd sky130_fd_pr__pfet_01v8 w=1.65 l=0.15
X419 t_Xsh_d1_Xf0_s2 t_Xsh_d1_Xf0_qi t_Xsh_d1_Xf0_Xsfb_mid vss sky130_fd_pr__nfet_01v8_lvt w=0.8 l=0.15
X420 t_Xsh_d1_Xf0_Xsfb_mid rst_n vss vss sky130_fd_pr__nfet_01v8_lvt w=0.8 l=0.15
X421 t_Xsh_d1_Xf0_s2 t_Xsh_d1_Xf0_qi vdd vdd sky130_fd_pr__pfet_01v8 w=1.4 l=0.15
X422 t_Xsh_d1_Xf0_s2 rst_n vdd vdd sky130_fd_pr__pfet_01v8 w=1.4 l=0.15
X423 t_Xsh_d1_Xf0_s2 t_ck0ba t_Xsh_d1_Xf0_s1 vss sky130_fd_pr__nfet_01v8_lvt w=0.45 l=0.15
X424 t_Xsh_d1_Xf0_s2 t_ck0a t_Xsh_d1_Xf0_s1 vdd sky130_fd_pr__pfet_01v8 w=1.05 l=0.15
X425 t_d1_0 t_Xsh_d1_Xf0_s1 vss vss sky130_fd_pr__nfet_01v8_lvt w=0.8 l=0.15
X426 t_d1_0 t_Xsh_d1_Xf0_s1 vdd vdd sky130_fd_pr__pfet_01v8 w=2.4 l=0.15
X427 t_Xsh_d1_s0b t_d1_0 vss vss sky130_fd_pr__nfet_01v8_lvt w=0.55 l=0.15
X428 t_Xsh_d1_s0b t_d1_0 vdd vdd sky130_fd_pr__pfet_01v8 w=1.4 l=0.15
X429 t_d1_0 t_ck0ba t_Xsh_d1_Xf1_m1 vss sky130_fd_pr__nfet_01v8_lvt w=0.65 l=0.15
X430 t_d1_0 t_ck0a t_Xsh_d1_Xf1_m1 vdd sky130_fd_pr__pfet_01v8 w=2.2 l=0.15
X431 t_Xsh_d1_Xf1_m2 t_Xsh_d1_Xf1_m1 t_Xsh_d1_Xf1_Xm2_mid vss sky130_fd_pr__nfet_01v8_lvt w=1 l=0.15
X432 t_Xsh_d1_Xf1_Xm2_mid rst_n vss vss sky130_fd_pr__nfet_01v8_lvt w=1 l=0.15
X433 t_Xsh_d1_Xf1_m2 t_Xsh_d1_Xf1_m1 vdd vdd sky130_fd_pr__pfet_01v8 w=2 l=0.15
X434 t_Xsh_d1_Xf1_m2 rst_n vdd vdd sky130_fd_pr__pfet_01v8 w=2 l=0.15
X435 t_Xsh_d1_Xf1_m3 t_Xsh_d1_Xf1_m2 vss vss sky130_fd_pr__nfet_01v8_lvt w=0.45 l=0.15
X436 t_Xsh_d1_Xf1_m3 t_Xsh_d1_Xf1_m2 vdd vdd sky130_fd_pr__pfet_01v8 w=1.15 l=0.15
X437 t_Xsh_d1_Xf1_m3 t_ck0a t_Xsh_d1_Xf1_m1 vss sky130_fd_pr__nfet_01v8_lvt w=0.45 l=0.15
X438 t_Xsh_d1_Xf1_m3 t_ck0ba t_Xsh_d1_Xf1_m1 vdd sky130_fd_pr__pfet_01v8 w=1.05 l=0.15
X439 t_Xsh_d1_Xf1_m2 t_ck0a t_Xsh_d1_Xf1_s1 vss sky130_fd_pr__nfet_01v8_lvt w=0.65 l=0.15
X440 t_Xsh_d1_Xf1_m2 t_ck0ba t_Xsh_d1_Xf1_s1 vdd sky130_fd_pr__pfet_01v8 w=2.2 l=0.15
X441 t_Xsh_d1_Xf1_qi t_Xsh_d1_Xf1_s1 vss vss sky130_fd_pr__nfet_01v8_lvt w=0.65 l=0.15
X442 t_Xsh_d1_Xf1_qi t_Xsh_d1_Xf1_s1 vdd vdd sky130_fd_pr__pfet_01v8 w=1.65 l=0.15
X443 t_Xsh_d1_Xf1_s2 t_Xsh_d1_Xf1_qi t_Xsh_d1_Xf1_Xsfb_mid vss sky130_fd_pr__nfet_01v8_lvt w=0.8 l=0.15
X444 t_Xsh_d1_Xf1_Xsfb_mid rst_n vss vss sky130_fd_pr__nfet_01v8_lvt w=0.8 l=0.15
X445 t_Xsh_d1_Xf1_s2 t_Xsh_d1_Xf1_qi vdd vdd sky130_fd_pr__pfet_01v8 w=1.4 l=0.15
X446 t_Xsh_d1_Xf1_s2 rst_n vdd vdd sky130_fd_pr__pfet_01v8 w=1.4 l=0.15
X447 t_Xsh_d1_Xf1_s2 t_ck0ba t_Xsh_d1_Xf1_s1 vss sky130_fd_pr__nfet_01v8_lvt w=0.45 l=0.15
X448 t_Xsh_d1_Xf1_s2 t_ck0a t_Xsh_d1_Xf1_s1 vdd sky130_fd_pr__pfet_01v8 w=1.05 l=0.15
X449 t_d1_1 t_Xsh_d1_Xf1_s1 vss vss sky130_fd_pr__nfet_01v8_lvt w=0.8 l=0.15
X450 t_d1_1 t_Xsh_d1_Xf1_s1 vdd vdd sky130_fd_pr__pfet_01v8 w=2.4 l=0.15
X451 t_Xsh_d1_s1b t_d1_1 vss vss sky130_fd_pr__nfet_01v8_lvt w=0.55 l=0.15
X452 t_Xsh_d1_s1b t_d1_1 vdd vdd sky130_fd_pr__pfet_01v8 w=1.4 l=0.15
X453 t_d1_1 t_ck0ba t_Xsh_d1_Xf2_m1 vss sky130_fd_pr__nfet_01v8_lvt w=0.65 l=0.15
X454 t_d1_1 t_ck0a t_Xsh_d1_Xf2_m1 vdd sky130_fd_pr__pfet_01v8 w=2.2 l=0.15
X455 t_Xsh_d1_Xf2_m2 t_Xsh_d1_Xf2_m1 t_Xsh_d1_Xf2_Xm2_mid vss sky130_fd_pr__nfet_01v8_lvt w=1 l=0.15
X456 t_Xsh_d1_Xf2_Xm2_mid rst_n vss vss sky130_fd_pr__nfet_01v8_lvt w=1 l=0.15
X457 t_Xsh_d1_Xf2_m2 t_Xsh_d1_Xf2_m1 vdd vdd sky130_fd_pr__pfet_01v8 w=2 l=0.15
X458 t_Xsh_d1_Xf2_m2 rst_n vdd vdd sky130_fd_pr__pfet_01v8 w=2 l=0.15
X459 t_Xsh_d1_Xf2_m3 t_Xsh_d1_Xf2_m2 vss vss sky130_fd_pr__nfet_01v8_lvt w=0.45 l=0.15
X460 t_Xsh_d1_Xf2_m3 t_Xsh_d1_Xf2_m2 vdd vdd sky130_fd_pr__pfet_01v8 w=1.15 l=0.15
X461 t_Xsh_d1_Xf2_m3 t_ck0a t_Xsh_d1_Xf2_m1 vss sky130_fd_pr__nfet_01v8_lvt w=0.45 l=0.15
X462 t_Xsh_d1_Xf2_m3 t_ck0ba t_Xsh_d1_Xf2_m1 vdd sky130_fd_pr__pfet_01v8 w=1.05 l=0.15
X463 t_Xsh_d1_Xf2_m2 t_ck0a t_Xsh_d1_Xf2_s1 vss sky130_fd_pr__nfet_01v8_lvt w=0.65 l=0.15
X464 t_Xsh_d1_Xf2_m2 t_ck0ba t_Xsh_d1_Xf2_s1 vdd sky130_fd_pr__pfet_01v8 w=2.2 l=0.15
X465 t_Xsh_d1_Xf2_qi t_Xsh_d1_Xf2_s1 vss vss sky130_fd_pr__nfet_01v8_lvt w=0.65 l=0.15
X466 t_Xsh_d1_Xf2_qi t_Xsh_d1_Xf2_s1 vdd vdd sky130_fd_pr__pfet_01v8 w=1.65 l=0.15
X467 t_Xsh_d1_Xf2_s2 t_Xsh_d1_Xf2_qi t_Xsh_d1_Xf2_Xsfb_mid vss sky130_fd_pr__nfet_01v8_lvt w=0.8 l=0.15
X468 t_Xsh_d1_Xf2_Xsfb_mid rst_n vss vss sky130_fd_pr__nfet_01v8_lvt w=0.8 l=0.15
X469 t_Xsh_d1_Xf2_s2 t_Xsh_d1_Xf2_qi vdd vdd sky130_fd_pr__pfet_01v8 w=1.4 l=0.15
X470 t_Xsh_d1_Xf2_s2 rst_n vdd vdd sky130_fd_pr__pfet_01v8 w=1.4 l=0.15
X471 t_Xsh_d1_Xf2_s2 t_ck0ba t_Xsh_d1_Xf2_s1 vss sky130_fd_pr__nfet_01v8_lvt w=0.45 l=0.15
X472 t_Xsh_d1_Xf2_s2 t_ck0a t_Xsh_d1_Xf2_s1 vdd sky130_fd_pr__pfet_01v8 w=1.05 l=0.15
X473 t_d1_2 t_Xsh_d1_Xf2_s1 vss vss sky130_fd_pr__nfet_01v8_lvt w=0.8 l=0.15
X474 t_d1_2 t_Xsh_d1_Xf2_s1 vdd vdd sky130_fd_pr__pfet_01v8 w=2.4 l=0.15
X475 t_Xsh_d1_s2b t_d1_2 vss vss sky130_fd_pr__nfet_01v8_lvt w=0.55 l=0.15
X476 t_Xsh_d1_s2b t_d1_2 vdd vdd sky130_fd_pr__pfet_01v8 w=1.4 l=0.15
X477 t_d1_2 t_ck0ba t_Xsh_d1_Xf3_m1 vss sky130_fd_pr__nfet_01v8_lvt w=0.65 l=0.15
X478 t_d1_2 t_ck0a t_Xsh_d1_Xf3_m1 vdd sky130_fd_pr__pfet_01v8 w=2.2 l=0.15
X479 t_Xsh_d1_Xf3_m2 t_Xsh_d1_Xf3_m1 t_Xsh_d1_Xf3_Xm2_mid vss sky130_fd_pr__nfet_01v8_lvt w=1 l=0.15
X480 t_Xsh_d1_Xf3_Xm2_mid rst_n vss vss sky130_fd_pr__nfet_01v8_lvt w=1 l=0.15
X481 t_Xsh_d1_Xf3_m2 t_Xsh_d1_Xf3_m1 vdd vdd sky130_fd_pr__pfet_01v8 w=2 l=0.15
X482 t_Xsh_d1_Xf3_m2 rst_n vdd vdd sky130_fd_pr__pfet_01v8 w=2 l=0.15
X483 t_Xsh_d1_Xf3_m3 t_Xsh_d1_Xf3_m2 vss vss sky130_fd_pr__nfet_01v8_lvt w=0.45 l=0.15
X484 t_Xsh_d1_Xf3_m3 t_Xsh_d1_Xf3_m2 vdd vdd sky130_fd_pr__pfet_01v8 w=1.15 l=0.15
X485 t_Xsh_d1_Xf3_m3 t_ck0a t_Xsh_d1_Xf3_m1 vss sky130_fd_pr__nfet_01v8_lvt w=0.45 l=0.15
X486 t_Xsh_d1_Xf3_m3 t_ck0ba t_Xsh_d1_Xf3_m1 vdd sky130_fd_pr__pfet_01v8 w=1.05 l=0.15
X487 t_Xsh_d1_Xf3_m2 t_ck0a t_Xsh_d1_Xf3_s1 vss sky130_fd_pr__nfet_01v8_lvt w=0.65 l=0.15
X488 t_Xsh_d1_Xf3_m2 t_ck0ba t_Xsh_d1_Xf3_s1 vdd sky130_fd_pr__pfet_01v8 w=2.2 l=0.15
X489 t_Xsh_d1_Xf3_qi t_Xsh_d1_Xf3_s1 vss vss sky130_fd_pr__nfet_01v8_lvt w=0.65 l=0.15
X490 t_Xsh_d1_Xf3_qi t_Xsh_d1_Xf3_s1 vdd vdd sky130_fd_pr__pfet_01v8 w=1.65 l=0.15
X491 t_Xsh_d1_Xf3_s2 t_Xsh_d1_Xf3_qi t_Xsh_d1_Xf3_Xsfb_mid vss sky130_fd_pr__nfet_01v8_lvt w=0.8 l=0.15
X492 t_Xsh_d1_Xf3_Xsfb_mid rst_n vss vss sky130_fd_pr__nfet_01v8_lvt w=0.8 l=0.15
X493 t_Xsh_d1_Xf3_s2 t_Xsh_d1_Xf3_qi vdd vdd sky130_fd_pr__pfet_01v8 w=1.4 l=0.15
X494 t_Xsh_d1_Xf3_s2 rst_n vdd vdd sky130_fd_pr__pfet_01v8 w=1.4 l=0.15
X495 t_Xsh_d1_Xf3_s2 t_ck0ba t_Xsh_d1_Xf3_s1 vss sky130_fd_pr__nfet_01v8_lvt w=0.45 l=0.15
X496 t_Xsh_d1_Xf3_s2 t_ck0a t_Xsh_d1_Xf3_s1 vdd sky130_fd_pr__pfet_01v8 w=1.05 l=0.15
X497 t_d1_3 t_Xsh_d1_Xf3_s1 vss vss sky130_fd_pr__nfet_01v8_lvt w=0.8 l=0.15
X498 t_d1_3 t_Xsh_d1_Xf3_s1 vdd vdd sky130_fd_pr__pfet_01v8 w=2.4 l=0.15
X499 t_Xsh_d1_s3b t_d1_3 vss vss sky130_fd_pr__nfet_01v8_lvt w=0.55 l=0.15
X500 t_Xsh_d1_s3b t_d1_3 vdd vdd sky130_fd_pr__pfet_01v8 w=1.4 l=0.15
X501 t_d2_p t_ck0ba t_Xsh_d2_Xf0_m1 vss sky130_fd_pr__nfet_01v8_lvt w=0.65 l=0.15
X502 t_d2_p t_ck0a t_Xsh_d2_Xf0_m1 vdd sky130_fd_pr__pfet_01v8 w=2.2 l=0.15
X503 t_Xsh_d2_Xf0_m2 t_Xsh_d2_Xf0_m1 t_Xsh_d2_Xf0_Xm2_mid vss sky130_fd_pr__nfet_01v8_lvt w=1 l=0.15
X504 t_Xsh_d2_Xf0_Xm2_mid rst_n vss vss sky130_fd_pr__nfet_01v8_lvt w=1 l=0.15
X505 t_Xsh_d2_Xf0_m2 t_Xsh_d2_Xf0_m1 vdd vdd sky130_fd_pr__pfet_01v8 w=2 l=0.15
X506 t_Xsh_d2_Xf0_m2 rst_n vdd vdd sky130_fd_pr__pfet_01v8 w=2 l=0.15
X507 t_Xsh_d2_Xf0_m3 t_Xsh_d2_Xf0_m2 vss vss sky130_fd_pr__nfet_01v8_lvt w=0.45 l=0.15
X508 t_Xsh_d2_Xf0_m3 t_Xsh_d2_Xf0_m2 vdd vdd sky130_fd_pr__pfet_01v8 w=1.15 l=0.15
X509 t_Xsh_d2_Xf0_m3 t_ck0a t_Xsh_d2_Xf0_m1 vss sky130_fd_pr__nfet_01v8_lvt w=0.45 l=0.15
X510 t_Xsh_d2_Xf0_m3 t_ck0ba t_Xsh_d2_Xf0_m1 vdd sky130_fd_pr__pfet_01v8 w=1.05 l=0.15
X511 t_Xsh_d2_Xf0_m2 t_ck0a t_Xsh_d2_Xf0_s1 vss sky130_fd_pr__nfet_01v8_lvt w=0.65 l=0.15
X512 t_Xsh_d2_Xf0_m2 t_ck0ba t_Xsh_d2_Xf0_s1 vdd sky130_fd_pr__pfet_01v8 w=2.2 l=0.15
X513 t_Xsh_d2_Xf0_qi t_Xsh_d2_Xf0_s1 vss vss sky130_fd_pr__nfet_01v8_lvt w=0.65 l=0.15
X514 t_Xsh_d2_Xf0_qi t_Xsh_d2_Xf0_s1 vdd vdd sky130_fd_pr__pfet_01v8 w=1.65 l=0.15
X515 t_Xsh_d2_Xf0_s2 t_Xsh_d2_Xf0_qi t_Xsh_d2_Xf0_Xsfb_mid vss sky130_fd_pr__nfet_01v8_lvt w=0.8 l=0.15
X516 t_Xsh_d2_Xf0_Xsfb_mid rst_n vss vss sky130_fd_pr__nfet_01v8_lvt w=0.8 l=0.15
X517 t_Xsh_d2_Xf0_s2 t_Xsh_d2_Xf0_qi vdd vdd sky130_fd_pr__pfet_01v8 w=1.4 l=0.15
X518 t_Xsh_d2_Xf0_s2 rst_n vdd vdd sky130_fd_pr__pfet_01v8 w=1.4 l=0.15
X519 t_Xsh_d2_Xf0_s2 t_ck0ba t_Xsh_d2_Xf0_s1 vss sky130_fd_pr__nfet_01v8_lvt w=0.45 l=0.15
X520 t_Xsh_d2_Xf0_s2 t_ck0a t_Xsh_d2_Xf0_s1 vdd sky130_fd_pr__pfet_01v8 w=1.05 l=0.15
X521 t_d2_0 t_Xsh_d2_Xf0_s1 vss vss sky130_fd_pr__nfet_01v8_lvt w=0.8 l=0.15
X522 t_d2_0 t_Xsh_d2_Xf0_s1 vdd vdd sky130_fd_pr__pfet_01v8 w=2.4 l=0.15
X523 t_Xsh_d2_s0b t_d2_0 vss vss sky130_fd_pr__nfet_01v8_lvt w=0.55 l=0.15
X524 t_Xsh_d2_s0b t_d2_0 vdd vdd sky130_fd_pr__pfet_01v8 w=1.4 l=0.15
X525 t_d2_0 t_ck0ba t_Xsh_d2_Xf1_m1 vss sky130_fd_pr__nfet_01v8_lvt w=0.65 l=0.15
X526 t_d2_0 t_ck0a t_Xsh_d2_Xf1_m1 vdd sky130_fd_pr__pfet_01v8 w=2.2 l=0.15
X527 t_Xsh_d2_Xf1_m2 t_Xsh_d2_Xf1_m1 t_Xsh_d2_Xf1_Xm2_mid vss sky130_fd_pr__nfet_01v8_lvt w=1 l=0.15
X528 t_Xsh_d2_Xf1_Xm2_mid rst_n vss vss sky130_fd_pr__nfet_01v8_lvt w=1 l=0.15
X529 t_Xsh_d2_Xf1_m2 t_Xsh_d2_Xf1_m1 vdd vdd sky130_fd_pr__pfet_01v8 w=2 l=0.15
X530 t_Xsh_d2_Xf1_m2 rst_n vdd vdd sky130_fd_pr__pfet_01v8 w=2 l=0.15
X531 t_Xsh_d2_Xf1_m3 t_Xsh_d2_Xf1_m2 vss vss sky130_fd_pr__nfet_01v8_lvt w=0.45 l=0.15
X532 t_Xsh_d2_Xf1_m3 t_Xsh_d2_Xf1_m2 vdd vdd sky130_fd_pr__pfet_01v8 w=1.15 l=0.15
X533 t_Xsh_d2_Xf1_m3 t_ck0a t_Xsh_d2_Xf1_m1 vss sky130_fd_pr__nfet_01v8_lvt w=0.45 l=0.15
X534 t_Xsh_d2_Xf1_m3 t_ck0ba t_Xsh_d2_Xf1_m1 vdd sky130_fd_pr__pfet_01v8 w=1.05 l=0.15
X535 t_Xsh_d2_Xf1_m2 t_ck0a t_Xsh_d2_Xf1_s1 vss sky130_fd_pr__nfet_01v8_lvt w=0.65 l=0.15
X536 t_Xsh_d2_Xf1_m2 t_ck0ba t_Xsh_d2_Xf1_s1 vdd sky130_fd_pr__pfet_01v8 w=2.2 l=0.15
X537 t_Xsh_d2_Xf1_qi t_Xsh_d2_Xf1_s1 vss vss sky130_fd_pr__nfet_01v8_lvt w=0.65 l=0.15
X538 t_Xsh_d2_Xf1_qi t_Xsh_d2_Xf1_s1 vdd vdd sky130_fd_pr__pfet_01v8 w=1.65 l=0.15
X539 t_Xsh_d2_Xf1_s2 t_Xsh_d2_Xf1_qi t_Xsh_d2_Xf1_Xsfb_mid vss sky130_fd_pr__nfet_01v8_lvt w=0.8 l=0.15
X540 t_Xsh_d2_Xf1_Xsfb_mid rst_n vss vss sky130_fd_pr__nfet_01v8_lvt w=0.8 l=0.15
X541 t_Xsh_d2_Xf1_s2 t_Xsh_d2_Xf1_qi vdd vdd sky130_fd_pr__pfet_01v8 w=1.4 l=0.15
X542 t_Xsh_d2_Xf1_s2 rst_n vdd vdd sky130_fd_pr__pfet_01v8 w=1.4 l=0.15
X543 t_Xsh_d2_Xf1_s2 t_ck0ba t_Xsh_d2_Xf1_s1 vss sky130_fd_pr__nfet_01v8_lvt w=0.45 l=0.15
X544 t_Xsh_d2_Xf1_s2 t_ck0a t_Xsh_d2_Xf1_s1 vdd sky130_fd_pr__pfet_01v8 w=1.05 l=0.15
X545 t_d2_1 t_Xsh_d2_Xf1_s1 vss vss sky130_fd_pr__nfet_01v8_lvt w=0.8 l=0.15
X546 t_d2_1 t_Xsh_d2_Xf1_s1 vdd vdd sky130_fd_pr__pfet_01v8 w=2.4 l=0.15
X547 t_Xsh_d2_s1b t_d2_1 vss vss sky130_fd_pr__nfet_01v8_lvt w=0.55 l=0.15
X548 t_Xsh_d2_s1b t_d2_1 vdd vdd sky130_fd_pr__pfet_01v8 w=1.4 l=0.15
X549 t_d2_1 t_ck0ba t_Xsh_d2_Xf2_m1 vss sky130_fd_pr__nfet_01v8_lvt w=0.65 l=0.15
X550 t_d2_1 t_ck0a t_Xsh_d2_Xf2_m1 vdd sky130_fd_pr__pfet_01v8 w=2.2 l=0.15
X551 t_Xsh_d2_Xf2_m2 t_Xsh_d2_Xf2_m1 t_Xsh_d2_Xf2_Xm2_mid vss sky130_fd_pr__nfet_01v8_lvt w=1 l=0.15
X552 t_Xsh_d2_Xf2_Xm2_mid rst_n vss vss sky130_fd_pr__nfet_01v8_lvt w=1 l=0.15
X553 t_Xsh_d2_Xf2_m2 t_Xsh_d2_Xf2_m1 vdd vdd sky130_fd_pr__pfet_01v8 w=2 l=0.15
X554 t_Xsh_d2_Xf2_m2 rst_n vdd vdd sky130_fd_pr__pfet_01v8 w=2 l=0.15
X555 t_Xsh_d2_Xf2_m3 t_Xsh_d2_Xf2_m2 vss vss sky130_fd_pr__nfet_01v8_lvt w=0.45 l=0.15
X556 t_Xsh_d2_Xf2_m3 t_Xsh_d2_Xf2_m2 vdd vdd sky130_fd_pr__pfet_01v8 w=1.15 l=0.15
X557 t_Xsh_d2_Xf2_m3 t_ck0a t_Xsh_d2_Xf2_m1 vss sky130_fd_pr__nfet_01v8_lvt w=0.45 l=0.15
X558 t_Xsh_d2_Xf2_m3 t_ck0ba t_Xsh_d2_Xf2_m1 vdd sky130_fd_pr__pfet_01v8 w=1.05 l=0.15
X559 t_Xsh_d2_Xf2_m2 t_ck0a t_Xsh_d2_Xf2_s1 vss sky130_fd_pr__nfet_01v8_lvt w=0.65 l=0.15
X560 t_Xsh_d2_Xf2_m2 t_ck0ba t_Xsh_d2_Xf2_s1 vdd sky130_fd_pr__pfet_01v8 w=2.2 l=0.15
X561 t_Xsh_d2_Xf2_qi t_Xsh_d2_Xf2_s1 vss vss sky130_fd_pr__nfet_01v8_lvt w=0.65 l=0.15
X562 t_Xsh_d2_Xf2_qi t_Xsh_d2_Xf2_s1 vdd vdd sky130_fd_pr__pfet_01v8 w=1.65 l=0.15
X563 t_Xsh_d2_Xf2_s2 t_Xsh_d2_Xf2_qi t_Xsh_d2_Xf2_Xsfb_mid vss sky130_fd_pr__nfet_01v8_lvt w=0.8 l=0.15
X564 t_Xsh_d2_Xf2_Xsfb_mid rst_n vss vss sky130_fd_pr__nfet_01v8_lvt w=0.8 l=0.15
X565 t_Xsh_d2_Xf2_s2 t_Xsh_d2_Xf2_qi vdd vdd sky130_fd_pr__pfet_01v8 w=1.4 l=0.15
X566 t_Xsh_d2_Xf2_s2 rst_n vdd vdd sky130_fd_pr__pfet_01v8 w=1.4 l=0.15
X567 t_Xsh_d2_Xf2_s2 t_ck0ba t_Xsh_d2_Xf2_s1 vss sky130_fd_pr__nfet_01v8_lvt w=0.45 l=0.15
X568 t_Xsh_d2_Xf2_s2 t_ck0a t_Xsh_d2_Xf2_s1 vdd sky130_fd_pr__pfet_01v8 w=1.05 l=0.15
X569 t_d2_2 t_Xsh_d2_Xf2_s1 vss vss sky130_fd_pr__nfet_01v8_lvt w=0.8 l=0.15
X570 t_d2_2 t_Xsh_d2_Xf2_s1 vdd vdd sky130_fd_pr__pfet_01v8 w=2.4 l=0.15
X571 t_Xsh_d2_s2b t_d2_2 vss vss sky130_fd_pr__nfet_01v8_lvt w=0.55 l=0.15
X572 t_Xsh_d2_s2b t_d2_2 vdd vdd sky130_fd_pr__pfet_01v8 w=1.4 l=0.15
X573 t_d2_2 t_ck0ba t_Xsh_d2_Xf3_m1 vss sky130_fd_pr__nfet_01v8_lvt w=0.65 l=0.15
X574 t_d2_2 t_ck0a t_Xsh_d2_Xf3_m1 vdd sky130_fd_pr__pfet_01v8 w=2.2 l=0.15
X575 t_Xsh_d2_Xf3_m2 t_Xsh_d2_Xf3_m1 t_Xsh_d2_Xf3_Xm2_mid vss sky130_fd_pr__nfet_01v8_lvt w=1 l=0.15
X576 t_Xsh_d2_Xf3_Xm2_mid rst_n vss vss sky130_fd_pr__nfet_01v8_lvt w=1 l=0.15
X577 t_Xsh_d2_Xf3_m2 t_Xsh_d2_Xf3_m1 vdd vdd sky130_fd_pr__pfet_01v8 w=2 l=0.15
X578 t_Xsh_d2_Xf3_m2 rst_n vdd vdd sky130_fd_pr__pfet_01v8 w=2 l=0.15
X579 t_Xsh_d2_Xf3_m3 t_Xsh_d2_Xf3_m2 vss vss sky130_fd_pr__nfet_01v8_lvt w=0.45 l=0.15
X580 t_Xsh_d2_Xf3_m3 t_Xsh_d2_Xf3_m2 vdd vdd sky130_fd_pr__pfet_01v8 w=1.15 l=0.15
X581 t_Xsh_d2_Xf3_m3 t_ck0a t_Xsh_d2_Xf3_m1 vss sky130_fd_pr__nfet_01v8_lvt w=0.45 l=0.15
X582 t_Xsh_d2_Xf3_m3 t_ck0ba t_Xsh_d2_Xf3_m1 vdd sky130_fd_pr__pfet_01v8 w=1.05 l=0.15
X583 t_Xsh_d2_Xf3_m2 t_ck0a t_Xsh_d2_Xf3_s1 vss sky130_fd_pr__nfet_01v8_lvt w=0.65 l=0.15
X584 t_Xsh_d2_Xf3_m2 t_ck0ba t_Xsh_d2_Xf3_s1 vdd sky130_fd_pr__pfet_01v8 w=2.2 l=0.15
X585 t_Xsh_d2_Xf3_qi t_Xsh_d2_Xf3_s1 vss vss sky130_fd_pr__nfet_01v8_lvt w=0.65 l=0.15
X586 t_Xsh_d2_Xf3_qi t_Xsh_d2_Xf3_s1 vdd vdd sky130_fd_pr__pfet_01v8 w=1.65 l=0.15
X587 t_Xsh_d2_Xf3_s2 t_Xsh_d2_Xf3_qi t_Xsh_d2_Xf3_Xsfb_mid vss sky130_fd_pr__nfet_01v8_lvt w=0.8 l=0.15
X588 t_Xsh_d2_Xf3_Xsfb_mid rst_n vss vss sky130_fd_pr__nfet_01v8_lvt w=0.8 l=0.15
X589 t_Xsh_d2_Xf3_s2 t_Xsh_d2_Xf3_qi vdd vdd sky130_fd_pr__pfet_01v8 w=1.4 l=0.15
X590 t_Xsh_d2_Xf3_s2 rst_n vdd vdd sky130_fd_pr__pfet_01v8 w=1.4 l=0.15
X591 t_Xsh_d2_Xf3_s2 t_ck0ba t_Xsh_d2_Xf3_s1 vss sky130_fd_pr__nfet_01v8_lvt w=0.45 l=0.15
X592 t_Xsh_d2_Xf3_s2 t_ck0a t_Xsh_d2_Xf3_s1 vdd sky130_fd_pr__pfet_01v8 w=1.05 l=0.15
X593 t_d2_3 t_Xsh_d2_Xf3_s1 vss vss sky130_fd_pr__nfet_01v8_lvt w=0.8 l=0.15
X594 t_d2_3 t_Xsh_d2_Xf3_s1 vdd vdd sky130_fd_pr__pfet_01v8 w=2.4 l=0.15
X595 t_Xsh_d2_s3b t_d2_3 vss vss sky130_fd_pr__nfet_01v8_lvt w=0.55 l=0.15
X596 t_Xsh_d2_s3b t_d2_3 vdd vdd sky130_fd_pr__pfet_01v8 w=1.4 l=0.15
X597 t_d3_a t_ck0ba t_Xsh_d3_Xf0_m1 vss sky130_fd_pr__nfet_01v8_lvt w=0.65 l=0.15
X598 t_d3_a t_ck0a t_Xsh_d3_Xf0_m1 vdd sky130_fd_pr__pfet_01v8 w=2.2 l=0.15
X599 t_Xsh_d3_Xf0_m2 t_Xsh_d3_Xf0_m1 t_Xsh_d3_Xf0_Xm2_mid vss sky130_fd_pr__nfet_01v8_lvt w=1 l=0.15
X600 t_Xsh_d3_Xf0_Xm2_mid rst_n vss vss sky130_fd_pr__nfet_01v8_lvt w=1 l=0.15
X601 t_Xsh_d3_Xf0_m2 t_Xsh_d3_Xf0_m1 vdd vdd sky130_fd_pr__pfet_01v8 w=2 l=0.15
X602 t_Xsh_d3_Xf0_m2 rst_n vdd vdd sky130_fd_pr__pfet_01v8 w=2 l=0.15
X603 t_Xsh_d3_Xf0_m3 t_Xsh_d3_Xf0_m2 vss vss sky130_fd_pr__nfet_01v8_lvt w=0.45 l=0.15
X604 t_Xsh_d3_Xf0_m3 t_Xsh_d3_Xf0_m2 vdd vdd sky130_fd_pr__pfet_01v8 w=1.15 l=0.15
X605 t_Xsh_d3_Xf0_m3 t_ck0a t_Xsh_d3_Xf0_m1 vss sky130_fd_pr__nfet_01v8_lvt w=0.45 l=0.15
X606 t_Xsh_d3_Xf0_m3 t_ck0ba t_Xsh_d3_Xf0_m1 vdd sky130_fd_pr__pfet_01v8 w=1.05 l=0.15
X607 t_Xsh_d3_Xf0_m2 t_ck0a t_Xsh_d3_Xf0_s1 vss sky130_fd_pr__nfet_01v8_lvt w=0.65 l=0.15
X608 t_Xsh_d3_Xf0_m2 t_ck0ba t_Xsh_d3_Xf0_s1 vdd sky130_fd_pr__pfet_01v8 w=2.2 l=0.15
X609 t_Xsh_d3_Xf0_qi t_Xsh_d3_Xf0_s1 vss vss sky130_fd_pr__nfet_01v8_lvt w=0.65 l=0.15
X610 t_Xsh_d3_Xf0_qi t_Xsh_d3_Xf0_s1 vdd vdd sky130_fd_pr__pfet_01v8 w=1.65 l=0.15
X611 t_Xsh_d3_Xf0_s2 t_Xsh_d3_Xf0_qi t_Xsh_d3_Xf0_Xsfb_mid vss sky130_fd_pr__nfet_01v8_lvt w=0.8 l=0.15
X612 t_Xsh_d3_Xf0_Xsfb_mid rst_n vss vss sky130_fd_pr__nfet_01v8_lvt w=0.8 l=0.15
X613 t_Xsh_d3_Xf0_s2 t_Xsh_d3_Xf0_qi vdd vdd sky130_fd_pr__pfet_01v8 w=1.4 l=0.15
X614 t_Xsh_d3_Xf0_s2 rst_n vdd vdd sky130_fd_pr__pfet_01v8 w=1.4 l=0.15
X615 t_Xsh_d3_Xf0_s2 t_ck0ba t_Xsh_d3_Xf0_s1 vss sky130_fd_pr__nfet_01v8_lvt w=0.45 l=0.15
X616 t_Xsh_d3_Xf0_s2 t_ck0a t_Xsh_d3_Xf0_s1 vdd sky130_fd_pr__pfet_01v8 w=1.05 l=0.15
X617 t_d3_0 t_Xsh_d3_Xf0_s1 vss vss sky130_fd_pr__nfet_01v8_lvt w=0.8 l=0.15
X618 t_d3_0 t_Xsh_d3_Xf0_s1 vdd vdd sky130_fd_pr__pfet_01v8 w=2.4 l=0.15
X619 t_Xsh_d3_s0b t_d3_0 vss vss sky130_fd_pr__nfet_01v8_lvt w=0.55 l=0.15
X620 t_Xsh_d3_s0b t_d3_0 vdd vdd sky130_fd_pr__pfet_01v8 w=1.4 l=0.15
X621 t_d3_0 t_ck0ba t_Xsh_d3_Xf1_m1 vss sky130_fd_pr__nfet_01v8_lvt w=0.65 l=0.15
X622 t_d3_0 t_ck0a t_Xsh_d3_Xf1_m1 vdd sky130_fd_pr__pfet_01v8 w=2.2 l=0.15
X623 t_Xsh_d3_Xf1_m2 t_Xsh_d3_Xf1_m1 t_Xsh_d3_Xf1_Xm2_mid vss sky130_fd_pr__nfet_01v8_lvt w=1 l=0.15
X624 t_Xsh_d3_Xf1_Xm2_mid rst_n vss vss sky130_fd_pr__nfet_01v8_lvt w=1 l=0.15
X625 t_Xsh_d3_Xf1_m2 t_Xsh_d3_Xf1_m1 vdd vdd sky130_fd_pr__pfet_01v8 w=2 l=0.15
X626 t_Xsh_d3_Xf1_m2 rst_n vdd vdd sky130_fd_pr__pfet_01v8 w=2 l=0.15
X627 t_Xsh_d3_Xf1_m3 t_Xsh_d3_Xf1_m2 vss vss sky130_fd_pr__nfet_01v8_lvt w=0.45 l=0.15
X628 t_Xsh_d3_Xf1_m3 t_Xsh_d3_Xf1_m2 vdd vdd sky130_fd_pr__pfet_01v8 w=1.15 l=0.15
X629 t_Xsh_d3_Xf1_m3 t_ck0a t_Xsh_d3_Xf1_m1 vss sky130_fd_pr__nfet_01v8_lvt w=0.45 l=0.15
X630 t_Xsh_d3_Xf1_m3 t_ck0ba t_Xsh_d3_Xf1_m1 vdd sky130_fd_pr__pfet_01v8 w=1.05 l=0.15
X631 t_Xsh_d3_Xf1_m2 t_ck0a t_Xsh_d3_Xf1_s1 vss sky130_fd_pr__nfet_01v8_lvt w=0.65 l=0.15
X632 t_Xsh_d3_Xf1_m2 t_ck0ba t_Xsh_d3_Xf1_s1 vdd sky130_fd_pr__pfet_01v8 w=2.2 l=0.15
X633 t_Xsh_d3_Xf1_qi t_Xsh_d3_Xf1_s1 vss vss sky130_fd_pr__nfet_01v8_lvt w=0.65 l=0.15
X634 t_Xsh_d3_Xf1_qi t_Xsh_d3_Xf1_s1 vdd vdd sky130_fd_pr__pfet_01v8 w=1.65 l=0.15
X635 t_Xsh_d3_Xf1_s2 t_Xsh_d3_Xf1_qi t_Xsh_d3_Xf1_Xsfb_mid vss sky130_fd_pr__nfet_01v8_lvt w=0.8 l=0.15
X636 t_Xsh_d3_Xf1_Xsfb_mid rst_n vss vss sky130_fd_pr__nfet_01v8_lvt w=0.8 l=0.15
X637 t_Xsh_d3_Xf1_s2 t_Xsh_d3_Xf1_qi vdd vdd sky130_fd_pr__pfet_01v8 w=1.4 l=0.15
X638 t_Xsh_d3_Xf1_s2 rst_n vdd vdd sky130_fd_pr__pfet_01v8 w=1.4 l=0.15
X639 t_Xsh_d3_Xf1_s2 t_ck0ba t_Xsh_d3_Xf1_s1 vss sky130_fd_pr__nfet_01v8_lvt w=0.45 l=0.15
X640 t_Xsh_d3_Xf1_s2 t_ck0a t_Xsh_d3_Xf1_s1 vdd sky130_fd_pr__pfet_01v8 w=1.05 l=0.15
X641 t_d3_1 t_Xsh_d3_Xf1_s1 vss vss sky130_fd_pr__nfet_01v8_lvt w=0.8 l=0.15
X642 t_d3_1 t_Xsh_d3_Xf1_s1 vdd vdd sky130_fd_pr__pfet_01v8 w=2.4 l=0.15
X643 t_Xsh_d3_s1b t_d3_1 vss vss sky130_fd_pr__nfet_01v8_lvt w=0.55 l=0.15
X644 t_Xsh_d3_s1b t_d3_1 vdd vdd sky130_fd_pr__pfet_01v8 w=1.4 l=0.15
X645 t_d3_1 t_ck0ba t_Xsh_d3_Xf2_m1 vss sky130_fd_pr__nfet_01v8_lvt w=0.65 l=0.15
X646 t_d3_1 t_ck0a t_Xsh_d3_Xf2_m1 vdd sky130_fd_pr__pfet_01v8 w=2.2 l=0.15
X647 t_Xsh_d3_Xf2_m2 t_Xsh_d3_Xf2_m1 t_Xsh_d3_Xf2_Xm2_mid vss sky130_fd_pr__nfet_01v8_lvt w=1 l=0.15
X648 t_Xsh_d3_Xf2_Xm2_mid rst_n vss vss sky130_fd_pr__nfet_01v8_lvt w=1 l=0.15
X649 t_Xsh_d3_Xf2_m2 t_Xsh_d3_Xf2_m1 vdd vdd sky130_fd_pr__pfet_01v8 w=2 l=0.15
X650 t_Xsh_d3_Xf2_m2 rst_n vdd vdd sky130_fd_pr__pfet_01v8 w=2 l=0.15
X651 t_Xsh_d3_Xf2_m3 t_Xsh_d3_Xf2_m2 vss vss sky130_fd_pr__nfet_01v8_lvt w=0.45 l=0.15
X652 t_Xsh_d3_Xf2_m3 t_Xsh_d3_Xf2_m2 vdd vdd sky130_fd_pr__pfet_01v8 w=1.15 l=0.15
X653 t_Xsh_d3_Xf2_m3 t_ck0a t_Xsh_d3_Xf2_m1 vss sky130_fd_pr__nfet_01v8_lvt w=0.45 l=0.15
X654 t_Xsh_d3_Xf2_m3 t_ck0ba t_Xsh_d3_Xf2_m1 vdd sky130_fd_pr__pfet_01v8 w=1.05 l=0.15
X655 t_Xsh_d3_Xf2_m2 t_ck0a t_Xsh_d3_Xf2_s1 vss sky130_fd_pr__nfet_01v8_lvt w=0.65 l=0.15
X656 t_Xsh_d3_Xf2_m2 t_ck0ba t_Xsh_d3_Xf2_s1 vdd sky130_fd_pr__pfet_01v8 w=2.2 l=0.15
X657 t_Xsh_d3_Xf2_qi t_Xsh_d3_Xf2_s1 vss vss sky130_fd_pr__nfet_01v8_lvt w=0.65 l=0.15
X658 t_Xsh_d3_Xf2_qi t_Xsh_d3_Xf2_s1 vdd vdd sky130_fd_pr__pfet_01v8 w=1.65 l=0.15
X659 t_Xsh_d3_Xf2_s2 t_Xsh_d3_Xf2_qi t_Xsh_d3_Xf2_Xsfb_mid vss sky130_fd_pr__nfet_01v8_lvt w=0.8 l=0.15
X660 t_Xsh_d3_Xf2_Xsfb_mid rst_n vss vss sky130_fd_pr__nfet_01v8_lvt w=0.8 l=0.15
X661 t_Xsh_d3_Xf2_s2 t_Xsh_d3_Xf2_qi vdd vdd sky130_fd_pr__pfet_01v8 w=1.4 l=0.15
X662 t_Xsh_d3_Xf2_s2 rst_n vdd vdd sky130_fd_pr__pfet_01v8 w=1.4 l=0.15
X663 t_Xsh_d3_Xf2_s2 t_ck0ba t_Xsh_d3_Xf2_s1 vss sky130_fd_pr__nfet_01v8_lvt w=0.45 l=0.15
X664 t_Xsh_d3_Xf2_s2 t_ck0a t_Xsh_d3_Xf2_s1 vdd sky130_fd_pr__pfet_01v8 w=1.05 l=0.15
X665 t_d3_2 t_Xsh_d3_Xf2_s1 vss vss sky130_fd_pr__nfet_01v8_lvt w=0.8 l=0.15
X666 t_d3_2 t_Xsh_d3_Xf2_s1 vdd vdd sky130_fd_pr__pfet_01v8 w=2.4 l=0.15
X667 t_Xsh_d3_s2b t_d3_2 vss vss sky130_fd_pr__nfet_01v8_lvt w=0.55 l=0.15
X668 t_Xsh_d3_s2b t_d3_2 vdd vdd sky130_fd_pr__pfet_01v8 w=1.4 l=0.15
X669 t_d3_2 t_ck0ba t_Xsh_d3_Xf3_m1 vss sky130_fd_pr__nfet_01v8_lvt w=0.65 l=0.15
X670 t_d3_2 t_ck0a t_Xsh_d3_Xf3_m1 vdd sky130_fd_pr__pfet_01v8 w=2.2 l=0.15
X671 t_Xsh_d3_Xf3_m2 t_Xsh_d3_Xf3_m1 t_Xsh_d3_Xf3_Xm2_mid vss sky130_fd_pr__nfet_01v8_lvt w=1 l=0.15
X672 t_Xsh_d3_Xf3_Xm2_mid rst_n vss vss sky130_fd_pr__nfet_01v8_lvt w=1 l=0.15
X673 t_Xsh_d3_Xf3_m2 t_Xsh_d3_Xf3_m1 vdd vdd sky130_fd_pr__pfet_01v8 w=2 l=0.15
X674 t_Xsh_d3_Xf3_m2 rst_n vdd vdd sky130_fd_pr__pfet_01v8 w=2 l=0.15
X675 t_Xsh_d3_Xf3_m3 t_Xsh_d3_Xf3_m2 vss vss sky130_fd_pr__nfet_01v8_lvt w=0.45 l=0.15
X676 t_Xsh_d3_Xf3_m3 t_Xsh_d3_Xf3_m2 vdd vdd sky130_fd_pr__pfet_01v8 w=1.15 l=0.15
X677 t_Xsh_d3_Xf3_m3 t_ck0a t_Xsh_d3_Xf3_m1 vss sky130_fd_pr__nfet_01v8_lvt w=0.45 l=0.15
X678 t_Xsh_d3_Xf3_m3 t_ck0ba t_Xsh_d3_Xf3_m1 vdd sky130_fd_pr__pfet_01v8 w=1.05 l=0.15
X679 t_Xsh_d3_Xf3_m2 t_ck0a t_Xsh_d3_Xf3_s1 vss sky130_fd_pr__nfet_01v8_lvt w=0.65 l=0.15
X680 t_Xsh_d3_Xf3_m2 t_ck0ba t_Xsh_d3_Xf3_s1 vdd sky130_fd_pr__pfet_01v8 w=2.2 l=0.15
X681 t_Xsh_d3_Xf3_qi t_Xsh_d3_Xf3_s1 vss vss sky130_fd_pr__nfet_01v8_lvt w=0.65 l=0.15
X682 t_Xsh_d3_Xf3_qi t_Xsh_d3_Xf3_s1 vdd vdd sky130_fd_pr__pfet_01v8 w=1.65 l=0.15
X683 t_Xsh_d3_Xf3_s2 t_Xsh_d3_Xf3_qi t_Xsh_d3_Xf3_Xsfb_mid vss sky130_fd_pr__nfet_01v8_lvt w=0.8 l=0.15
X684 t_Xsh_d3_Xf3_Xsfb_mid rst_n vss vss sky130_fd_pr__nfet_01v8_lvt w=0.8 l=0.15
X685 t_Xsh_d3_Xf3_s2 t_Xsh_d3_Xf3_qi vdd vdd sky130_fd_pr__pfet_01v8 w=1.4 l=0.15
X686 t_Xsh_d3_Xf3_s2 rst_n vdd vdd sky130_fd_pr__pfet_01v8 w=1.4 l=0.15
X687 t_Xsh_d3_Xf3_s2 t_ck0ba t_Xsh_d3_Xf3_s1 vss sky130_fd_pr__nfet_01v8_lvt w=0.45 l=0.15
X688 t_Xsh_d3_Xf3_s2 t_ck0a t_Xsh_d3_Xf3_s1 vdd sky130_fd_pr__pfet_01v8 w=1.05 l=0.15
X689 t_d3_3 t_Xsh_d3_Xf3_s1 vss vss sky130_fd_pr__nfet_01v8_lvt w=0.8 l=0.15
X690 t_d3_3 t_Xsh_d3_Xf3_s1 vdd vdd sky130_fd_pr__pfet_01v8 w=2.4 l=0.15
X691 t_Xsh_d3_s3b t_d3_3 vss vss sky130_fd_pr__nfet_01v8_lvt w=0.55 l=0.15
X692 t_Xsh_d3_s3b t_d3_3 vdd vdd sky130_fd_pr__pfet_01v8 w=1.4 l=0.15
X693 t_e0_p t_ck0bb t_Xsh_e0_Xf0_m1 vss sky130_fd_pr__nfet_01v8_lvt w=0.65 l=0.15
X694 t_e0_p t_ck0b t_Xsh_e0_Xf0_m1 vdd sky130_fd_pr__pfet_01v8 w=2.2 l=0.15
X695 t_Xsh_e0_Xf0_m2 t_Xsh_e0_Xf0_m1 t_Xsh_e0_Xf0_Xm2_mid vss sky130_fd_pr__nfet_01v8_lvt w=1 l=0.15
X696 t_Xsh_e0_Xf0_Xm2_mid rst_n vss vss sky130_fd_pr__nfet_01v8_lvt w=1 l=0.15
X697 t_Xsh_e0_Xf0_m2 t_Xsh_e0_Xf0_m1 vdd vdd sky130_fd_pr__pfet_01v8 w=2 l=0.15
X698 t_Xsh_e0_Xf0_m2 rst_n vdd vdd sky130_fd_pr__pfet_01v8 w=2 l=0.15
X699 t_Xsh_e0_Xf0_m3 t_Xsh_e0_Xf0_m2 vss vss sky130_fd_pr__nfet_01v8_lvt w=0.45 l=0.15
X700 t_Xsh_e0_Xf0_m3 t_Xsh_e0_Xf0_m2 vdd vdd sky130_fd_pr__pfet_01v8 w=1.15 l=0.15
X701 t_Xsh_e0_Xf0_m3 t_ck0b t_Xsh_e0_Xf0_m1 vss sky130_fd_pr__nfet_01v8_lvt w=0.45 l=0.15
X702 t_Xsh_e0_Xf0_m3 t_ck0bb t_Xsh_e0_Xf0_m1 vdd sky130_fd_pr__pfet_01v8 w=1.05 l=0.15
X703 t_Xsh_e0_Xf0_m2 t_ck0b t_Xsh_e0_Xf0_s1 vss sky130_fd_pr__nfet_01v8_lvt w=0.65 l=0.15
X704 t_Xsh_e0_Xf0_m2 t_ck0bb t_Xsh_e0_Xf0_s1 vdd sky130_fd_pr__pfet_01v8 w=2.2 l=0.15
X705 t_Xsh_e0_Xf0_qi t_Xsh_e0_Xf0_s1 vss vss sky130_fd_pr__nfet_01v8_lvt w=0.65 l=0.15
X706 t_Xsh_e0_Xf0_qi t_Xsh_e0_Xf0_s1 vdd vdd sky130_fd_pr__pfet_01v8 w=1.65 l=0.15
X707 t_Xsh_e0_Xf0_s2 t_Xsh_e0_Xf0_qi t_Xsh_e0_Xf0_Xsfb_mid vss sky130_fd_pr__nfet_01v8_lvt w=0.8 l=0.15
X708 t_Xsh_e0_Xf0_Xsfb_mid rst_n vss vss sky130_fd_pr__nfet_01v8_lvt w=0.8 l=0.15
X709 t_Xsh_e0_Xf0_s2 t_Xsh_e0_Xf0_qi vdd vdd sky130_fd_pr__pfet_01v8 w=1.4 l=0.15
X710 t_Xsh_e0_Xf0_s2 rst_n vdd vdd sky130_fd_pr__pfet_01v8 w=1.4 l=0.15
X711 t_Xsh_e0_Xf0_s2 t_ck0bb t_Xsh_e0_Xf0_s1 vss sky130_fd_pr__nfet_01v8_lvt w=0.45 l=0.15
X712 t_Xsh_e0_Xf0_s2 t_ck0b t_Xsh_e0_Xf0_s1 vdd sky130_fd_pr__pfet_01v8 w=1.05 l=0.15
X713 t_e0_0 t_Xsh_e0_Xf0_s1 vss vss sky130_fd_pr__nfet_01v8_lvt w=0.8 l=0.15
X714 t_e0_0 t_Xsh_e0_Xf0_s1 vdd vdd sky130_fd_pr__pfet_01v8 w=2.4 l=0.15
X715 t_Xsh_e0_s0b t_e0_0 vss vss sky130_fd_pr__nfet_01v8_lvt w=0.55 l=0.15
X716 t_Xsh_e0_s0b t_e0_0 vdd vdd sky130_fd_pr__pfet_01v8 w=1.4 l=0.15
X717 t_e0_0 t_ck0bb t_Xsh_e0_Xf1_m1 vss sky130_fd_pr__nfet_01v8_lvt w=0.65 l=0.15
X718 t_e0_0 t_ck0b t_Xsh_e0_Xf1_m1 vdd sky130_fd_pr__pfet_01v8 w=2.2 l=0.15
X719 t_Xsh_e0_Xf1_m2 t_Xsh_e0_Xf1_m1 t_Xsh_e0_Xf1_Xm2_mid vss sky130_fd_pr__nfet_01v8_lvt w=1 l=0.15
X720 t_Xsh_e0_Xf1_Xm2_mid rst_n vss vss sky130_fd_pr__nfet_01v8_lvt w=1 l=0.15
X721 t_Xsh_e0_Xf1_m2 t_Xsh_e0_Xf1_m1 vdd vdd sky130_fd_pr__pfet_01v8 w=2 l=0.15
X722 t_Xsh_e0_Xf1_m2 rst_n vdd vdd sky130_fd_pr__pfet_01v8 w=2 l=0.15
X723 t_Xsh_e0_Xf1_m3 t_Xsh_e0_Xf1_m2 vss vss sky130_fd_pr__nfet_01v8_lvt w=0.45 l=0.15
X724 t_Xsh_e0_Xf1_m3 t_Xsh_e0_Xf1_m2 vdd vdd sky130_fd_pr__pfet_01v8 w=1.15 l=0.15
X725 t_Xsh_e0_Xf1_m3 t_ck0b t_Xsh_e0_Xf1_m1 vss sky130_fd_pr__nfet_01v8_lvt w=0.45 l=0.15
X726 t_Xsh_e0_Xf1_m3 t_ck0bb t_Xsh_e0_Xf1_m1 vdd sky130_fd_pr__pfet_01v8 w=1.05 l=0.15
X727 t_Xsh_e0_Xf1_m2 t_ck0b t_Xsh_e0_Xf1_s1 vss sky130_fd_pr__nfet_01v8_lvt w=0.65 l=0.15
X728 t_Xsh_e0_Xf1_m2 t_ck0bb t_Xsh_e0_Xf1_s1 vdd sky130_fd_pr__pfet_01v8 w=2.2 l=0.15
X729 t_Xsh_e0_Xf1_qi t_Xsh_e0_Xf1_s1 vss vss sky130_fd_pr__nfet_01v8_lvt w=0.65 l=0.15
X730 t_Xsh_e0_Xf1_qi t_Xsh_e0_Xf1_s1 vdd vdd sky130_fd_pr__pfet_01v8 w=1.65 l=0.15
X731 t_Xsh_e0_Xf1_s2 t_Xsh_e0_Xf1_qi t_Xsh_e0_Xf1_Xsfb_mid vss sky130_fd_pr__nfet_01v8_lvt w=0.8 l=0.15
X732 t_Xsh_e0_Xf1_Xsfb_mid rst_n vss vss sky130_fd_pr__nfet_01v8_lvt w=0.8 l=0.15
X733 t_Xsh_e0_Xf1_s2 t_Xsh_e0_Xf1_qi vdd vdd sky130_fd_pr__pfet_01v8 w=1.4 l=0.15
X734 t_Xsh_e0_Xf1_s2 rst_n vdd vdd sky130_fd_pr__pfet_01v8 w=1.4 l=0.15
X735 t_Xsh_e0_Xf1_s2 t_ck0bb t_Xsh_e0_Xf1_s1 vss sky130_fd_pr__nfet_01v8_lvt w=0.45 l=0.15
X736 t_Xsh_e0_Xf1_s2 t_ck0b t_Xsh_e0_Xf1_s1 vdd sky130_fd_pr__pfet_01v8 w=1.05 l=0.15
X737 t_e0_1 t_Xsh_e0_Xf1_s1 vss vss sky130_fd_pr__nfet_01v8_lvt w=0.8 l=0.15
X738 t_e0_1 t_Xsh_e0_Xf1_s1 vdd vdd sky130_fd_pr__pfet_01v8 w=2.4 l=0.15
X739 t_Xsh_e0_s1b t_e0_1 vss vss sky130_fd_pr__nfet_01v8_lvt w=0.55 l=0.15
X740 t_Xsh_e0_s1b t_e0_1 vdd vdd sky130_fd_pr__pfet_01v8 w=1.4 l=0.15
X741 t_e0_1 t_ck0bb t_Xsh_e0_Xf2_m1 vss sky130_fd_pr__nfet_01v8_lvt w=0.65 l=0.15
X742 t_e0_1 t_ck0b t_Xsh_e0_Xf2_m1 vdd sky130_fd_pr__pfet_01v8 w=2.2 l=0.15
X743 t_Xsh_e0_Xf2_m2 t_Xsh_e0_Xf2_m1 t_Xsh_e0_Xf2_Xm2_mid vss sky130_fd_pr__nfet_01v8_lvt w=1 l=0.15
X744 t_Xsh_e0_Xf2_Xm2_mid rst_n vss vss sky130_fd_pr__nfet_01v8_lvt w=1 l=0.15
X745 t_Xsh_e0_Xf2_m2 t_Xsh_e0_Xf2_m1 vdd vdd sky130_fd_pr__pfet_01v8 w=2 l=0.15
X746 t_Xsh_e0_Xf2_m2 rst_n vdd vdd sky130_fd_pr__pfet_01v8 w=2 l=0.15
X747 t_Xsh_e0_Xf2_m3 t_Xsh_e0_Xf2_m2 vss vss sky130_fd_pr__nfet_01v8_lvt w=0.45 l=0.15
X748 t_Xsh_e0_Xf2_m3 t_Xsh_e0_Xf2_m2 vdd vdd sky130_fd_pr__pfet_01v8 w=1.15 l=0.15
X749 t_Xsh_e0_Xf2_m3 t_ck0b t_Xsh_e0_Xf2_m1 vss sky130_fd_pr__nfet_01v8_lvt w=0.45 l=0.15
X750 t_Xsh_e0_Xf2_m3 t_ck0bb t_Xsh_e0_Xf2_m1 vdd sky130_fd_pr__pfet_01v8 w=1.05 l=0.15
X751 t_Xsh_e0_Xf2_m2 t_ck0b t_Xsh_e0_Xf2_s1 vss sky130_fd_pr__nfet_01v8_lvt w=0.65 l=0.15
X752 t_Xsh_e0_Xf2_m2 t_ck0bb t_Xsh_e0_Xf2_s1 vdd sky130_fd_pr__pfet_01v8 w=2.2 l=0.15
X753 t_Xsh_e0_Xf2_qi t_Xsh_e0_Xf2_s1 vss vss sky130_fd_pr__nfet_01v8_lvt w=0.65 l=0.15
X754 t_Xsh_e0_Xf2_qi t_Xsh_e0_Xf2_s1 vdd vdd sky130_fd_pr__pfet_01v8 w=1.65 l=0.15
X755 t_Xsh_e0_Xf2_s2 t_Xsh_e0_Xf2_qi t_Xsh_e0_Xf2_Xsfb_mid vss sky130_fd_pr__nfet_01v8_lvt w=0.8 l=0.15
X756 t_Xsh_e0_Xf2_Xsfb_mid rst_n vss vss sky130_fd_pr__nfet_01v8_lvt w=0.8 l=0.15
X757 t_Xsh_e0_Xf2_s2 t_Xsh_e0_Xf2_qi vdd vdd sky130_fd_pr__pfet_01v8 w=1.4 l=0.15
X758 t_Xsh_e0_Xf2_s2 rst_n vdd vdd sky130_fd_pr__pfet_01v8 w=1.4 l=0.15
X759 t_Xsh_e0_Xf2_s2 t_ck0bb t_Xsh_e0_Xf2_s1 vss sky130_fd_pr__nfet_01v8_lvt w=0.45 l=0.15
X760 t_Xsh_e0_Xf2_s2 t_ck0b t_Xsh_e0_Xf2_s1 vdd sky130_fd_pr__pfet_01v8 w=1.05 l=0.15
X761 t_e0_2 t_Xsh_e0_Xf2_s1 vss vss sky130_fd_pr__nfet_01v8_lvt w=0.8 l=0.15
X762 t_e0_2 t_Xsh_e0_Xf2_s1 vdd vdd sky130_fd_pr__pfet_01v8 w=2.4 l=0.15
X763 t_Xsh_e0_s2b t_e0_2 vss vss sky130_fd_pr__nfet_01v8_lvt w=0.55 l=0.15
X764 t_Xsh_e0_s2b t_e0_2 vdd vdd sky130_fd_pr__pfet_01v8 w=1.4 l=0.15
X765 t_e0_2 t_ck0bb t_Xsh_e0_Xf3_m1 vss sky130_fd_pr__nfet_01v8_lvt w=0.65 l=0.15
X766 t_e0_2 t_ck0b t_Xsh_e0_Xf3_m1 vdd sky130_fd_pr__pfet_01v8 w=2.2 l=0.15
X767 t_Xsh_e0_Xf3_m2 t_Xsh_e0_Xf3_m1 t_Xsh_e0_Xf3_Xm2_mid vss sky130_fd_pr__nfet_01v8_lvt w=1 l=0.15
X768 t_Xsh_e0_Xf3_Xm2_mid rst_n vss vss sky130_fd_pr__nfet_01v8_lvt w=1 l=0.15
X769 t_Xsh_e0_Xf3_m2 t_Xsh_e0_Xf3_m1 vdd vdd sky130_fd_pr__pfet_01v8 w=2 l=0.15
X770 t_Xsh_e0_Xf3_m2 rst_n vdd vdd sky130_fd_pr__pfet_01v8 w=2 l=0.15
X771 t_Xsh_e0_Xf3_m3 t_Xsh_e0_Xf3_m2 vss vss sky130_fd_pr__nfet_01v8_lvt w=0.45 l=0.15
X772 t_Xsh_e0_Xf3_m3 t_Xsh_e0_Xf3_m2 vdd vdd sky130_fd_pr__pfet_01v8 w=1.15 l=0.15
X773 t_Xsh_e0_Xf3_m3 t_ck0b t_Xsh_e0_Xf3_m1 vss sky130_fd_pr__nfet_01v8_lvt w=0.45 l=0.15
X774 t_Xsh_e0_Xf3_m3 t_ck0bb t_Xsh_e0_Xf3_m1 vdd sky130_fd_pr__pfet_01v8 w=1.05 l=0.15
X775 t_Xsh_e0_Xf3_m2 t_ck0b t_Xsh_e0_Xf3_s1 vss sky130_fd_pr__nfet_01v8_lvt w=0.65 l=0.15
X776 t_Xsh_e0_Xf3_m2 t_ck0bb t_Xsh_e0_Xf3_s1 vdd sky130_fd_pr__pfet_01v8 w=2.2 l=0.15
X777 t_Xsh_e0_Xf3_qi t_Xsh_e0_Xf3_s1 vss vss sky130_fd_pr__nfet_01v8_lvt w=0.65 l=0.15
X778 t_Xsh_e0_Xf3_qi t_Xsh_e0_Xf3_s1 vdd vdd sky130_fd_pr__pfet_01v8 w=1.65 l=0.15
X779 t_Xsh_e0_Xf3_s2 t_Xsh_e0_Xf3_qi t_Xsh_e0_Xf3_Xsfb_mid vss sky130_fd_pr__nfet_01v8_lvt w=0.8 l=0.15
X780 t_Xsh_e0_Xf3_Xsfb_mid rst_n vss vss sky130_fd_pr__nfet_01v8_lvt w=0.8 l=0.15
X781 t_Xsh_e0_Xf3_s2 t_Xsh_e0_Xf3_qi vdd vdd sky130_fd_pr__pfet_01v8 w=1.4 l=0.15
X782 t_Xsh_e0_Xf3_s2 rst_n vdd vdd sky130_fd_pr__pfet_01v8 w=1.4 l=0.15
X783 t_Xsh_e0_Xf3_s2 t_ck0bb t_Xsh_e0_Xf3_s1 vss sky130_fd_pr__nfet_01v8_lvt w=0.45 l=0.15
X784 t_Xsh_e0_Xf3_s2 t_ck0b t_Xsh_e0_Xf3_s1 vdd sky130_fd_pr__pfet_01v8 w=1.05 l=0.15
X785 t_e0_3 t_Xsh_e0_Xf3_s1 vss vss sky130_fd_pr__nfet_01v8_lvt w=0.8 l=0.15
X786 t_e0_3 t_Xsh_e0_Xf3_s1 vdd vdd sky130_fd_pr__pfet_01v8 w=2.4 l=0.15
X787 t_Xsh_e0_s3b t_e0_3 vss vss sky130_fd_pr__nfet_01v8_lvt w=0.55 l=0.15
X788 t_Xsh_e0_s3b t_e0_3 vdd vdd sky130_fd_pr__pfet_01v8 w=1.4 l=0.15
X789 t_e1_p t_ck0bb t_Xsh_e1_Xf0_m1 vss sky130_fd_pr__nfet_01v8_lvt w=0.65 l=0.15
X790 t_e1_p t_ck0b t_Xsh_e1_Xf0_m1 vdd sky130_fd_pr__pfet_01v8 w=2.2 l=0.15
X791 t_Xsh_e1_Xf0_m2 t_Xsh_e1_Xf0_m1 t_Xsh_e1_Xf0_Xm2_mid vss sky130_fd_pr__nfet_01v8_lvt w=1 l=0.15
X792 t_Xsh_e1_Xf0_Xm2_mid rst_n vss vss sky130_fd_pr__nfet_01v8_lvt w=1 l=0.15
X793 t_Xsh_e1_Xf0_m2 t_Xsh_e1_Xf0_m1 vdd vdd sky130_fd_pr__pfet_01v8 w=2 l=0.15
X794 t_Xsh_e1_Xf0_m2 rst_n vdd vdd sky130_fd_pr__pfet_01v8 w=2 l=0.15
X795 t_Xsh_e1_Xf0_m3 t_Xsh_e1_Xf0_m2 vss vss sky130_fd_pr__nfet_01v8_lvt w=0.45 l=0.15
X796 t_Xsh_e1_Xf0_m3 t_Xsh_e1_Xf0_m2 vdd vdd sky130_fd_pr__pfet_01v8 w=1.15 l=0.15
X797 t_Xsh_e1_Xf0_m3 t_ck0b t_Xsh_e1_Xf0_m1 vss sky130_fd_pr__nfet_01v8_lvt w=0.45 l=0.15
X798 t_Xsh_e1_Xf0_m3 t_ck0bb t_Xsh_e1_Xf0_m1 vdd sky130_fd_pr__pfet_01v8 w=1.05 l=0.15
X799 t_Xsh_e1_Xf0_m2 t_ck0b t_Xsh_e1_Xf0_s1 vss sky130_fd_pr__nfet_01v8_lvt w=0.65 l=0.15
X800 t_Xsh_e1_Xf0_m2 t_ck0bb t_Xsh_e1_Xf0_s1 vdd sky130_fd_pr__pfet_01v8 w=2.2 l=0.15
X801 t_Xsh_e1_Xf0_qi t_Xsh_e1_Xf0_s1 vss vss sky130_fd_pr__nfet_01v8_lvt w=0.65 l=0.15
X802 t_Xsh_e1_Xf0_qi t_Xsh_e1_Xf0_s1 vdd vdd sky130_fd_pr__pfet_01v8 w=1.65 l=0.15
X803 t_Xsh_e1_Xf0_s2 t_Xsh_e1_Xf0_qi t_Xsh_e1_Xf0_Xsfb_mid vss sky130_fd_pr__nfet_01v8_lvt w=0.8 l=0.15
X804 t_Xsh_e1_Xf0_Xsfb_mid rst_n vss vss sky130_fd_pr__nfet_01v8_lvt w=0.8 l=0.15
X805 t_Xsh_e1_Xf0_s2 t_Xsh_e1_Xf0_qi vdd vdd sky130_fd_pr__pfet_01v8 w=1.4 l=0.15
X806 t_Xsh_e1_Xf0_s2 rst_n vdd vdd sky130_fd_pr__pfet_01v8 w=1.4 l=0.15
X807 t_Xsh_e1_Xf0_s2 t_ck0bb t_Xsh_e1_Xf0_s1 vss sky130_fd_pr__nfet_01v8_lvt w=0.45 l=0.15
X808 t_Xsh_e1_Xf0_s2 t_ck0b t_Xsh_e1_Xf0_s1 vdd sky130_fd_pr__pfet_01v8 w=1.05 l=0.15
X809 t_e1_0 t_Xsh_e1_Xf0_s1 vss vss sky130_fd_pr__nfet_01v8_lvt w=0.8 l=0.15
X810 t_e1_0 t_Xsh_e1_Xf0_s1 vdd vdd sky130_fd_pr__pfet_01v8 w=2.4 l=0.15
X811 t_Xsh_e1_s0b t_e1_0 vss vss sky130_fd_pr__nfet_01v8_lvt w=0.55 l=0.15
X812 t_Xsh_e1_s0b t_e1_0 vdd vdd sky130_fd_pr__pfet_01v8 w=1.4 l=0.15
X813 t_e1_0 t_ck0bb t_Xsh_e1_Xf1_m1 vss sky130_fd_pr__nfet_01v8_lvt w=0.65 l=0.15
X814 t_e1_0 t_ck0b t_Xsh_e1_Xf1_m1 vdd sky130_fd_pr__pfet_01v8 w=2.2 l=0.15
X815 t_Xsh_e1_Xf1_m2 t_Xsh_e1_Xf1_m1 t_Xsh_e1_Xf1_Xm2_mid vss sky130_fd_pr__nfet_01v8_lvt w=1 l=0.15
X816 t_Xsh_e1_Xf1_Xm2_mid rst_n vss vss sky130_fd_pr__nfet_01v8_lvt w=1 l=0.15
X817 t_Xsh_e1_Xf1_m2 t_Xsh_e1_Xf1_m1 vdd vdd sky130_fd_pr__pfet_01v8 w=2 l=0.15
X818 t_Xsh_e1_Xf1_m2 rst_n vdd vdd sky130_fd_pr__pfet_01v8 w=2 l=0.15
X819 t_Xsh_e1_Xf1_m3 t_Xsh_e1_Xf1_m2 vss vss sky130_fd_pr__nfet_01v8_lvt w=0.45 l=0.15
X820 t_Xsh_e1_Xf1_m3 t_Xsh_e1_Xf1_m2 vdd vdd sky130_fd_pr__pfet_01v8 w=1.15 l=0.15
X821 t_Xsh_e1_Xf1_m3 t_ck0b t_Xsh_e1_Xf1_m1 vss sky130_fd_pr__nfet_01v8_lvt w=0.45 l=0.15
X822 t_Xsh_e1_Xf1_m3 t_ck0bb t_Xsh_e1_Xf1_m1 vdd sky130_fd_pr__pfet_01v8 w=1.05 l=0.15
X823 t_Xsh_e1_Xf1_m2 t_ck0b t_Xsh_e1_Xf1_s1 vss sky130_fd_pr__nfet_01v8_lvt w=0.65 l=0.15
X824 t_Xsh_e1_Xf1_m2 t_ck0bb t_Xsh_e1_Xf1_s1 vdd sky130_fd_pr__pfet_01v8 w=2.2 l=0.15
X825 t_Xsh_e1_Xf1_qi t_Xsh_e1_Xf1_s1 vss vss sky130_fd_pr__nfet_01v8_lvt w=0.65 l=0.15
X826 t_Xsh_e1_Xf1_qi t_Xsh_e1_Xf1_s1 vdd vdd sky130_fd_pr__pfet_01v8 w=1.65 l=0.15
X827 t_Xsh_e1_Xf1_s2 t_Xsh_e1_Xf1_qi t_Xsh_e1_Xf1_Xsfb_mid vss sky130_fd_pr__nfet_01v8_lvt w=0.8 l=0.15
X828 t_Xsh_e1_Xf1_Xsfb_mid rst_n vss vss sky130_fd_pr__nfet_01v8_lvt w=0.8 l=0.15
X829 t_Xsh_e1_Xf1_s2 t_Xsh_e1_Xf1_qi vdd vdd sky130_fd_pr__pfet_01v8 w=1.4 l=0.15
X830 t_Xsh_e1_Xf1_s2 rst_n vdd vdd sky130_fd_pr__pfet_01v8 w=1.4 l=0.15
X831 t_Xsh_e1_Xf1_s2 t_ck0bb t_Xsh_e1_Xf1_s1 vss sky130_fd_pr__nfet_01v8_lvt w=0.45 l=0.15
X832 t_Xsh_e1_Xf1_s2 t_ck0b t_Xsh_e1_Xf1_s1 vdd sky130_fd_pr__pfet_01v8 w=1.05 l=0.15
X833 t_e1_1 t_Xsh_e1_Xf1_s1 vss vss sky130_fd_pr__nfet_01v8_lvt w=0.8 l=0.15
X834 t_e1_1 t_Xsh_e1_Xf1_s1 vdd vdd sky130_fd_pr__pfet_01v8 w=2.4 l=0.15
X835 t_Xsh_e1_s1b t_e1_1 vss vss sky130_fd_pr__nfet_01v8_lvt w=0.55 l=0.15
X836 t_Xsh_e1_s1b t_e1_1 vdd vdd sky130_fd_pr__pfet_01v8 w=1.4 l=0.15
X837 t_e1_1 t_ck0bb t_Xsh_e1_Xf2_m1 vss sky130_fd_pr__nfet_01v8_lvt w=0.65 l=0.15
X838 t_e1_1 t_ck0b t_Xsh_e1_Xf2_m1 vdd sky130_fd_pr__pfet_01v8 w=2.2 l=0.15
X839 t_Xsh_e1_Xf2_m2 t_Xsh_e1_Xf2_m1 t_Xsh_e1_Xf2_Xm2_mid vss sky130_fd_pr__nfet_01v8_lvt w=1 l=0.15
X840 t_Xsh_e1_Xf2_Xm2_mid rst_n vss vss sky130_fd_pr__nfet_01v8_lvt w=1 l=0.15
X841 t_Xsh_e1_Xf2_m2 t_Xsh_e1_Xf2_m1 vdd vdd sky130_fd_pr__pfet_01v8 w=2 l=0.15
X842 t_Xsh_e1_Xf2_m2 rst_n vdd vdd sky130_fd_pr__pfet_01v8 w=2 l=0.15
X843 t_Xsh_e1_Xf2_m3 t_Xsh_e1_Xf2_m2 vss vss sky130_fd_pr__nfet_01v8_lvt w=0.45 l=0.15
X844 t_Xsh_e1_Xf2_m3 t_Xsh_e1_Xf2_m2 vdd vdd sky130_fd_pr__pfet_01v8 w=1.15 l=0.15
X845 t_Xsh_e1_Xf2_m3 t_ck0b t_Xsh_e1_Xf2_m1 vss sky130_fd_pr__nfet_01v8_lvt w=0.45 l=0.15
X846 t_Xsh_e1_Xf2_m3 t_ck0bb t_Xsh_e1_Xf2_m1 vdd sky130_fd_pr__pfet_01v8 w=1.05 l=0.15
X847 t_Xsh_e1_Xf2_m2 t_ck0b t_Xsh_e1_Xf2_s1 vss sky130_fd_pr__nfet_01v8_lvt w=0.65 l=0.15
X848 t_Xsh_e1_Xf2_m2 t_ck0bb t_Xsh_e1_Xf2_s1 vdd sky130_fd_pr__pfet_01v8 w=2.2 l=0.15
X849 t_Xsh_e1_Xf2_qi t_Xsh_e1_Xf2_s1 vss vss sky130_fd_pr__nfet_01v8_lvt w=0.65 l=0.15
X850 t_Xsh_e1_Xf2_qi t_Xsh_e1_Xf2_s1 vdd vdd sky130_fd_pr__pfet_01v8 w=1.65 l=0.15
X851 t_Xsh_e1_Xf2_s2 t_Xsh_e1_Xf2_qi t_Xsh_e1_Xf2_Xsfb_mid vss sky130_fd_pr__nfet_01v8_lvt w=0.8 l=0.15
X852 t_Xsh_e1_Xf2_Xsfb_mid rst_n vss vss sky130_fd_pr__nfet_01v8_lvt w=0.8 l=0.15
X853 t_Xsh_e1_Xf2_s2 t_Xsh_e1_Xf2_qi vdd vdd sky130_fd_pr__pfet_01v8 w=1.4 l=0.15
X854 t_Xsh_e1_Xf2_s2 rst_n vdd vdd sky130_fd_pr__pfet_01v8 w=1.4 l=0.15
X855 t_Xsh_e1_Xf2_s2 t_ck0bb t_Xsh_e1_Xf2_s1 vss sky130_fd_pr__nfet_01v8_lvt w=0.45 l=0.15
X856 t_Xsh_e1_Xf2_s2 t_ck0b t_Xsh_e1_Xf2_s1 vdd sky130_fd_pr__pfet_01v8 w=1.05 l=0.15
X857 t_e1_2 t_Xsh_e1_Xf2_s1 vss vss sky130_fd_pr__nfet_01v8_lvt w=0.8 l=0.15
X858 t_e1_2 t_Xsh_e1_Xf2_s1 vdd vdd sky130_fd_pr__pfet_01v8 w=2.4 l=0.15
X859 t_Xsh_e1_s2b t_e1_2 vss vss sky130_fd_pr__nfet_01v8_lvt w=0.55 l=0.15
X860 t_Xsh_e1_s2b t_e1_2 vdd vdd sky130_fd_pr__pfet_01v8 w=1.4 l=0.15
X861 t_e1_2 t_ck0bb t_Xsh_e1_Xf3_m1 vss sky130_fd_pr__nfet_01v8_lvt w=0.65 l=0.15
X862 t_e1_2 t_ck0b t_Xsh_e1_Xf3_m1 vdd sky130_fd_pr__pfet_01v8 w=2.2 l=0.15
X863 t_Xsh_e1_Xf3_m2 t_Xsh_e1_Xf3_m1 t_Xsh_e1_Xf3_Xm2_mid vss sky130_fd_pr__nfet_01v8_lvt w=1 l=0.15
X864 t_Xsh_e1_Xf3_Xm2_mid rst_n vss vss sky130_fd_pr__nfet_01v8_lvt w=1 l=0.15
X865 t_Xsh_e1_Xf3_m2 t_Xsh_e1_Xf3_m1 vdd vdd sky130_fd_pr__pfet_01v8 w=2 l=0.15
X866 t_Xsh_e1_Xf3_m2 rst_n vdd vdd sky130_fd_pr__pfet_01v8 w=2 l=0.15
X867 t_Xsh_e1_Xf3_m3 t_Xsh_e1_Xf3_m2 vss vss sky130_fd_pr__nfet_01v8_lvt w=0.45 l=0.15
X868 t_Xsh_e1_Xf3_m3 t_Xsh_e1_Xf3_m2 vdd vdd sky130_fd_pr__pfet_01v8 w=1.15 l=0.15
X869 t_Xsh_e1_Xf3_m3 t_ck0b t_Xsh_e1_Xf3_m1 vss sky130_fd_pr__nfet_01v8_lvt w=0.45 l=0.15
X870 t_Xsh_e1_Xf3_m3 t_ck0bb t_Xsh_e1_Xf3_m1 vdd sky130_fd_pr__pfet_01v8 w=1.05 l=0.15
X871 t_Xsh_e1_Xf3_m2 t_ck0b t_Xsh_e1_Xf3_s1 vss sky130_fd_pr__nfet_01v8_lvt w=0.65 l=0.15
X872 t_Xsh_e1_Xf3_m2 t_ck0bb t_Xsh_e1_Xf3_s1 vdd sky130_fd_pr__pfet_01v8 w=2.2 l=0.15
X873 t_Xsh_e1_Xf3_qi t_Xsh_e1_Xf3_s1 vss vss sky130_fd_pr__nfet_01v8_lvt w=0.65 l=0.15
X874 t_Xsh_e1_Xf3_qi t_Xsh_e1_Xf3_s1 vdd vdd sky130_fd_pr__pfet_01v8 w=1.65 l=0.15
X875 t_Xsh_e1_Xf3_s2 t_Xsh_e1_Xf3_qi t_Xsh_e1_Xf3_Xsfb_mid vss sky130_fd_pr__nfet_01v8_lvt w=0.8 l=0.15
X876 t_Xsh_e1_Xf3_Xsfb_mid rst_n vss vss sky130_fd_pr__nfet_01v8_lvt w=0.8 l=0.15
X877 t_Xsh_e1_Xf3_s2 t_Xsh_e1_Xf3_qi vdd vdd sky130_fd_pr__pfet_01v8 w=1.4 l=0.15
X878 t_Xsh_e1_Xf3_s2 rst_n vdd vdd sky130_fd_pr__pfet_01v8 w=1.4 l=0.15
X879 t_Xsh_e1_Xf3_s2 t_ck0bb t_Xsh_e1_Xf3_s1 vss sky130_fd_pr__nfet_01v8_lvt w=0.45 l=0.15
X880 t_Xsh_e1_Xf3_s2 t_ck0b t_Xsh_e1_Xf3_s1 vdd sky130_fd_pr__pfet_01v8 w=1.05 l=0.15
X881 t_e1_3 t_Xsh_e1_Xf3_s1 vss vss sky130_fd_pr__nfet_01v8_lvt w=0.8 l=0.15
X882 t_e1_3 t_Xsh_e1_Xf3_s1 vdd vdd sky130_fd_pr__pfet_01v8 w=2.4 l=0.15
X883 t_Xsh_e1_s3b t_e1_3 vss vss sky130_fd_pr__nfet_01v8_lvt w=0.55 l=0.15
X884 t_Xsh_e1_s3b t_e1_3 vdd vdd sky130_fd_pr__pfet_01v8 w=1.4 l=0.15
X885 t_e2_a t_ck0bb t_Xsh_e2_Xf0_m1 vss sky130_fd_pr__nfet_01v8_lvt w=0.65 l=0.15
X886 t_e2_a t_ck0b t_Xsh_e2_Xf0_m1 vdd sky130_fd_pr__pfet_01v8 w=2.2 l=0.15
X887 t_Xsh_e2_Xf0_m2 t_Xsh_e2_Xf0_m1 t_Xsh_e2_Xf0_Xm2_mid vss sky130_fd_pr__nfet_01v8_lvt w=1 l=0.15
X888 t_Xsh_e2_Xf0_Xm2_mid rst_n vss vss sky130_fd_pr__nfet_01v8_lvt w=1 l=0.15
X889 t_Xsh_e2_Xf0_m2 t_Xsh_e2_Xf0_m1 vdd vdd sky130_fd_pr__pfet_01v8 w=2 l=0.15
X890 t_Xsh_e2_Xf0_m2 rst_n vdd vdd sky130_fd_pr__pfet_01v8 w=2 l=0.15
X891 t_Xsh_e2_Xf0_m3 t_Xsh_e2_Xf0_m2 vss vss sky130_fd_pr__nfet_01v8_lvt w=0.45 l=0.15
X892 t_Xsh_e2_Xf0_m3 t_Xsh_e2_Xf0_m2 vdd vdd sky130_fd_pr__pfet_01v8 w=1.15 l=0.15
X893 t_Xsh_e2_Xf0_m3 t_ck0b t_Xsh_e2_Xf0_m1 vss sky130_fd_pr__nfet_01v8_lvt w=0.45 l=0.15
X894 t_Xsh_e2_Xf0_m3 t_ck0bb t_Xsh_e2_Xf0_m1 vdd sky130_fd_pr__pfet_01v8 w=1.05 l=0.15
X895 t_Xsh_e2_Xf0_m2 t_ck0b t_Xsh_e2_Xf0_s1 vss sky130_fd_pr__nfet_01v8_lvt w=0.65 l=0.15
X896 t_Xsh_e2_Xf0_m2 t_ck0bb t_Xsh_e2_Xf0_s1 vdd sky130_fd_pr__pfet_01v8 w=2.2 l=0.15
X897 t_Xsh_e2_Xf0_qi t_Xsh_e2_Xf0_s1 vss vss sky130_fd_pr__nfet_01v8_lvt w=0.65 l=0.15
X898 t_Xsh_e2_Xf0_qi t_Xsh_e2_Xf0_s1 vdd vdd sky130_fd_pr__pfet_01v8 w=1.65 l=0.15
X899 t_Xsh_e2_Xf0_s2 t_Xsh_e2_Xf0_qi t_Xsh_e2_Xf0_Xsfb_mid vss sky130_fd_pr__nfet_01v8_lvt w=0.8 l=0.15
X900 t_Xsh_e2_Xf0_Xsfb_mid rst_n vss vss sky130_fd_pr__nfet_01v8_lvt w=0.8 l=0.15
X901 t_Xsh_e2_Xf0_s2 t_Xsh_e2_Xf0_qi vdd vdd sky130_fd_pr__pfet_01v8 w=1.4 l=0.15
X902 t_Xsh_e2_Xf0_s2 rst_n vdd vdd sky130_fd_pr__pfet_01v8 w=1.4 l=0.15
X903 t_Xsh_e2_Xf0_s2 t_ck0bb t_Xsh_e2_Xf0_s1 vss sky130_fd_pr__nfet_01v8_lvt w=0.45 l=0.15
X904 t_Xsh_e2_Xf0_s2 t_ck0b t_Xsh_e2_Xf0_s1 vdd sky130_fd_pr__pfet_01v8 w=1.05 l=0.15
X905 t_e2_0 t_Xsh_e2_Xf0_s1 vss vss sky130_fd_pr__nfet_01v8_lvt w=0.8 l=0.15
X906 t_e2_0 t_Xsh_e2_Xf0_s1 vdd vdd sky130_fd_pr__pfet_01v8 w=2.4 l=0.15
X907 t_Xsh_e2_s0b t_e2_0 vss vss sky130_fd_pr__nfet_01v8_lvt w=0.55 l=0.15
X908 t_Xsh_e2_s0b t_e2_0 vdd vdd sky130_fd_pr__pfet_01v8 w=1.4 l=0.15
X909 t_e2_0 t_ck0bb t_Xsh_e2_Xf1_m1 vss sky130_fd_pr__nfet_01v8_lvt w=0.65 l=0.15
X910 t_e2_0 t_ck0b t_Xsh_e2_Xf1_m1 vdd sky130_fd_pr__pfet_01v8 w=2.2 l=0.15
X911 t_Xsh_e2_Xf1_m2 t_Xsh_e2_Xf1_m1 t_Xsh_e2_Xf1_Xm2_mid vss sky130_fd_pr__nfet_01v8_lvt w=1 l=0.15
X912 t_Xsh_e2_Xf1_Xm2_mid rst_n vss vss sky130_fd_pr__nfet_01v8_lvt w=1 l=0.15
X913 t_Xsh_e2_Xf1_m2 t_Xsh_e2_Xf1_m1 vdd vdd sky130_fd_pr__pfet_01v8 w=2 l=0.15
X914 t_Xsh_e2_Xf1_m2 rst_n vdd vdd sky130_fd_pr__pfet_01v8 w=2 l=0.15
X915 t_Xsh_e2_Xf1_m3 t_Xsh_e2_Xf1_m2 vss vss sky130_fd_pr__nfet_01v8_lvt w=0.45 l=0.15
X916 t_Xsh_e2_Xf1_m3 t_Xsh_e2_Xf1_m2 vdd vdd sky130_fd_pr__pfet_01v8 w=1.15 l=0.15
X917 t_Xsh_e2_Xf1_m3 t_ck0b t_Xsh_e2_Xf1_m1 vss sky130_fd_pr__nfet_01v8_lvt w=0.45 l=0.15
X918 t_Xsh_e2_Xf1_m3 t_ck0bb t_Xsh_e2_Xf1_m1 vdd sky130_fd_pr__pfet_01v8 w=1.05 l=0.15
X919 t_Xsh_e2_Xf1_m2 t_ck0b t_Xsh_e2_Xf1_s1 vss sky130_fd_pr__nfet_01v8_lvt w=0.65 l=0.15
X920 t_Xsh_e2_Xf1_m2 t_ck0bb t_Xsh_e2_Xf1_s1 vdd sky130_fd_pr__pfet_01v8 w=2.2 l=0.15
X921 t_Xsh_e2_Xf1_qi t_Xsh_e2_Xf1_s1 vss vss sky130_fd_pr__nfet_01v8_lvt w=0.65 l=0.15
X922 t_Xsh_e2_Xf1_qi t_Xsh_e2_Xf1_s1 vdd vdd sky130_fd_pr__pfet_01v8 w=1.65 l=0.15
X923 t_Xsh_e2_Xf1_s2 t_Xsh_e2_Xf1_qi t_Xsh_e2_Xf1_Xsfb_mid vss sky130_fd_pr__nfet_01v8_lvt w=0.8 l=0.15
X924 t_Xsh_e2_Xf1_Xsfb_mid rst_n vss vss sky130_fd_pr__nfet_01v8_lvt w=0.8 l=0.15
X925 t_Xsh_e2_Xf1_s2 t_Xsh_e2_Xf1_qi vdd vdd sky130_fd_pr__pfet_01v8 w=1.4 l=0.15
X926 t_Xsh_e2_Xf1_s2 rst_n vdd vdd sky130_fd_pr__pfet_01v8 w=1.4 l=0.15
X927 t_Xsh_e2_Xf1_s2 t_ck0bb t_Xsh_e2_Xf1_s1 vss sky130_fd_pr__nfet_01v8_lvt w=0.45 l=0.15
X928 t_Xsh_e2_Xf1_s2 t_ck0b t_Xsh_e2_Xf1_s1 vdd sky130_fd_pr__pfet_01v8 w=1.05 l=0.15
X929 t_e2_1 t_Xsh_e2_Xf1_s1 vss vss sky130_fd_pr__nfet_01v8_lvt w=0.8 l=0.15
X930 t_e2_1 t_Xsh_e2_Xf1_s1 vdd vdd sky130_fd_pr__pfet_01v8 w=2.4 l=0.15
X931 t_Xsh_e2_s1b t_e2_1 vss vss sky130_fd_pr__nfet_01v8_lvt w=0.55 l=0.15
X932 t_Xsh_e2_s1b t_e2_1 vdd vdd sky130_fd_pr__pfet_01v8 w=1.4 l=0.15
X933 t_e2_1 t_ck0bb t_Xsh_e2_Xf2_m1 vss sky130_fd_pr__nfet_01v8_lvt w=0.65 l=0.15
X934 t_e2_1 t_ck0b t_Xsh_e2_Xf2_m1 vdd sky130_fd_pr__pfet_01v8 w=2.2 l=0.15
X935 t_Xsh_e2_Xf2_m2 t_Xsh_e2_Xf2_m1 t_Xsh_e2_Xf2_Xm2_mid vss sky130_fd_pr__nfet_01v8_lvt w=1 l=0.15
X936 t_Xsh_e2_Xf2_Xm2_mid rst_n vss vss sky130_fd_pr__nfet_01v8_lvt w=1 l=0.15
X937 t_Xsh_e2_Xf2_m2 t_Xsh_e2_Xf2_m1 vdd vdd sky130_fd_pr__pfet_01v8 w=2 l=0.15
X938 t_Xsh_e2_Xf2_m2 rst_n vdd vdd sky130_fd_pr__pfet_01v8 w=2 l=0.15
X939 t_Xsh_e2_Xf2_m3 t_Xsh_e2_Xf2_m2 vss vss sky130_fd_pr__nfet_01v8_lvt w=0.45 l=0.15
X940 t_Xsh_e2_Xf2_m3 t_Xsh_e2_Xf2_m2 vdd vdd sky130_fd_pr__pfet_01v8 w=1.15 l=0.15
X941 t_Xsh_e2_Xf2_m3 t_ck0b t_Xsh_e2_Xf2_m1 vss sky130_fd_pr__nfet_01v8_lvt w=0.45 l=0.15
X942 t_Xsh_e2_Xf2_m3 t_ck0bb t_Xsh_e2_Xf2_m1 vdd sky130_fd_pr__pfet_01v8 w=1.05 l=0.15
X943 t_Xsh_e2_Xf2_m2 t_ck0b t_Xsh_e2_Xf2_s1 vss sky130_fd_pr__nfet_01v8_lvt w=0.65 l=0.15
X944 t_Xsh_e2_Xf2_m2 t_ck0bb t_Xsh_e2_Xf2_s1 vdd sky130_fd_pr__pfet_01v8 w=2.2 l=0.15
X945 t_Xsh_e2_Xf2_qi t_Xsh_e2_Xf2_s1 vss vss sky130_fd_pr__nfet_01v8_lvt w=0.65 l=0.15
X946 t_Xsh_e2_Xf2_qi t_Xsh_e2_Xf2_s1 vdd vdd sky130_fd_pr__pfet_01v8 w=1.65 l=0.15
X947 t_Xsh_e2_Xf2_s2 t_Xsh_e2_Xf2_qi t_Xsh_e2_Xf2_Xsfb_mid vss sky130_fd_pr__nfet_01v8_lvt w=0.8 l=0.15
X948 t_Xsh_e2_Xf2_Xsfb_mid rst_n vss vss sky130_fd_pr__nfet_01v8_lvt w=0.8 l=0.15
X949 t_Xsh_e2_Xf2_s2 t_Xsh_e2_Xf2_qi vdd vdd sky130_fd_pr__pfet_01v8 w=1.4 l=0.15
X950 t_Xsh_e2_Xf2_s2 rst_n vdd vdd sky130_fd_pr__pfet_01v8 w=1.4 l=0.15
X951 t_Xsh_e2_Xf2_s2 t_ck0bb t_Xsh_e2_Xf2_s1 vss sky130_fd_pr__nfet_01v8_lvt w=0.45 l=0.15
X952 t_Xsh_e2_Xf2_s2 t_ck0b t_Xsh_e2_Xf2_s1 vdd sky130_fd_pr__pfet_01v8 w=1.05 l=0.15
X953 t_e2_2 t_Xsh_e2_Xf2_s1 vss vss sky130_fd_pr__nfet_01v8_lvt w=0.8 l=0.15
X954 t_e2_2 t_Xsh_e2_Xf2_s1 vdd vdd sky130_fd_pr__pfet_01v8 w=2.4 l=0.15
X955 t_Xsh_e2_s2b t_e2_2 vss vss sky130_fd_pr__nfet_01v8_lvt w=0.55 l=0.15
X956 t_Xsh_e2_s2b t_e2_2 vdd vdd sky130_fd_pr__pfet_01v8 w=1.4 l=0.15
X957 t_e2_2 t_ck0bb t_Xsh_e2_Xf3_m1 vss sky130_fd_pr__nfet_01v8_lvt w=0.65 l=0.15
X958 t_e2_2 t_ck0b t_Xsh_e2_Xf3_m1 vdd sky130_fd_pr__pfet_01v8 w=2.2 l=0.15
X959 t_Xsh_e2_Xf3_m2 t_Xsh_e2_Xf3_m1 t_Xsh_e2_Xf3_Xm2_mid vss sky130_fd_pr__nfet_01v8_lvt w=1 l=0.15
X960 t_Xsh_e2_Xf3_Xm2_mid rst_n vss vss sky130_fd_pr__nfet_01v8_lvt w=1 l=0.15
X961 t_Xsh_e2_Xf3_m2 t_Xsh_e2_Xf3_m1 vdd vdd sky130_fd_pr__pfet_01v8 w=2 l=0.15
X962 t_Xsh_e2_Xf3_m2 rst_n vdd vdd sky130_fd_pr__pfet_01v8 w=2 l=0.15
X963 t_Xsh_e2_Xf3_m3 t_Xsh_e2_Xf3_m2 vss vss sky130_fd_pr__nfet_01v8_lvt w=0.45 l=0.15
X964 t_Xsh_e2_Xf3_m3 t_Xsh_e2_Xf3_m2 vdd vdd sky130_fd_pr__pfet_01v8 w=1.15 l=0.15
X965 t_Xsh_e2_Xf3_m3 t_ck0b t_Xsh_e2_Xf3_m1 vss sky130_fd_pr__nfet_01v8_lvt w=0.45 l=0.15
X966 t_Xsh_e2_Xf3_m3 t_ck0bb t_Xsh_e2_Xf3_m1 vdd sky130_fd_pr__pfet_01v8 w=1.05 l=0.15
X967 t_Xsh_e2_Xf3_m2 t_ck0b t_Xsh_e2_Xf3_s1 vss sky130_fd_pr__nfet_01v8_lvt w=0.65 l=0.15
X968 t_Xsh_e2_Xf3_m2 t_ck0bb t_Xsh_e2_Xf3_s1 vdd sky130_fd_pr__pfet_01v8 w=2.2 l=0.15
X969 t_Xsh_e2_Xf3_qi t_Xsh_e2_Xf3_s1 vss vss sky130_fd_pr__nfet_01v8_lvt w=0.65 l=0.15
X970 t_Xsh_e2_Xf3_qi t_Xsh_e2_Xf3_s1 vdd vdd sky130_fd_pr__pfet_01v8 w=1.65 l=0.15
X971 t_Xsh_e2_Xf3_s2 t_Xsh_e2_Xf3_qi t_Xsh_e2_Xf3_Xsfb_mid vss sky130_fd_pr__nfet_01v8_lvt w=0.8 l=0.15
X972 t_Xsh_e2_Xf3_Xsfb_mid rst_n vss vss sky130_fd_pr__nfet_01v8_lvt w=0.8 l=0.15
X973 t_Xsh_e2_Xf3_s2 t_Xsh_e2_Xf3_qi vdd vdd sky130_fd_pr__pfet_01v8 w=1.4 l=0.15
X974 t_Xsh_e2_Xf3_s2 rst_n vdd vdd sky130_fd_pr__pfet_01v8 w=1.4 l=0.15
X975 t_Xsh_e2_Xf3_s2 t_ck0bb t_Xsh_e2_Xf3_s1 vss sky130_fd_pr__nfet_01v8_lvt w=0.45 l=0.15
X976 t_Xsh_e2_Xf3_s2 t_ck0b t_Xsh_e2_Xf3_s1 vdd sky130_fd_pr__pfet_01v8 w=1.05 l=0.15
X977 t_e2_3 t_Xsh_e2_Xf3_s1 vss vss sky130_fd_pr__nfet_01v8_lvt w=0.8 l=0.15
X978 t_e2_3 t_Xsh_e2_Xf3_s1 vdd vdd sky130_fd_pr__pfet_01v8 w=2.4 l=0.15
X979 t_Xsh_e2_s3b t_e2_3 vss vss sky130_fd_pr__nfet_01v8_lvt w=0.55 l=0.15
X980 t_Xsh_e2_s3b t_e2_3 vdd vdd sky130_fd_pr__pfet_01v8 w=1.4 l=0.15
X981 t_e3_a t_ck0bb t_Xsh_e3_Xf0_m1 vss sky130_fd_pr__nfet_01v8_lvt w=0.65 l=0.15
X982 t_e3_a t_ck0b t_Xsh_e3_Xf0_m1 vdd sky130_fd_pr__pfet_01v8 w=2.2 l=0.15
X983 t_Xsh_e3_Xf0_m2 t_Xsh_e3_Xf0_m1 t_Xsh_e3_Xf0_Xm2_mid vss sky130_fd_pr__nfet_01v8_lvt w=1 l=0.15
X984 t_Xsh_e3_Xf0_Xm2_mid rst_n vss vss sky130_fd_pr__nfet_01v8_lvt w=1 l=0.15
X985 t_Xsh_e3_Xf0_m2 t_Xsh_e3_Xf0_m1 vdd vdd sky130_fd_pr__pfet_01v8 w=2 l=0.15
X986 t_Xsh_e3_Xf0_m2 rst_n vdd vdd sky130_fd_pr__pfet_01v8 w=2 l=0.15
X987 t_Xsh_e3_Xf0_m3 t_Xsh_e3_Xf0_m2 vss vss sky130_fd_pr__nfet_01v8_lvt w=0.45 l=0.15
X988 t_Xsh_e3_Xf0_m3 t_Xsh_e3_Xf0_m2 vdd vdd sky130_fd_pr__pfet_01v8 w=1.15 l=0.15
X989 t_Xsh_e3_Xf0_m3 t_ck0b t_Xsh_e3_Xf0_m1 vss sky130_fd_pr__nfet_01v8_lvt w=0.45 l=0.15
X990 t_Xsh_e3_Xf0_m3 t_ck0bb t_Xsh_e3_Xf0_m1 vdd sky130_fd_pr__pfet_01v8 w=1.05 l=0.15
X991 t_Xsh_e3_Xf0_m2 t_ck0b t_Xsh_e3_Xf0_s1 vss sky130_fd_pr__nfet_01v8_lvt w=0.65 l=0.15
X992 t_Xsh_e3_Xf0_m2 t_ck0bb t_Xsh_e3_Xf0_s1 vdd sky130_fd_pr__pfet_01v8 w=2.2 l=0.15
X993 t_Xsh_e3_Xf0_qi t_Xsh_e3_Xf0_s1 vss vss sky130_fd_pr__nfet_01v8_lvt w=0.65 l=0.15
X994 t_Xsh_e3_Xf0_qi t_Xsh_e3_Xf0_s1 vdd vdd sky130_fd_pr__pfet_01v8 w=1.65 l=0.15
X995 t_Xsh_e3_Xf0_s2 t_Xsh_e3_Xf0_qi t_Xsh_e3_Xf0_Xsfb_mid vss sky130_fd_pr__nfet_01v8_lvt w=0.8 l=0.15
X996 t_Xsh_e3_Xf0_Xsfb_mid rst_n vss vss sky130_fd_pr__nfet_01v8_lvt w=0.8 l=0.15
X997 t_Xsh_e3_Xf0_s2 t_Xsh_e3_Xf0_qi vdd vdd sky130_fd_pr__pfet_01v8 w=1.4 l=0.15
X998 t_Xsh_e3_Xf0_s2 rst_n vdd vdd sky130_fd_pr__pfet_01v8 w=1.4 l=0.15
X999 t_Xsh_e3_Xf0_s2 t_ck0bb t_Xsh_e3_Xf0_s1 vss sky130_fd_pr__nfet_01v8_lvt w=0.45 l=0.15
X1000 t_Xsh_e3_Xf0_s2 t_ck0b t_Xsh_e3_Xf0_s1 vdd sky130_fd_pr__pfet_01v8 w=1.05 l=0.15
X1001 t_e3_0 t_Xsh_e3_Xf0_s1 vss vss sky130_fd_pr__nfet_01v8_lvt w=0.8 l=0.15
X1002 t_e3_0 t_Xsh_e3_Xf0_s1 vdd vdd sky130_fd_pr__pfet_01v8 w=2.4 l=0.15
X1003 t_Xsh_e3_s0b t_e3_0 vss vss sky130_fd_pr__nfet_01v8_lvt w=0.55 l=0.15
X1004 t_Xsh_e3_s0b t_e3_0 vdd vdd sky130_fd_pr__pfet_01v8 w=1.4 l=0.15
X1005 t_e3_0 t_ck0bb t_Xsh_e3_Xf1_m1 vss sky130_fd_pr__nfet_01v8_lvt w=0.65 l=0.15
X1006 t_e3_0 t_ck0b t_Xsh_e3_Xf1_m1 vdd sky130_fd_pr__pfet_01v8 w=2.2 l=0.15
X1007 t_Xsh_e3_Xf1_m2 t_Xsh_e3_Xf1_m1 t_Xsh_e3_Xf1_Xm2_mid vss sky130_fd_pr__nfet_01v8_lvt w=1 l=0.15
X1008 t_Xsh_e3_Xf1_Xm2_mid rst_n vss vss sky130_fd_pr__nfet_01v8_lvt w=1 l=0.15
X1009 t_Xsh_e3_Xf1_m2 t_Xsh_e3_Xf1_m1 vdd vdd sky130_fd_pr__pfet_01v8 w=2 l=0.15
X1010 t_Xsh_e3_Xf1_m2 rst_n vdd vdd sky130_fd_pr__pfet_01v8 w=2 l=0.15
X1011 t_Xsh_e3_Xf1_m3 t_Xsh_e3_Xf1_m2 vss vss sky130_fd_pr__nfet_01v8_lvt w=0.45 l=0.15
X1012 t_Xsh_e3_Xf1_m3 t_Xsh_e3_Xf1_m2 vdd vdd sky130_fd_pr__pfet_01v8 w=1.15 l=0.15
X1013 t_Xsh_e3_Xf1_m3 t_ck0b t_Xsh_e3_Xf1_m1 vss sky130_fd_pr__nfet_01v8_lvt w=0.45 l=0.15
X1014 t_Xsh_e3_Xf1_m3 t_ck0bb t_Xsh_e3_Xf1_m1 vdd sky130_fd_pr__pfet_01v8 w=1.05 l=0.15
X1015 t_Xsh_e3_Xf1_m2 t_ck0b t_Xsh_e3_Xf1_s1 vss sky130_fd_pr__nfet_01v8_lvt w=0.65 l=0.15
X1016 t_Xsh_e3_Xf1_m2 t_ck0bb t_Xsh_e3_Xf1_s1 vdd sky130_fd_pr__pfet_01v8 w=2.2 l=0.15
X1017 t_Xsh_e3_Xf1_qi t_Xsh_e3_Xf1_s1 vss vss sky130_fd_pr__nfet_01v8_lvt w=0.65 l=0.15
X1018 t_Xsh_e3_Xf1_qi t_Xsh_e3_Xf1_s1 vdd vdd sky130_fd_pr__pfet_01v8 w=1.65 l=0.15
X1019 t_Xsh_e3_Xf1_s2 t_Xsh_e3_Xf1_qi t_Xsh_e3_Xf1_Xsfb_mid vss sky130_fd_pr__nfet_01v8_lvt w=0.8 l=0.15
X1020 t_Xsh_e3_Xf1_Xsfb_mid rst_n vss vss sky130_fd_pr__nfet_01v8_lvt w=0.8 l=0.15
X1021 t_Xsh_e3_Xf1_s2 t_Xsh_e3_Xf1_qi vdd vdd sky130_fd_pr__pfet_01v8 w=1.4 l=0.15
X1022 t_Xsh_e3_Xf1_s2 rst_n vdd vdd sky130_fd_pr__pfet_01v8 w=1.4 l=0.15
X1023 t_Xsh_e3_Xf1_s2 t_ck0bb t_Xsh_e3_Xf1_s1 vss sky130_fd_pr__nfet_01v8_lvt w=0.45 l=0.15
X1024 t_Xsh_e3_Xf1_s2 t_ck0b t_Xsh_e3_Xf1_s1 vdd sky130_fd_pr__pfet_01v8 w=1.05 l=0.15
X1025 t_e3_1 t_Xsh_e3_Xf1_s1 vss vss sky130_fd_pr__nfet_01v8_lvt w=0.8 l=0.15
X1026 t_e3_1 t_Xsh_e3_Xf1_s1 vdd vdd sky130_fd_pr__pfet_01v8 w=2.4 l=0.15
X1027 t_Xsh_e3_s1b t_e3_1 vss vss sky130_fd_pr__nfet_01v8_lvt w=0.55 l=0.15
X1028 t_Xsh_e3_s1b t_e3_1 vdd vdd sky130_fd_pr__pfet_01v8 w=1.4 l=0.15
X1029 t_e3_1 t_ck0bb t_Xsh_e3_Xf2_m1 vss sky130_fd_pr__nfet_01v8_lvt w=0.65 l=0.15
X1030 t_e3_1 t_ck0b t_Xsh_e3_Xf2_m1 vdd sky130_fd_pr__pfet_01v8 w=2.2 l=0.15
X1031 t_Xsh_e3_Xf2_m2 t_Xsh_e3_Xf2_m1 t_Xsh_e3_Xf2_Xm2_mid vss sky130_fd_pr__nfet_01v8_lvt w=1 l=0.15
X1032 t_Xsh_e3_Xf2_Xm2_mid rst_n vss vss sky130_fd_pr__nfet_01v8_lvt w=1 l=0.15
X1033 t_Xsh_e3_Xf2_m2 t_Xsh_e3_Xf2_m1 vdd vdd sky130_fd_pr__pfet_01v8 w=2 l=0.15
X1034 t_Xsh_e3_Xf2_m2 rst_n vdd vdd sky130_fd_pr__pfet_01v8 w=2 l=0.15
X1035 t_Xsh_e3_Xf2_m3 t_Xsh_e3_Xf2_m2 vss vss sky130_fd_pr__nfet_01v8_lvt w=0.45 l=0.15
X1036 t_Xsh_e3_Xf2_m3 t_Xsh_e3_Xf2_m2 vdd vdd sky130_fd_pr__pfet_01v8 w=1.15 l=0.15
X1037 t_Xsh_e3_Xf2_m3 t_ck0b t_Xsh_e3_Xf2_m1 vss sky130_fd_pr__nfet_01v8_lvt w=0.45 l=0.15
X1038 t_Xsh_e3_Xf2_m3 t_ck0bb t_Xsh_e3_Xf2_m1 vdd sky130_fd_pr__pfet_01v8 w=1.05 l=0.15
X1039 t_Xsh_e3_Xf2_m2 t_ck0b t_Xsh_e3_Xf2_s1 vss sky130_fd_pr__nfet_01v8_lvt w=0.65 l=0.15
X1040 t_Xsh_e3_Xf2_m2 t_ck0bb t_Xsh_e3_Xf2_s1 vdd sky130_fd_pr__pfet_01v8 w=2.2 l=0.15
X1041 t_Xsh_e3_Xf2_qi t_Xsh_e3_Xf2_s1 vss vss sky130_fd_pr__nfet_01v8_lvt w=0.65 l=0.15
X1042 t_Xsh_e3_Xf2_qi t_Xsh_e3_Xf2_s1 vdd vdd sky130_fd_pr__pfet_01v8 w=1.65 l=0.15
X1043 t_Xsh_e3_Xf2_s2 t_Xsh_e3_Xf2_qi t_Xsh_e3_Xf2_Xsfb_mid vss sky130_fd_pr__nfet_01v8_lvt w=0.8 l=0.15
X1044 t_Xsh_e3_Xf2_Xsfb_mid rst_n vss vss sky130_fd_pr__nfet_01v8_lvt w=0.8 l=0.15
X1045 t_Xsh_e3_Xf2_s2 t_Xsh_e3_Xf2_qi vdd vdd sky130_fd_pr__pfet_01v8 w=1.4 l=0.15
X1046 t_Xsh_e3_Xf2_s2 rst_n vdd vdd sky130_fd_pr__pfet_01v8 w=1.4 l=0.15
X1047 t_Xsh_e3_Xf2_s2 t_ck0bb t_Xsh_e3_Xf2_s1 vss sky130_fd_pr__nfet_01v8_lvt w=0.45 l=0.15
X1048 t_Xsh_e3_Xf2_s2 t_ck0b t_Xsh_e3_Xf2_s1 vdd sky130_fd_pr__pfet_01v8 w=1.05 l=0.15
X1049 t_e3_2 t_Xsh_e3_Xf2_s1 vss vss sky130_fd_pr__nfet_01v8_lvt w=0.8 l=0.15
X1050 t_e3_2 t_Xsh_e3_Xf2_s1 vdd vdd sky130_fd_pr__pfet_01v8 w=2.4 l=0.15
X1051 t_Xsh_e3_s2b t_e3_2 vss vss sky130_fd_pr__nfet_01v8_lvt w=0.55 l=0.15
X1052 t_Xsh_e3_s2b t_e3_2 vdd vdd sky130_fd_pr__pfet_01v8 w=1.4 l=0.15
X1053 t_e3_2 t_ck0bb t_Xsh_e3_Xf3_m1 vss sky130_fd_pr__nfet_01v8_lvt w=0.65 l=0.15
X1054 t_e3_2 t_ck0b t_Xsh_e3_Xf3_m1 vdd sky130_fd_pr__pfet_01v8 w=2.2 l=0.15
X1055 t_Xsh_e3_Xf3_m2 t_Xsh_e3_Xf3_m1 t_Xsh_e3_Xf3_Xm2_mid vss sky130_fd_pr__nfet_01v8_lvt w=1 l=0.15
X1056 t_Xsh_e3_Xf3_Xm2_mid rst_n vss vss sky130_fd_pr__nfet_01v8_lvt w=1 l=0.15
X1057 t_Xsh_e3_Xf3_m2 t_Xsh_e3_Xf3_m1 vdd vdd sky130_fd_pr__pfet_01v8 w=2 l=0.15
X1058 t_Xsh_e3_Xf3_m2 rst_n vdd vdd sky130_fd_pr__pfet_01v8 w=2 l=0.15
X1059 t_Xsh_e3_Xf3_m3 t_Xsh_e3_Xf3_m2 vss vss sky130_fd_pr__nfet_01v8_lvt w=0.45 l=0.15
X1060 t_Xsh_e3_Xf3_m3 t_Xsh_e3_Xf3_m2 vdd vdd sky130_fd_pr__pfet_01v8 w=1.15 l=0.15
X1061 t_Xsh_e3_Xf3_m3 t_ck0b t_Xsh_e3_Xf3_m1 vss sky130_fd_pr__nfet_01v8_lvt w=0.45 l=0.15
X1062 t_Xsh_e3_Xf3_m3 t_ck0bb t_Xsh_e3_Xf3_m1 vdd sky130_fd_pr__pfet_01v8 w=1.05 l=0.15
X1063 t_Xsh_e3_Xf3_m2 t_ck0b t_Xsh_e3_Xf3_s1 vss sky130_fd_pr__nfet_01v8_lvt w=0.65 l=0.15
X1064 t_Xsh_e3_Xf3_m2 t_ck0bb t_Xsh_e3_Xf3_s1 vdd sky130_fd_pr__pfet_01v8 w=2.2 l=0.15
X1065 t_Xsh_e3_Xf3_qi t_Xsh_e3_Xf3_s1 vss vss sky130_fd_pr__nfet_01v8_lvt w=0.65 l=0.15
X1066 t_Xsh_e3_Xf3_qi t_Xsh_e3_Xf3_s1 vdd vdd sky130_fd_pr__pfet_01v8 w=1.65 l=0.15
X1067 t_Xsh_e3_Xf3_s2 t_Xsh_e3_Xf3_qi t_Xsh_e3_Xf3_Xsfb_mid vss sky130_fd_pr__nfet_01v8_lvt w=0.8 l=0.15
X1068 t_Xsh_e3_Xf3_Xsfb_mid rst_n vss vss sky130_fd_pr__nfet_01v8_lvt w=0.8 l=0.15
X1069 t_Xsh_e3_Xf3_s2 t_Xsh_e3_Xf3_qi vdd vdd sky130_fd_pr__pfet_01v8 w=1.4 l=0.15
X1070 t_Xsh_e3_Xf3_s2 rst_n vdd vdd sky130_fd_pr__pfet_01v8 w=1.4 l=0.15
X1071 t_Xsh_e3_Xf3_s2 t_ck0bb t_Xsh_e3_Xf3_s1 vss sky130_fd_pr__nfet_01v8_lvt w=0.45 l=0.15
X1072 t_Xsh_e3_Xf3_s2 t_ck0b t_Xsh_e3_Xf3_s1 vdd sky130_fd_pr__pfet_01v8 w=1.05 l=0.15
X1073 t_e3_3 t_Xsh_e3_Xf3_s1 vss vss sky130_fd_pr__nfet_01v8_lvt w=0.8 l=0.15
X1074 t_e3_3 t_Xsh_e3_Xf3_s1 vdd vdd sky130_fd_pr__pfet_01v8 w=2.4 l=0.15
X1075 t_Xsh_e3_s3b t_e3_3 vss vss sky130_fd_pr__nfet_01v8_lvt w=0.55 l=0.15
X1076 t_Xsh_e3_s3b t_e3_3 vdd vdd sky130_fd_pr__pfet_01v8 w=1.4 l=0.15
X1077 t_e3_3 t_ck0bb t_Xe3_4_m1 vss sky130_fd_pr__nfet_01v8_lvt w=0.65 l=0.15
X1078 t_e3_3 t_ck0b t_Xe3_4_m1 vdd sky130_fd_pr__pfet_01v8 w=2.2 l=0.15
X1079 t_Xe3_4_m2 t_Xe3_4_m1 t_Xe3_4_Xm2_mid vss sky130_fd_pr__nfet_01v8_lvt w=1 l=0.15
X1080 t_Xe3_4_Xm2_mid rst_n vss vss sky130_fd_pr__nfet_01v8_lvt w=1 l=0.15
X1081 t_Xe3_4_m2 t_Xe3_4_m1 vdd vdd sky130_fd_pr__pfet_01v8 w=2 l=0.15
X1082 t_Xe3_4_m2 rst_n vdd vdd sky130_fd_pr__pfet_01v8 w=2 l=0.15
X1083 t_Xe3_4_m3 t_Xe3_4_m2 vss vss sky130_fd_pr__nfet_01v8_lvt w=0.45 l=0.15
X1084 t_Xe3_4_m3 t_Xe3_4_m2 vdd vdd sky130_fd_pr__pfet_01v8 w=1.15 l=0.15
X1085 t_Xe3_4_m3 t_ck0b t_Xe3_4_m1 vss sky130_fd_pr__nfet_01v8_lvt w=0.45 l=0.15
X1086 t_Xe3_4_m3 t_ck0bb t_Xe3_4_m1 vdd sky130_fd_pr__pfet_01v8 w=1.05 l=0.15
X1087 t_Xe3_4_m2 t_ck0b t_Xe3_4_s1 vss sky130_fd_pr__nfet_01v8_lvt w=0.65 l=0.15
X1088 t_Xe3_4_m2 t_ck0bb t_Xe3_4_s1 vdd sky130_fd_pr__pfet_01v8 w=2.2 l=0.15
X1089 t_Xe3_4_qi t_Xe3_4_s1 vss vss sky130_fd_pr__nfet_01v8_lvt w=0.65 l=0.15
X1090 t_Xe3_4_qi t_Xe3_4_s1 vdd vdd sky130_fd_pr__pfet_01v8 w=1.65 l=0.15
X1091 t_Xe3_4_s2 t_Xe3_4_qi t_Xe3_4_Xsfb_mid vss sky130_fd_pr__nfet_01v8_lvt w=0.8 l=0.15
X1092 t_Xe3_4_Xsfb_mid rst_n vss vss sky130_fd_pr__nfet_01v8_lvt w=0.8 l=0.15
X1093 t_Xe3_4_s2 t_Xe3_4_qi vdd vdd sky130_fd_pr__pfet_01v8 w=1.4 l=0.15
X1094 t_Xe3_4_s2 rst_n vdd vdd sky130_fd_pr__pfet_01v8 w=1.4 l=0.15
X1095 t_Xe3_4_s2 t_ck0bb t_Xe3_4_s1 vss sky130_fd_pr__nfet_01v8_lvt w=0.45 l=0.15
X1096 t_Xe3_4_s2 t_ck0b t_Xe3_4_s1 vdd sky130_fd_pr__pfet_01v8 w=1.05 l=0.15
X1097 t_e3_4 t_Xe3_4_s1 vss vss sky130_fd_pr__nfet_01v8_lvt w=0.8 l=0.15
X1098 t_e3_4 t_Xe3_4_s1 vdd vdd sky130_fd_pr__pfet_01v8 w=2.4 l=0.15
X1099 t_e3_4b t_e3_4 vss vss sky130_fd_pr__nfet_01v8_lvt w=0.55 l=0.15
X1100 t_e3_4b t_e3_4 vdd vdd sky130_fd_pr__pfet_01v8 w=1.4 l=0.15
X1101 t_j1b t_ck0a t_Xj0_m1 vss sky130_fd_pr__nfet_01v8_lvt w=0.65 l=0.15
X1102 t_j1b t_ck0ba t_Xj0_m1 vdd sky130_fd_pr__pfet_01v8 w=2.2 l=0.15
X1103 t_Xj0_m2 t_Xj0_m1 t_Xj0_Xm2_mid vss sky130_fd_pr__nfet_01v8_lvt w=1 l=0.15
X1104 t_Xj0_Xm2_mid rst_n vss vss sky130_fd_pr__nfet_01v8_lvt w=1 l=0.15
X1105 t_Xj0_m2 t_Xj0_m1 vdd vdd sky130_fd_pr__pfet_01v8 w=2 l=0.15
X1106 t_Xj0_m2 rst_n vdd vdd sky130_fd_pr__pfet_01v8 w=2 l=0.15
X1107 t_Xj0_m3 t_Xj0_m2 vss vss sky130_fd_pr__nfet_01v8_lvt w=0.45 l=0.15
X1108 t_Xj0_m3 t_Xj0_m2 vdd vdd sky130_fd_pr__pfet_01v8 w=1.15 l=0.15
X1109 t_Xj0_m3 t_ck0ba t_Xj0_m1 vss sky130_fd_pr__nfet_01v8_lvt w=0.45 l=0.15
X1110 t_Xj0_m3 t_ck0a t_Xj0_m1 vdd sky130_fd_pr__pfet_01v8 w=1.05 l=0.15
X1111 t_Xj0_m2 t_ck0ba t_Xj0_s1 vss sky130_fd_pr__nfet_01v8_lvt w=0.65 l=0.15
X1112 t_Xj0_m2 t_ck0a t_Xj0_s1 vdd sky130_fd_pr__pfet_01v8 w=2.2 l=0.15
X1113 t_Xj0_qi t_Xj0_s1 vss vss sky130_fd_pr__nfet_01v8_lvt w=0.65 l=0.15
X1114 t_Xj0_qi t_Xj0_s1 vdd vdd sky130_fd_pr__pfet_01v8 w=1.65 l=0.15
X1115 t_Xj0_s2 t_Xj0_qi t_Xj0_Xsfb_mid vss sky130_fd_pr__nfet_01v8_lvt w=0.8 l=0.15
X1116 t_Xj0_Xsfb_mid rst_n vss vss sky130_fd_pr__nfet_01v8_lvt w=0.8 l=0.15
X1117 t_Xj0_s2 t_Xj0_qi vdd vdd sky130_fd_pr__pfet_01v8 w=1.4 l=0.15
X1118 t_Xj0_s2 rst_n vdd vdd sky130_fd_pr__pfet_01v8 w=1.4 l=0.15
X1119 t_Xj0_s2 t_ck0a t_Xj0_s1 vss sky130_fd_pr__nfet_01v8_lvt w=0.45 l=0.15
X1120 t_Xj0_s2 t_ck0ba t_Xj0_s1 vdd sky130_fd_pr__pfet_01v8 w=1.05 l=0.15
X1121 t_j0 t_Xj0_s1 vss vss sky130_fd_pr__nfet_01v8_lvt w=0.8 l=0.15
X1122 t_j0 t_Xj0_s1 vdd vdd sky130_fd_pr__pfet_01v8 w=2.4 l=0.15
X1123 t_j0b t_j0 vss vss sky130_fd_pr__nfet_01v8_lvt w=0.55 l=0.15
X1124 t_j0b t_j0 vdd vdd sky130_fd_pr__pfet_01v8 w=1.4 l=0.15
X1125 t_j0 t_ck0a t_Xj1_m1 vss sky130_fd_pr__nfet_01v8_lvt w=0.65 l=0.15
X1126 t_j0 t_ck0ba t_Xj1_m1 vdd sky130_fd_pr__pfet_01v8 w=2.2 l=0.15
X1127 t_Xj1_m2 t_Xj1_m1 t_Xj1_Xm2_mid vss sky130_fd_pr__nfet_01v8_lvt w=1 l=0.15
X1128 t_Xj1_Xm2_mid rst_n vss vss sky130_fd_pr__nfet_01v8_lvt w=1 l=0.15
X1129 t_Xj1_m2 t_Xj1_m1 vdd vdd sky130_fd_pr__pfet_01v8 w=2 l=0.15
X1130 t_Xj1_m2 rst_n vdd vdd sky130_fd_pr__pfet_01v8 w=2 l=0.15
X1131 t_Xj1_m3 t_Xj1_m2 vss vss sky130_fd_pr__nfet_01v8_lvt w=0.45 l=0.15
X1132 t_Xj1_m3 t_Xj1_m2 vdd vdd sky130_fd_pr__pfet_01v8 w=1.15 l=0.15
X1133 t_Xj1_m3 t_ck0ba t_Xj1_m1 vss sky130_fd_pr__nfet_01v8_lvt w=0.45 l=0.15
X1134 t_Xj1_m3 t_ck0a t_Xj1_m1 vdd sky130_fd_pr__pfet_01v8 w=1.05 l=0.15
X1135 t_Xj1_m2 t_ck0ba t_Xj1_s1 vss sky130_fd_pr__nfet_01v8_lvt w=0.65 l=0.15
X1136 t_Xj1_m2 t_ck0a t_Xj1_s1 vdd sky130_fd_pr__pfet_01v8 w=2.2 l=0.15
X1137 t_Xj1_qi t_Xj1_s1 vss vss sky130_fd_pr__nfet_01v8_lvt w=0.65 l=0.15
X1138 t_Xj1_qi t_Xj1_s1 vdd vdd sky130_fd_pr__pfet_01v8 w=1.65 l=0.15
X1139 t_Xj1_s2 t_Xj1_qi t_Xj1_Xsfb_mid vss sky130_fd_pr__nfet_01v8_lvt w=0.8 l=0.15
X1140 t_Xj1_Xsfb_mid rst_n vss vss sky130_fd_pr__nfet_01v8_lvt w=0.8 l=0.15
X1141 t_Xj1_s2 t_Xj1_qi vdd vdd sky130_fd_pr__pfet_01v8 w=1.4 l=0.15
X1142 t_Xj1_s2 rst_n vdd vdd sky130_fd_pr__pfet_01v8 w=1.4 l=0.15
X1143 t_Xj1_s2 t_ck0a t_Xj1_s1 vss sky130_fd_pr__nfet_01v8_lvt w=0.45 l=0.15
X1144 t_Xj1_s2 t_ck0ba t_Xj1_s1 vdd sky130_fd_pr__pfet_01v8 w=1.05 l=0.15
X1145 t_j1 t_Xj1_s1 vss vss sky130_fd_pr__nfet_01v8_lvt w=0.8 l=0.15
X1146 t_j1 t_Xj1_s1 vdd vdd sky130_fd_pr__pfet_01v8 w=2.4 l=0.15
X1147 t_j1b t_j1 vss vss sky130_fd_pr__nfet_01v8_lvt w=0.55 l=0.15
X1148 t_j1b t_j1 vdd vdd sky130_fd_pr__pfet_01v8 w=1.4 l=0.15
X1149 t_wcapb_i t_j0 vss vss sky130_fd_pr__nfet_01v8_lvt w=1.4 l=0.15
X1150 t_wcapb_i t_j0 vdd vdd sky130_fd_pr__pfet_01v8 w=3.4 l=0.15
X1151 t_wcap t_wcapb_i vss vss sky130_fd_pr__nfet_01v8_lvt w=2.4 l=0.15
X1152 t_wcap t_wcapb_i vdd vdd sky130_fd_pr__pfet_01v8 w=5.8 l=0.15
X1153 t_wcap_i t_j0b vss vss sky130_fd_pr__nfet_01v8_lvt w=1.4 l=0.15
X1154 t_wcap_i t_j0b vdd vdd sky130_fd_pr__pfet_01v8 w=3.4 l=0.15
X1155 t_wcapb t_wcap_i vss vss sky130_fd_pr__nfet_01v8_lvt w=2.4 l=0.15
X1156 t_wcapb t_wcap_i vdd vdd sky130_fd_pr__pfet_01v8 w=5.8 l=0.15
X1157 t_wcapb t_wcap vss vss sky130_fd_pr__nfet_01v8_lvt w=0.45 l=0.15
X1158 t_wcapb t_wcap vdd vdd sky130_fd_pr__pfet_01v8 w=1.1 l=0.15
X1159 t_wcap t_wcapb vss vss sky130_fd_pr__nfet_01v8_lvt w=0.45 l=0.15
X1160 t_wcap t_wcapb vdd vdd sky130_fd_pr__pfet_01v8 w=1.1 l=0.15
X1161 t_wclk_b t_j0b vss vss sky130_fd_pr__nfet_01v8_lvt w=1 l=0.15
X1162 t_wclk_b t_j0b vdd vdd sky130_fd_pr__pfet_01v8 w=2.4 l=0.15
X1163 wclk t_wclk_b vss vss sky130_fd_pr__nfet_01v8_lvt w=1.6 l=0.15
X1164 wclk t_wclk_b vdd vdd sky130_fd_pr__pfet_01v8 w=3.8 l=0.15
X1165 t_d0_3 t_wcapb t_Xwd0_m1 vss sky130_fd_pr__nfet_01v8 w=0.5 l=0.18
X1166 t_d0_3 t_wcap t_Xwd0_m1 vdd sky130_fd_pr__pfet_01v8 w=1 l=0.18
X1167 t_Xwd0_m2 t_Xwd0_m1 t_Xwd0_Xm2_mid vss sky130_fd_pr__nfet_01v8 w=0.75 l=0.18
X1168 t_Xwd0_Xm2_mid rst_n vss vss sky130_fd_pr__nfet_01v8 w=0.75 l=0.18
X1169 t_Xwd0_m2 t_Xwd0_m1 vdd vdd sky130_fd_pr__pfet_01v8 w=1 l=0.18
X1170 t_Xwd0_m2 rst_n vdd vdd sky130_fd_pr__pfet_01v8 w=1 l=0.18
X1171 t_Xwd0_m3 t_Xwd0_m2 vss vss sky130_fd_pr__nfet_01v8 w=0.45 l=0.18
X1172 t_Xwd0_m3 t_Xwd0_m2 vdd vdd sky130_fd_pr__pfet_01v8 w=0.9 l=0.18
X1173 t_Xwd0_m3 t_wcap t_Xwd0_m1 vss sky130_fd_pr__nfet_01v8 w=0.45 l=0.18
X1174 t_Xwd0_m3 t_wcapb t_Xwd0_m1 vdd sky130_fd_pr__pfet_01v8 w=0.9 l=0.18
X1175 t_Xwd0_m2 t_wcap t_Xwd0_s1 vss sky130_fd_pr__nfet_01v8 w=0.5 l=0.18
X1176 t_Xwd0_m2 t_wcapb t_Xwd0_s1 vdd sky130_fd_pr__pfet_01v8 w=1 l=0.18
X1177 t_Xwd0_qi t_Xwd0_s1 vss vss sky130_fd_pr__nfet_01v8 w=0.55 l=0.18
X1178 t_Xwd0_qi t_Xwd0_s1 vdd vdd sky130_fd_pr__pfet_01v8 w=1.2 l=0.18
X1179 t_Xwd0_s2 t_Xwd0_qi t_Xwd0_Xsfb_mid vss sky130_fd_pr__nfet_01v8 w=0.7 l=0.18
X1180 t_Xwd0_Xsfb_mid rst_n vss vss sky130_fd_pr__nfet_01v8 w=0.7 l=0.18
X1181 t_Xwd0_s2 t_Xwd0_qi vdd vdd sky130_fd_pr__pfet_01v8 w=0.95 l=0.18
X1182 t_Xwd0_s2 rst_n vdd vdd sky130_fd_pr__pfet_01v8 w=0.95 l=0.18
X1183 t_Xwd0_s2 t_wcapb t_Xwd0_s1 vss sky130_fd_pr__nfet_01v8 w=0.45 l=0.18
X1184 t_Xwd0_s2 t_wcap t_Xwd0_s1 vdd sky130_fd_pr__pfet_01v8 w=0.9 l=0.18
X1185 wd0 t_Xwd0_s1 vss vss sky130_fd_pr__nfet_01v8 w=0.75 l=0.18
X1186 wd0 t_Xwd0_s1 vdd vdd sky130_fd_pr__pfet_01v8 w=1.6 l=0.18
X1187 t_d1_3 t_wcapb t_Xwd1_m1 vss sky130_fd_pr__nfet_01v8 w=0.5 l=0.18
X1188 t_d1_3 t_wcap t_Xwd1_m1 vdd sky130_fd_pr__pfet_01v8 w=1 l=0.18
X1189 t_Xwd1_m2 t_Xwd1_m1 t_Xwd1_Xm2_mid vss sky130_fd_pr__nfet_01v8 w=0.75 l=0.18
X1190 t_Xwd1_Xm2_mid rst_n vss vss sky130_fd_pr__nfet_01v8 w=0.75 l=0.18
X1191 t_Xwd1_m2 t_Xwd1_m1 vdd vdd sky130_fd_pr__pfet_01v8 w=1 l=0.18
X1192 t_Xwd1_m2 rst_n vdd vdd sky130_fd_pr__pfet_01v8 w=1 l=0.18
X1193 t_Xwd1_m3 t_Xwd1_m2 vss vss sky130_fd_pr__nfet_01v8 w=0.45 l=0.18
X1194 t_Xwd1_m3 t_Xwd1_m2 vdd vdd sky130_fd_pr__pfet_01v8 w=0.9 l=0.18
X1195 t_Xwd1_m3 t_wcap t_Xwd1_m1 vss sky130_fd_pr__nfet_01v8 w=0.45 l=0.18
X1196 t_Xwd1_m3 t_wcapb t_Xwd1_m1 vdd sky130_fd_pr__pfet_01v8 w=0.9 l=0.18
X1197 t_Xwd1_m2 t_wcap t_Xwd1_s1 vss sky130_fd_pr__nfet_01v8 w=0.5 l=0.18
X1198 t_Xwd1_m2 t_wcapb t_Xwd1_s1 vdd sky130_fd_pr__pfet_01v8 w=1 l=0.18
X1199 t_Xwd1_qi t_Xwd1_s1 vss vss sky130_fd_pr__nfet_01v8 w=0.55 l=0.18
X1200 t_Xwd1_qi t_Xwd1_s1 vdd vdd sky130_fd_pr__pfet_01v8 w=1.2 l=0.18
X1201 t_Xwd1_s2 t_Xwd1_qi t_Xwd1_Xsfb_mid vss sky130_fd_pr__nfet_01v8 w=0.7 l=0.18
X1202 t_Xwd1_Xsfb_mid rst_n vss vss sky130_fd_pr__nfet_01v8 w=0.7 l=0.18
X1203 t_Xwd1_s2 t_Xwd1_qi vdd vdd sky130_fd_pr__pfet_01v8 w=0.95 l=0.18
X1204 t_Xwd1_s2 rst_n vdd vdd sky130_fd_pr__pfet_01v8 w=0.95 l=0.18
X1205 t_Xwd1_s2 t_wcapb t_Xwd1_s1 vss sky130_fd_pr__nfet_01v8 w=0.45 l=0.18
X1206 t_Xwd1_s2 t_wcap t_Xwd1_s1 vdd sky130_fd_pr__pfet_01v8 w=0.9 l=0.18
X1207 wd1 t_Xwd1_s1 vss vss sky130_fd_pr__nfet_01v8 w=0.75 l=0.18
X1208 wd1 t_Xwd1_s1 vdd vdd sky130_fd_pr__pfet_01v8 w=1.6 l=0.18
X1209 t_d2_3 t_wcapb t_Xwd2_m1 vss sky130_fd_pr__nfet_01v8 w=0.5 l=0.18
X1210 t_d2_3 t_wcap t_Xwd2_m1 vdd sky130_fd_pr__pfet_01v8 w=1 l=0.18
X1211 t_Xwd2_m2 t_Xwd2_m1 t_Xwd2_Xm2_mid vss sky130_fd_pr__nfet_01v8 w=0.75 l=0.18
X1212 t_Xwd2_Xm2_mid rst_n vss vss sky130_fd_pr__nfet_01v8 w=0.75 l=0.18
X1213 t_Xwd2_m2 t_Xwd2_m1 vdd vdd sky130_fd_pr__pfet_01v8 w=1 l=0.18
X1214 t_Xwd2_m2 rst_n vdd vdd sky130_fd_pr__pfet_01v8 w=1 l=0.18
X1215 t_Xwd2_m3 t_Xwd2_m2 vss vss sky130_fd_pr__nfet_01v8 w=0.45 l=0.18
X1216 t_Xwd2_m3 t_Xwd2_m2 vdd vdd sky130_fd_pr__pfet_01v8 w=0.9 l=0.18
X1217 t_Xwd2_m3 t_wcap t_Xwd2_m1 vss sky130_fd_pr__nfet_01v8 w=0.45 l=0.18
X1218 t_Xwd2_m3 t_wcapb t_Xwd2_m1 vdd sky130_fd_pr__pfet_01v8 w=0.9 l=0.18
X1219 t_Xwd2_m2 t_wcap t_Xwd2_s1 vss sky130_fd_pr__nfet_01v8 w=0.5 l=0.18
X1220 t_Xwd2_m2 t_wcapb t_Xwd2_s1 vdd sky130_fd_pr__pfet_01v8 w=1 l=0.18
X1221 t_Xwd2_qi t_Xwd2_s1 vss vss sky130_fd_pr__nfet_01v8 w=0.55 l=0.18
X1222 t_Xwd2_qi t_Xwd2_s1 vdd vdd sky130_fd_pr__pfet_01v8 w=1.2 l=0.18
X1223 t_Xwd2_s2 t_Xwd2_qi t_Xwd2_Xsfb_mid vss sky130_fd_pr__nfet_01v8 w=0.7 l=0.18
X1224 t_Xwd2_Xsfb_mid rst_n vss vss sky130_fd_pr__nfet_01v8 w=0.7 l=0.18
X1225 t_Xwd2_s2 t_Xwd2_qi vdd vdd sky130_fd_pr__pfet_01v8 w=0.95 l=0.18
X1226 t_Xwd2_s2 rst_n vdd vdd sky130_fd_pr__pfet_01v8 w=0.95 l=0.18
X1227 t_Xwd2_s2 t_wcapb t_Xwd2_s1 vss sky130_fd_pr__nfet_01v8 w=0.45 l=0.18
X1228 t_Xwd2_s2 t_wcap t_Xwd2_s1 vdd sky130_fd_pr__pfet_01v8 w=0.9 l=0.18
X1229 wd2 t_Xwd2_s1 vss vss sky130_fd_pr__nfet_01v8 w=0.75 l=0.18
X1230 wd2 t_Xwd2_s1 vdd vdd sky130_fd_pr__pfet_01v8 w=1.6 l=0.18
X1231 t_d3_3 t_wcapb t_Xwd3_m1 vss sky130_fd_pr__nfet_01v8 w=0.5 l=0.18
X1232 t_d3_3 t_wcap t_Xwd3_m1 vdd sky130_fd_pr__pfet_01v8 w=1 l=0.18
X1233 t_Xwd3_m2 t_Xwd3_m1 t_Xwd3_Xm2_mid vss sky130_fd_pr__nfet_01v8 w=0.75 l=0.18
X1234 t_Xwd3_Xm2_mid rst_n vss vss sky130_fd_pr__nfet_01v8 w=0.75 l=0.18
X1235 t_Xwd3_m2 t_Xwd3_m1 vdd vdd sky130_fd_pr__pfet_01v8 w=1 l=0.18
X1236 t_Xwd3_m2 rst_n vdd vdd sky130_fd_pr__pfet_01v8 w=1 l=0.18
X1237 t_Xwd3_m3 t_Xwd3_m2 vss vss sky130_fd_pr__nfet_01v8 w=0.45 l=0.18
X1238 t_Xwd3_m3 t_Xwd3_m2 vdd vdd sky130_fd_pr__pfet_01v8 w=0.9 l=0.18
X1239 t_Xwd3_m3 t_wcap t_Xwd3_m1 vss sky130_fd_pr__nfet_01v8 w=0.45 l=0.18
X1240 t_Xwd3_m3 t_wcapb t_Xwd3_m1 vdd sky130_fd_pr__pfet_01v8 w=0.9 l=0.18
X1241 t_Xwd3_m2 t_wcap t_Xwd3_s1 vss sky130_fd_pr__nfet_01v8 w=0.5 l=0.18
X1242 t_Xwd3_m2 t_wcapb t_Xwd3_s1 vdd sky130_fd_pr__pfet_01v8 w=1 l=0.18
X1243 t_Xwd3_qi t_Xwd3_s1 vss vss sky130_fd_pr__nfet_01v8 w=0.55 l=0.18
X1244 t_Xwd3_qi t_Xwd3_s1 vdd vdd sky130_fd_pr__pfet_01v8 w=1.2 l=0.18
X1245 t_Xwd3_s2 t_Xwd3_qi t_Xwd3_Xsfb_mid vss sky130_fd_pr__nfet_01v8 w=0.7 l=0.18
X1246 t_Xwd3_Xsfb_mid rst_n vss vss sky130_fd_pr__nfet_01v8 w=0.7 l=0.18
X1247 t_Xwd3_s2 t_Xwd3_qi vdd vdd sky130_fd_pr__pfet_01v8 w=0.95 l=0.18
X1248 t_Xwd3_s2 rst_n vdd vdd sky130_fd_pr__pfet_01v8 w=0.95 l=0.18
X1249 t_Xwd3_s2 t_wcapb t_Xwd3_s1 vss sky130_fd_pr__nfet_01v8 w=0.45 l=0.18
X1250 t_Xwd3_s2 t_wcap t_Xwd3_s1 vdd sky130_fd_pr__pfet_01v8 w=0.9 l=0.18
X1251 wd3 t_Xwd3_s1 vss vss sky130_fd_pr__nfet_01v8 w=0.75 l=0.18
X1252 wd3 t_Xwd3_s1 vdd vdd sky130_fd_pr__pfet_01v8 w=1.6 l=0.18
X1253 t_d0_2 t_wcapb t_Xwd4_m1 vss sky130_fd_pr__nfet_01v8 w=0.5 l=0.18
X1254 t_d0_2 t_wcap t_Xwd4_m1 vdd sky130_fd_pr__pfet_01v8 w=1 l=0.18
X1255 t_Xwd4_m2 t_Xwd4_m1 t_Xwd4_Xm2_mid vss sky130_fd_pr__nfet_01v8 w=0.75 l=0.18
X1256 t_Xwd4_Xm2_mid rst_n vss vss sky130_fd_pr__nfet_01v8 w=0.75 l=0.18
X1257 t_Xwd4_m2 t_Xwd4_m1 vdd vdd sky130_fd_pr__pfet_01v8 w=1 l=0.18
X1258 t_Xwd4_m2 rst_n vdd vdd sky130_fd_pr__pfet_01v8 w=1 l=0.18
X1259 t_Xwd4_m3 t_Xwd4_m2 vss vss sky130_fd_pr__nfet_01v8 w=0.45 l=0.18
X1260 t_Xwd4_m3 t_Xwd4_m2 vdd vdd sky130_fd_pr__pfet_01v8 w=0.9 l=0.18
X1261 t_Xwd4_m3 t_wcap t_Xwd4_m1 vss sky130_fd_pr__nfet_01v8 w=0.45 l=0.18
X1262 t_Xwd4_m3 t_wcapb t_Xwd4_m1 vdd sky130_fd_pr__pfet_01v8 w=0.9 l=0.18
X1263 t_Xwd4_m2 t_wcap t_Xwd4_s1 vss sky130_fd_pr__nfet_01v8 w=0.5 l=0.18
X1264 t_Xwd4_m2 t_wcapb t_Xwd4_s1 vdd sky130_fd_pr__pfet_01v8 w=1 l=0.18
X1265 t_Xwd4_qi t_Xwd4_s1 vss vss sky130_fd_pr__nfet_01v8 w=0.55 l=0.18
X1266 t_Xwd4_qi t_Xwd4_s1 vdd vdd sky130_fd_pr__pfet_01v8 w=1.2 l=0.18
X1267 t_Xwd4_s2 t_Xwd4_qi t_Xwd4_Xsfb_mid vss sky130_fd_pr__nfet_01v8 w=0.7 l=0.18
X1268 t_Xwd4_Xsfb_mid rst_n vss vss sky130_fd_pr__nfet_01v8 w=0.7 l=0.18
X1269 t_Xwd4_s2 t_Xwd4_qi vdd vdd sky130_fd_pr__pfet_01v8 w=0.95 l=0.18
X1270 t_Xwd4_s2 rst_n vdd vdd sky130_fd_pr__pfet_01v8 w=0.95 l=0.18
X1271 t_Xwd4_s2 t_wcapb t_Xwd4_s1 vss sky130_fd_pr__nfet_01v8 w=0.45 l=0.18
X1272 t_Xwd4_s2 t_wcap t_Xwd4_s1 vdd sky130_fd_pr__pfet_01v8 w=0.9 l=0.18
X1273 wd4 t_Xwd4_s1 vss vss sky130_fd_pr__nfet_01v8 w=0.75 l=0.18
X1274 wd4 t_Xwd4_s1 vdd vdd sky130_fd_pr__pfet_01v8 w=1.6 l=0.18
X1275 t_d1_2 t_wcapb t_Xwd5_m1 vss sky130_fd_pr__nfet_01v8 w=0.5 l=0.18
X1276 t_d1_2 t_wcap t_Xwd5_m1 vdd sky130_fd_pr__pfet_01v8 w=1 l=0.18
X1277 t_Xwd5_m2 t_Xwd5_m1 t_Xwd5_Xm2_mid vss sky130_fd_pr__nfet_01v8 w=0.75 l=0.18
X1278 t_Xwd5_Xm2_mid rst_n vss vss sky130_fd_pr__nfet_01v8 w=0.75 l=0.18
X1279 t_Xwd5_m2 t_Xwd5_m1 vdd vdd sky130_fd_pr__pfet_01v8 w=1 l=0.18
X1280 t_Xwd5_m2 rst_n vdd vdd sky130_fd_pr__pfet_01v8 w=1 l=0.18
X1281 t_Xwd5_m3 t_Xwd5_m2 vss vss sky130_fd_pr__nfet_01v8 w=0.45 l=0.18
X1282 t_Xwd5_m3 t_Xwd5_m2 vdd vdd sky130_fd_pr__pfet_01v8 w=0.9 l=0.18
X1283 t_Xwd5_m3 t_wcap t_Xwd5_m1 vss sky130_fd_pr__nfet_01v8 w=0.45 l=0.18
X1284 t_Xwd5_m3 t_wcapb t_Xwd5_m1 vdd sky130_fd_pr__pfet_01v8 w=0.9 l=0.18
X1285 t_Xwd5_m2 t_wcap t_Xwd5_s1 vss sky130_fd_pr__nfet_01v8 w=0.5 l=0.18
X1286 t_Xwd5_m2 t_wcapb t_Xwd5_s1 vdd sky130_fd_pr__pfet_01v8 w=1 l=0.18
X1287 t_Xwd5_qi t_Xwd5_s1 vss vss sky130_fd_pr__nfet_01v8 w=0.55 l=0.18
X1288 t_Xwd5_qi t_Xwd5_s1 vdd vdd sky130_fd_pr__pfet_01v8 w=1.2 l=0.18
X1289 t_Xwd5_s2 t_Xwd5_qi t_Xwd5_Xsfb_mid vss sky130_fd_pr__nfet_01v8 w=0.7 l=0.18
X1290 t_Xwd5_Xsfb_mid rst_n vss vss sky130_fd_pr__nfet_01v8 w=0.7 l=0.18
X1291 t_Xwd5_s2 t_Xwd5_qi vdd vdd sky130_fd_pr__pfet_01v8 w=0.95 l=0.18
X1292 t_Xwd5_s2 rst_n vdd vdd sky130_fd_pr__pfet_01v8 w=0.95 l=0.18
X1293 t_Xwd5_s2 t_wcapb t_Xwd5_s1 vss sky130_fd_pr__nfet_01v8 w=0.45 l=0.18
X1294 t_Xwd5_s2 t_wcap t_Xwd5_s1 vdd sky130_fd_pr__pfet_01v8 w=0.9 l=0.18
X1295 wd5 t_Xwd5_s1 vss vss sky130_fd_pr__nfet_01v8 w=0.75 l=0.18
X1296 wd5 t_Xwd5_s1 vdd vdd sky130_fd_pr__pfet_01v8 w=1.6 l=0.18
X1297 t_d2_2 t_wcapb t_Xwd6_m1 vss sky130_fd_pr__nfet_01v8 w=0.5 l=0.18
X1298 t_d2_2 t_wcap t_Xwd6_m1 vdd sky130_fd_pr__pfet_01v8 w=1 l=0.18
X1299 t_Xwd6_m2 t_Xwd6_m1 t_Xwd6_Xm2_mid vss sky130_fd_pr__nfet_01v8 w=0.75 l=0.18
X1300 t_Xwd6_Xm2_mid rst_n vss vss sky130_fd_pr__nfet_01v8 w=0.75 l=0.18
X1301 t_Xwd6_m2 t_Xwd6_m1 vdd vdd sky130_fd_pr__pfet_01v8 w=1 l=0.18
X1302 t_Xwd6_m2 rst_n vdd vdd sky130_fd_pr__pfet_01v8 w=1 l=0.18
X1303 t_Xwd6_m3 t_Xwd6_m2 vss vss sky130_fd_pr__nfet_01v8 w=0.45 l=0.18
X1304 t_Xwd6_m3 t_Xwd6_m2 vdd vdd sky130_fd_pr__pfet_01v8 w=0.9 l=0.18
X1305 t_Xwd6_m3 t_wcap t_Xwd6_m1 vss sky130_fd_pr__nfet_01v8 w=0.45 l=0.18
X1306 t_Xwd6_m3 t_wcapb t_Xwd6_m1 vdd sky130_fd_pr__pfet_01v8 w=0.9 l=0.18
X1307 t_Xwd6_m2 t_wcap t_Xwd6_s1 vss sky130_fd_pr__nfet_01v8 w=0.5 l=0.18
X1308 t_Xwd6_m2 t_wcapb t_Xwd6_s1 vdd sky130_fd_pr__pfet_01v8 w=1 l=0.18
X1309 t_Xwd6_qi t_Xwd6_s1 vss vss sky130_fd_pr__nfet_01v8 w=0.55 l=0.18
X1310 t_Xwd6_qi t_Xwd6_s1 vdd vdd sky130_fd_pr__pfet_01v8 w=1.2 l=0.18
X1311 t_Xwd6_s2 t_Xwd6_qi t_Xwd6_Xsfb_mid vss sky130_fd_pr__nfet_01v8 w=0.7 l=0.18
X1312 t_Xwd6_Xsfb_mid rst_n vss vss sky130_fd_pr__nfet_01v8 w=0.7 l=0.18
X1313 t_Xwd6_s2 t_Xwd6_qi vdd vdd sky130_fd_pr__pfet_01v8 w=0.95 l=0.18
X1314 t_Xwd6_s2 rst_n vdd vdd sky130_fd_pr__pfet_01v8 w=0.95 l=0.18
X1315 t_Xwd6_s2 t_wcapb t_Xwd6_s1 vss sky130_fd_pr__nfet_01v8 w=0.45 l=0.18
X1316 t_Xwd6_s2 t_wcap t_Xwd6_s1 vdd sky130_fd_pr__pfet_01v8 w=0.9 l=0.18
X1317 wd6 t_Xwd6_s1 vss vss sky130_fd_pr__nfet_01v8 w=0.75 l=0.18
X1318 wd6 t_Xwd6_s1 vdd vdd sky130_fd_pr__pfet_01v8 w=1.6 l=0.18
X1319 t_d3_2 t_wcapb t_Xwd7_m1 vss sky130_fd_pr__nfet_01v8 w=0.5 l=0.18
X1320 t_d3_2 t_wcap t_Xwd7_m1 vdd sky130_fd_pr__pfet_01v8 w=1 l=0.18
X1321 t_Xwd7_m2 t_Xwd7_m1 t_Xwd7_Xm2_mid vss sky130_fd_pr__nfet_01v8 w=0.75 l=0.18
X1322 t_Xwd7_Xm2_mid rst_n vss vss sky130_fd_pr__nfet_01v8 w=0.75 l=0.18
X1323 t_Xwd7_m2 t_Xwd7_m1 vdd vdd sky130_fd_pr__pfet_01v8 w=1 l=0.18
X1324 t_Xwd7_m2 rst_n vdd vdd sky130_fd_pr__pfet_01v8 w=1 l=0.18
X1325 t_Xwd7_m3 t_Xwd7_m2 vss vss sky130_fd_pr__nfet_01v8 w=0.45 l=0.18
X1326 t_Xwd7_m3 t_Xwd7_m2 vdd vdd sky130_fd_pr__pfet_01v8 w=0.9 l=0.18
X1327 t_Xwd7_m3 t_wcap t_Xwd7_m1 vss sky130_fd_pr__nfet_01v8 w=0.45 l=0.18
X1328 t_Xwd7_m3 t_wcapb t_Xwd7_m1 vdd sky130_fd_pr__pfet_01v8 w=0.9 l=0.18
X1329 t_Xwd7_m2 t_wcap t_Xwd7_s1 vss sky130_fd_pr__nfet_01v8 w=0.5 l=0.18
X1330 t_Xwd7_m2 t_wcapb t_Xwd7_s1 vdd sky130_fd_pr__pfet_01v8 w=1 l=0.18
X1331 t_Xwd7_qi t_Xwd7_s1 vss vss sky130_fd_pr__nfet_01v8 w=0.55 l=0.18
X1332 t_Xwd7_qi t_Xwd7_s1 vdd vdd sky130_fd_pr__pfet_01v8 w=1.2 l=0.18
X1333 t_Xwd7_s2 t_Xwd7_qi t_Xwd7_Xsfb_mid vss sky130_fd_pr__nfet_01v8 w=0.7 l=0.18
X1334 t_Xwd7_Xsfb_mid rst_n vss vss sky130_fd_pr__nfet_01v8 w=0.7 l=0.18
X1335 t_Xwd7_s2 t_Xwd7_qi vdd vdd sky130_fd_pr__pfet_01v8 w=0.95 l=0.18
X1336 t_Xwd7_s2 rst_n vdd vdd sky130_fd_pr__pfet_01v8 w=0.95 l=0.18
X1337 t_Xwd7_s2 t_wcapb t_Xwd7_s1 vss sky130_fd_pr__nfet_01v8 w=0.45 l=0.18
X1338 t_Xwd7_s2 t_wcap t_Xwd7_s1 vdd sky130_fd_pr__pfet_01v8 w=0.9 l=0.18
X1339 wd7 t_Xwd7_s1 vss vss sky130_fd_pr__nfet_01v8 w=0.75 l=0.18
X1340 wd7 t_Xwd7_s1 vdd vdd sky130_fd_pr__pfet_01v8 w=1.6 l=0.18
X1341 t_d0_1 t_wcapb t_Xwd8_m1 vss sky130_fd_pr__nfet_01v8 w=0.5 l=0.18
X1342 t_d0_1 t_wcap t_Xwd8_m1 vdd sky130_fd_pr__pfet_01v8 w=1 l=0.18
X1343 t_Xwd8_m2 t_Xwd8_m1 t_Xwd8_Xm2_mid vss sky130_fd_pr__nfet_01v8 w=0.75 l=0.18
X1344 t_Xwd8_Xm2_mid rst_n vss vss sky130_fd_pr__nfet_01v8 w=0.75 l=0.18
X1345 t_Xwd8_m2 t_Xwd8_m1 vdd vdd sky130_fd_pr__pfet_01v8 w=1 l=0.18
X1346 t_Xwd8_m2 rst_n vdd vdd sky130_fd_pr__pfet_01v8 w=1 l=0.18
X1347 t_Xwd8_m3 t_Xwd8_m2 vss vss sky130_fd_pr__nfet_01v8 w=0.45 l=0.18
X1348 t_Xwd8_m3 t_Xwd8_m2 vdd vdd sky130_fd_pr__pfet_01v8 w=0.9 l=0.18
X1349 t_Xwd8_m3 t_wcap t_Xwd8_m1 vss sky130_fd_pr__nfet_01v8 w=0.45 l=0.18
X1350 t_Xwd8_m3 t_wcapb t_Xwd8_m1 vdd sky130_fd_pr__pfet_01v8 w=0.9 l=0.18
X1351 t_Xwd8_m2 t_wcap t_Xwd8_s1 vss sky130_fd_pr__nfet_01v8 w=0.5 l=0.18
X1352 t_Xwd8_m2 t_wcapb t_Xwd8_s1 vdd sky130_fd_pr__pfet_01v8 w=1 l=0.18
X1353 t_Xwd8_qi t_Xwd8_s1 vss vss sky130_fd_pr__nfet_01v8 w=0.55 l=0.18
X1354 t_Xwd8_qi t_Xwd8_s1 vdd vdd sky130_fd_pr__pfet_01v8 w=1.2 l=0.18
X1355 t_Xwd8_s2 t_Xwd8_qi t_Xwd8_Xsfb_mid vss sky130_fd_pr__nfet_01v8 w=0.7 l=0.18
X1356 t_Xwd8_Xsfb_mid rst_n vss vss sky130_fd_pr__nfet_01v8 w=0.7 l=0.18
X1357 t_Xwd8_s2 t_Xwd8_qi vdd vdd sky130_fd_pr__pfet_01v8 w=0.95 l=0.18
X1358 t_Xwd8_s2 rst_n vdd vdd sky130_fd_pr__pfet_01v8 w=0.95 l=0.18
X1359 t_Xwd8_s2 t_wcapb t_Xwd8_s1 vss sky130_fd_pr__nfet_01v8 w=0.45 l=0.18
X1360 t_Xwd8_s2 t_wcap t_Xwd8_s1 vdd sky130_fd_pr__pfet_01v8 w=0.9 l=0.18
X1361 wd8 t_Xwd8_s1 vss vss sky130_fd_pr__nfet_01v8 w=0.75 l=0.18
X1362 wd8 t_Xwd8_s1 vdd vdd sky130_fd_pr__pfet_01v8 w=1.6 l=0.18
X1363 t_d1_1 t_wcapb t_Xwd9_m1 vss sky130_fd_pr__nfet_01v8 w=0.5 l=0.18
X1364 t_d1_1 t_wcap t_Xwd9_m1 vdd sky130_fd_pr__pfet_01v8 w=1 l=0.18
X1365 t_Xwd9_m2 t_Xwd9_m1 t_Xwd9_Xm2_mid vss sky130_fd_pr__nfet_01v8 w=0.75 l=0.18
X1366 t_Xwd9_Xm2_mid rst_n vss vss sky130_fd_pr__nfet_01v8 w=0.75 l=0.18
X1367 t_Xwd9_m2 t_Xwd9_m1 vdd vdd sky130_fd_pr__pfet_01v8 w=1 l=0.18
X1368 t_Xwd9_m2 rst_n vdd vdd sky130_fd_pr__pfet_01v8 w=1 l=0.18
X1369 t_Xwd9_m3 t_Xwd9_m2 vss vss sky130_fd_pr__nfet_01v8 w=0.45 l=0.18
X1370 t_Xwd9_m3 t_Xwd9_m2 vdd vdd sky130_fd_pr__pfet_01v8 w=0.9 l=0.18
X1371 t_Xwd9_m3 t_wcap t_Xwd9_m1 vss sky130_fd_pr__nfet_01v8 w=0.45 l=0.18
X1372 t_Xwd9_m3 t_wcapb t_Xwd9_m1 vdd sky130_fd_pr__pfet_01v8 w=0.9 l=0.18
X1373 t_Xwd9_m2 t_wcap t_Xwd9_s1 vss sky130_fd_pr__nfet_01v8 w=0.5 l=0.18
X1374 t_Xwd9_m2 t_wcapb t_Xwd9_s1 vdd sky130_fd_pr__pfet_01v8 w=1 l=0.18
X1375 t_Xwd9_qi t_Xwd9_s1 vss vss sky130_fd_pr__nfet_01v8 w=0.55 l=0.18
X1376 t_Xwd9_qi t_Xwd9_s1 vdd vdd sky130_fd_pr__pfet_01v8 w=1.2 l=0.18
X1377 t_Xwd9_s2 t_Xwd9_qi t_Xwd9_Xsfb_mid vss sky130_fd_pr__nfet_01v8 w=0.7 l=0.18
X1378 t_Xwd9_Xsfb_mid rst_n vss vss sky130_fd_pr__nfet_01v8 w=0.7 l=0.18
X1379 t_Xwd9_s2 t_Xwd9_qi vdd vdd sky130_fd_pr__pfet_01v8 w=0.95 l=0.18
X1380 t_Xwd9_s2 rst_n vdd vdd sky130_fd_pr__pfet_01v8 w=0.95 l=0.18
X1381 t_Xwd9_s2 t_wcapb t_Xwd9_s1 vss sky130_fd_pr__nfet_01v8 w=0.45 l=0.18
X1382 t_Xwd9_s2 t_wcap t_Xwd9_s1 vdd sky130_fd_pr__pfet_01v8 w=0.9 l=0.18
X1383 wd9 t_Xwd9_s1 vss vss sky130_fd_pr__nfet_01v8 w=0.75 l=0.18
X1384 wd9 t_Xwd9_s1 vdd vdd sky130_fd_pr__pfet_01v8 w=1.6 l=0.18
X1385 t_d2_1 t_wcapb t_Xwd10_m1 vss sky130_fd_pr__nfet_01v8 w=0.5 l=0.18
X1386 t_d2_1 t_wcap t_Xwd10_m1 vdd sky130_fd_pr__pfet_01v8 w=1 l=0.18
X1387 t_Xwd10_m2 t_Xwd10_m1 t_Xwd10_Xm2_mid vss sky130_fd_pr__nfet_01v8 w=0.75 l=0.18
X1388 t_Xwd10_Xm2_mid rst_n vss vss sky130_fd_pr__nfet_01v8 w=0.75 l=0.18
X1389 t_Xwd10_m2 t_Xwd10_m1 vdd vdd sky130_fd_pr__pfet_01v8 w=1 l=0.18
X1390 t_Xwd10_m2 rst_n vdd vdd sky130_fd_pr__pfet_01v8 w=1 l=0.18
X1391 t_Xwd10_m3 t_Xwd10_m2 vss vss sky130_fd_pr__nfet_01v8 w=0.45 l=0.18
X1392 t_Xwd10_m3 t_Xwd10_m2 vdd vdd sky130_fd_pr__pfet_01v8 w=0.9 l=0.18
X1393 t_Xwd10_m3 t_wcap t_Xwd10_m1 vss sky130_fd_pr__nfet_01v8 w=0.45 l=0.18
X1394 t_Xwd10_m3 t_wcapb t_Xwd10_m1 vdd sky130_fd_pr__pfet_01v8 w=0.9 l=0.18
X1395 t_Xwd10_m2 t_wcap t_Xwd10_s1 vss sky130_fd_pr__nfet_01v8 w=0.5 l=0.18
X1396 t_Xwd10_m2 t_wcapb t_Xwd10_s1 vdd sky130_fd_pr__pfet_01v8 w=1 l=0.18
X1397 t_Xwd10_qi t_Xwd10_s1 vss vss sky130_fd_pr__nfet_01v8 w=0.55 l=0.18
X1398 t_Xwd10_qi t_Xwd10_s1 vdd vdd sky130_fd_pr__pfet_01v8 w=1.2 l=0.18
X1399 t_Xwd10_s2 t_Xwd10_qi t_Xwd10_Xsfb_mid vss sky130_fd_pr__nfet_01v8 w=0.7 l=0.18
X1400 t_Xwd10_Xsfb_mid rst_n vss vss sky130_fd_pr__nfet_01v8 w=0.7 l=0.18
X1401 t_Xwd10_s2 t_Xwd10_qi vdd vdd sky130_fd_pr__pfet_01v8 w=0.95 l=0.18
X1402 t_Xwd10_s2 rst_n vdd vdd sky130_fd_pr__pfet_01v8 w=0.95 l=0.18
X1403 t_Xwd10_s2 t_wcapb t_Xwd10_s1 vss sky130_fd_pr__nfet_01v8 w=0.45 l=0.18
X1404 t_Xwd10_s2 t_wcap t_Xwd10_s1 vdd sky130_fd_pr__pfet_01v8 w=0.9 l=0.18
X1405 wd10 t_Xwd10_s1 vss vss sky130_fd_pr__nfet_01v8 w=0.75 l=0.18
X1406 wd10 t_Xwd10_s1 vdd vdd sky130_fd_pr__pfet_01v8 w=1.6 l=0.18
X1407 t_d3_1 t_wcapb t_Xwd11_m1 vss sky130_fd_pr__nfet_01v8 w=0.5 l=0.18
X1408 t_d3_1 t_wcap t_Xwd11_m1 vdd sky130_fd_pr__pfet_01v8 w=1 l=0.18
X1409 t_Xwd11_m2 t_Xwd11_m1 t_Xwd11_Xm2_mid vss sky130_fd_pr__nfet_01v8 w=0.75 l=0.18
X1410 t_Xwd11_Xm2_mid rst_n vss vss sky130_fd_pr__nfet_01v8 w=0.75 l=0.18
X1411 t_Xwd11_m2 t_Xwd11_m1 vdd vdd sky130_fd_pr__pfet_01v8 w=1 l=0.18
X1412 t_Xwd11_m2 rst_n vdd vdd sky130_fd_pr__pfet_01v8 w=1 l=0.18
X1413 t_Xwd11_m3 t_Xwd11_m2 vss vss sky130_fd_pr__nfet_01v8 w=0.45 l=0.18
X1414 t_Xwd11_m3 t_Xwd11_m2 vdd vdd sky130_fd_pr__pfet_01v8 w=0.9 l=0.18
X1415 t_Xwd11_m3 t_wcap t_Xwd11_m1 vss sky130_fd_pr__nfet_01v8 w=0.45 l=0.18
X1416 t_Xwd11_m3 t_wcapb t_Xwd11_m1 vdd sky130_fd_pr__pfet_01v8 w=0.9 l=0.18
X1417 t_Xwd11_m2 t_wcap t_Xwd11_s1 vss sky130_fd_pr__nfet_01v8 w=0.5 l=0.18
X1418 t_Xwd11_m2 t_wcapb t_Xwd11_s1 vdd sky130_fd_pr__pfet_01v8 w=1 l=0.18
X1419 t_Xwd11_qi t_Xwd11_s1 vss vss sky130_fd_pr__nfet_01v8 w=0.55 l=0.18
X1420 t_Xwd11_qi t_Xwd11_s1 vdd vdd sky130_fd_pr__pfet_01v8 w=1.2 l=0.18
X1421 t_Xwd11_s2 t_Xwd11_qi t_Xwd11_Xsfb_mid vss sky130_fd_pr__nfet_01v8 w=0.7 l=0.18
X1422 t_Xwd11_Xsfb_mid rst_n vss vss sky130_fd_pr__nfet_01v8 w=0.7 l=0.18
X1423 t_Xwd11_s2 t_Xwd11_qi vdd vdd sky130_fd_pr__pfet_01v8 w=0.95 l=0.18
X1424 t_Xwd11_s2 rst_n vdd vdd sky130_fd_pr__pfet_01v8 w=0.95 l=0.18
X1425 t_Xwd11_s2 t_wcapb t_Xwd11_s1 vss sky130_fd_pr__nfet_01v8 w=0.45 l=0.18
X1426 t_Xwd11_s2 t_wcap t_Xwd11_s1 vdd sky130_fd_pr__pfet_01v8 w=0.9 l=0.18
X1427 wd11 t_Xwd11_s1 vss vss sky130_fd_pr__nfet_01v8 w=0.75 l=0.18
X1428 wd11 t_Xwd11_s1 vdd vdd sky130_fd_pr__pfet_01v8 w=1.6 l=0.18
X1429 t_d0_0 t_wcapb t_Xwd12_m1 vss sky130_fd_pr__nfet_01v8 w=0.5 l=0.18
X1430 t_d0_0 t_wcap t_Xwd12_m1 vdd sky130_fd_pr__pfet_01v8 w=1 l=0.18
X1431 t_Xwd12_m2 t_Xwd12_m1 t_Xwd12_Xm2_mid vss sky130_fd_pr__nfet_01v8 w=0.75 l=0.18
X1432 t_Xwd12_Xm2_mid rst_n vss vss sky130_fd_pr__nfet_01v8 w=0.75 l=0.18
X1433 t_Xwd12_m2 t_Xwd12_m1 vdd vdd sky130_fd_pr__pfet_01v8 w=1 l=0.18
X1434 t_Xwd12_m2 rst_n vdd vdd sky130_fd_pr__pfet_01v8 w=1 l=0.18
X1435 t_Xwd12_m3 t_Xwd12_m2 vss vss sky130_fd_pr__nfet_01v8 w=0.45 l=0.18
X1436 t_Xwd12_m3 t_Xwd12_m2 vdd vdd sky130_fd_pr__pfet_01v8 w=0.9 l=0.18
X1437 t_Xwd12_m3 t_wcap t_Xwd12_m1 vss sky130_fd_pr__nfet_01v8 w=0.45 l=0.18
X1438 t_Xwd12_m3 t_wcapb t_Xwd12_m1 vdd sky130_fd_pr__pfet_01v8 w=0.9 l=0.18
X1439 t_Xwd12_m2 t_wcap t_Xwd12_s1 vss sky130_fd_pr__nfet_01v8 w=0.5 l=0.18
X1440 t_Xwd12_m2 t_wcapb t_Xwd12_s1 vdd sky130_fd_pr__pfet_01v8 w=1 l=0.18
X1441 t_Xwd12_qi t_Xwd12_s1 vss vss sky130_fd_pr__nfet_01v8 w=0.55 l=0.18
X1442 t_Xwd12_qi t_Xwd12_s1 vdd vdd sky130_fd_pr__pfet_01v8 w=1.2 l=0.18
X1443 t_Xwd12_s2 t_Xwd12_qi t_Xwd12_Xsfb_mid vss sky130_fd_pr__nfet_01v8 w=0.7 l=0.18
X1444 t_Xwd12_Xsfb_mid rst_n vss vss sky130_fd_pr__nfet_01v8 w=0.7 l=0.18
X1445 t_Xwd12_s2 t_Xwd12_qi vdd vdd sky130_fd_pr__pfet_01v8 w=0.95 l=0.18
X1446 t_Xwd12_s2 rst_n vdd vdd sky130_fd_pr__pfet_01v8 w=0.95 l=0.18
X1447 t_Xwd12_s2 t_wcapb t_Xwd12_s1 vss sky130_fd_pr__nfet_01v8 w=0.45 l=0.18
X1448 t_Xwd12_s2 t_wcap t_Xwd12_s1 vdd sky130_fd_pr__pfet_01v8 w=0.9 l=0.18
X1449 wd12 t_Xwd12_s1 vss vss sky130_fd_pr__nfet_01v8 w=0.75 l=0.18
X1450 wd12 t_Xwd12_s1 vdd vdd sky130_fd_pr__pfet_01v8 w=1.6 l=0.18
X1451 t_d1_0 t_wcapb t_Xwd13_m1 vss sky130_fd_pr__nfet_01v8 w=0.5 l=0.18
X1452 t_d1_0 t_wcap t_Xwd13_m1 vdd sky130_fd_pr__pfet_01v8 w=1 l=0.18
X1453 t_Xwd13_m2 t_Xwd13_m1 t_Xwd13_Xm2_mid vss sky130_fd_pr__nfet_01v8 w=0.75 l=0.18
X1454 t_Xwd13_Xm2_mid rst_n vss vss sky130_fd_pr__nfet_01v8 w=0.75 l=0.18
X1455 t_Xwd13_m2 t_Xwd13_m1 vdd vdd sky130_fd_pr__pfet_01v8 w=1 l=0.18
X1456 t_Xwd13_m2 rst_n vdd vdd sky130_fd_pr__pfet_01v8 w=1 l=0.18
X1457 t_Xwd13_m3 t_Xwd13_m2 vss vss sky130_fd_pr__nfet_01v8 w=0.45 l=0.18
X1458 t_Xwd13_m3 t_Xwd13_m2 vdd vdd sky130_fd_pr__pfet_01v8 w=0.9 l=0.18
X1459 t_Xwd13_m3 t_wcap t_Xwd13_m1 vss sky130_fd_pr__nfet_01v8 w=0.45 l=0.18
X1460 t_Xwd13_m3 t_wcapb t_Xwd13_m1 vdd sky130_fd_pr__pfet_01v8 w=0.9 l=0.18
X1461 t_Xwd13_m2 t_wcap t_Xwd13_s1 vss sky130_fd_pr__nfet_01v8 w=0.5 l=0.18
X1462 t_Xwd13_m2 t_wcapb t_Xwd13_s1 vdd sky130_fd_pr__pfet_01v8 w=1 l=0.18
X1463 t_Xwd13_qi t_Xwd13_s1 vss vss sky130_fd_pr__nfet_01v8 w=0.55 l=0.18
X1464 t_Xwd13_qi t_Xwd13_s1 vdd vdd sky130_fd_pr__pfet_01v8 w=1.2 l=0.18
X1465 t_Xwd13_s2 t_Xwd13_qi t_Xwd13_Xsfb_mid vss sky130_fd_pr__nfet_01v8 w=0.7 l=0.18
X1466 t_Xwd13_Xsfb_mid rst_n vss vss sky130_fd_pr__nfet_01v8 w=0.7 l=0.18
X1467 t_Xwd13_s2 t_Xwd13_qi vdd vdd sky130_fd_pr__pfet_01v8 w=0.95 l=0.18
X1468 t_Xwd13_s2 rst_n vdd vdd sky130_fd_pr__pfet_01v8 w=0.95 l=0.18
X1469 t_Xwd13_s2 t_wcapb t_Xwd13_s1 vss sky130_fd_pr__nfet_01v8 w=0.45 l=0.18
X1470 t_Xwd13_s2 t_wcap t_Xwd13_s1 vdd sky130_fd_pr__pfet_01v8 w=0.9 l=0.18
X1471 wd13 t_Xwd13_s1 vss vss sky130_fd_pr__nfet_01v8 w=0.75 l=0.18
X1472 wd13 t_Xwd13_s1 vdd vdd sky130_fd_pr__pfet_01v8 w=1.6 l=0.18
X1473 t_d2_0 t_wcapb t_Xwd14_m1 vss sky130_fd_pr__nfet_01v8 w=0.5 l=0.18
X1474 t_d2_0 t_wcap t_Xwd14_m1 vdd sky130_fd_pr__pfet_01v8 w=1 l=0.18
X1475 t_Xwd14_m2 t_Xwd14_m1 t_Xwd14_Xm2_mid vss sky130_fd_pr__nfet_01v8 w=0.75 l=0.18
X1476 t_Xwd14_Xm2_mid rst_n vss vss sky130_fd_pr__nfet_01v8 w=0.75 l=0.18
X1477 t_Xwd14_m2 t_Xwd14_m1 vdd vdd sky130_fd_pr__pfet_01v8 w=1 l=0.18
X1478 t_Xwd14_m2 rst_n vdd vdd sky130_fd_pr__pfet_01v8 w=1 l=0.18
X1479 t_Xwd14_m3 t_Xwd14_m2 vss vss sky130_fd_pr__nfet_01v8 w=0.45 l=0.18
X1480 t_Xwd14_m3 t_Xwd14_m2 vdd vdd sky130_fd_pr__pfet_01v8 w=0.9 l=0.18
X1481 t_Xwd14_m3 t_wcap t_Xwd14_m1 vss sky130_fd_pr__nfet_01v8 w=0.45 l=0.18
X1482 t_Xwd14_m3 t_wcapb t_Xwd14_m1 vdd sky130_fd_pr__pfet_01v8 w=0.9 l=0.18
X1483 t_Xwd14_m2 t_wcap t_Xwd14_s1 vss sky130_fd_pr__nfet_01v8 w=0.5 l=0.18
X1484 t_Xwd14_m2 t_wcapb t_Xwd14_s1 vdd sky130_fd_pr__pfet_01v8 w=1 l=0.18
X1485 t_Xwd14_qi t_Xwd14_s1 vss vss sky130_fd_pr__nfet_01v8 w=0.55 l=0.18
X1486 t_Xwd14_qi t_Xwd14_s1 vdd vdd sky130_fd_pr__pfet_01v8 w=1.2 l=0.18
X1487 t_Xwd14_s2 t_Xwd14_qi t_Xwd14_Xsfb_mid vss sky130_fd_pr__nfet_01v8 w=0.7 l=0.18
X1488 t_Xwd14_Xsfb_mid rst_n vss vss sky130_fd_pr__nfet_01v8 w=0.7 l=0.18
X1489 t_Xwd14_s2 t_Xwd14_qi vdd vdd sky130_fd_pr__pfet_01v8 w=0.95 l=0.18
X1490 t_Xwd14_s2 rst_n vdd vdd sky130_fd_pr__pfet_01v8 w=0.95 l=0.18
X1491 t_Xwd14_s2 t_wcapb t_Xwd14_s1 vss sky130_fd_pr__nfet_01v8 w=0.45 l=0.18
X1492 t_Xwd14_s2 t_wcap t_Xwd14_s1 vdd sky130_fd_pr__pfet_01v8 w=0.9 l=0.18
X1493 wd14 t_Xwd14_s1 vss vss sky130_fd_pr__nfet_01v8 w=0.75 l=0.18
X1494 wd14 t_Xwd14_s1 vdd vdd sky130_fd_pr__pfet_01v8 w=1.6 l=0.18
X1495 t_d3_0 t_wcapb t_Xwd15_m1 vss sky130_fd_pr__nfet_01v8 w=0.5 l=0.18
X1496 t_d3_0 t_wcap t_Xwd15_m1 vdd sky130_fd_pr__pfet_01v8 w=1 l=0.18
X1497 t_Xwd15_m2 t_Xwd15_m1 t_Xwd15_Xm2_mid vss sky130_fd_pr__nfet_01v8 w=0.75 l=0.18
X1498 t_Xwd15_Xm2_mid rst_n vss vss sky130_fd_pr__nfet_01v8 w=0.75 l=0.18
X1499 t_Xwd15_m2 t_Xwd15_m1 vdd vdd sky130_fd_pr__pfet_01v8 w=1 l=0.18
X1500 t_Xwd15_m2 rst_n vdd vdd sky130_fd_pr__pfet_01v8 w=1 l=0.18
X1501 t_Xwd15_m3 t_Xwd15_m2 vss vss sky130_fd_pr__nfet_01v8 w=0.45 l=0.18
X1502 t_Xwd15_m3 t_Xwd15_m2 vdd vdd sky130_fd_pr__pfet_01v8 w=0.9 l=0.18
X1503 t_Xwd15_m3 t_wcap t_Xwd15_m1 vss sky130_fd_pr__nfet_01v8 w=0.45 l=0.18
X1504 t_Xwd15_m3 t_wcapb t_Xwd15_m1 vdd sky130_fd_pr__pfet_01v8 w=0.9 l=0.18
X1505 t_Xwd15_m2 t_wcap t_Xwd15_s1 vss sky130_fd_pr__nfet_01v8 w=0.5 l=0.18
X1506 t_Xwd15_m2 t_wcapb t_Xwd15_s1 vdd sky130_fd_pr__pfet_01v8 w=1 l=0.18
X1507 t_Xwd15_qi t_Xwd15_s1 vss vss sky130_fd_pr__nfet_01v8 w=0.55 l=0.18
X1508 t_Xwd15_qi t_Xwd15_s1 vdd vdd sky130_fd_pr__pfet_01v8 w=1.2 l=0.18
X1509 t_Xwd15_s2 t_Xwd15_qi t_Xwd15_Xsfb_mid vss sky130_fd_pr__nfet_01v8 w=0.7 l=0.18
X1510 t_Xwd15_Xsfb_mid rst_n vss vss sky130_fd_pr__nfet_01v8 w=0.7 l=0.18
X1511 t_Xwd15_s2 t_Xwd15_qi vdd vdd sky130_fd_pr__pfet_01v8 w=0.95 l=0.18
X1512 t_Xwd15_s2 rst_n vdd vdd sky130_fd_pr__pfet_01v8 w=0.95 l=0.18
X1513 t_Xwd15_s2 t_wcapb t_Xwd15_s1 vss sky130_fd_pr__nfet_01v8 w=0.45 l=0.18
X1514 t_Xwd15_s2 t_wcap t_Xwd15_s1 vdd sky130_fd_pr__pfet_01v8 w=0.9 l=0.18
X1515 wd15 t_Xwd15_s1 vss vss sky130_fd_pr__nfet_01v8 w=0.75 l=0.18
X1516 wd15 t_Xwd15_s1 vdd vdd sky130_fd_pr__pfet_01v8 w=1.6 l=0.18
X1517 t_e3_4 t_wcapb t_Xwe0_m1 vss sky130_fd_pr__nfet_01v8 w=0.5 l=0.18
X1518 t_e3_4 t_wcap t_Xwe0_m1 vdd sky130_fd_pr__pfet_01v8 w=1 l=0.18
X1519 t_Xwe0_m2 t_Xwe0_m1 t_Xwe0_Xm2_mid vss sky130_fd_pr__nfet_01v8 w=0.75 l=0.18
X1520 t_Xwe0_Xm2_mid rst_n vss vss sky130_fd_pr__nfet_01v8 w=0.75 l=0.18
X1521 t_Xwe0_m2 t_Xwe0_m1 vdd vdd sky130_fd_pr__pfet_01v8 w=1 l=0.18
X1522 t_Xwe0_m2 rst_n vdd vdd sky130_fd_pr__pfet_01v8 w=1 l=0.18
X1523 t_Xwe0_m3 t_Xwe0_m2 vss vss sky130_fd_pr__nfet_01v8 w=0.45 l=0.18
X1524 t_Xwe0_m3 t_Xwe0_m2 vdd vdd sky130_fd_pr__pfet_01v8 w=0.9 l=0.18
X1525 t_Xwe0_m3 t_wcap t_Xwe0_m1 vss sky130_fd_pr__nfet_01v8 w=0.45 l=0.18
X1526 t_Xwe0_m3 t_wcapb t_Xwe0_m1 vdd sky130_fd_pr__pfet_01v8 w=0.9 l=0.18
X1527 t_Xwe0_m2 t_wcap t_Xwe0_s1 vss sky130_fd_pr__nfet_01v8 w=0.5 l=0.18
X1528 t_Xwe0_m2 t_wcapb t_Xwe0_s1 vdd sky130_fd_pr__pfet_01v8 w=1 l=0.18
X1529 t_Xwe0_qi t_Xwe0_s1 vss vss sky130_fd_pr__nfet_01v8 w=0.55 l=0.18
X1530 t_Xwe0_qi t_Xwe0_s1 vdd vdd sky130_fd_pr__pfet_01v8 w=1.2 l=0.18
X1531 t_Xwe0_s2 t_Xwe0_qi t_Xwe0_Xsfb_mid vss sky130_fd_pr__nfet_01v8 w=0.7 l=0.18
X1532 t_Xwe0_Xsfb_mid rst_n vss vss sky130_fd_pr__nfet_01v8 w=0.7 l=0.18
X1533 t_Xwe0_s2 t_Xwe0_qi vdd vdd sky130_fd_pr__pfet_01v8 w=0.95 l=0.18
X1534 t_Xwe0_s2 rst_n vdd vdd sky130_fd_pr__pfet_01v8 w=0.95 l=0.18
X1535 t_Xwe0_s2 t_wcapb t_Xwe0_s1 vss sky130_fd_pr__nfet_01v8 w=0.45 l=0.18
X1536 t_Xwe0_s2 t_wcap t_Xwe0_s1 vdd sky130_fd_pr__pfet_01v8 w=0.9 l=0.18
X1537 we0 t_Xwe0_s1 vss vss sky130_fd_pr__nfet_01v8 w=0.75 l=0.18
X1538 we0 t_Xwe0_s1 vdd vdd sky130_fd_pr__pfet_01v8 w=1.6 l=0.18
X1539 t_e0_3 t_wcapb t_Xwe1_m1 vss sky130_fd_pr__nfet_01v8 w=0.5 l=0.18
X1540 t_e0_3 t_wcap t_Xwe1_m1 vdd sky130_fd_pr__pfet_01v8 w=1 l=0.18
X1541 t_Xwe1_m2 t_Xwe1_m1 t_Xwe1_Xm2_mid vss sky130_fd_pr__nfet_01v8 w=0.75 l=0.18
X1542 t_Xwe1_Xm2_mid rst_n vss vss sky130_fd_pr__nfet_01v8 w=0.75 l=0.18
X1543 t_Xwe1_m2 t_Xwe1_m1 vdd vdd sky130_fd_pr__pfet_01v8 w=1 l=0.18
X1544 t_Xwe1_m2 rst_n vdd vdd sky130_fd_pr__pfet_01v8 w=1 l=0.18
X1545 t_Xwe1_m3 t_Xwe1_m2 vss vss sky130_fd_pr__nfet_01v8 w=0.45 l=0.18
X1546 t_Xwe1_m3 t_Xwe1_m2 vdd vdd sky130_fd_pr__pfet_01v8 w=0.9 l=0.18
X1547 t_Xwe1_m3 t_wcap t_Xwe1_m1 vss sky130_fd_pr__nfet_01v8 w=0.45 l=0.18
X1548 t_Xwe1_m3 t_wcapb t_Xwe1_m1 vdd sky130_fd_pr__pfet_01v8 w=0.9 l=0.18
X1549 t_Xwe1_m2 t_wcap t_Xwe1_s1 vss sky130_fd_pr__nfet_01v8 w=0.5 l=0.18
X1550 t_Xwe1_m2 t_wcapb t_Xwe1_s1 vdd sky130_fd_pr__pfet_01v8 w=1 l=0.18
X1551 t_Xwe1_qi t_Xwe1_s1 vss vss sky130_fd_pr__nfet_01v8 w=0.55 l=0.18
X1552 t_Xwe1_qi t_Xwe1_s1 vdd vdd sky130_fd_pr__pfet_01v8 w=1.2 l=0.18
X1553 t_Xwe1_s2 t_Xwe1_qi t_Xwe1_Xsfb_mid vss sky130_fd_pr__nfet_01v8 w=0.7 l=0.18
X1554 t_Xwe1_Xsfb_mid rst_n vss vss sky130_fd_pr__nfet_01v8 w=0.7 l=0.18
X1555 t_Xwe1_s2 t_Xwe1_qi vdd vdd sky130_fd_pr__pfet_01v8 w=0.95 l=0.18
X1556 t_Xwe1_s2 rst_n vdd vdd sky130_fd_pr__pfet_01v8 w=0.95 l=0.18
X1557 t_Xwe1_s2 t_wcapb t_Xwe1_s1 vss sky130_fd_pr__nfet_01v8 w=0.45 l=0.18
X1558 t_Xwe1_s2 t_wcap t_Xwe1_s1 vdd sky130_fd_pr__pfet_01v8 w=0.9 l=0.18
X1559 we1 t_Xwe1_s1 vss vss sky130_fd_pr__nfet_01v8 w=0.75 l=0.18
X1560 we1 t_Xwe1_s1 vdd vdd sky130_fd_pr__pfet_01v8 w=1.6 l=0.18
X1561 t_e1_3 t_wcapb t_Xwe2_m1 vss sky130_fd_pr__nfet_01v8 w=0.5 l=0.18
X1562 t_e1_3 t_wcap t_Xwe2_m1 vdd sky130_fd_pr__pfet_01v8 w=1 l=0.18
X1563 t_Xwe2_m2 t_Xwe2_m1 t_Xwe2_Xm2_mid vss sky130_fd_pr__nfet_01v8 w=0.75 l=0.18
X1564 t_Xwe2_Xm2_mid rst_n vss vss sky130_fd_pr__nfet_01v8 w=0.75 l=0.18
X1565 t_Xwe2_m2 t_Xwe2_m1 vdd vdd sky130_fd_pr__pfet_01v8 w=1 l=0.18
X1566 t_Xwe2_m2 rst_n vdd vdd sky130_fd_pr__pfet_01v8 w=1 l=0.18
X1567 t_Xwe2_m3 t_Xwe2_m2 vss vss sky130_fd_pr__nfet_01v8 w=0.45 l=0.18
X1568 t_Xwe2_m3 t_Xwe2_m2 vdd vdd sky130_fd_pr__pfet_01v8 w=0.9 l=0.18
X1569 t_Xwe2_m3 t_wcap t_Xwe2_m1 vss sky130_fd_pr__nfet_01v8 w=0.45 l=0.18
X1570 t_Xwe2_m3 t_wcapb t_Xwe2_m1 vdd sky130_fd_pr__pfet_01v8 w=0.9 l=0.18
X1571 t_Xwe2_m2 t_wcap t_Xwe2_s1 vss sky130_fd_pr__nfet_01v8 w=0.5 l=0.18
X1572 t_Xwe2_m2 t_wcapb t_Xwe2_s1 vdd sky130_fd_pr__pfet_01v8 w=1 l=0.18
X1573 t_Xwe2_qi t_Xwe2_s1 vss vss sky130_fd_pr__nfet_01v8 w=0.55 l=0.18
X1574 t_Xwe2_qi t_Xwe2_s1 vdd vdd sky130_fd_pr__pfet_01v8 w=1.2 l=0.18
X1575 t_Xwe2_s2 t_Xwe2_qi t_Xwe2_Xsfb_mid vss sky130_fd_pr__nfet_01v8 w=0.7 l=0.18
X1576 t_Xwe2_Xsfb_mid rst_n vss vss sky130_fd_pr__nfet_01v8 w=0.7 l=0.18
X1577 t_Xwe2_s2 t_Xwe2_qi vdd vdd sky130_fd_pr__pfet_01v8 w=0.95 l=0.18
X1578 t_Xwe2_s2 rst_n vdd vdd sky130_fd_pr__pfet_01v8 w=0.95 l=0.18
X1579 t_Xwe2_s2 t_wcapb t_Xwe2_s1 vss sky130_fd_pr__nfet_01v8 w=0.45 l=0.18
X1580 t_Xwe2_s2 t_wcap t_Xwe2_s1 vdd sky130_fd_pr__pfet_01v8 w=0.9 l=0.18
X1581 we2 t_Xwe2_s1 vss vss sky130_fd_pr__nfet_01v8 w=0.75 l=0.18
X1582 we2 t_Xwe2_s1 vdd vdd sky130_fd_pr__pfet_01v8 w=1.6 l=0.18
X1583 t_e2_3 t_wcapb t_Xwe3_m1 vss sky130_fd_pr__nfet_01v8 w=0.5 l=0.18
X1584 t_e2_3 t_wcap t_Xwe3_m1 vdd sky130_fd_pr__pfet_01v8 w=1 l=0.18
X1585 t_Xwe3_m2 t_Xwe3_m1 t_Xwe3_Xm2_mid vss sky130_fd_pr__nfet_01v8 w=0.75 l=0.18
X1586 t_Xwe3_Xm2_mid rst_n vss vss sky130_fd_pr__nfet_01v8 w=0.75 l=0.18
X1587 t_Xwe3_m2 t_Xwe3_m1 vdd vdd sky130_fd_pr__pfet_01v8 w=1 l=0.18
X1588 t_Xwe3_m2 rst_n vdd vdd sky130_fd_pr__pfet_01v8 w=1 l=0.18
X1589 t_Xwe3_m3 t_Xwe3_m2 vss vss sky130_fd_pr__nfet_01v8 w=0.45 l=0.18
X1590 t_Xwe3_m3 t_Xwe3_m2 vdd vdd sky130_fd_pr__pfet_01v8 w=0.9 l=0.18
X1591 t_Xwe3_m3 t_wcap t_Xwe3_m1 vss sky130_fd_pr__nfet_01v8 w=0.45 l=0.18
X1592 t_Xwe3_m3 t_wcapb t_Xwe3_m1 vdd sky130_fd_pr__pfet_01v8 w=0.9 l=0.18
X1593 t_Xwe3_m2 t_wcap t_Xwe3_s1 vss sky130_fd_pr__nfet_01v8 w=0.5 l=0.18
X1594 t_Xwe3_m2 t_wcapb t_Xwe3_s1 vdd sky130_fd_pr__pfet_01v8 w=1 l=0.18
X1595 t_Xwe3_qi t_Xwe3_s1 vss vss sky130_fd_pr__nfet_01v8 w=0.55 l=0.18
X1596 t_Xwe3_qi t_Xwe3_s1 vdd vdd sky130_fd_pr__pfet_01v8 w=1.2 l=0.18
X1597 t_Xwe3_s2 t_Xwe3_qi t_Xwe3_Xsfb_mid vss sky130_fd_pr__nfet_01v8 w=0.7 l=0.18
X1598 t_Xwe3_Xsfb_mid rst_n vss vss sky130_fd_pr__nfet_01v8 w=0.7 l=0.18
X1599 t_Xwe3_s2 t_Xwe3_qi vdd vdd sky130_fd_pr__pfet_01v8 w=0.95 l=0.18
X1600 t_Xwe3_s2 rst_n vdd vdd sky130_fd_pr__pfet_01v8 w=0.95 l=0.18
X1601 t_Xwe3_s2 t_wcapb t_Xwe3_s1 vss sky130_fd_pr__nfet_01v8 w=0.45 l=0.18
X1602 t_Xwe3_s2 t_wcap t_Xwe3_s1 vdd sky130_fd_pr__pfet_01v8 w=0.9 l=0.18
X1603 we3 t_Xwe3_s1 vss vss sky130_fd_pr__nfet_01v8 w=0.75 l=0.18
X1604 we3 t_Xwe3_s1 vdd vdd sky130_fd_pr__pfet_01v8 w=1.6 l=0.18
X1605 t_e3_3 t_wcapb t_Xwe4_m1 vss sky130_fd_pr__nfet_01v8 w=0.5 l=0.18
X1606 t_e3_3 t_wcap t_Xwe4_m1 vdd sky130_fd_pr__pfet_01v8 w=1 l=0.18
X1607 t_Xwe4_m2 t_Xwe4_m1 t_Xwe4_Xm2_mid vss sky130_fd_pr__nfet_01v8 w=0.75 l=0.18
X1608 t_Xwe4_Xm2_mid rst_n vss vss sky130_fd_pr__nfet_01v8 w=0.75 l=0.18
X1609 t_Xwe4_m2 t_Xwe4_m1 vdd vdd sky130_fd_pr__pfet_01v8 w=1 l=0.18
X1610 t_Xwe4_m2 rst_n vdd vdd sky130_fd_pr__pfet_01v8 w=1 l=0.18
X1611 t_Xwe4_m3 t_Xwe4_m2 vss vss sky130_fd_pr__nfet_01v8 w=0.45 l=0.18
X1612 t_Xwe4_m3 t_Xwe4_m2 vdd vdd sky130_fd_pr__pfet_01v8 w=0.9 l=0.18
X1613 t_Xwe4_m3 t_wcap t_Xwe4_m1 vss sky130_fd_pr__nfet_01v8 w=0.45 l=0.18
X1614 t_Xwe4_m3 t_wcapb t_Xwe4_m1 vdd sky130_fd_pr__pfet_01v8 w=0.9 l=0.18
X1615 t_Xwe4_m2 t_wcap t_Xwe4_s1 vss sky130_fd_pr__nfet_01v8 w=0.5 l=0.18
X1616 t_Xwe4_m2 t_wcapb t_Xwe4_s1 vdd sky130_fd_pr__pfet_01v8 w=1 l=0.18
X1617 t_Xwe4_qi t_Xwe4_s1 vss vss sky130_fd_pr__nfet_01v8 w=0.55 l=0.18
X1618 t_Xwe4_qi t_Xwe4_s1 vdd vdd sky130_fd_pr__pfet_01v8 w=1.2 l=0.18
X1619 t_Xwe4_s2 t_Xwe4_qi t_Xwe4_Xsfb_mid vss sky130_fd_pr__nfet_01v8 w=0.7 l=0.18
X1620 t_Xwe4_Xsfb_mid rst_n vss vss sky130_fd_pr__nfet_01v8 w=0.7 l=0.18
X1621 t_Xwe4_s2 t_Xwe4_qi vdd vdd sky130_fd_pr__pfet_01v8 w=0.95 l=0.18
X1622 t_Xwe4_s2 rst_n vdd vdd sky130_fd_pr__pfet_01v8 w=0.95 l=0.18
X1623 t_Xwe4_s2 t_wcapb t_Xwe4_s1 vss sky130_fd_pr__nfet_01v8 w=0.45 l=0.18
X1624 t_Xwe4_s2 t_wcap t_Xwe4_s1 vdd sky130_fd_pr__pfet_01v8 w=0.9 l=0.18
X1625 we4 t_Xwe4_s1 vss vss sky130_fd_pr__nfet_01v8 w=0.75 l=0.18
X1626 we4 t_Xwe4_s1 vdd vdd sky130_fd_pr__pfet_01v8 w=1.6 l=0.18
X1627 t_e0_2 t_wcapb t_Xwe5_m1 vss sky130_fd_pr__nfet_01v8 w=0.5 l=0.18
X1628 t_e0_2 t_wcap t_Xwe5_m1 vdd sky130_fd_pr__pfet_01v8 w=1 l=0.18
X1629 t_Xwe5_m2 t_Xwe5_m1 t_Xwe5_Xm2_mid vss sky130_fd_pr__nfet_01v8 w=0.75 l=0.18
X1630 t_Xwe5_Xm2_mid rst_n vss vss sky130_fd_pr__nfet_01v8 w=0.75 l=0.18
X1631 t_Xwe5_m2 t_Xwe5_m1 vdd vdd sky130_fd_pr__pfet_01v8 w=1 l=0.18
X1632 t_Xwe5_m2 rst_n vdd vdd sky130_fd_pr__pfet_01v8 w=1 l=0.18
X1633 t_Xwe5_m3 t_Xwe5_m2 vss vss sky130_fd_pr__nfet_01v8 w=0.45 l=0.18
X1634 t_Xwe5_m3 t_Xwe5_m2 vdd vdd sky130_fd_pr__pfet_01v8 w=0.9 l=0.18
X1635 t_Xwe5_m3 t_wcap t_Xwe5_m1 vss sky130_fd_pr__nfet_01v8 w=0.45 l=0.18
X1636 t_Xwe5_m3 t_wcapb t_Xwe5_m1 vdd sky130_fd_pr__pfet_01v8 w=0.9 l=0.18
X1637 t_Xwe5_m2 t_wcap t_Xwe5_s1 vss sky130_fd_pr__nfet_01v8 w=0.5 l=0.18
X1638 t_Xwe5_m2 t_wcapb t_Xwe5_s1 vdd sky130_fd_pr__pfet_01v8 w=1 l=0.18
X1639 t_Xwe5_qi t_Xwe5_s1 vss vss sky130_fd_pr__nfet_01v8 w=0.55 l=0.18
X1640 t_Xwe5_qi t_Xwe5_s1 vdd vdd sky130_fd_pr__pfet_01v8 w=1.2 l=0.18
X1641 t_Xwe5_s2 t_Xwe5_qi t_Xwe5_Xsfb_mid vss sky130_fd_pr__nfet_01v8 w=0.7 l=0.18
X1642 t_Xwe5_Xsfb_mid rst_n vss vss sky130_fd_pr__nfet_01v8 w=0.7 l=0.18
X1643 t_Xwe5_s2 t_Xwe5_qi vdd vdd sky130_fd_pr__pfet_01v8 w=0.95 l=0.18
X1644 t_Xwe5_s2 rst_n vdd vdd sky130_fd_pr__pfet_01v8 w=0.95 l=0.18
X1645 t_Xwe5_s2 t_wcapb t_Xwe5_s1 vss sky130_fd_pr__nfet_01v8 w=0.45 l=0.18
X1646 t_Xwe5_s2 t_wcap t_Xwe5_s1 vdd sky130_fd_pr__pfet_01v8 w=0.9 l=0.18
X1647 we5 t_Xwe5_s1 vss vss sky130_fd_pr__nfet_01v8 w=0.75 l=0.18
X1648 we5 t_Xwe5_s1 vdd vdd sky130_fd_pr__pfet_01v8 w=1.6 l=0.18
X1649 t_e1_2 t_wcapb t_Xwe6_m1 vss sky130_fd_pr__nfet_01v8 w=0.5 l=0.18
X1650 t_e1_2 t_wcap t_Xwe6_m1 vdd sky130_fd_pr__pfet_01v8 w=1 l=0.18
X1651 t_Xwe6_m2 t_Xwe6_m1 t_Xwe6_Xm2_mid vss sky130_fd_pr__nfet_01v8 w=0.75 l=0.18
X1652 t_Xwe6_Xm2_mid rst_n vss vss sky130_fd_pr__nfet_01v8 w=0.75 l=0.18
X1653 t_Xwe6_m2 t_Xwe6_m1 vdd vdd sky130_fd_pr__pfet_01v8 w=1 l=0.18
X1654 t_Xwe6_m2 rst_n vdd vdd sky130_fd_pr__pfet_01v8 w=1 l=0.18
X1655 t_Xwe6_m3 t_Xwe6_m2 vss vss sky130_fd_pr__nfet_01v8 w=0.45 l=0.18
X1656 t_Xwe6_m3 t_Xwe6_m2 vdd vdd sky130_fd_pr__pfet_01v8 w=0.9 l=0.18
X1657 t_Xwe6_m3 t_wcap t_Xwe6_m1 vss sky130_fd_pr__nfet_01v8 w=0.45 l=0.18
X1658 t_Xwe6_m3 t_wcapb t_Xwe6_m1 vdd sky130_fd_pr__pfet_01v8 w=0.9 l=0.18
X1659 t_Xwe6_m2 t_wcap t_Xwe6_s1 vss sky130_fd_pr__nfet_01v8 w=0.5 l=0.18
X1660 t_Xwe6_m2 t_wcapb t_Xwe6_s1 vdd sky130_fd_pr__pfet_01v8 w=1 l=0.18
X1661 t_Xwe6_qi t_Xwe6_s1 vss vss sky130_fd_pr__nfet_01v8 w=0.55 l=0.18
X1662 t_Xwe6_qi t_Xwe6_s1 vdd vdd sky130_fd_pr__pfet_01v8 w=1.2 l=0.18
X1663 t_Xwe6_s2 t_Xwe6_qi t_Xwe6_Xsfb_mid vss sky130_fd_pr__nfet_01v8 w=0.7 l=0.18
X1664 t_Xwe6_Xsfb_mid rst_n vss vss sky130_fd_pr__nfet_01v8 w=0.7 l=0.18
X1665 t_Xwe6_s2 t_Xwe6_qi vdd vdd sky130_fd_pr__pfet_01v8 w=0.95 l=0.18
X1666 t_Xwe6_s2 rst_n vdd vdd sky130_fd_pr__pfet_01v8 w=0.95 l=0.18
X1667 t_Xwe6_s2 t_wcapb t_Xwe6_s1 vss sky130_fd_pr__nfet_01v8 w=0.45 l=0.18
X1668 t_Xwe6_s2 t_wcap t_Xwe6_s1 vdd sky130_fd_pr__pfet_01v8 w=0.9 l=0.18
X1669 we6 t_Xwe6_s1 vss vss sky130_fd_pr__nfet_01v8 w=0.75 l=0.18
X1670 we6 t_Xwe6_s1 vdd vdd sky130_fd_pr__pfet_01v8 w=1.6 l=0.18
X1671 t_e2_2 t_wcapb t_Xwe7_m1 vss sky130_fd_pr__nfet_01v8 w=0.5 l=0.18
X1672 t_e2_2 t_wcap t_Xwe7_m1 vdd sky130_fd_pr__pfet_01v8 w=1 l=0.18
X1673 t_Xwe7_m2 t_Xwe7_m1 t_Xwe7_Xm2_mid vss sky130_fd_pr__nfet_01v8 w=0.75 l=0.18
X1674 t_Xwe7_Xm2_mid rst_n vss vss sky130_fd_pr__nfet_01v8 w=0.75 l=0.18
X1675 t_Xwe7_m2 t_Xwe7_m1 vdd vdd sky130_fd_pr__pfet_01v8 w=1 l=0.18
X1676 t_Xwe7_m2 rst_n vdd vdd sky130_fd_pr__pfet_01v8 w=1 l=0.18
X1677 t_Xwe7_m3 t_Xwe7_m2 vss vss sky130_fd_pr__nfet_01v8 w=0.45 l=0.18
X1678 t_Xwe7_m3 t_Xwe7_m2 vdd vdd sky130_fd_pr__pfet_01v8 w=0.9 l=0.18
X1679 t_Xwe7_m3 t_wcap t_Xwe7_m1 vss sky130_fd_pr__nfet_01v8 w=0.45 l=0.18
X1680 t_Xwe7_m3 t_wcapb t_Xwe7_m1 vdd sky130_fd_pr__pfet_01v8 w=0.9 l=0.18
X1681 t_Xwe7_m2 t_wcap t_Xwe7_s1 vss sky130_fd_pr__nfet_01v8 w=0.5 l=0.18
X1682 t_Xwe7_m2 t_wcapb t_Xwe7_s1 vdd sky130_fd_pr__pfet_01v8 w=1 l=0.18
X1683 t_Xwe7_qi t_Xwe7_s1 vss vss sky130_fd_pr__nfet_01v8 w=0.55 l=0.18
X1684 t_Xwe7_qi t_Xwe7_s1 vdd vdd sky130_fd_pr__pfet_01v8 w=1.2 l=0.18
X1685 t_Xwe7_s2 t_Xwe7_qi t_Xwe7_Xsfb_mid vss sky130_fd_pr__nfet_01v8 w=0.7 l=0.18
X1686 t_Xwe7_Xsfb_mid rst_n vss vss sky130_fd_pr__nfet_01v8 w=0.7 l=0.18
X1687 t_Xwe7_s2 t_Xwe7_qi vdd vdd sky130_fd_pr__pfet_01v8 w=0.95 l=0.18
X1688 t_Xwe7_s2 rst_n vdd vdd sky130_fd_pr__pfet_01v8 w=0.95 l=0.18
X1689 t_Xwe7_s2 t_wcapb t_Xwe7_s1 vss sky130_fd_pr__nfet_01v8 w=0.45 l=0.18
X1690 t_Xwe7_s2 t_wcap t_Xwe7_s1 vdd sky130_fd_pr__pfet_01v8 w=0.9 l=0.18
X1691 we7 t_Xwe7_s1 vss vss sky130_fd_pr__nfet_01v8 w=0.75 l=0.18
X1692 we7 t_Xwe7_s1 vdd vdd sky130_fd_pr__pfet_01v8 w=1.6 l=0.18
X1693 t_e3_2 t_wcapb t_Xwe8_m1 vss sky130_fd_pr__nfet_01v8 w=0.5 l=0.18
X1694 t_e3_2 t_wcap t_Xwe8_m1 vdd sky130_fd_pr__pfet_01v8 w=1 l=0.18
X1695 t_Xwe8_m2 t_Xwe8_m1 t_Xwe8_Xm2_mid vss sky130_fd_pr__nfet_01v8 w=0.75 l=0.18
X1696 t_Xwe8_Xm2_mid rst_n vss vss sky130_fd_pr__nfet_01v8 w=0.75 l=0.18
X1697 t_Xwe8_m2 t_Xwe8_m1 vdd vdd sky130_fd_pr__pfet_01v8 w=1 l=0.18
X1698 t_Xwe8_m2 rst_n vdd vdd sky130_fd_pr__pfet_01v8 w=1 l=0.18
X1699 t_Xwe8_m3 t_Xwe8_m2 vss vss sky130_fd_pr__nfet_01v8 w=0.45 l=0.18
X1700 t_Xwe8_m3 t_Xwe8_m2 vdd vdd sky130_fd_pr__pfet_01v8 w=0.9 l=0.18
X1701 t_Xwe8_m3 t_wcap t_Xwe8_m1 vss sky130_fd_pr__nfet_01v8 w=0.45 l=0.18
X1702 t_Xwe8_m3 t_wcapb t_Xwe8_m1 vdd sky130_fd_pr__pfet_01v8 w=0.9 l=0.18
X1703 t_Xwe8_m2 t_wcap t_Xwe8_s1 vss sky130_fd_pr__nfet_01v8 w=0.5 l=0.18
X1704 t_Xwe8_m2 t_wcapb t_Xwe8_s1 vdd sky130_fd_pr__pfet_01v8 w=1 l=0.18
X1705 t_Xwe8_qi t_Xwe8_s1 vss vss sky130_fd_pr__nfet_01v8 w=0.55 l=0.18
X1706 t_Xwe8_qi t_Xwe8_s1 vdd vdd sky130_fd_pr__pfet_01v8 w=1.2 l=0.18
X1707 t_Xwe8_s2 t_Xwe8_qi t_Xwe8_Xsfb_mid vss sky130_fd_pr__nfet_01v8 w=0.7 l=0.18
X1708 t_Xwe8_Xsfb_mid rst_n vss vss sky130_fd_pr__nfet_01v8 w=0.7 l=0.18
X1709 t_Xwe8_s2 t_Xwe8_qi vdd vdd sky130_fd_pr__pfet_01v8 w=0.95 l=0.18
X1710 t_Xwe8_s2 rst_n vdd vdd sky130_fd_pr__pfet_01v8 w=0.95 l=0.18
X1711 t_Xwe8_s2 t_wcapb t_Xwe8_s1 vss sky130_fd_pr__nfet_01v8 w=0.45 l=0.18
X1712 t_Xwe8_s2 t_wcap t_Xwe8_s1 vdd sky130_fd_pr__pfet_01v8 w=0.9 l=0.18
X1713 we8 t_Xwe8_s1 vss vss sky130_fd_pr__nfet_01v8 w=0.75 l=0.18
X1714 we8 t_Xwe8_s1 vdd vdd sky130_fd_pr__pfet_01v8 w=1.6 l=0.18
X1715 t_e0_1 t_wcapb t_Xwe9_m1 vss sky130_fd_pr__nfet_01v8 w=0.5 l=0.18
X1716 t_e0_1 t_wcap t_Xwe9_m1 vdd sky130_fd_pr__pfet_01v8 w=1 l=0.18
X1717 t_Xwe9_m2 t_Xwe9_m1 t_Xwe9_Xm2_mid vss sky130_fd_pr__nfet_01v8 w=0.75 l=0.18
X1718 t_Xwe9_Xm2_mid rst_n vss vss sky130_fd_pr__nfet_01v8 w=0.75 l=0.18
X1719 t_Xwe9_m2 t_Xwe9_m1 vdd vdd sky130_fd_pr__pfet_01v8 w=1 l=0.18
X1720 t_Xwe9_m2 rst_n vdd vdd sky130_fd_pr__pfet_01v8 w=1 l=0.18
X1721 t_Xwe9_m3 t_Xwe9_m2 vss vss sky130_fd_pr__nfet_01v8 w=0.45 l=0.18
X1722 t_Xwe9_m3 t_Xwe9_m2 vdd vdd sky130_fd_pr__pfet_01v8 w=0.9 l=0.18
X1723 t_Xwe9_m3 t_wcap t_Xwe9_m1 vss sky130_fd_pr__nfet_01v8 w=0.45 l=0.18
X1724 t_Xwe9_m3 t_wcapb t_Xwe9_m1 vdd sky130_fd_pr__pfet_01v8 w=0.9 l=0.18
X1725 t_Xwe9_m2 t_wcap t_Xwe9_s1 vss sky130_fd_pr__nfet_01v8 w=0.5 l=0.18
X1726 t_Xwe9_m2 t_wcapb t_Xwe9_s1 vdd sky130_fd_pr__pfet_01v8 w=1 l=0.18
X1727 t_Xwe9_qi t_Xwe9_s1 vss vss sky130_fd_pr__nfet_01v8 w=0.55 l=0.18
X1728 t_Xwe9_qi t_Xwe9_s1 vdd vdd sky130_fd_pr__pfet_01v8 w=1.2 l=0.18
X1729 t_Xwe9_s2 t_Xwe9_qi t_Xwe9_Xsfb_mid vss sky130_fd_pr__nfet_01v8 w=0.7 l=0.18
X1730 t_Xwe9_Xsfb_mid rst_n vss vss sky130_fd_pr__nfet_01v8 w=0.7 l=0.18
X1731 t_Xwe9_s2 t_Xwe9_qi vdd vdd sky130_fd_pr__pfet_01v8 w=0.95 l=0.18
X1732 t_Xwe9_s2 rst_n vdd vdd sky130_fd_pr__pfet_01v8 w=0.95 l=0.18
X1733 t_Xwe9_s2 t_wcapb t_Xwe9_s1 vss sky130_fd_pr__nfet_01v8 w=0.45 l=0.18
X1734 t_Xwe9_s2 t_wcap t_Xwe9_s1 vdd sky130_fd_pr__pfet_01v8 w=0.9 l=0.18
X1735 we9 t_Xwe9_s1 vss vss sky130_fd_pr__nfet_01v8 w=0.75 l=0.18
X1736 we9 t_Xwe9_s1 vdd vdd sky130_fd_pr__pfet_01v8 w=1.6 l=0.18
X1737 t_e1_1 t_wcapb t_Xwe10_m1 vss sky130_fd_pr__nfet_01v8 w=0.5 l=0.18
X1738 t_e1_1 t_wcap t_Xwe10_m1 vdd sky130_fd_pr__pfet_01v8 w=1 l=0.18
X1739 t_Xwe10_m2 t_Xwe10_m1 t_Xwe10_Xm2_mid vss sky130_fd_pr__nfet_01v8 w=0.75 l=0.18
X1740 t_Xwe10_Xm2_mid rst_n vss vss sky130_fd_pr__nfet_01v8 w=0.75 l=0.18
X1741 t_Xwe10_m2 t_Xwe10_m1 vdd vdd sky130_fd_pr__pfet_01v8 w=1 l=0.18
X1742 t_Xwe10_m2 rst_n vdd vdd sky130_fd_pr__pfet_01v8 w=1 l=0.18
X1743 t_Xwe10_m3 t_Xwe10_m2 vss vss sky130_fd_pr__nfet_01v8 w=0.45 l=0.18
X1744 t_Xwe10_m3 t_Xwe10_m2 vdd vdd sky130_fd_pr__pfet_01v8 w=0.9 l=0.18
X1745 t_Xwe10_m3 t_wcap t_Xwe10_m1 vss sky130_fd_pr__nfet_01v8 w=0.45 l=0.18
X1746 t_Xwe10_m3 t_wcapb t_Xwe10_m1 vdd sky130_fd_pr__pfet_01v8 w=0.9 l=0.18
X1747 t_Xwe10_m2 t_wcap t_Xwe10_s1 vss sky130_fd_pr__nfet_01v8 w=0.5 l=0.18
X1748 t_Xwe10_m2 t_wcapb t_Xwe10_s1 vdd sky130_fd_pr__pfet_01v8 w=1 l=0.18
X1749 t_Xwe10_qi t_Xwe10_s1 vss vss sky130_fd_pr__nfet_01v8 w=0.55 l=0.18
X1750 t_Xwe10_qi t_Xwe10_s1 vdd vdd sky130_fd_pr__pfet_01v8 w=1.2 l=0.18
X1751 t_Xwe10_s2 t_Xwe10_qi t_Xwe10_Xsfb_mid vss sky130_fd_pr__nfet_01v8 w=0.7 l=0.18
X1752 t_Xwe10_Xsfb_mid rst_n vss vss sky130_fd_pr__nfet_01v8 w=0.7 l=0.18
X1753 t_Xwe10_s2 t_Xwe10_qi vdd vdd sky130_fd_pr__pfet_01v8 w=0.95 l=0.18
X1754 t_Xwe10_s2 rst_n vdd vdd sky130_fd_pr__pfet_01v8 w=0.95 l=0.18
X1755 t_Xwe10_s2 t_wcapb t_Xwe10_s1 vss sky130_fd_pr__nfet_01v8 w=0.45 l=0.18
X1756 t_Xwe10_s2 t_wcap t_Xwe10_s1 vdd sky130_fd_pr__pfet_01v8 w=0.9 l=0.18
X1757 we10 t_Xwe10_s1 vss vss sky130_fd_pr__nfet_01v8 w=0.75 l=0.18
X1758 we10 t_Xwe10_s1 vdd vdd sky130_fd_pr__pfet_01v8 w=1.6 l=0.18
X1759 t_e2_1 t_wcapb t_Xwe11_m1 vss sky130_fd_pr__nfet_01v8 w=0.5 l=0.18
X1760 t_e2_1 t_wcap t_Xwe11_m1 vdd sky130_fd_pr__pfet_01v8 w=1 l=0.18
X1761 t_Xwe11_m2 t_Xwe11_m1 t_Xwe11_Xm2_mid vss sky130_fd_pr__nfet_01v8 w=0.75 l=0.18
X1762 t_Xwe11_Xm2_mid rst_n vss vss sky130_fd_pr__nfet_01v8 w=0.75 l=0.18
X1763 t_Xwe11_m2 t_Xwe11_m1 vdd vdd sky130_fd_pr__pfet_01v8 w=1 l=0.18
X1764 t_Xwe11_m2 rst_n vdd vdd sky130_fd_pr__pfet_01v8 w=1 l=0.18
X1765 t_Xwe11_m3 t_Xwe11_m2 vss vss sky130_fd_pr__nfet_01v8 w=0.45 l=0.18
X1766 t_Xwe11_m3 t_Xwe11_m2 vdd vdd sky130_fd_pr__pfet_01v8 w=0.9 l=0.18
X1767 t_Xwe11_m3 t_wcap t_Xwe11_m1 vss sky130_fd_pr__nfet_01v8 w=0.45 l=0.18
X1768 t_Xwe11_m3 t_wcapb t_Xwe11_m1 vdd sky130_fd_pr__pfet_01v8 w=0.9 l=0.18
X1769 t_Xwe11_m2 t_wcap t_Xwe11_s1 vss sky130_fd_pr__nfet_01v8 w=0.5 l=0.18
X1770 t_Xwe11_m2 t_wcapb t_Xwe11_s1 vdd sky130_fd_pr__pfet_01v8 w=1 l=0.18
X1771 t_Xwe11_qi t_Xwe11_s1 vss vss sky130_fd_pr__nfet_01v8 w=0.55 l=0.18
X1772 t_Xwe11_qi t_Xwe11_s1 vdd vdd sky130_fd_pr__pfet_01v8 w=1.2 l=0.18
X1773 t_Xwe11_s2 t_Xwe11_qi t_Xwe11_Xsfb_mid vss sky130_fd_pr__nfet_01v8 w=0.7 l=0.18
X1774 t_Xwe11_Xsfb_mid rst_n vss vss sky130_fd_pr__nfet_01v8 w=0.7 l=0.18
X1775 t_Xwe11_s2 t_Xwe11_qi vdd vdd sky130_fd_pr__pfet_01v8 w=0.95 l=0.18
X1776 t_Xwe11_s2 rst_n vdd vdd sky130_fd_pr__pfet_01v8 w=0.95 l=0.18
X1777 t_Xwe11_s2 t_wcapb t_Xwe11_s1 vss sky130_fd_pr__nfet_01v8 w=0.45 l=0.18
X1778 t_Xwe11_s2 t_wcap t_Xwe11_s1 vdd sky130_fd_pr__pfet_01v8 w=0.9 l=0.18
X1779 we11 t_Xwe11_s1 vss vss sky130_fd_pr__nfet_01v8 w=0.75 l=0.18
X1780 we11 t_Xwe11_s1 vdd vdd sky130_fd_pr__pfet_01v8 w=1.6 l=0.18
X1781 t_e3_1 t_wcapb t_Xwe12_m1 vss sky130_fd_pr__nfet_01v8 w=0.5 l=0.18
X1782 t_e3_1 t_wcap t_Xwe12_m1 vdd sky130_fd_pr__pfet_01v8 w=1 l=0.18
X1783 t_Xwe12_m2 t_Xwe12_m1 t_Xwe12_Xm2_mid vss sky130_fd_pr__nfet_01v8 w=0.75 l=0.18
X1784 t_Xwe12_Xm2_mid rst_n vss vss sky130_fd_pr__nfet_01v8 w=0.75 l=0.18
X1785 t_Xwe12_m2 t_Xwe12_m1 vdd vdd sky130_fd_pr__pfet_01v8 w=1 l=0.18
X1786 t_Xwe12_m2 rst_n vdd vdd sky130_fd_pr__pfet_01v8 w=1 l=0.18
X1787 t_Xwe12_m3 t_Xwe12_m2 vss vss sky130_fd_pr__nfet_01v8 w=0.45 l=0.18
X1788 t_Xwe12_m3 t_Xwe12_m2 vdd vdd sky130_fd_pr__pfet_01v8 w=0.9 l=0.18
X1789 t_Xwe12_m3 t_wcap t_Xwe12_m1 vss sky130_fd_pr__nfet_01v8 w=0.45 l=0.18
X1790 t_Xwe12_m3 t_wcapb t_Xwe12_m1 vdd sky130_fd_pr__pfet_01v8 w=0.9 l=0.18
X1791 t_Xwe12_m2 t_wcap t_Xwe12_s1 vss sky130_fd_pr__nfet_01v8 w=0.5 l=0.18
X1792 t_Xwe12_m2 t_wcapb t_Xwe12_s1 vdd sky130_fd_pr__pfet_01v8 w=1 l=0.18
X1793 t_Xwe12_qi t_Xwe12_s1 vss vss sky130_fd_pr__nfet_01v8 w=0.55 l=0.18
X1794 t_Xwe12_qi t_Xwe12_s1 vdd vdd sky130_fd_pr__pfet_01v8 w=1.2 l=0.18
X1795 t_Xwe12_s2 t_Xwe12_qi t_Xwe12_Xsfb_mid vss sky130_fd_pr__nfet_01v8 w=0.7 l=0.18
X1796 t_Xwe12_Xsfb_mid rst_n vss vss sky130_fd_pr__nfet_01v8 w=0.7 l=0.18
X1797 t_Xwe12_s2 t_Xwe12_qi vdd vdd sky130_fd_pr__pfet_01v8 w=0.95 l=0.18
X1798 t_Xwe12_s2 rst_n vdd vdd sky130_fd_pr__pfet_01v8 w=0.95 l=0.18
X1799 t_Xwe12_s2 t_wcapb t_Xwe12_s1 vss sky130_fd_pr__nfet_01v8 w=0.45 l=0.18
X1800 t_Xwe12_s2 t_wcap t_Xwe12_s1 vdd sky130_fd_pr__pfet_01v8 w=0.9 l=0.18
X1801 we12 t_Xwe12_s1 vss vss sky130_fd_pr__nfet_01v8 w=0.75 l=0.18
X1802 we12 t_Xwe12_s1 vdd vdd sky130_fd_pr__pfet_01v8 w=1.6 l=0.18
X1803 t_e0_0 t_wcapb t_Xwe13_m1 vss sky130_fd_pr__nfet_01v8 w=0.5 l=0.18
X1804 t_e0_0 t_wcap t_Xwe13_m1 vdd sky130_fd_pr__pfet_01v8 w=1 l=0.18
X1805 t_Xwe13_m2 t_Xwe13_m1 t_Xwe13_Xm2_mid vss sky130_fd_pr__nfet_01v8 w=0.75 l=0.18
X1806 t_Xwe13_Xm2_mid rst_n vss vss sky130_fd_pr__nfet_01v8 w=0.75 l=0.18
X1807 t_Xwe13_m2 t_Xwe13_m1 vdd vdd sky130_fd_pr__pfet_01v8 w=1 l=0.18
X1808 t_Xwe13_m2 rst_n vdd vdd sky130_fd_pr__pfet_01v8 w=1 l=0.18
X1809 t_Xwe13_m3 t_Xwe13_m2 vss vss sky130_fd_pr__nfet_01v8 w=0.45 l=0.18
X1810 t_Xwe13_m3 t_Xwe13_m2 vdd vdd sky130_fd_pr__pfet_01v8 w=0.9 l=0.18
X1811 t_Xwe13_m3 t_wcap t_Xwe13_m1 vss sky130_fd_pr__nfet_01v8 w=0.45 l=0.18
X1812 t_Xwe13_m3 t_wcapb t_Xwe13_m1 vdd sky130_fd_pr__pfet_01v8 w=0.9 l=0.18
X1813 t_Xwe13_m2 t_wcap t_Xwe13_s1 vss sky130_fd_pr__nfet_01v8 w=0.5 l=0.18
X1814 t_Xwe13_m2 t_wcapb t_Xwe13_s1 vdd sky130_fd_pr__pfet_01v8 w=1 l=0.18
X1815 t_Xwe13_qi t_Xwe13_s1 vss vss sky130_fd_pr__nfet_01v8 w=0.55 l=0.18
X1816 t_Xwe13_qi t_Xwe13_s1 vdd vdd sky130_fd_pr__pfet_01v8 w=1.2 l=0.18
X1817 t_Xwe13_s2 t_Xwe13_qi t_Xwe13_Xsfb_mid vss sky130_fd_pr__nfet_01v8 w=0.7 l=0.18
X1818 t_Xwe13_Xsfb_mid rst_n vss vss sky130_fd_pr__nfet_01v8 w=0.7 l=0.18
X1819 t_Xwe13_s2 t_Xwe13_qi vdd vdd sky130_fd_pr__pfet_01v8 w=0.95 l=0.18
X1820 t_Xwe13_s2 rst_n vdd vdd sky130_fd_pr__pfet_01v8 w=0.95 l=0.18
X1821 t_Xwe13_s2 t_wcapb t_Xwe13_s1 vss sky130_fd_pr__nfet_01v8 w=0.45 l=0.18
X1822 t_Xwe13_s2 t_wcap t_Xwe13_s1 vdd sky130_fd_pr__pfet_01v8 w=0.9 l=0.18
X1823 we13 t_Xwe13_s1 vss vss sky130_fd_pr__nfet_01v8 w=0.75 l=0.18
X1824 we13 t_Xwe13_s1 vdd vdd sky130_fd_pr__pfet_01v8 w=1.6 l=0.18
X1825 t_e1_0 t_wcapb t_Xwe14_m1 vss sky130_fd_pr__nfet_01v8 w=0.5 l=0.18
X1826 t_e1_0 t_wcap t_Xwe14_m1 vdd sky130_fd_pr__pfet_01v8 w=1 l=0.18
X1827 t_Xwe14_m2 t_Xwe14_m1 t_Xwe14_Xm2_mid vss sky130_fd_pr__nfet_01v8 w=0.75 l=0.18
X1828 t_Xwe14_Xm2_mid rst_n vss vss sky130_fd_pr__nfet_01v8 w=0.75 l=0.18
X1829 t_Xwe14_m2 t_Xwe14_m1 vdd vdd sky130_fd_pr__pfet_01v8 w=1 l=0.18
X1830 t_Xwe14_m2 rst_n vdd vdd sky130_fd_pr__pfet_01v8 w=1 l=0.18
X1831 t_Xwe14_m3 t_Xwe14_m2 vss vss sky130_fd_pr__nfet_01v8 w=0.45 l=0.18
X1832 t_Xwe14_m3 t_Xwe14_m2 vdd vdd sky130_fd_pr__pfet_01v8 w=0.9 l=0.18
X1833 t_Xwe14_m3 t_wcap t_Xwe14_m1 vss sky130_fd_pr__nfet_01v8 w=0.45 l=0.18
X1834 t_Xwe14_m3 t_wcapb t_Xwe14_m1 vdd sky130_fd_pr__pfet_01v8 w=0.9 l=0.18
X1835 t_Xwe14_m2 t_wcap t_Xwe14_s1 vss sky130_fd_pr__nfet_01v8 w=0.5 l=0.18
X1836 t_Xwe14_m2 t_wcapb t_Xwe14_s1 vdd sky130_fd_pr__pfet_01v8 w=1 l=0.18
X1837 t_Xwe14_qi t_Xwe14_s1 vss vss sky130_fd_pr__nfet_01v8 w=0.55 l=0.18
X1838 t_Xwe14_qi t_Xwe14_s1 vdd vdd sky130_fd_pr__pfet_01v8 w=1.2 l=0.18
X1839 t_Xwe14_s2 t_Xwe14_qi t_Xwe14_Xsfb_mid vss sky130_fd_pr__nfet_01v8 w=0.7 l=0.18
X1840 t_Xwe14_Xsfb_mid rst_n vss vss sky130_fd_pr__nfet_01v8 w=0.7 l=0.18
X1841 t_Xwe14_s2 t_Xwe14_qi vdd vdd sky130_fd_pr__pfet_01v8 w=0.95 l=0.18
X1842 t_Xwe14_s2 rst_n vdd vdd sky130_fd_pr__pfet_01v8 w=0.95 l=0.18
X1843 t_Xwe14_s2 t_wcapb t_Xwe14_s1 vss sky130_fd_pr__nfet_01v8 w=0.45 l=0.18
X1844 t_Xwe14_s2 t_wcap t_Xwe14_s1 vdd sky130_fd_pr__pfet_01v8 w=0.9 l=0.18
X1845 we14 t_Xwe14_s1 vss vss sky130_fd_pr__nfet_01v8 w=0.75 l=0.18
X1846 we14 t_Xwe14_s1 vdd vdd sky130_fd_pr__pfet_01v8 w=1.6 l=0.18
X1847 t_e2_0 t_wcapb t_Xwe15_m1 vss sky130_fd_pr__nfet_01v8 w=0.5 l=0.18
X1848 t_e2_0 t_wcap t_Xwe15_m1 vdd sky130_fd_pr__pfet_01v8 w=1 l=0.18
X1849 t_Xwe15_m2 t_Xwe15_m1 t_Xwe15_Xm2_mid vss sky130_fd_pr__nfet_01v8 w=0.75 l=0.18
X1850 t_Xwe15_Xm2_mid rst_n vss vss sky130_fd_pr__nfet_01v8 w=0.75 l=0.18
X1851 t_Xwe15_m2 t_Xwe15_m1 vdd vdd sky130_fd_pr__pfet_01v8 w=1 l=0.18
X1852 t_Xwe15_m2 rst_n vdd vdd sky130_fd_pr__pfet_01v8 w=1 l=0.18
X1853 t_Xwe15_m3 t_Xwe15_m2 vss vss sky130_fd_pr__nfet_01v8 w=0.45 l=0.18
X1854 t_Xwe15_m3 t_Xwe15_m2 vdd vdd sky130_fd_pr__pfet_01v8 w=0.9 l=0.18
X1855 t_Xwe15_m3 t_wcap t_Xwe15_m1 vss sky130_fd_pr__nfet_01v8 w=0.45 l=0.18
X1856 t_Xwe15_m3 t_wcapb t_Xwe15_m1 vdd sky130_fd_pr__pfet_01v8 w=0.9 l=0.18
X1857 t_Xwe15_m2 t_wcap t_Xwe15_s1 vss sky130_fd_pr__nfet_01v8 w=0.5 l=0.18
X1858 t_Xwe15_m2 t_wcapb t_Xwe15_s1 vdd sky130_fd_pr__pfet_01v8 w=1 l=0.18
X1859 t_Xwe15_qi t_Xwe15_s1 vss vss sky130_fd_pr__nfet_01v8 w=0.55 l=0.18
X1860 t_Xwe15_qi t_Xwe15_s1 vdd vdd sky130_fd_pr__pfet_01v8 w=1.2 l=0.18
X1861 t_Xwe15_s2 t_Xwe15_qi t_Xwe15_Xsfb_mid vss sky130_fd_pr__nfet_01v8 w=0.7 l=0.18
X1862 t_Xwe15_Xsfb_mid rst_n vss vss sky130_fd_pr__nfet_01v8 w=0.7 l=0.18
X1863 t_Xwe15_s2 t_Xwe15_qi vdd vdd sky130_fd_pr__pfet_01v8 w=0.95 l=0.18
X1864 t_Xwe15_s2 rst_n vdd vdd sky130_fd_pr__pfet_01v8 w=0.95 l=0.18
X1865 t_Xwe15_s2 t_wcapb t_Xwe15_s1 vss sky130_fd_pr__nfet_01v8 w=0.45 l=0.18
X1866 t_Xwe15_s2 t_wcap t_Xwe15_s1 vdd sky130_fd_pr__pfet_01v8 w=0.9 l=0.18
X1867 we15 t_Xwe15_s1 vss vss sky130_fd_pr__nfet_01v8 w=0.75 l=0.18
X1868 we15 t_Xwe15_s1 vdd vdd sky130_fd_pr__pfet_01v8 w=1.6 l=0.18
.ends serdes_rx_cmos_deser16_pdk

.subckt serdes_rx_cmos_top_5g_pdk rxp rxn vcm_ref ibias_ctle eq0 eq1 ip qp in qn a0 a1 a2 a3 a4 a5 a6 a7 b0 b1 b2 b3 b4 b5 b6 b7 f0 f1 f2 f3 f4 f5 f6 f7 rst_n wd0 wd1 wd2 wd3 wd4 wd5 wd6 wd7 wd8 wd9 wd10 wd11 wd12 wd13 wd14 wd15 we0 we1 we2 we3 we4 we5 we6 we7 we8 we9 we10 we11 we12 we13 we14 we15 wclk ctle_p ctle_n vdd vss
Xterm rxp rxn vcm_ref vss serdes_rx_term_pdk
Xbias_ctle ibias_ctle vss serdes_bias_ctle_v2_pdk
Xctle rxp rxn ctle_p ctle_n eq0 eq1 ibias_ctle vdd vss serdes_rx_ctle_shunt_5g_dc
Xpi ip qp in qn a0 a1 a2 a3 a4 a5 a6 a7 b0 b1 b2 b3 b4 b5 b6 b7 f0 f1 f2 f3 f4 f5 f6 f7 rst_n dp dn ep en ckd0 ckd1 ckd2 ckd3 cke0 cke1 cke2 cke3 vdd vss serdes_rx_pi_4ph_5g_pdk
Xsd0 ctle_p ctle_n ckd0 d0 d0b vdd vss vss vss vss vss vdd vss serdes_rx_dt_slicer_5g_pdk
Xsd1 ctle_p ctle_n ckd1 d1 d1b vdd vss vss vss vss vss vdd vss serdes_rx_dt_slicer_5g_pdk
Xsd2 ctle_p ctle_n ckd2 d2 d2b vdd vss vss vss vss vss vdd vss serdes_rx_dt_slicer_5g_pdk
Xsd3 ctle_p ctle_n ckd3 d3 d3b vdd vss vss vss vss vss vdd vss serdes_rx_dt_slicer_5g_pdk
Xse0 ctle_p ctle_n cke0 e0 e0b vdd vss vss vss vss vss vdd vss serdes_rx_dt_slicer_5g_pdk
Xse1 ctle_p ctle_n cke1 e1 e1b vdd vss vss vss vss vss vdd vss serdes_rx_dt_slicer_5g_pdk
Xse2 ctle_p ctle_n cke2 e2 e2b vdd vss vss vss vss vss vdd vss serdes_rx_dt_slicer_5g_pdk
Xse3 ctle_p ctle_n cke3 e3 e3b vdd vss vss vss vss vss vdd vss serdes_rx_dt_slicer_5g_pdk
Xdeser d0 d1 d2 d3 e0 e1 e2 e3 ckd0 ckd1 ckd2 ckd3 cke0 cke1 cke2 cke3 rst_n wd0 wd1 wd2 wd3 wd4 wd5 wd6 wd7 wd8 wd9 wd10 wd11 wd12 wd13 wd14 wd15 we0 we1 we2 we3 we4 we5 we6 we7 we8 we9 we10 we11 we12 we13 we14 we15 wclk vdd vss serdes_rx_cmos_deser16_pdk
.ends serdes_rx_cmos_top_5g_pdk
