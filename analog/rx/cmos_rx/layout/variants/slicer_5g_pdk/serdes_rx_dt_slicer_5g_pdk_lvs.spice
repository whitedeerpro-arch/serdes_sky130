* NGSPICE file created from serdes_rx_dt_slicer_5g_pdk.ext - technology: sky130A

.subckt serdes_rx_dt_slicer_5g_pdk inp inn clk qp qn t5 t4 t3 t2 t1 t0 vdd vss
X0 a_n2657_626# a_n1385_2474# a_n1463_5242# vss sky130_fd_pr__nfet_01v8_lvt ad=0.744 pd=5.42 as=0.396 ps=2.73 w=2.4 l=0.15
X1 a_n81_1730# clk vdd vdd sky130_fd_pr__pfet_01v8 ad=0.651 pd=4.82 as=0.3465 ps=2.43 w=2.1 l=0.15
X2 vss a_n2651_180# a_2209_180# vss sky130_fd_pr__nfet_01v8 ad=0.59 pd=4.59 as=0.3 ps=2.3 w=2 l=0.18
X3 a_2034_5310# a_n81_1730# a_2034_5310# vss sky130_fd_pr__nfet_01v8 ad=0.27 pd=2.1 as=2.202 ps=17.18 w=1.8 l=0.18
X4 vdd a_n1385_2474# a_n1463_5242# vdd sky130_fd_pr__pfet_01v8 ad=0.3465 pd=2.43 as=0.3465 ps=2.43 w=2.1 l=0.15
X5 a_2034_5310# a_n81_1730# a_2034_5310# vss sky130_fd_pr__nfet_01v8 ad=0.531 pd=4.19 as=0 ps=0 w=1.8 l=0.18
X6 vdd clk a_n2657_626# vdd sky130_fd_pr__pfet_01v8 ad=0.3465 pd=2.43 as=0.651 ps=4.82 w=2.1 l=0.15
X7 vss t4 a_n2355_780# vss sky130_fd_pr__nfet_01v8 ad=0.59 pd=4.59 as=0.3 ps=2.3 w=2 l=0.18
X8 a_n2355_780# a_n2657_626# a_n2355_780# vss sky130_fd_pr__nfet_01v8 ad=0.531 pd=4.19 as=2.202 ps=17.18 w=1.8 l=0.18
X9 a_n2355_780# a_n2657_626# a_n2355_780# vss sky130_fd_pr__nfet_01v8 ad=0.27 pd=2.1 as=0 ps=0 w=1.8 l=0.18
X10 vdd t5 a_n2651_180# vdd sky130_fd_pr__pfet_01v8 ad=0.3 pd=2.3 as=0.3 ps=2.3 w=2 l=0.18
X11 vdd a_n1463_5242# a_n1433_5310# vdd sky130_fd_pr__pfet_01v8_lvt ad=0.609 pd=4.78 as=0.609 ps=4.78 w=2.1 l=0.35
X12 vdd a_n1463_5242# a_n1385_2474# vdd sky130_fd_pr__pfet_01v8_lvt ad=0.464 pd=3.78 as=0.232 ps=1.89 w=1.6 l=0.35
X13 a_n81_1730# a_n1463_5242# a_n1385_2474# vss sky130_fd_pr__nfet_01v8_lvt ad=0.396 pd=2.73 as=0.396 ps=2.73 w=2.4 l=0.15
X14 a_n1826_315# t1 vss vss sky130_fd_pr__nfet_01v8 ad=0.29 pd=2.58 as=0.29 ps=2.58 w=1 l=0.18
X15 vdd a_n2355_780# a_2034_5310# vdd sky130_fd_pr__pfet_01v8 ad=0.59 pd=4.59 as=0.3 ps=2.3 w=2 l=0.18
X16 a_n2651_180# t5 vss vss sky130_fd_pr__nfet_01v8 ad=0.3 pd=2.3 as=0.59 ps=4.59 w=2 l=0.18
X17 a_n1976_780# t3 vdd vdd sky130_fd_pr__pfet_01v8 ad=0.3 pd=2.3 as=0.59 ps=4.59 w=2 l=0.18
X18 a_n1463_5242# a_n1385_2474# a_n2657_626# vss sky130_fd_pr__nfet_01v8_lvt ad=0.396 pd=2.73 as=0.396 ps=2.73 w=2.4 l=0.15
X19 vss a_n1385_2474# a_n493_4282# vss sky130_fd_pr__nfet_01v8_lvt ad=0.372 pd=3.02 as=0.198 ps=1.53 w=1.2 l=0.15
X20 vdd t4 a_n2355_780# vdd sky130_fd_pr__pfet_01v8 ad=0.3 pd=2.3 as=0.3 ps=2.3 w=2 l=0.18
X21 vss t0 a_n2716_4460# vss sky130_fd_pr__nfet_01v8 ad=0.29 pd=2.58 as=0.29 ps=2.58 w=1 l=0.18
X22 vss a_n493_4282# qp vss sky130_fd_pr__nfet_01v8_lvt ad=0.775 pd=5.62 as=0.4125 ps=2.83 w=2.5 l=0.15
X23 vdd a_n1385_2474# a_n493_4282# vdd sky130_fd_pr__pfet_01v8 ad=0.33 pd=2.33 as=0.33 ps=2.33 w=2 l=0.15
X24 a_2209_180# a_n2651_180# vdd vdd sky130_fd_pr__pfet_01v8 ad=0.3 pd=2.3 as=0.59 ps=4.59 w=2 l=0.18
X25 a_n1385_2474# clk vdd vdd sky130_fd_pr__pfet_01v8 ad=0.3465 pd=2.43 as=0.651 ps=4.82 w=2.1 l=0.15
X26 a_n493_4282# a_n1385_2474# vdd vdd sky130_fd_pr__pfet_01v8_lvt ad=0.609 pd=4.78 as=0.609 ps=4.78 w=2.1 l=0.35
X27 a_n1433_5310# a_n1463_5242# vss vss sky130_fd_pr__nfet_01v8_lvt ad=0.198 pd=1.53 as=0.372 ps=3.02 w=1.2 l=0.15
X28 vdd clk a_n1463_5242# vdd sky130_fd_pr__pfet_01v8 ad=0.651 pd=4.82 as=0.3465 ps=2.43 w=2.1 l=0.15
X29 a_n1385_2474# clk a_n1463_5242# vdd sky130_fd_pr__pfet_01v8 ad=0.264 pd=1.93 as=0.496 ps=3.82 w=1.6 l=0.15
X30 vdd clk a_n81_1730# vdd sky130_fd_pr__pfet_01v8 ad=0.3465 pd=2.43 as=0.3465 ps=2.43 w=2.1 l=0.15
X31 vdd a_n1463_5242# a_n1385_2474# vdd sky130_fd_pr__pfet_01v8 ad=0.3465 pd=2.43 as=0.3465 ps=2.43 w=2.1 l=0.15
X32 a_n1463_5242# a_n1385_2474# vdd vdd sky130_fd_pr__pfet_01v8 ad=0.3465 pd=2.43 as=0.3465 ps=2.43 w=2.1 l=0.15
X33 a_n1463_5242# a_n1385_2474# vdd vdd sky130_fd_pr__pfet_01v8_lvt ad=0.232 pd=1.89 as=0.464 ps=3.78 w=1.6 l=0.35
X34 a_n2657_626# clk vdd vdd sky130_fd_pr__pfet_01v8 ad=0.3465 pd=2.43 as=0.3465 ps=2.43 w=2.1 l=0.15
X35 vss a_n1976_780# a_1824_780# vss sky130_fd_pr__nfet_01v8 ad=0.58 pd=4.58 as=0.58 ps=4.58 w=2 l=0.18
X36 a_2209_180# a_n2651_180# vdd vdd sky130_fd_pr__pfet_01v8 ad=0.3 pd=2.3 as=0.3 ps=2.3 w=2 l=0.18
X37 a_n1463_5242# clk a_n1385_2474# vdd sky130_fd_pr__pfet_01v8 ad=0.264 pd=1.93 as=0.264 ps=1.93 w=1.6 l=0.15
X38 vss a_n2355_780# a_2034_5310# vss sky130_fd_pr__nfet_01v8 ad=0.59 pd=4.59 as=0.3 ps=2.3 w=2 l=0.18
X39 vdd t5 a_n2651_180# vdd sky130_fd_pr__pfet_01v8 ad=0.59 pd=4.59 as=0.3 ps=2.3 w=2 l=0.18
X40 a_2209_180# a_n81_1730# a_2209_180# vss sky130_fd_pr__nfet_01v8 ad=0.27 pd=2.1 as=3.882 ps=30.18 w=1.8 l=0.18
X41 vss a_n1826_315# a_1674_315# vss sky130_fd_pr__nfet_01v8 ad=0.29 pd=2.58 as=0.29 ps=2.58 w=1 l=0.18
X42 vdd a_n2651_180# a_2209_180# vdd sky130_fd_pr__pfet_01v8 ad=0.59 pd=4.59 as=0.3 ps=2.3 w=2 l=0.18
X43 vdd a_n1976_780# a_1824_780# vdd sky130_fd_pr__pfet_01v8 ad=0.59 pd=4.59 as=0.3 ps=2.3 w=2 l=0.18
X44 qn a_n493_4282# vdd vss sky130_fd_pr__nfet_01v8_lvt ad=0.4125 pd=2.83 as=0.775 ps=5.62 w=2.5 l=0.15
X45 a_2209_180# a_n81_1730# a_2209_180# vss sky130_fd_pr__nfet_01v8 ad=0.27 pd=2.1 as=0 ps=0 w=1.8 l=0.18
X46 a_n2651_180# a_n2657_626# a_n2651_180# vss sky130_fd_pr__nfet_01v8 ad=0.531 pd=4.19 as=3.882 ps=30.18 w=1.8 l=0.18
X47 a_n2651_180# t5 vdd vdd sky130_fd_pr__pfet_01v8 ad=0.3 pd=2.3 as=0.3 ps=2.3 w=2 l=0.18
X48 vdd a_n1433_5310# qp vss sky130_fd_pr__nfet_01v8_lvt ad=0.775 pd=5.62 as=0.4125 ps=2.83 w=2.5 l=0.15
X49 a_2209_180# a_n81_1730# a_2209_180# vss sky130_fd_pr__nfet_01v8 ad=0.27 pd=2.1 as=0 ps=0 w=1.8 l=0.18
X50 a_2209_180# a_n81_1730# a_2209_180# vss sky130_fd_pr__nfet_01v8 ad=0.531 pd=4.19 as=0 ps=0 w=1.8 l=0.18
X51 a_n2651_180# a_n2657_626# a_n2651_180# vss sky130_fd_pr__nfet_01v8 ad=0.27 pd=2.1 as=0 ps=0 w=1.8 l=0.18
X52 a_n1385_2474# a_n1463_5242# a_n81_1730# vss sky130_fd_pr__nfet_01v8_lvt ad=0.396 pd=2.73 as=0.396 ps=2.73 w=2.4 l=0.15
X53 a_n1433_5310# a_n1463_5242# vdd vdd sky130_fd_pr__pfet_01v8 ad=0.33 pd=2.33 as=0.62 ps=4.62 w=2 l=0.15
X54 vss t5 a_n2651_180# vss sky130_fd_pr__nfet_01v8 ad=0.3 pd=2.3 as=0.3 ps=2.3 w=2 l=0.18
X55 a_1824_780# a_n81_1730# a_1824_780# vss sky130_fd_pr__nfet_01v8 ad=0.522 pd=4.18 as=1.624 ps=12.94 w=1.8 l=0.18
X56 vdd t3 a_n1976_780# vdd sky130_fd_pr__pfet_01v8 ad=0.59 pd=4.59 as=0.3 ps=2.3 w=2 l=0.18
X57 a_n2657_626# a_n1385_2474# a_n1463_5242# vss sky130_fd_pr__nfet_01v8_lvt ad=0.396 pd=2.73 as=0.396 ps=2.73 w=2.4 l=0.15
X58 a_n2651_180# a_n2657_626# a_n2651_180# vss sky130_fd_pr__nfet_01v8 ad=0.27 pd=2.1 as=0 ps=0 w=1.8 l=0.18
X59 a_2554_915# vdd vss vss sky130_fd_pr__nfet_01v8 ad=0.29 pd=2.58 as=0.29 ps=2.58 w=1 l=0.18
X60 a_n493_4282# a_n1385_2474# vss vss sky130_fd_pr__nfet_01v8_lvt ad=0.198 pd=1.53 as=0.372 ps=3.02 w=1.2 l=0.15
X61 vdd qp qn vdd sky130_fd_pr__pfet_01v8 ad=0.372 pd=3.02 as=0.198 ps=1.53 w=1.2 l=0.15
X62 a_n2651_180# t5 vdd vdd sky130_fd_pr__pfet_01v8 ad=0.3 pd=2.3 as=0.59 ps=4.59 w=2 l=0.18
X63 a_n2355_780# t4 vdd vdd sky130_fd_pr__pfet_01v8 ad=0.3 pd=2.3 as=0.3 ps=2.3 w=2 l=0.18
X64 a_n81_1730# a_n1463_5242# a_n1385_2474# vss sky130_fd_pr__nfet_01v8_lvt ad=0.744 pd=5.42 as=0.396 ps=2.73 w=2.4 l=0.15
X65 a_n81_1730# clk a_n2657_626# vdd sky130_fd_pr__pfet_01v8 ad=0.496 pd=3.82 as=0.264 ps=1.93 w=1.6 l=0.15
X66 a_n881_180# clk vss vss sky130_fd_pr__nfet_01v8_lvt ad=0.66 pd=4.33 as=0.66 ps=4.33 w=4 l=0.15
X67 vss a_n1463_5242# a_n1433_5310# vss sky130_fd_pr__nfet_01v8_lvt ad=0.372 pd=3.02 as=0.198 ps=1.53 w=1.2 l=0.15
X68 a_n1463_5242# a_n1385_2474# a_n2657_626# vss sky130_fd_pr__nfet_01v8_lvt ad=0.396 pd=2.73 as=0.744 ps=5.42 w=2.4 l=0.15
X69 a_n81_1730# clk vdd vdd sky130_fd_pr__pfet_01v8 ad=0.3465 pd=2.43 as=0.651 ps=4.82 w=2.1 l=0.15
X70 vss clk a_n881_180# vss sky130_fd_pr__nfet_01v8_lvt ad=1.24 pd=8.62 as=0.66 ps=4.33 w=4 l=0.15
X71 vdd clk a_n2657_626# vdd sky130_fd_pr__pfet_01v8 ad=0.651 pd=4.82 as=0.3465 ps=2.43 w=2.1 l=0.15
X72 a_n881_180# clk vss vss sky130_fd_pr__nfet_01v8_lvt ad=0.66 pd=4.33 as=0.66 ps=4.33 w=4 l=0.15
X73 vdd a_n2651_180# a_2209_180# vdd sky130_fd_pr__pfet_01v8 ad=0.3 pd=2.3 as=0.3 ps=2.3 w=2 l=0.18
X74 a_2034_5310# a_n2355_780# vss vss sky130_fd_pr__nfet_01v8 ad=0.3 pd=2.3 as=0.59 ps=4.59 w=2 l=0.18
X75 a_n1385_2474# clk vdd vdd sky130_fd_pr__pfet_01v8 ad=0.651 pd=4.82 as=0.3465 ps=2.43 w=2.1 l=0.15
X76 a_1824_780# a_n1976_780# vdd vdd sky130_fd_pr__pfet_01v8 ad=0.3 pd=2.3 as=0.59 ps=4.59 w=2 l=0.18
X77 a_2209_180# a_n2651_180# vss vss sky130_fd_pr__nfet_01v8 ad=0.3 pd=2.3 as=0.3 ps=2.3 w=2 l=0.18
X78 a_n81_1730# inn a_n881_180# vss sky130_fd_pr__nfet_01v8_lvt ad=0.5775 pd=3.83 as=0.5775 ps=3.83 w=3.5 l=0.15
X79 vdd clk a_n1463_5242# vdd sky130_fd_pr__pfet_01v8 ad=0.3465 pd=2.43 as=0.651 ps=4.82 w=2.1 l=0.15
X80 a_n881_180# inn a_n81_1730# vss sky130_fd_pr__nfet_01v8_lvt ad=0.5775 pd=3.83 as=0.5775 ps=3.83 w=3.5 l=0.15
X81 vdd a_n1463_5242# a_n1433_5310# vdd sky130_fd_pr__pfet_01v8 ad=0.33 pd=2.33 as=0.33 ps=2.33 w=2 l=0.15
X82 a_n2651_180# t5 vss vss sky130_fd_pr__nfet_01v8 ad=0.3 pd=2.3 as=0.3 ps=2.3 w=2 l=0.18
X83 a_n881_180# inn a_n81_1730# vss sky130_fd_pr__nfet_01v8_lvt ad=1.085 pd=7.62 as=0.5775 ps=3.83 w=3.5 l=0.15
X84 a_n2651_180# a_n2657_626# a_n2651_180# vss sky130_fd_pr__nfet_01v8 ad=0.27 pd=2.1 as=0 ps=0 w=1.8 l=0.18
X85 qn qp vdd vdd sky130_fd_pr__pfet_01v8 ad=0.198 pd=1.53 as=0.372 ps=3.02 w=1.2 l=0.15
X86 a_2034_5310# a_n2355_780# vdd vdd sky130_fd_pr__pfet_01v8 ad=0.3 pd=2.3 as=0.3 ps=2.3 w=2 l=0.18
X87 vdd t5 a_n2651_180# vdd sky130_fd_pr__pfet_01v8 ad=0.3 pd=2.3 as=0.3 ps=2.3 w=2 l=0.18
X88 a_n881_180# clk vss vss sky130_fd_pr__nfet_01v8_lvt ad=0.66 pd=4.33 as=1.24 ps=8.62 w=4 l=0.15
X89 vss clk a_n881_180# vss sky130_fd_pr__nfet_01v8_lvt ad=0.66 pd=4.33 as=0.66 ps=4.33 w=4 l=0.15
X90 a_n1976_780# a_n2657_626# a_n1976_780# vss sky130_fd_pr__nfet_01v8 ad=0.522 pd=4.18 as=1.624 ps=12.94 w=1.8 l=0.18
X91 qp qn vdd vdd sky130_fd_pr__pfet_01v8 ad=0.198 pd=1.53 as=0.372 ps=3.02 w=1.2 l=0.15
X92 vss qp qn vss sky130_fd_pr__nfet_01v8_lvt ad=0.232 pd=2.18 as=0.232 ps=2.18 w=0.8 l=0.15
X93 a_n1656_870# t2 vss vss sky130_fd_pr__nfet_01v8 ad=0.29 pd=2.58 as=0.29 ps=2.58 w=1 l=0.18
X94 a_n493_4282# a_n1385_2474# vdd vdd sky130_fd_pr__pfet_01v8 ad=0.33 pd=2.33 as=0.62 ps=4.62 w=2 l=0.15
X95 a_2034_5310# a_n2355_780# vdd vdd sky130_fd_pr__pfet_01v8 ad=0.3 pd=2.3 as=0.59 ps=4.59 w=2 l=0.18
X96 vss a_n1433_5310# qn vss sky130_fd_pr__nfet_01v8_lvt ad=0.775 pd=5.62 as=0.4125 ps=2.83 w=2.5 l=0.15
X97 a_2554_915# a_n81_1730# a_2554_915# vss sky130_fd_pr__nfet_01v8 ad=0.1305 pd=1.48 as=0.551 ps=5.54 w=0.45 l=0.18
X98 a_2209_180# a_n2651_180# vdd vdd sky130_fd_pr__pfet_01v8 ad=0.3 pd=2.3 as=0.59 ps=4.59 w=2 l=0.18
X99 a_n1826_315# t1 vdd vdd sky130_fd_pr__pfet_01v8 ad=0.58 pd=4.58 as=0.58 ps=4.58 w=2 l=0.18
X100 a_n1385_2474# a_n1463_5242# vdd vdd sky130_fd_pr__pfet_01v8 ad=0.3465 pd=2.43 as=0.651 ps=4.82 w=2.1 l=0.15
X101 vdd clk a_n1385_2474# vdd sky130_fd_pr__pfet_01v8 ad=0.3465 pd=2.43 as=0.3465 ps=2.43 w=2.1 l=0.15
X102 a_n1656_870# t2 vdd vdd sky130_fd_pr__pfet_01v8 ad=0.58 pd=4.58 as=0.58 ps=4.58 w=2 l=0.18
X103 a_1504_870# a_n81_1730# a_1504_870# vss sky130_fd_pr__nfet_01v8 ad=0.261 pd=2.38 as=0.812 ps=7.34 w=0.9 l=0.18
X104 a_n2716_4460# a_n2657_626# a_n2716_4460# vss sky130_fd_pr__nfet_01v8 ad=0.1305 pd=1.48 as=0.551 ps=5.54 w=0.45 l=0.18
X105 a_n81_1730# clk a_n2657_626# vdd sky130_fd_pr__pfet_01v8 ad=0.264 pd=1.93 as=0.496 ps=3.82 w=1.6 l=0.15
X106 vss a_n2651_180# a_2209_180# vss sky130_fd_pr__nfet_01v8 ad=0.3 pd=2.3 as=0.3 ps=2.3 w=2 l=0.18
X107 a_n1463_5242# clk vdd vdd sky130_fd_pr__pfet_01v8 ad=0.3465 pd=2.43 as=0.3465 ps=2.43 w=2.1 l=0.15
X108 vdd a_n1385_2474# a_n1463_5242# vdd sky130_fd_pr__pfet_01v8 ad=0.651 pd=4.82 as=0.3465 ps=2.43 w=2.1 l=0.15
X109 a_n1656_870# a_n2657_626# a_n1656_870# vss sky130_fd_pr__nfet_01v8 ad=0.261 pd=2.38 as=0.812 ps=7.34 w=0.9 l=0.18
X110 vdd t0 a_n2716_4460# vdd sky130_fd_pr__pfet_01v8 ad=0.58 pd=4.58 as=0.58 ps=4.58 w=2 l=0.18
X111 a_n81_1730# inn a_n881_180# vss sky130_fd_pr__nfet_01v8_lvt ad=0.5775 pd=3.83 as=1.085 ps=7.62 w=3.5 l=0.15
X112 a_2209_180# a_n2651_180# vdd vdd sky130_fd_pr__pfet_01v8 ad=0.3 pd=2.3 as=0.3 ps=2.3 w=2 l=0.18
X113 a_n2657_626# clk a_n81_1730# vdd sky130_fd_pr__pfet_01v8 ad=0.264 pd=1.93 as=0.264 ps=1.93 w=1.6 l=0.15
X114 vdd t5 a_n2651_180# vdd sky130_fd_pr__pfet_01v8 ad=0.59 pd=4.59 as=0.3 ps=2.3 w=2 l=0.18
X115 a_n81_1730# a_n1463_5242# a_n1385_2474# vss sky130_fd_pr__nfet_01v8_lvt ad=0.396 pd=2.73 as=0.396 ps=2.73 w=2.4 l=0.15
X116 vdd a_n2651_180# a_2209_180# vdd sky130_fd_pr__pfet_01v8 ad=0.59 pd=4.59 as=0.3 ps=2.3 w=2 l=0.18
X117 vdd a_n2355_780# a_2034_5310# vdd sky130_fd_pr__pfet_01v8 ad=0.3 pd=2.3 as=0.3 ps=2.3 w=2 l=0.18
X118 a_n2651_180# t5 vdd vdd sky130_fd_pr__pfet_01v8 ad=0.3 pd=2.3 as=0.3 ps=2.3 w=2 l=0.18
X119 vdd a_n1463_5242# a_n1385_2474# vdd sky130_fd_pr__pfet_01v8 ad=0.651 pd=4.82 as=0.3465 ps=2.43 w=2.1 l=0.15
X120 a_n1463_5242# a_n1385_2474# a_n2657_626# vss sky130_fd_pr__nfet_01v8_lvt ad=0.396 pd=2.73 as=0.396 ps=2.73 w=2.4 l=0.15
X121 vdd a_n493_4282# qn vss sky130_fd_pr__nfet_01v8_lvt ad=0.775 pd=5.62 as=0.4125 ps=2.83 w=2.5 l=0.15
X122 a_n1976_780# t3 vss vss sky130_fd_pr__nfet_01v8 ad=0.58 pd=4.58 as=0.58 ps=4.58 w=2 l=0.18
X123 vss clk a_n881_180# vss sky130_fd_pr__nfet_01v8_lvt ad=0.66 pd=4.33 as=0.66 ps=4.33 w=4 l=0.15
X124 qp a_n1433_5310# vdd vss sky130_fd_pr__nfet_01v8_lvt ad=0.4125 pd=2.83 as=0.775 ps=5.62 w=2.5 l=0.15
X125 vss a_n1656_870# a_1504_870# vss sky130_fd_pr__nfet_01v8 ad=0.29 pd=2.58 as=0.29 ps=2.58 w=1 l=0.18
X126 a_n2355_780# t4 vss vss sky130_fd_pr__nfet_01v8 ad=0.3 pd=2.3 as=0.59 ps=4.59 w=2 l=0.18
X127 vdd t4 a_n2355_780# vdd sky130_fd_pr__pfet_01v8 ad=0.59 pd=4.59 as=0.3 ps=2.3 w=2 l=0.18
X128 vdd qn qp vdd sky130_fd_pr__pfet_01v8 ad=0.372 pd=3.02 as=0.198 ps=1.53 w=1.2 l=0.15
X129 a_n2651_180# t5 vdd vdd sky130_fd_pr__pfet_01v8 ad=0.3 pd=2.3 as=0.59 ps=4.59 w=2 l=0.18
X130 a_n1463_5242# a_n1385_2474# vdd vdd sky130_fd_pr__pfet_01v8 ad=0.3465 pd=2.43 as=0.651 ps=4.82 w=2.1 l=0.15
X131 a_n1385_2474# clk a_n1463_5242# vdd sky130_fd_pr__pfet_01v8 ad=0.496 pd=3.82 as=0.264 ps=1.93 w=1.6 l=0.15
X132 vdd a_n1385_2474# a_n1463_5242# vdd sky130_fd_pr__pfet_01v8_lvt ad=0.464 pd=3.78 as=0.232 ps=1.89 w=1.6 l=0.35
X133 a_n1385_2474# a_n1463_5242# a_n81_1730# vss sky130_fd_pr__nfet_01v8_lvt ad=0.396 pd=2.73 as=0.396 ps=2.73 w=2.4 l=0.15
X134 vdd qp qn vdd sky130_fd_pr__pfet_01v8_lvt ad=0.29 pd=2.58 as=0.29 ps=2.58 w=1 l=0.35
X135 a_n881_180# inp a_n2657_626# vss sky130_fd_pr__nfet_01v8_lvt ad=1.085 pd=7.62 as=0.5775 ps=3.83 w=3.5 l=0.15
X136 vdd a_n1826_315# a_1674_315# vdd sky130_fd_pr__pfet_01v8 ad=0.58 pd=4.58 as=0.58 ps=4.58 w=2 l=0.18
X137 qp qn vss vss sky130_fd_pr__nfet_01v8_lvt ad=0.232 pd=2.18 as=0.232 ps=2.18 w=0.8 l=0.15
X138 qn a_n1433_5310# vss vss sky130_fd_pr__nfet_01v8_lvt ad=0.4125 pd=2.83 as=0.775 ps=5.62 w=2.5 l=0.15
X139 a_n881_180# inp a_n2657_626# vss sky130_fd_pr__nfet_01v8_lvt ad=0.5775 pd=3.83 as=0.5775 ps=3.83 w=3.5 l=0.15
X140 vdd a_n1656_870# a_1504_870# vdd sky130_fd_pr__pfet_01v8 ad=0.58 pd=4.58 as=0.58 ps=4.58 w=2 l=0.18
X141 a_n2657_626# inp a_n881_180# vss sky130_fd_pr__nfet_01v8_lvt ad=0.5775 pd=3.83 as=0.5775 ps=3.83 w=3.5 l=0.15
X142 a_n2355_780# t4 vdd vdd sky130_fd_pr__pfet_01v8 ad=0.3 pd=2.3 as=0.59 ps=4.59 w=2 l=0.18
X143 a_n2657_626# inp a_n881_180# vss sky130_fd_pr__nfet_01v8_lvt ad=0.5775 pd=3.83 as=1.085 ps=7.62 w=3.5 l=0.15
X144 qp a_n493_4282# vss vss sky130_fd_pr__nfet_01v8_lvt ad=0.4125 pd=2.83 as=0.775 ps=5.62 w=2.5 l=0.15
X145 a_2554_915# vdd vdd vdd sky130_fd_pr__pfet_01v8 ad=0.58 pd=4.58 as=0.58 ps=4.58 w=2 l=0.18
X146 a_n2657_626# a_n1385_2474# a_n1463_5242# vss sky130_fd_pr__nfet_01v8_lvt ad=0.396 pd=2.73 as=0.396 ps=2.73 w=2.4 l=0.15
X147 a_2209_180# a_n2651_180# vss vss sky130_fd_pr__nfet_01v8 ad=0.3 pd=2.3 as=0.59 ps=4.59 w=2 l=0.18
X148 qp qn vdd vdd sky130_fd_pr__pfet_01v8_lvt ad=0.29 pd=2.58 as=0.29 ps=2.58 w=1 l=0.35
X149 a_n493_4282# a_n1385_2474# vdd vdd sky130_fd_pr__pfet_01v8 ad=0.62 pd=4.62 as=0.33 ps=2.33 w=2 l=0.15
X150 a_1674_315# a_n81_1730# a_1674_315# vss sky130_fd_pr__nfet_01v8 ad=0.1305 pd=1.48 as=0.551 ps=5.54 w=0.45 l=0.18
X151 a_n1385_2474# a_n1463_5242# vdd vdd sky130_fd_pr__pfet_01v8_lvt ad=0.232 pd=1.89 as=0.464 ps=3.78 w=1.6 l=0.35
X152 vdd a_n2651_180# a_2209_180# vdd sky130_fd_pr__pfet_01v8 ad=0.3 pd=2.3 as=0.3 ps=2.3 w=2 l=0.18
X153 a_n1826_315# a_n2657_626# a_n1826_315# vss sky130_fd_pr__nfet_01v8 ad=0.1305 pd=1.48 as=0.551 ps=5.54 w=0.45 l=0.18
X154 a_n1433_5310# a_n1463_5242# vdd vdd sky130_fd_pr__pfet_01v8 ad=0.62 pd=4.62 as=0.33 ps=2.33 w=2 l=0.15
X155 vss t5 a_n2651_180# vss sky130_fd_pr__nfet_01v8 ad=0.59 pd=4.59 as=0.3 ps=2.3 w=2 l=0.18
X156 a_n1385_2474# a_n1463_5242# a_n81_1730# vss sky130_fd_pr__nfet_01v8_lvt ad=0.396 pd=2.73 as=0.744 ps=5.42 w=2.4 l=0.15
X157 a_n1385_2474# a_n1463_5242# vdd vdd sky130_fd_pr__pfet_01v8 ad=0.3465 pd=2.43 as=0.3465 ps=2.43 w=2.1 l=0.15
.ends
