* NGSPICE file created from serdes_rx_dt_slicer_5g_pdk.ext - technology: sky130A

.subckt serdes_rx_dt_slicer_5g_pdk inp inn clk qp qn t5 t4 t3 t2 t1 t0 vdd vss
X0 a_n2657_626# a_n1385_2474# a_n1463_5242# vss sky130_fd_pr__nfet_01v8_lvt ad=0.744 pd=5.42 as=0.396 ps=2.73 w=2.4 l=0.15
X1 a_n81_1730# clk vdd vdd sky130_fd_pr__pfet_01v8 ad=0.651 pd=4.82 as=0.3465 ps=2.43 w=2.1 l=0.15
X2 vss a_n2651_180# a_2209_180# vss sky130_fd_pr__nfet_01v8 ad=0.59 pd=4.59 as=0.3 ps=2.3 w=2 l=0.18
X3 a_2034_5310# a_n81_1730# a_2034_5310# vss sky130_fd_pr__nfet_01v8 ad=0.27 pd=2.1 as=2.202 ps=17.18 w=1.8 l=0.18
X4 vdd a_n1385_2474# a_n1463_5242# vdd sky130_fd_pr__pfet_01v8 ad=0.3465 pd=2.43 as=0.3465 ps=2.43 w=2.1 l=0.15
X5 a_2034_5310# a_n81_1730# a_2034_5310# vss sky130_fd_pr__nfet_01v8 ad=0.531 pd=4.19 as=0 ps=0 w=1.8 l=0.18
X6 vdd clk a_n2657_626# vdd sky130_fd_pr__pfet_01v8 ad=0.3465 pd=2.43 as=0.651 ps=4.82 w=2.1 l=0.15
X7 vss t4 a_n2355_780# vss sky130_fd_pr__nfet_01v8 ad=0.59 pd=4.59 as=0.3 ps=2.3 w=2 l=0.18
X8 a_n2355_780# a_n2657_626# a_n2355_780# vss sky130_fd_pr__nfet_01v8 ad=0.531 pd=4.19 as=2.202 ps=17.18 w=1.8 l=0.18
X9 a_n2355_780# a_n2657_626# a_n2355_780# vss sky130_fd_pr__nfet_01v8 ad=0.27 pd=2.1 as=0 ps=0 w=1.8 l=0.18
X10 vdd t5 a_n2651_180# vdd sky130_fd_pr__pfet_01v8 ad=0.3 pd=2.3 as=0.3 ps=2.3 w=2 l=0.18
X11 vdd a_n1463_5242# a_n1433_5310# vdd sky130_fd_pr__pfet_01v8_lvt ad=0.609 pd=4.78 as=0.609 ps=4.78 w=2.1 l=0.35
X12 vdd a_n1463_5242# a_n1385_2474# vdd sky130_fd_pr__pfet_01v8_lvt ad=0.464 pd=3.78 as=0.232 ps=1.89 w=1.6 l=0.35
X13 a_n81_1730# a_n1463_5242# a_n1385_2474# vss sky130_fd_pr__nfet_01v8_lvt ad=0.396 pd=2.73 as=0.396 ps=2.73 w=2.4 l=0.15
X14 a_n1826_315# t1 vss vss sky130_fd_pr__nfet_01v8 ad=0.29 pd=2.58 as=0.29 ps=2.58 w=1 l=0.18
X15 vdd a_n2355_780# a_2034_5310# vdd sky130_fd_pr__pfet_01v8 ad=0.59 pd=4.59 as=0.3 ps=2.3 w=2 l=0.18
X16 a_n2651_180# t5 vss vss sky130_fd_pr__nfet_01v8 ad=0.3 pd=2.3 as=0.59 ps=4.59 w=2 l=0.18
X17 a_n1976_780# t3 vdd vdd sky130_fd_pr__pfet_01v8 ad=0.3 pd=2.3 as=0.59 ps=4.59 w=2 l=0.18
X18 a_n1463_5242# a_n1385_2474# a_n2657_626# vss sky130_fd_pr__nfet_01v8_lvt ad=0.396 pd=2.73 as=0.396 ps=2.73 w=2.4 l=0.15
X19 vss a_n1385_2474# a_n493_4282# vss sky130_fd_pr__nfet_01v8_lvt ad=0.372 pd=3.02 as=0.198 ps=1.53 w=1.2 l=0.15
X20 vdd t4 a_n2355_780# vdd sky130_fd_pr__pfet_01v8 ad=0.3 pd=2.3 as=0.3 ps=2.3 w=2 l=0.18
X21 vss t0 a_n2716_4460# vss sky130_fd_pr__nfet_01v8 ad=0.29 pd=2.58 as=0.29 ps=2.58 w=1 l=0.18
X22 vss a_n493_4282# qp vss sky130_fd_pr__nfet_01v8_lvt ad=0.775 pd=5.62 as=0.4125 ps=2.83 w=2.5 l=0.15
X23 vdd a_n1385_2474# a_n493_4282# vdd sky130_fd_pr__pfet_01v8 ad=0.33 pd=2.33 as=0.33 ps=2.33 w=2 l=0.15
X24 a_2209_180# a_n2651_180# vdd vdd sky130_fd_pr__pfet_01v8 ad=0.3 pd=2.3 as=0.59 ps=4.59 w=2 l=0.18
X25 a_n1385_2474# clk vdd vdd sky130_fd_pr__pfet_01v8 ad=0.3465 pd=2.43 as=0.651 ps=4.82 w=2.1 l=0.15
X26 a_n493_4282# a_n1385_2474# vdd vdd sky130_fd_pr__pfet_01v8_lvt ad=0.609 pd=4.78 as=0.609 ps=4.78 w=2.1 l=0.35
X27 a_n1433_5310# a_n1463_5242# vss vss sky130_fd_pr__nfet_01v8_lvt ad=0.198 pd=1.53 as=0.372 ps=3.02 w=1.2 l=0.15
X28 vdd clk a_n1463_5242# vdd sky130_fd_pr__pfet_01v8 ad=0.651 pd=4.82 as=0.3465 ps=2.43 w=2.1 l=0.15
X29 a_n1385_2474# clk a_n1463_5242# vdd sky130_fd_pr__pfet_01v8 ad=0.264 pd=1.93 as=0.496 ps=3.82 w=1.6 l=0.15
X30 vdd clk a_n81_1730# vdd sky130_fd_pr__pfet_01v8 ad=0.3465 pd=2.43 as=0.3465 ps=2.43 w=2.1 l=0.15
X31 vdd a_n1463_5242# a_n1385_2474# vdd sky130_fd_pr__pfet_01v8 ad=0.3465 pd=2.43 as=0.3465 ps=2.43 w=2.1 l=0.15
X32 a_n1463_5242# a_n1385_2474# vdd vdd sky130_fd_pr__pfet_01v8 ad=0.3465 pd=2.43 as=0.3465 ps=2.43 w=2.1 l=0.15
X33 a_n1463_5242# a_n1385_2474# vdd vdd sky130_fd_pr__pfet_01v8_lvt ad=0.232 pd=1.89 as=0.464 ps=3.78 w=1.6 l=0.35
X34 a_n2657_626# clk vdd vdd sky130_fd_pr__pfet_01v8 ad=0.3465 pd=2.43 as=0.3465 ps=2.43 w=2.1 l=0.15
X35 vss a_n1976_780# a_1824_780# vss sky130_fd_pr__nfet_01v8 ad=0.58 pd=4.58 as=0.58 ps=4.58 w=2 l=0.18
X36 a_2209_180# a_n2651_180# vdd vdd sky130_fd_pr__pfet_01v8 ad=0.3 pd=2.3 as=0.3 ps=2.3 w=2 l=0.18
X37 a_n1463_5242# clk a_n1385_2474# vdd sky130_fd_pr__pfet_01v8 ad=0.264 pd=1.93 as=0.264 ps=1.93 w=1.6 l=0.15
X38 vss a_n2355_780# a_2034_5310# vss sky130_fd_pr__nfet_01v8 ad=0.59 pd=4.59 as=0.3 ps=2.3 w=2 l=0.18
X39 vdd t5 a_n2651_180# vdd sky130_fd_pr__pfet_01v8 ad=0.59 pd=4.59 as=0.3 ps=2.3 w=2 l=0.18
X40 a_2209_180# a_n81_1730# a_2209_180# vss sky130_fd_pr__nfet_01v8 ad=0.27 pd=2.1 as=3.882 ps=30.18 w=1.8 l=0.18
X41 vss a_n1826_315# a_1674_315# vss sky130_fd_pr__nfet_01v8 ad=0.29 pd=2.58 as=0.29 ps=2.58 w=1 l=0.18
X42 vdd a_n2651_180# a_2209_180# vdd sky130_fd_pr__pfet_01v8 ad=0.59 pd=4.59 as=0.3 ps=2.3 w=2 l=0.18
X43 vdd a_n1976_780# a_1824_780# vdd sky130_fd_pr__pfet_01v8 ad=0.59 pd=4.59 as=0.3 ps=2.3 w=2 l=0.18
X44 qn a_n493_4282# vdd vss sky130_fd_pr__nfet_01v8_lvt ad=0.4125 pd=2.83 as=0.775 ps=5.62 w=2.5 l=0.15
X45 a_2209_180# a_n81_1730# a_2209_180# vss sky130_fd_pr__nfet_01v8 ad=0.27 pd=2.1 as=0 ps=0 w=1.8 l=0.18
X46 a_n2651_180# a_n2657_626# a_n2651_180# vss sky130_fd_pr__nfet_01v8 ad=0.531 pd=4.19 as=3.882 ps=30.18 w=1.8 l=0.18
X47 a_n2651_180# t5 vdd vdd sky130_fd_pr__pfet_01v8 ad=0.3 pd=2.3 as=0.3 ps=2.3 w=2 l=0.18
X48 vdd a_n1433_5310# qp vss sky130_fd_pr__nfet_01v8_lvt ad=0.775 pd=5.62 as=0.4125 ps=2.83 w=2.5 l=0.15
X49 a_2209_180# a_n81_1730# a_2209_180# vss sky130_fd_pr__nfet_01v8 ad=0.27 pd=2.1 as=0 ps=0 w=1.8 l=0.18
X50 a_2209_180# a_n81_1730# a_2209_180# vss sky130_fd_pr__nfet_01v8 ad=0.531 pd=4.19 as=0 ps=0 w=1.8 l=0.18
X51 a_n2651_180# a_n2657_626# a_n2651_180# vss sky130_fd_pr__nfet_01v8 ad=0.27 pd=2.1 as=0 ps=0 w=1.8 l=0.18
X52 a_n1385_2474# a_n1463_5242# a_n81_1730# vss sky130_fd_pr__nfet_01v8_lvt ad=0.396 pd=2.73 as=0.396 ps=2.73 w=2.4 l=0.15
X53 a_n1433_5310# a_n1463_5242# vdd vdd sky130_fd_pr__pfet_01v8 ad=0.33 pd=2.33 as=0.62 ps=4.62 w=2 l=0.15
X54 vss t5 a_n2651_180# vss sky130_fd_pr__nfet_01v8 ad=0.3 pd=2.3 as=0.3 ps=2.3 w=2 l=0.18
X55 a_1824_780# a_n81_1730# a_1824_780# vss sky130_fd_pr__nfet_01v8 ad=0.522 pd=4.18 as=1.624 ps=12.94 w=1.8 l=0.18
X56 vdd t3 a_n1976_780# vdd sky130_fd_pr__pfet_01v8 ad=0.59 pd=4.59 as=0.3 ps=2.3 w=2 l=0.18
X57 a_n2657_626# a_n1385_2474# a_n1463_5242# vss sky130_fd_pr__nfet_01v8_lvt ad=0.396 pd=2.73 as=0.396 ps=2.73 w=2.4 l=0.15
X58 a_n2651_180# a_n2657_626# a_n2651_180# vss sky130_fd_pr__nfet_01v8 ad=0.27 pd=2.1 as=0 ps=0 w=1.8 l=0.18
X59 a_2554_915# vdd vss vss sky130_fd_pr__nfet_01v8 ad=0.29 pd=2.58 as=0.29 ps=2.58 w=1 l=0.18
X60 a_n493_4282# a_n1385_2474# vss vss sky130_fd_pr__nfet_01v8_lvt ad=0.198 pd=1.53 as=0.372 ps=3.02 w=1.2 l=0.15
X61 vdd qp qn vdd sky130_fd_pr__pfet_01v8 ad=0.372 pd=3.02 as=0.198 ps=1.53 w=1.2 l=0.15
X62 a_n2651_180# t5 vdd vdd sky130_fd_pr__pfet_01v8 ad=0.3 pd=2.3 as=0.59 ps=4.59 w=2 l=0.18
X63 a_n2355_780# t4 vdd vdd sky130_fd_pr__pfet_01v8 ad=0.3 pd=2.3 as=0.3 ps=2.3 w=2 l=0.18
X64 a_n81_1730# a_n1463_5242# a_n1385_2474# vss sky130_fd_pr__nfet_01v8_lvt ad=0.744 pd=5.42 as=0.396 ps=2.73 w=2.4 l=0.15
X65 a_n81_1730# clk a_n2657_626# vdd sky130_fd_pr__pfet_01v8 ad=0.496 pd=3.82 as=0.264 ps=1.93 w=1.6 l=0.15
X66 a_n881_180# clk vss vss sky130_fd_pr__nfet_01v8_lvt ad=0.66 pd=4.33 as=0.66 ps=4.33 w=4 l=0.15
X67 vss a_n1463_5242# a_n1433_5310# vss sky130_fd_pr__nfet_01v8_lvt ad=0.372 pd=3.02 as=0.198 ps=1.53 w=1.2 l=0.15
X68 a_n1463_5242# a_n1385_2474# a_n2657_626# vss sky130_fd_pr__nfet_01v8_lvt ad=0.396 pd=2.73 as=0.744 ps=5.42 w=2.4 l=0.15
X69 a_n81_1730# clk vdd vdd sky130_fd_pr__pfet_01v8 ad=0.3465 pd=2.43 as=0.651 ps=4.82 w=2.1 l=0.15
X70 vss clk a_n881_180# vss sky130_fd_pr__nfet_01v8_lvt ad=1.24 pd=8.62 as=0.66 ps=4.33 w=4 l=0.15
X71 vdd clk a_n2657_626# vdd sky130_fd_pr__pfet_01v8 ad=0.651 pd=4.82 as=0.3465 ps=2.43 w=2.1 l=0.15
X72 a_n881_180# clk vss vss sky130_fd_pr__nfet_01v8_lvt ad=0.66 pd=4.33 as=0.66 ps=4.33 w=4 l=0.15
X73 vdd a_n2651_180# a_2209_180# vdd sky130_fd_pr__pfet_01v8 ad=0.3 pd=2.3 as=0.3 ps=2.3 w=2 l=0.18
X74 a_2034_5310# a_n2355_780# vss vss sky130_fd_pr__nfet_01v8 ad=0.3 pd=2.3 as=0.59 ps=4.59 w=2 l=0.18
X75 a_n1385_2474# clk vdd vdd sky130_fd_pr__pfet_01v8 ad=0.651 pd=4.82 as=0.3465 ps=2.43 w=2.1 l=0.15
X76 a_1824_780# a_n1976_780# vdd vdd sky130_fd_pr__pfet_01v8 ad=0.3 pd=2.3 as=0.59 ps=4.59 w=2 l=0.18
X77 a_2209_180# a_n2651_180# vss vss sky130_fd_pr__nfet_01v8 ad=0.3 pd=2.3 as=0.3 ps=2.3 w=2 l=0.18
X78 a_n81_1730# inn a_n881_180# vss sky130_fd_pr__nfet_01v8_lvt ad=0.5775 pd=3.83 as=0.5775 ps=3.83 w=3.5 l=0.15
X79 vdd clk a_n1463_5242# vdd sky130_fd_pr__pfet_01v8 ad=0.3465 pd=2.43 as=0.651 ps=4.82 w=2.1 l=0.15
X80 a_n881_180# inn a_n81_1730# vss sky130_fd_pr__nfet_01v8_lvt ad=0.5775 pd=3.83 as=0.5775 ps=3.83 w=3.5 l=0.15
X81 vdd a_n1463_5242# a_n1433_5310# vdd sky130_fd_pr__pfet_01v8 ad=0.33 pd=2.33 as=0.33 ps=2.33 w=2 l=0.15
X82 a_n2651_180# t5 vss vss sky130_fd_pr__nfet_01v8 ad=0.3 pd=2.3 as=0.3 ps=2.3 w=2 l=0.18
X83 a_n881_180# inn a_n81_1730# vss sky130_fd_pr__nfet_01v8_lvt ad=1.085 pd=7.62 as=0.5775 ps=3.83 w=3.5 l=0.15
X84 a_n2651_180# a_n2657_626# a_n2651_180# vss sky130_fd_pr__nfet_01v8 ad=0.27 pd=2.1 as=0 ps=0 w=1.8 l=0.18
X85 qn qp vdd vdd sky130_fd_pr__pfet_01v8 ad=0.198 pd=1.53 as=0.372 ps=3.02 w=1.2 l=0.15
X86 a_2034_5310# a_n2355_780# vdd vdd sky130_fd_pr__pfet_01v8 ad=0.3 pd=2.3 as=0.3 ps=2.3 w=2 l=0.18
X87 vdd t5 a_n2651_180# vdd sky130_fd_pr__pfet_01v8 ad=0.3 pd=2.3 as=0.3 ps=2.3 w=2 l=0.18
X88 a_n881_180# clk vss vss sky130_fd_pr__nfet_01v8_lvt ad=0.66 pd=4.33 as=1.24 ps=8.62 w=4 l=0.15
X89 vss clk a_n881_180# vss sky130_fd_pr__nfet_01v8_lvt ad=0.66 pd=4.33 as=0.66 ps=4.33 w=4 l=0.15
X90 a_n1976_780# a_n2657_626# a_n1976_780# vss sky130_fd_pr__nfet_01v8 ad=0.522 pd=4.18 as=1.624 ps=12.94 w=1.8 l=0.18
X91 qp qn vdd vdd sky130_fd_pr__pfet_01v8 ad=0.198 pd=1.53 as=0.372 ps=3.02 w=1.2 l=0.15
X92 vss qp qn vss sky130_fd_pr__nfet_01v8_lvt ad=0.232 pd=2.18 as=0.232 ps=2.18 w=0.8 l=0.15
X93 a_n1656_870# t2 vss vss sky130_fd_pr__nfet_01v8 ad=0.29 pd=2.58 as=0.29 ps=2.58 w=1 l=0.18
X94 a_n493_4282# a_n1385_2474# vdd vdd sky130_fd_pr__pfet_01v8 ad=0.33 pd=2.33 as=0.62 ps=4.62 w=2 l=0.15
X95 a_2034_5310# a_n2355_780# vdd vdd sky130_fd_pr__pfet_01v8 ad=0.3 pd=2.3 as=0.59 ps=4.59 w=2 l=0.18
X96 vss a_n1433_5310# qn vss sky130_fd_pr__nfet_01v8_lvt ad=0.775 pd=5.62 as=0.4125 ps=2.83 w=2.5 l=0.15
X97 a_2554_915# a_n81_1730# a_2554_915# vss sky130_fd_pr__nfet_01v8 ad=0.1305 pd=1.48 as=0.551 ps=5.54 w=0.45 l=0.18
X98 a_2209_180# a_n2651_180# vdd vdd sky130_fd_pr__pfet_01v8 ad=0.3 pd=2.3 as=0.59 ps=4.59 w=2 l=0.18
X99 a_n1826_315# t1 vdd vdd sky130_fd_pr__pfet_01v8 ad=0.58 pd=4.58 as=0.58 ps=4.58 w=2 l=0.18
X100 a_n1385_2474# a_n1463_5242# vdd vdd sky130_fd_pr__pfet_01v8 ad=0.3465 pd=2.43 as=0.651 ps=4.82 w=2.1 l=0.15
X101 vdd clk a_n1385_2474# vdd sky130_fd_pr__pfet_01v8 ad=0.3465 pd=2.43 as=0.3465 ps=2.43 w=2.1 l=0.15
X102 a_n1656_870# t2 vdd vdd sky130_fd_pr__pfet_01v8 ad=0.58 pd=4.58 as=0.58 ps=4.58 w=2 l=0.18
X103 a_1504_870# a_n81_1730# a_1504_870# vss sky130_fd_pr__nfet_01v8 ad=0.261 pd=2.38 as=0.812 ps=7.34 w=0.9 l=0.18
X104 a_n2716_4460# a_n2657_626# a_n2716_4460# vss sky130_fd_pr__nfet_01v8 ad=0.1305 pd=1.48 as=0.551 ps=5.54 w=0.45 l=0.18
X105 a_n81_1730# clk a_n2657_626# vdd sky130_fd_pr__pfet_01v8 ad=0.264 pd=1.93 as=0.496 ps=3.82 w=1.6 l=0.15
X106 vss a_n2651_180# a_2209_180# vss sky130_fd_pr__nfet_01v8 ad=0.3 pd=2.3 as=0.3 ps=2.3 w=2 l=0.18
X107 a_n1463_5242# clk vdd vdd sky130_fd_pr__pfet_01v8 ad=0.3465 pd=2.43 as=0.3465 ps=2.43 w=2.1 l=0.15
X108 vdd a_n1385_2474# a_n1463_5242# vdd sky130_fd_pr__pfet_01v8 ad=0.651 pd=4.82 as=0.3465 ps=2.43 w=2.1 l=0.15
X109 a_n1656_870# a_n2657_626# a_n1656_870# vss sky130_fd_pr__nfet_01v8 ad=0.261 pd=2.38 as=0.812 ps=7.34 w=0.9 l=0.18
X110 vdd t0 a_n2716_4460# vdd sky130_fd_pr__pfet_01v8 ad=0.58 pd=4.58 as=0.58 ps=4.58 w=2 l=0.18
X111 a_n81_1730# inn a_n881_180# vss sky130_fd_pr__nfet_01v8_lvt ad=0.5775 pd=3.83 as=1.085 ps=7.62 w=3.5 l=0.15
X112 a_2209_180# a_n2651_180# vdd vdd sky130_fd_pr__pfet_01v8 ad=0.3 pd=2.3 as=0.3 ps=2.3 w=2 l=0.18
X113 a_n2657_626# clk a_n81_1730# vdd sky130_fd_pr__pfet_01v8 ad=0.264 pd=1.93 as=0.264 ps=1.93 w=1.6 l=0.15
X114 vdd t5 a_n2651_180# vdd sky130_fd_pr__pfet_01v8 ad=0.59 pd=4.59 as=0.3 ps=2.3 w=2 l=0.18
X115 a_n81_1730# a_n1463_5242# a_n1385_2474# vss sky130_fd_pr__nfet_01v8_lvt ad=0.396 pd=2.73 as=0.396 ps=2.73 w=2.4 l=0.15
X116 vdd a_n2651_180# a_2209_180# vdd sky130_fd_pr__pfet_01v8 ad=0.59 pd=4.59 as=0.3 ps=2.3 w=2 l=0.18
X117 vdd a_n2355_780# a_2034_5310# vdd sky130_fd_pr__pfet_01v8 ad=0.3 pd=2.3 as=0.3 ps=2.3 w=2 l=0.18
X118 a_n2651_180# t5 vdd vdd sky130_fd_pr__pfet_01v8 ad=0.3 pd=2.3 as=0.3 ps=2.3 w=2 l=0.18
X119 vdd a_n1463_5242# a_n1385_2474# vdd sky130_fd_pr__pfet_01v8 ad=0.651 pd=4.82 as=0.3465 ps=2.43 w=2.1 l=0.15
X120 a_n1463_5242# a_n1385_2474# a_n2657_626# vss sky130_fd_pr__nfet_01v8_lvt ad=0.396 pd=2.73 as=0.396 ps=2.73 w=2.4 l=0.15
X121 vdd a_n493_4282# qn vss sky130_fd_pr__nfet_01v8_lvt ad=0.775 pd=5.62 as=0.4125 ps=2.83 w=2.5 l=0.15
X122 a_n1976_780# t3 vss vss sky130_fd_pr__nfet_01v8 ad=0.58 pd=4.58 as=0.58 ps=4.58 w=2 l=0.18
X123 vss clk a_n881_180# vss sky130_fd_pr__nfet_01v8_lvt ad=0.66 pd=4.33 as=0.66 ps=4.33 w=4 l=0.15
X124 qp a_n1433_5310# vdd vss sky130_fd_pr__nfet_01v8_lvt ad=0.4125 pd=2.83 as=0.775 ps=5.62 w=2.5 l=0.15
X125 vss a_n1656_870# a_1504_870# vss sky130_fd_pr__nfet_01v8 ad=0.29 pd=2.58 as=0.29 ps=2.58 w=1 l=0.18
X126 a_n2355_780# t4 vss vss sky130_fd_pr__nfet_01v8 ad=0.3 pd=2.3 as=0.59 ps=4.59 w=2 l=0.18
X127 vdd t4 a_n2355_780# vdd sky130_fd_pr__pfet_01v8 ad=0.59 pd=4.59 as=0.3 ps=2.3 w=2 l=0.18
X128 vdd qn qp vdd sky130_fd_pr__pfet_01v8 ad=0.372 pd=3.02 as=0.198 ps=1.53 w=1.2 l=0.15
X129 a_n2651_180# t5 vdd vdd sky130_fd_pr__pfet_01v8 ad=0.3 pd=2.3 as=0.59 ps=4.59 w=2 l=0.18
X130 a_n1463_5242# a_n1385_2474# vdd vdd sky130_fd_pr__pfet_01v8 ad=0.3465 pd=2.43 as=0.651 ps=4.82 w=2.1 l=0.15
X131 a_n1385_2474# clk a_n1463_5242# vdd sky130_fd_pr__pfet_01v8 ad=0.496 pd=3.82 as=0.264 ps=1.93 w=1.6 l=0.15
X132 vdd a_n1385_2474# a_n1463_5242# vdd sky130_fd_pr__pfet_01v8_lvt ad=0.464 pd=3.78 as=0.232 ps=1.89 w=1.6 l=0.35
X133 a_n1385_2474# a_n1463_5242# a_n81_1730# vss sky130_fd_pr__nfet_01v8_lvt ad=0.396 pd=2.73 as=0.396 ps=2.73 w=2.4 l=0.15
X134 vdd qp qn vdd sky130_fd_pr__pfet_01v8_lvt ad=0.29 pd=2.58 as=0.29 ps=2.58 w=1 l=0.35
X135 a_n881_180# inp a_n2657_626# vss sky130_fd_pr__nfet_01v8_lvt ad=1.085 pd=7.62 as=0.5775 ps=3.83 w=3.5 l=0.15
X136 vdd a_n1826_315# a_1674_315# vdd sky130_fd_pr__pfet_01v8 ad=0.58 pd=4.58 as=0.58 ps=4.58 w=2 l=0.18
X137 qp qn vss vss sky130_fd_pr__nfet_01v8_lvt ad=0.232 pd=2.18 as=0.232 ps=2.18 w=0.8 l=0.15
X138 qn a_n1433_5310# vss vss sky130_fd_pr__nfet_01v8_lvt ad=0.4125 pd=2.83 as=0.775 ps=5.62 w=2.5 l=0.15
X139 a_n881_180# inp a_n2657_626# vss sky130_fd_pr__nfet_01v8_lvt ad=0.5775 pd=3.83 as=0.5775 ps=3.83 w=3.5 l=0.15
X140 vdd a_n1656_870# a_1504_870# vdd sky130_fd_pr__pfet_01v8 ad=0.58 pd=4.58 as=0.58 ps=4.58 w=2 l=0.18
X141 a_n2657_626# inp a_n881_180# vss sky130_fd_pr__nfet_01v8_lvt ad=0.5775 pd=3.83 as=0.5775 ps=3.83 w=3.5 l=0.15
X142 a_n2355_780# t4 vdd vdd sky130_fd_pr__pfet_01v8 ad=0.3 pd=2.3 as=0.59 ps=4.59 w=2 l=0.18
X143 a_n2657_626# inp a_n881_180# vss sky130_fd_pr__nfet_01v8_lvt ad=0.5775 pd=3.83 as=1.085 ps=7.62 w=3.5 l=0.15
X144 qp a_n493_4282# vss vss sky130_fd_pr__nfet_01v8_lvt ad=0.4125 pd=2.83 as=0.775 ps=5.62 w=2.5 l=0.15
X145 a_2554_915# vdd vdd vdd sky130_fd_pr__pfet_01v8 ad=0.58 pd=4.58 as=0.58 ps=4.58 w=2 l=0.18
X146 a_n2657_626# a_n1385_2474# a_n1463_5242# vss sky130_fd_pr__nfet_01v8_lvt ad=0.396 pd=2.73 as=0.396 ps=2.73 w=2.4 l=0.15
X147 a_2209_180# a_n2651_180# vss vss sky130_fd_pr__nfet_01v8 ad=0.3 pd=2.3 as=0.59 ps=4.59 w=2 l=0.18
X148 qp qn vdd vdd sky130_fd_pr__pfet_01v8_lvt ad=0.29 pd=2.58 as=0.29 ps=2.58 w=1 l=0.35
X149 a_n493_4282# a_n1385_2474# vdd vdd sky130_fd_pr__pfet_01v8 ad=0.62 pd=4.62 as=0.33 ps=2.33 w=2 l=0.15
X150 a_1674_315# a_n81_1730# a_1674_315# vss sky130_fd_pr__nfet_01v8 ad=0.1305 pd=1.48 as=0.551 ps=5.54 w=0.45 l=0.18
X151 a_n1385_2474# a_n1463_5242# vdd vdd sky130_fd_pr__pfet_01v8_lvt ad=0.232 pd=1.89 as=0.464 ps=3.78 w=1.6 l=0.35
X152 vdd a_n2651_180# a_2209_180# vdd sky130_fd_pr__pfet_01v8 ad=0.3 pd=2.3 as=0.3 ps=2.3 w=2 l=0.18
X153 a_n1826_315# a_n2657_626# a_n1826_315# vss sky130_fd_pr__nfet_01v8 ad=0.1305 pd=1.48 as=0.551 ps=5.54 w=0.45 l=0.18
X154 a_n1433_5310# a_n1463_5242# vdd vdd sky130_fd_pr__pfet_01v8 ad=0.62 pd=4.62 as=0.33 ps=2.33 w=2 l=0.15
X155 vss t5 a_n2651_180# vss sky130_fd_pr__nfet_01v8 ad=0.59 pd=4.59 as=0.3 ps=2.3 w=2 l=0.18
X156 a_n1385_2474# a_n1463_5242# a_n81_1730# vss sky130_fd_pr__nfet_01v8_lvt ad=0.396 pd=2.73 as=0.744 ps=5.42 w=2.4 l=0.15
X157 a_n1385_2474# a_n1463_5242# vdd vdd sky130_fd_pr__pfet_01v8 ad=0.3465 pd=2.43 as=0.3465 ps=2.43 w=2.1 l=0.15
C0 a_n2355_780# a_n2716_4460# 0.07905f
C1 a_n1826_315# a_1504_870# 0
C2 a_1674_315# a_1824_780# 0.55884f
C3 a_1824_780# a_n1656_870# 0.00808f
C4 a_2034_5310# a_1504_870# 0
C5 a_n1976_780# inn 0.0826f
C6 inn t5 0.09913f
C7 t1 a_n2651_180# 0.07368f
C8 a_n2355_780# a_n1433_5310# 0.15005f
C9 a_n1385_2474# a_n1826_315# 0.08635f
C10 qp a_n2651_180# 0.02935f
C11 clk vdd 2.58464f
C12 a_n2716_4460# a_n1463_5242# 0
C13 a_n1385_2474# a_2034_5310# 0
C14 a_n493_4282# a_n2355_780# 0.13603f
C15 a_n2657_626# t3 0.02151f
C16 a_n2657_626# t4 0.01459f
C17 a_n1433_5310# a_n1463_5242# 0.49292f
C18 a_n1976_780# vdd 1.44119f
C19 t5 vdd 1.34357f
C20 a_2034_5310# a_2209_180# 0.45027f
C21 a_1674_315# a_n2355_780# 0.07726f
C22 inp clk 0.24462f
C23 a_n2355_780# a_n1656_870# 0.61806f
C24 a_n493_4282# a_n1463_5242# 0.00807f
C25 a_n2657_626# t0 0.00802f
C26 a_n881_180# a_n2651_180# 0.00566f
C27 inp t5 0.06372f
C28 a_n1976_780# inp 0.07282f
C29 a_1674_315# a_n1463_5242# 0.00142f
C30 a_n1656_870# a_n1463_5242# 0.1134f
C31 a_n2716_4460# a_n2651_180# 0.67117f
C32 a_2554_915# a_n2355_780# 0.0269f
C33 a_n1385_2474# t4 0
C34 a_n1385_2474# t3 0
C35 a_n1433_5310# a_n2651_180# 0.02423f
C36 a_n1385_2474# t0 0
C37 a_2554_915# a_n1463_5242# 0
C38 a_n493_4282# a_n2651_180# 0.02115f
C39 a_1674_315# a_n2651_180# 0.0523f
C40 t1 clk 0.00153f
C41 a_n1656_870# a_n2651_180# 0.10972f
C42 qp clk 0
C43 a_2034_5310# a_n1826_315# 0.00717f
C44 t1 t5 0.00165f
C45 a_n2657_626# t2 0.23229f
C46 a_n1976_780# t1 0.13345f
C47 a_n1976_780# qp 0.15353f
C48 a_2554_915# a_n2651_180# 0.0289f
C49 inn a_n81_1730# 0.34502f
C50 a_n881_180# clk 0.4712f
C51 a_n1385_2474# t2 0.05525f
C52 t3 a_n1826_315# 0.06194f
C53 t4 a_n1826_315# 0.02553f
C54 a_1824_780# a_1504_870# 0.03806f
C55 qn vdd 2.05016f
C56 a_n1976_780# a_n881_180# 0.00152f
C57 t5 a_n881_180# 0
C58 a_n1433_5310# clk 0
C59 a_n1976_780# a_n2716_4460# 0
C60 a_n81_1730# vdd 1.84245f
C61 t5 a_n2716_4460# 0.02524f
C62 a_n2657_626# a_n2355_780# 0.17672f
C63 a_n1826_315# t0 0
C64 a_n1385_2474# a_1824_780# 0
C65 a_n493_4282# clk 0
C66 a_n1976_780# a_n1433_5310# 0.08824f
C67 a_n2657_626# a_n1463_5242# 1.59916f
C68 a_1824_780# a_2209_180# 0.01269f
C69 a_n81_1730# inp 0.11266f
C70 a_n1976_780# a_n493_4282# 0.08077f
C71 a_1674_315# clk 0
C72 a_n2355_780# a_1504_870# 0
C73 a_n1656_870# clk 0.00553f
C74 a_n1976_780# a_1674_315# 0.16483f
C75 a_n1385_2474# a_n2355_780# 0.0683f
C76 a_n1976_780# a_n1656_870# 0.74438f
C77 t5 a_n1656_870# 0.00153f
C78 a_1504_870# a_n1463_5242# 0.00619f
C79 t3 t4 0
C80 inn vdd 0.52762f
C81 a_2209_180# a_n2355_780# 0.00177f
C82 a_n1385_2474# a_n1463_5242# 1.95791f
C83 t4 t0 1.26336f
C84 a_n2657_626# a_n2651_180# 0.41754f
C85 a_2554_915# a_n1976_780# 0
C86 inn inp 1.46168f
C87 a_2209_180# a_n1463_5242# 0
C88 t2 a_n1826_315# 0.02068f
C89 qn t1 0.00247f
C90 qp qn 0.80081f
C91 a_1504_870# a_n2651_180# 0.00112f
C92 inp vdd 0.01865f
C93 a_n1385_2474# a_n2651_180# 0.06358f
C94 a_2034_5310# a_1824_780# 0.11771f
C95 a_2209_180# a_n2651_180# 0.52747f
C96 a_n2355_780# a_n1826_315# 0.47067f
C97 a_n81_1730# a_n881_180# 1.21519f
C98 t3 t2 0.01681f
C99 inn t1 0.06697f
C100 t4 t2 0
C101 a_2034_5310# a_n2355_780# 0.37382f
C102 qn a_n1433_5310# 0.17949f
C103 a_n1826_315# a_n1463_5242# 0.05991f
C104 a_n493_4282# qn 0.19285f
C105 t1 vdd 0.36982f
C106 a_n2657_626# clk 0.32415f
C107 a_2034_5310# a_n1463_5242# 0
C108 qp vdd 1.915f
C109 a_n493_4282# a_n81_1730# 0.00966f
C110 a_1674_315# qn 0
C111 a_n1976_780# a_n2657_626# 0.109f
C112 a_n2657_626# t5 0.02166f
C113 qn a_n1656_870# 0.1032f
C114 a_1674_315# a_n81_1730# 0.14805f
C115 inn a_n881_180# 0.19647f
C116 a_n81_1730# a_n1656_870# 0.22666f
C117 inp t1 0.06778f
C118 clk a_1504_870# 0.0055f
C119 inn a_n2716_4460# 0.0487f
C120 a_n2355_780# t3 0.02948f
C121 a_n2355_780# t4 0.42617f
C122 a_n1826_315# a_n2651_180# 0.07622f
C123 a_n1385_2474# clk 0.55462f
C124 a_n1976_780# a_1504_870# 0.00256f
C125 a_n2355_780# t0 0.02f
C126 a_n881_180# vdd 0.02207f
C127 a_2034_5310# a_n2651_180# 0.76047f
C128 a_2554_915# a_n81_1730# 0.03383f
C129 t3 a_n1463_5242# 0
C130 t4 a_n1463_5242# 0
C131 a_n2716_4460# vdd 0.80174f
C132 a_n1385_2474# t5 0
C133 a_n1976_780# a_n1385_2474# 0.0492f
C134 a_n1463_5242# t0 0
C135 a_n1433_5310# vdd 1.11282f
C136 a_1674_315# inn 0.053f
C137 inp a_n881_180# 0.24393f
C138 inn a_n1656_870# 0.05631f
C139 a_n1976_780# a_2209_180# 0.003f
C140 inp a_n2716_4460# 0.04953f
C141 a_n493_4282# vdd 1.3389f
C142 a_1674_315# vdd 0.66919f
C143 qp t1 0.00528f
C144 t3 a_n2651_180# 0.00887f
C145 a_n1656_870# vdd 1.05594f
C146 t4 a_n2651_180# 0.24677f
C147 a_2554_915# inn 0.0487f
C148 a_n2651_180# t0 0.24431f
C149 a_1674_315# inp 0.05236f
C150 a_2554_915# vdd 0.92672f
C151 inp a_n1656_870# 0.06213f
C152 a_n2355_780# t2 0
C153 clk a_n1826_315# 0
C154 t1 a_n881_180# 0.00245f
C155 a_1824_780# a_n2355_780# 0
C156 a_2034_5310# clk 0
C157 t2 a_n1463_5242# 0.02634f
C158 a_2554_915# inp 0.04953f
C159 t5 a_n1826_315# 0.00612f
C160 a_n1976_780# a_n1826_315# 0.7698f
C161 t1 a_n1433_5310# 0.02135f
C162 a_n2657_626# a_n81_1730# 0.50711f
C163 a_n1976_780# a_2034_5310# 0.0511f
C164 a_1824_780# a_n1463_5242# 0
C165 qp a_n1433_5310# 0.22582f
C166 a_n493_4282# t1 0.0022f
C167 qp a_n493_4282# 0.36872f
C168 a_n81_1730# a_1504_870# 0.34878f
C169 t2 a_n2651_180# 0.002f
C170 t1 a_n1656_870# 0.17238f
C171 a_1674_315# qp 0
C172 a_n1385_2474# qn 0.01701f
C173 t3 clk 0.0032f
C174 qp a_n1656_870# 0.10313f
C175 a_n2355_780# a_n1463_5242# 0.069f
C176 a_n1385_2474# a_n81_1730# 1.59724f
C177 a_1824_780# a_n2651_180# 0.00513f
C178 a_n1976_780# t3 0.27615f
C179 a_n1976_780# t4 0.01946f
C180 t5 t3 0.93097f
C181 a_n2657_626# inn 0.10685f
C182 t5 t4 0.83456f
C183 a_n1433_5310# a_n2716_4460# 0
C184 a_2209_180# a_n81_1730# 0.41584f
C185 a_n1976_780# t0 0
C186 t5 t0 0.02042f
C187 a_n2657_626# vdd 1.80765f
C188 a_1674_315# a_n881_180# 0.00674f
C189 inn a_1504_870# 0.05804f
C190 a_n1656_870# a_n881_180# 0
C191 a_n493_4282# a_n1433_5310# 0.2442f
C192 a_n1656_870# a_n2716_4460# 0
C193 a_n2355_780# a_n2651_180# 0.63511f
C194 a_n1385_2474# inn 0
C195 a_1674_315# a_n1433_5310# 0
C196 a_n1433_5310# a_n1656_870# 0.13242f
C197 a_1504_870# vdd 0.62494f
C198 a_n2657_626# inp 0.34892f
C199 a_1674_315# a_n493_4282# 0.08776f
C200 a_n2651_180# a_n1463_5242# 0.06426f
C201 a_2209_180# inn 0.06764f
C202 a_n493_4282# a_n1656_870# 0.12089f
C203 a_n1385_2474# vdd 4.16409f
C204 inp a_1504_870# 0.06025f
C205 a_1674_315# a_n1656_870# 0.10684f
C206 clk t2 0.13488f
C207 qn a_n1826_315# 0.16838f
C208 a_2209_180# vdd 1.72901f
C209 a_2554_915# a_n493_4282# 0
C210 a_n81_1730# a_n1826_315# 0
C211 a_n1385_2474# inp 0
C212 a_n1976_780# t2 0.01124f
C213 t5 t2 0.01123f
C214 a_1824_780# clk 0
C215 a_2034_5310# a_n81_1730# 0.17663f
C216 a_2554_915# a_n1656_870# 0
C217 a_2209_180# inp 0.06747f
C218 a_n1976_780# a_1824_780# 0.6334f
C219 a_n2657_626# t1 0.04024f
C220 a_n2355_780# clk 0
C221 inn a_n1826_315# 0.05142f
C222 a_2034_5310# inn 0.0635f
C223 a_n1976_780# a_n2355_780# 0.40563f
C224 a_n2355_780# t5 0.26659f
C225 clk a_n1463_5242# 0.40161f
C226 a_n1385_2474# t1 0.00633f
C227 a_n1826_315# vdd 1.66834f
C228 a_n1385_2474# qp 0.01047f
C229 a_n2657_626# a_n881_180# 1.21706f
C230 a_2034_5310# vdd 1.14972f
C231 a_n1976_780# a_n1463_5242# 0.04922f
C232 a_n2657_626# a_n2716_4460# 0.03383f
C233 t5 a_n1463_5242# 0
C234 a_n2657_626# a_n1433_5310# 0.00968f
C235 inp a_n1826_315# 0.05394f
C236 a_n881_180# a_1504_870# 0
C237 a_2034_5310# inp 0.08683f
C238 inn t3 0.10095f
C239 inn t4 0.05925f
C240 clk a_n2651_180# 0
C241 a_n1385_2474# a_n2716_4460# 0
C242 inn t0 0.069f
C243 a_n2657_626# a_n1656_870# 0.42954f
C244 a_n1976_780# a_n2651_180# 1.18662f
C245 t5 a_n2651_180# 0.55572f
C246 t3 vdd 0.51761f
C247 t4 vdd 0.62354f
C248 a_2209_180# a_n881_180# 0.00566f
C249 a_n1385_2474# a_n1433_5310# 0.00686f
C250 vdd t0 0.39388f
C251 a_n1385_2474# a_n493_4282# 0.5175f
C252 a_1674_315# a_1504_870# 0.42799f
C253 a_n81_1730# t2 0
C254 a_n1656_870# a_1504_870# 0.2666f
C255 inp t3 0.07188f
C256 inp t4 0.05983f
C257 a_1674_315# a_n1385_2474# 0.00616f
C258 t1 a_n1826_315# 0.2743f
C259 a_n1385_2474# a_n1656_870# 0.10128f
C260 inp t0 0.06956f
C261 qp a_n1826_315# 0.14722f
C262 a_1824_780# a_n81_1730# 0.10874f
C263 a_2034_5310# qp 0
C264 a_1674_315# a_2209_180# 0.0309f
C265 a_2209_180# a_n1656_870# 0
C266 a_2554_915# a_n1385_2474# 0
C267 a_n2355_780# qn 0.09724f
C268 inn t2 0.07226f
C269 a_n81_1730# a_n2355_780# 0
C270 a_2554_915# a_2209_180# 0.5621f
C271 a_n881_180# a_n1826_315# 0.00674f
C272 a_n2716_4460# a_n1826_315# 0
C273 qn a_n1463_5242# 0.00609f
C274 a_1824_780# inn 0.05969f
C275 a_2034_5310# a_n881_180# 0
C276 t1 t3 0.41995f
C277 t1 t4 0.12913f
C278 t2 vdd 0.55067f
C279 a_n1976_780# clk 0.00294f
C280 t5 clk 0
C281 a_n81_1730# a_n1463_5242# 0.35576f
C282 qp t4 0
C283 a_n1433_5310# a_n1826_315# 0.16032f
C284 t1 t0 0.0013f
C285 a_n1976_780# t5 0.03332f
C286 a_1824_780# vdd 0.59712f
C287 a_n493_4282# a_n1826_315# 0.18221f
C288 inp t2 0.0812f
C289 a_2034_5310# a_n493_4282# 0
C290 inn a_n2355_780# 0.06335f
C291 a_1674_315# a_n1826_315# 0.16869f
C292 a_n1656_870# a_n1826_315# 0.60575f
C293 qn a_n2651_180# 0.02932f
C294 a_1824_780# inp 0.06927f
C295 a_1674_315# a_2034_5310# 0.07722f
C296 t3 a_n881_180# 0.00112f
C297 t4 a_n881_180# 0
C298 a_n81_1730# a_n2651_180# 0.01042f
C299 a_2034_5310# a_n1656_870# 0
C300 t4 a_n2716_4460# 0.01953f
C301 inn a_n1463_5242# 0
C302 a_n2355_780# vdd 1.99229f
C303 a_2554_915# a_n1826_315# 0
C304 a_n2716_4460# t0 0.18282f
C305 a_n1433_5310# t4 0
C306 a_2554_915# a_2034_5310# 0.08954f
C307 vdd a_n1463_5242# 4.1766f
C308 a_n1433_5310# t0 0
C309 a_n1385_2474# a_n2657_626# 0.32922f
C310 a_n2355_780# inp 0.08698f
C311 t1 t2 0.84973f
C312 t3 a_n1656_870# 0.00453f
C313 t4 a_n1656_870# 0.00192f
C314 inn a_n2651_180# 0.09773f
C315 inp a_n1463_5242# 0
C316 a_n1385_2474# a_1504_870# 0
C317 a_n1656_870# t0 0
C318 vdd a_n2651_180# 3.31731f
C319 a_2209_180# a_1504_870# 0.00336f
C320 qn clk 0
C321 a_n881_180# t2 0.01913f
C322 a_n2716_4460# t2 0
C323 a_n81_1730# clk 0.29793f
C324 inp a_n2651_180# 0.07043f
C325 a_n2355_780# t1 0.12119f
C326 qp a_n2355_780# 0.10297f
C327 a_n1976_780# qn 0.1535f
C328 a_1824_780# a_n881_180# 0.00152f
C329 a_n1976_780# a_n81_1730# 0.00516f
C330 t1 a_n1463_5242# 0.06197f
C331 qp a_n1463_5242# 0.02113f
C332 a_n2657_626# a_n1826_315# 0.1481f
C333 a_n1656_870# t2 0.20222f
C334 a_n2355_780# a_n881_180# 0
C335 inn clk 0.31248f
C336 inn vss 1.10799f
C337 inp vss 1.62533f
C338 clk vss 2.68419f
C339 t2 vss 0.81411f
C340 t3 vss 0.71436f
C341 t5 vss 1.1956f
C342 qp vss 1.54509f
C343 qn vss 1.44156f
C344 t1 vss 1.23189f
C345 t4 vss 1.06429f
C346 t0 vss 1.79326f
C347 vdd vss 45.439f
C348 a_n881_180# vss 3.5289f
C349 a_2209_180# vss 1.37361f
C350 a_1504_870# vss 0.39082f
C351 a_1824_780# vss 0.54284f
C352 a_n81_1730# vss 3.04851f
C353 a_n1656_870# vss 1.81934f
C354 a_n1976_780# vss 2.19611f
C355 a_n2651_180# vss 4.60826f
C356 a_n2657_626# vss 3.08704f
C357 a_2554_915# vss 1.64229f
C358 a_2034_5310# vss 1.1649f
C359 a_1674_315# vss 0.98136f
C360 a_n493_4282# vss 1.27787f
C361 a_n1433_5310# vss 1.24067f
C362 a_n1826_315# vss 1.59169f
C363 a_n2355_780# vss 2.27199f
C364 a_n2716_4460# vss 1.60795f
C365 a_n1385_2474# vss 2.77603f
C366 a_n1463_5242# vss 3.00858f
.ends
