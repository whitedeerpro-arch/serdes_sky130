* Exact flattened LVS reference netlist for serdes_rx_dt_slicer_5g_pdk
* Source subckt: serdes_rx_dt_slicer_5g (analog/rx/cmos_rx/spice/rx_dt_sampler_5g.spice)
.subckt serdes_rx_dt_slicer_5g_pdk inp inn clk qp qn t5 t4 t3 t2 t1 t0 vdd vss
X1 t_Xcomp_Xtrim_tb0 t0 vss vss sky130_fd_pr__nfet_01v8 w=1 l=0.18
X2 t_Xcomp_Xtrim_tb0 t0 vdd vdd sky130_fd_pr__pfet_01v8 w=2 l=0.18
X3 t_Xcomp_Xtrim_tb1 t1 vss vss sky130_fd_pr__nfet_01v8 w=1 l=0.18
X4 t_Xcomp_Xtrim_tb1 t1 vdd vdd sky130_fd_pr__pfet_01v8 w=2 l=0.18
X5 t_Xcomp_Xtrim_tb2 t2 vss vss sky130_fd_pr__nfet_01v8 w=1 l=0.18
X6 t_Xcomp_Xtrim_tb2 t2 vdd vdd sky130_fd_pr__pfet_01v8 w=2 l=0.18
X7 t_Xcomp_Xtrim_tb3 t3 vss vss sky130_fd_pr__nfet_01v8 w=2 l=0.18
X8 t_Xcomp_Xtrim_tb3 t3 vdd vdd sky130_fd_pr__pfet_01v8 w=4 l=0.18
X9 t_Xcomp_Xtrim_tb4 t4 vss vss sky130_fd_pr__nfet_01v8 w=4 l=0.18
X10 t_Xcomp_Xtrim_tb4 t4 vdd vdd sky130_fd_pr__pfet_01v8 w=8 l=0.18
X11 t_Xcomp_Xtrim_tb5 t5 vss vss sky130_fd_pr__nfet_01v8 w=8 l=0.18
X12 t_Xcomp_Xtrim_tb5 t5 vdd vdd sky130_fd_pr__pfet_01v8 w=16 l=0.18
X13 t_Xcomp_Xtrim_td1 t_Xcomp_Xtrim_tb1 vss vss sky130_fd_pr__nfet_01v8 w=1 l=0.18
X14 t_Xcomp_Xtrim_td1 t_Xcomp_Xtrim_tb1 vdd vdd sky130_fd_pr__pfet_01v8 w=2 l=0.18
X15 t_Xcomp_Xtrim_td2 t_Xcomp_Xtrim_tb2 vss vss sky130_fd_pr__nfet_01v8 w=1 l=0.18
X16 t_Xcomp_Xtrim_td2 t_Xcomp_Xtrim_tb2 vdd vdd sky130_fd_pr__pfet_01v8 w=2 l=0.18
X17 t_Xcomp_Xtrim_td3 t_Xcomp_Xtrim_tb3 vss vss sky130_fd_pr__nfet_01v8 w=2 l=0.18
X18 t_Xcomp_Xtrim_td3 t_Xcomp_Xtrim_tb3 vdd vdd sky130_fd_pr__pfet_01v8 w=4 l=0.18
X19 t_Xcomp_Xtrim_td4 t_Xcomp_Xtrim_tb4 vss vss sky130_fd_pr__nfet_01v8 w=4 l=0.18
X20 t_Xcomp_Xtrim_td4 t_Xcomp_Xtrim_tb4 vdd vdd sky130_fd_pr__pfet_01v8 w=8 l=0.18
X21 t_Xcomp_Xtrim_td5 t_Xcomp_Xtrim_tb5 vss vss sky130_fd_pr__nfet_01v8 w=8 l=0.18
X22 t_Xcomp_Xtrim_td5 t_Xcomp_Xtrim_tb5 vdd vdd sky130_fd_pr__pfet_01v8 w=16 l=0.18
X23 t_Xcomp_Xtrim_r_on vdd vss vss sky130_fd_pr__nfet_01v8 w=1 l=0.18
X24 t_Xcomp_Xtrim_r_on vdd vdd vdd sky130_fd_pr__pfet_01v8 w=2 l=0.18
X25 t_Xcomp_Xtrim_tb0 t_Xcomp_fn t_Xcomp_Xtrim_tb0 vss sky130_fd_pr__nfet_01v8 w=0.45 l=0.18
X26 t_Xcomp_Xtrim_tb1 t_Xcomp_fn t_Xcomp_Xtrim_tb1 vss sky130_fd_pr__nfet_01v8 w=0.45 l=0.18
X27 t_Xcomp_Xtrim_tb2 t_Xcomp_fn t_Xcomp_Xtrim_tb2 vss sky130_fd_pr__nfet_01v8 w=0.9 l=0.18
X28 t_Xcomp_Xtrim_tb3 t_Xcomp_fn t_Xcomp_Xtrim_tb3 vss sky130_fd_pr__nfet_01v8 w=1.8 l=0.18
X29 t_Xcomp_Xtrim_tb4 t_Xcomp_fn t_Xcomp_Xtrim_tb4 vss sky130_fd_pr__nfet_01v8 w=3.6 l=0.18
X30 t_Xcomp_Xtrim_tb5 t_Xcomp_fn t_Xcomp_Xtrim_tb5 vss sky130_fd_pr__nfet_01v8 w=7.2 l=0.18
X31 t_Xcomp_Xtrim_r_on t_Xcomp_fp t_Xcomp_Xtrim_r_on vss sky130_fd_pr__nfet_01v8 w=0.45 l=0.18
X32 t_Xcomp_Xtrim_td1 t_Xcomp_fp t_Xcomp_Xtrim_td1 vss sky130_fd_pr__nfet_01v8 w=0.45 l=0.18
X33 t_Xcomp_Xtrim_td2 t_Xcomp_fp t_Xcomp_Xtrim_td2 vss sky130_fd_pr__nfet_01v8 w=0.9 l=0.18
X34 t_Xcomp_Xtrim_td3 t_Xcomp_fp t_Xcomp_Xtrim_td3 vss sky130_fd_pr__nfet_01v8 w=1.8 l=0.18
X35 t_Xcomp_Xtrim_td4 t_Xcomp_fp t_Xcomp_Xtrim_td4 vss sky130_fd_pr__nfet_01v8 w=3.6 l=0.18
X36 t_Xcomp_Xtrim_td5 t_Xcomp_fp t_Xcomp_Xtrim_td5 vss sky130_fd_pr__nfet_01v8 w=7.2 l=0.18
X37 t_Xcomp_tail clk vss vss sky130_fd_pr__nfet_01v8_lvt w=24 l=0.15
X38 t_Xcomp_fn inp t_Xcomp_tail vss sky130_fd_pr__nfet_01v8_lvt w=14 l=0.15
X39 t_Xcomp_fp inn t_Xcomp_tail vss sky130_fd_pr__nfet_01v8_lvt w=14 l=0.15
X40 t_Xcomp_fn clk vdd vdd sky130_fd_pr__pfet_01v8 w=6.3 l=0.15
X41 t_Xcomp_fp clk vdd vdd sky130_fd_pr__pfet_01v8 w=6.3 l=0.15
X42 t_Xcomp_fn clk t_Xcomp_fp vdd sky130_fd_pr__pfet_01v8 w=4.8 l=0.15
X43 t_outp_b t_outn_b t_Xcomp_fn vss sky130_fd_pr__nfet_01v8_lvt w=14.4 l=0.15
X44 t_outn_b t_outp_b t_Xcomp_fp vss sky130_fd_pr__nfet_01v8_lvt w=14.4 l=0.15
X45 t_outp_b t_outn_b vdd vdd sky130_fd_pr__pfet_01v8 w=8.4 l=0.15
X46 t_outp_b t_outn_b vdd vdd sky130_fd_pr__pfet_01v8_lvt w=3.2 l=0.35
X47 t_outn_b t_outp_b vdd vdd sky130_fd_pr__pfet_01v8 w=8.4 l=0.15
X48 t_outn_b t_outp_b vdd vdd sky130_fd_pr__pfet_01v8_lvt w=3.2 l=0.35
X49 t_outp_b clk vdd vdd sky130_fd_pr__pfet_01v8 w=6.3 l=0.15
X50 t_outn_b clk vdd vdd sky130_fd_pr__pfet_01v8 w=6.3 l=0.15
X51 t_outp_b clk t_outn_b vdd sky130_fd_pr__pfet_01v8 w=4.8 l=0.15
X52 t_Xsr_sp t_outp_b vss vss sky130_fd_pr__nfet_01v8_lvt w=2.4 l=0.15
X53 t_Xsr_sp t_outp_b vdd vdd sky130_fd_pr__pfet_01v8 w=6 l=0.15
X54 t_Xsr_sp t_outp_b vdd vdd sky130_fd_pr__pfet_01v8_lvt w=2.1 l=0.35
X55 t_Xsr_sn t_outn_b vss vss sky130_fd_pr__nfet_01v8_lvt w=2.4 l=0.15
X56 t_Xsr_sn t_outn_b vdd vdd sky130_fd_pr__pfet_01v8 w=6 l=0.15
X57 t_Xsr_sn t_outn_b vdd vdd sky130_fd_pr__pfet_01v8_lvt w=2.1 l=0.35
X58 qn t_Xsr_sp vss vss sky130_fd_pr__nfet_01v8_lvt w=5 l=0.15
X59 qp t_Xsr_sn vss vss sky130_fd_pr__nfet_01v8_lvt w=5 l=0.15
X60 vdd t_Xsr_sp qp vss sky130_fd_pr__nfet_01v8_lvt w=5 l=0.15
X61 vdd t_Xsr_sn qn vss sky130_fd_pr__nfet_01v8_lvt w=5 l=0.15
X62 qp qn vss vss sky130_fd_pr__nfet_01v8_lvt w=0.8 l=0.15
X63 qn qp vss vss sky130_fd_pr__nfet_01v8_lvt w=0.8 l=0.15
X64 qp qn vdd vdd sky130_fd_pr__pfet_01v8 w=2.4 l=0.15
X65 qp qn vdd vdd sky130_fd_pr__pfet_01v8_lvt w=1 l=0.35
X66 qn qp vdd vdd sky130_fd_pr__pfet_01v8 w=2.4 l=0.15
X67 qn qp vdd vdd sky130_fd_pr__pfet_01v8_lvt w=1 l=0.35
.ends serdes_rx_dt_slicer_5g_pdk
