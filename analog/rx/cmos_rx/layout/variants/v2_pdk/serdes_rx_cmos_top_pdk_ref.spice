* Exact flattened LVS reference netlist for serdes_rx_cmos_top_pdk
* Source subckt: serdes_rx_cmos_top (frozen analog/rx/cmos_rx/spice/*.spice)
.subckt serdes_rx_cmos_top_pdk rxp rxn vcm_ref ibias_ctle eq0 eq1 c0 c1 c2 c3 c4 c5 c6 c7 a0 a1 a2 a3 a4 a5 a6 a7 b0 b1 b2 b3 b4 b5 b6 b7 f0 f1 f2 f3 f4 f5 f6 f7 rst_n wd0 wd1 wd2 wd3 wd4 wd5 wd6 wd7 wd8 wd9 wd10 wd11 wd12 wd13 wd14 wd15 we0 we1 we2 we3 we4 we5 we6 we7 we8 we9 we10 we11 we12 we13 we14 we15 wclk ctle_p ctle_n vdd vss
X1 rxp vcm_ref vss sky130_fd_pr__res_high_po_5p73 l=2.34
X2 rxp vcm_ref vss sky130_fd_pr__res_high_po_5p73 l=2.34
X3 rxp vcm_ref vss sky130_fd_pr__res_high_po_5p73 l=2.34
X4 rxp vcm_ref vss sky130_fd_pr__res_high_po_5p73 l=2.34
X5 rxn vcm_ref vss sky130_fd_pr__res_high_po_5p73 l=2.34
X6 rxn vcm_ref vss sky130_fd_pr__res_high_po_5p73 l=2.34
X7 rxn vcm_ref vss sky130_fd_pr__res_high_po_5p73 l=2.34
X8 rxn vcm_ref vss sky130_fd_pr__res_high_po_5p73 l=2.34
X9 ibias_ctle ibias_ctle vss vss sky130_fd_pr__nfet_01v8_lvt w=8 l=0.5
X10 vdd ctle_p vss sky130_fd_pr__res_high_po_2p85 l=4.14
X11 vdd ctle_n vss sky130_fd_pr__res_high_po_2p85 l=4.14
X12 ctle_n rxp t_Xrx_Xctle_sp vss sky130_fd_pr__nfet_01v8_lvt w=24 l=0.15
X13 ctle_p rxn t_Xrx_Xctle_sn vss sky130_fd_pr__nfet_01v8_lvt w=24 l=0.15
X14 t_Xrx_Xctle_sp ibias_ctle vss vss sky130_fd_pr__nfet_01v8_lvt w=48 l=0.5
X15 t_Xrx_Xctle_sn ibias_ctle vss vss sky130_fd_pr__nfet_01v8_lvt w=48 l=0.5
X16 t_Xrx_Xctle_sp t_Xrx_Xctle_sn vss sky130_fd_pr__res_high_po_2p85 l=4.14
X17 t_Xrx_Xctle_eq0_b eq0 vss vss sky130_fd_pr__nfet_01v8 w=1 l=0.18
X18 t_Xrx_Xctle_eq0_b eq0 vdd vdd sky130_fd_pr__pfet_01v8 w=2 l=0.18
X19 t_Xrx_Xctle_eq1_b eq1 vss vss sky130_fd_pr__nfet_01v8 w=1 l=0.18
X20 t_Xrx_Xctle_eq1_b eq1 vdd vdd sky130_fd_pr__pfet_01v8 w=2 l=0.18
X21 t_Xrx_Xctle_sp t_Xrx_Xctle_cap0 sky130_fd_pr__cap_mim_m3_1 w=9.81 l=9.81
X22 t_Xrx_Xctle_sp t_Xrx_Xctle_cap1 sky130_fd_pr__cap_mim_m3_1 w=9.81 l=9.81
X23 t_Xrx_Xctle_sp t_Xrx_Xctle_cap1 sky130_fd_pr__cap_mim_m3_1 w=9.81 l=9.81
X24 t_Xrx_Xctle_cap0 eq0 t_Xrx_Xctle_sn vss sky130_fd_pr__nfet_01v8 w=4 l=0.18
X25 t_Xrx_Xctle_cap0 t_Xrx_Xctle_eq0_b t_Xrx_Xctle_sn vdd sky130_fd_pr__pfet_01v8 w=8 l=0.18
X26 t_Xrx_Xctle_cap1 eq1 t_Xrx_Xctle_sn vss sky130_fd_pr__nfet_01v8 w=4 l=0.18
X27 t_Xrx_Xctle_cap1 t_Xrx_Xctle_eq1_b t_Xrx_Xctle_sn vdd sky130_fd_pr__pfet_01v8 w=8 l=0.18
X28 t_Xrx_Xctle_cap0 t_Xrx_Xctle_eq0_b t_Xrx_Xctle_sp vss sky130_fd_pr__nfet_01v8 w=0.42 l=0.5
X29 t_Xrx_Xctle_cap1 t_Xrx_Xctle_eq1_b t_Xrx_Xctle_sp vss sky130_fd_pr__nfet_01v8 w=0.42 l=0.5
X30 t_Xrx_Xpi_Xpi_ab0 a0 vss vss sky130_fd_pr__nfet_01v8 w=0.45 l=0.18
X31 t_Xrx_Xpi_Xpi_ab0 a0 vdd vdd sky130_fd_pr__pfet_01v8 w=0.9 l=0.18
X32 t_Xrx_Xpi_Xpi_ab1 a1 vss vss sky130_fd_pr__nfet_01v8 w=0.45 l=0.18
X33 t_Xrx_Xpi_Xpi_ab1 a1 vdd vdd sky130_fd_pr__pfet_01v8 w=0.9 l=0.18
X34 t_Xrx_Xpi_Xpi_ab2 a2 vss vss sky130_fd_pr__nfet_01v8 w=0.45 l=0.18
X35 t_Xrx_Xpi_Xpi_ab2 a2 vdd vdd sky130_fd_pr__pfet_01v8 w=0.9 l=0.18
X36 t_Xrx_Xpi_Xpi_ab3 a3 vss vss sky130_fd_pr__nfet_01v8 w=0.45 l=0.18
X37 t_Xrx_Xpi_Xpi_ab3 a3 vdd vdd sky130_fd_pr__pfet_01v8 w=0.9 l=0.18
X38 t_Xrx_Xpi_Xpi_ab4 a4 vss vss sky130_fd_pr__nfet_01v8 w=0.45 l=0.18
X39 t_Xrx_Xpi_Xpi_ab4 a4 vdd vdd sky130_fd_pr__pfet_01v8 w=0.9 l=0.18
X40 t_Xrx_Xpi_Xpi_ab5 a5 vss vss sky130_fd_pr__nfet_01v8 w=0.45 l=0.18
X41 t_Xrx_Xpi_Xpi_ab5 a5 vdd vdd sky130_fd_pr__pfet_01v8 w=0.9 l=0.18
X42 t_Xrx_Xpi_Xpi_ab6 a6 vss vss sky130_fd_pr__nfet_01v8 w=0.45 l=0.18
X43 t_Xrx_Xpi_Xpi_ab6 a6 vdd vdd sky130_fd_pr__pfet_01v8 w=0.9 l=0.18
X44 t_Xrx_Xpi_Xpi_ab7 a7 vss vss sky130_fd_pr__nfet_01v8 w=0.45 l=0.18
X45 t_Xrx_Xpi_Xpi_ab7 a7 vdd vdd sky130_fd_pr__pfet_01v8 w=0.9 l=0.18
X46 t_Xrx_Xpi_Xpi_bb0 b0 vss vss sky130_fd_pr__nfet_01v8 w=0.45 l=0.18
X47 t_Xrx_Xpi_Xpi_bb0 b0 vdd vdd sky130_fd_pr__pfet_01v8 w=0.9 l=0.18
X48 t_Xrx_Xpi_Xpi_bb1 b1 vss vss sky130_fd_pr__nfet_01v8 w=0.45 l=0.18
X49 t_Xrx_Xpi_Xpi_bb1 b1 vdd vdd sky130_fd_pr__pfet_01v8 w=0.9 l=0.18
X50 t_Xrx_Xpi_Xpi_bb2 b2 vss vss sky130_fd_pr__nfet_01v8 w=0.45 l=0.18
X51 t_Xrx_Xpi_Xpi_bb2 b2 vdd vdd sky130_fd_pr__pfet_01v8 w=0.9 l=0.18
X52 t_Xrx_Xpi_Xpi_bb3 b3 vss vss sky130_fd_pr__nfet_01v8 w=0.45 l=0.18
X53 t_Xrx_Xpi_Xpi_bb3 b3 vdd vdd sky130_fd_pr__pfet_01v8 w=0.9 l=0.18
X54 t_Xrx_Xpi_Xpi_bb4 b4 vss vss sky130_fd_pr__nfet_01v8 w=0.45 l=0.18
X55 t_Xrx_Xpi_Xpi_bb4 b4 vdd vdd sky130_fd_pr__pfet_01v8 w=0.9 l=0.18
X56 t_Xrx_Xpi_Xpi_bb5 b5 vss vss sky130_fd_pr__nfet_01v8 w=0.45 l=0.18
X57 t_Xrx_Xpi_Xpi_bb5 b5 vdd vdd sky130_fd_pr__pfet_01v8 w=0.9 l=0.18
X58 t_Xrx_Xpi_Xpi_bb6 b6 vss vss sky130_fd_pr__nfet_01v8 w=0.45 l=0.18
X59 t_Xrx_Xpi_Xpi_bb6 b6 vdd vdd sky130_fd_pr__pfet_01v8 w=0.9 l=0.18
X60 t_Xrx_Xpi_Xpi_bb7 b7 vss vss sky130_fd_pr__nfet_01v8 w=0.45 l=0.18
X61 t_Xrx_Xpi_Xpi_bb7 b7 vdd vdd sky130_fd_pr__pfet_01v8 w=0.9 l=0.18
X62 t_Xrx_Xpi_Xpi_fb0 f0 vss vss sky130_fd_pr__nfet_01v8 w=0.45 l=0.18
X63 t_Xrx_Xpi_Xpi_fb0 f0 vdd vdd sky130_fd_pr__pfet_01v8 w=0.9 l=0.18
X64 t_Xrx_Xpi_Xpi_fb1 f1 vss vss sky130_fd_pr__nfet_01v8 w=0.45 l=0.18
X65 t_Xrx_Xpi_Xpi_fb1 f1 vdd vdd sky130_fd_pr__pfet_01v8 w=0.9 l=0.18
X66 t_Xrx_Xpi_Xpi_fb2 f2 vss vss sky130_fd_pr__nfet_01v8 w=0.45 l=0.18
X67 t_Xrx_Xpi_Xpi_fb2 f2 vdd vdd sky130_fd_pr__pfet_01v8 w=0.9 l=0.18
X68 t_Xrx_Xpi_Xpi_fb3 f3 vss vss sky130_fd_pr__nfet_01v8 w=0.45 l=0.18
X69 t_Xrx_Xpi_Xpi_fb3 f3 vdd vdd sky130_fd_pr__pfet_01v8 w=0.9 l=0.18
X70 t_Xrx_Xpi_Xpi_fb4 f4 vss vss sky130_fd_pr__nfet_01v8 w=0.45 l=0.18
X71 t_Xrx_Xpi_Xpi_fb4 f4 vdd vdd sky130_fd_pr__pfet_01v8 w=0.9 l=0.18
X72 t_Xrx_Xpi_Xpi_fb5 f5 vss vss sky130_fd_pr__nfet_01v8 w=0.45 l=0.18
X73 t_Xrx_Xpi_Xpi_fb5 f5 vdd vdd sky130_fd_pr__pfet_01v8 w=0.9 l=0.18
X74 t_Xrx_Xpi_Xpi_fb6 f6 vss vss sky130_fd_pr__nfet_01v8 w=0.45 l=0.18
X75 t_Xrx_Xpi_Xpi_fb6 f6 vdd vdd sky130_fd_pr__pfet_01v8 w=0.9 l=0.18
X76 t_Xrx_Xpi_Xpi_fb7 f7 vss vss sky130_fd_pr__nfet_01v8 w=0.45 l=0.18
X77 t_Xrx_Xpi_Xpi_fb7 f7 vdd vdd sky130_fd_pr__pfet_01v8 w=0.9 l=0.18
X78 t_Xrx_Xpi_Xpi_cb0 c0 vss vss sky130_fd_pr__nfet_01v8_lvt w=1 l=0.15
X79 t_Xrx_Xpi_Xpi_cb0 c0 vdd vdd sky130_fd_pr__pfet_01v8 w=2.8 l=0.15
X80 t_Xrx_Xpi_Xpi_cb1 c1 vss vss sky130_fd_pr__nfet_01v8_lvt w=1 l=0.15
X81 t_Xrx_Xpi_Xpi_cb1 c1 vdd vdd sky130_fd_pr__pfet_01v8 w=2.8 l=0.15
X82 t_Xrx_Xpi_Xpi_cb2 c2 vss vss sky130_fd_pr__nfet_01v8_lvt w=1 l=0.15
X83 t_Xrx_Xpi_Xpi_cb2 c2 vdd vdd sky130_fd_pr__pfet_01v8 w=2.8 l=0.15
X84 t_Xrx_Xpi_Xpi_cb3 c3 vss vss sky130_fd_pr__nfet_01v8_lvt w=1 l=0.15
X85 t_Xrx_Xpi_Xpi_cb3 c3 vdd vdd sky130_fd_pr__pfet_01v8 w=2.8 l=0.15
X86 t_Xrx_Xpi_Xpi_cb4 c4 vss vss sky130_fd_pr__nfet_01v8_lvt w=1 l=0.15
X87 t_Xrx_Xpi_Xpi_cb4 c4 vdd vdd sky130_fd_pr__pfet_01v8 w=2.8 l=0.15
X88 t_Xrx_Xpi_Xpi_cb5 c5 vss vss sky130_fd_pr__nfet_01v8_lvt w=1 l=0.15
X89 t_Xrx_Xpi_Xpi_cb5 c5 vdd vdd sky130_fd_pr__pfet_01v8 w=2.8 l=0.15
X90 t_Xrx_Xpi_Xpi_cb6 c6 vss vss sky130_fd_pr__nfet_01v8_lvt w=1 l=0.15
X91 t_Xrx_Xpi_Xpi_cb6 c6 vdd vdd sky130_fd_pr__pfet_01v8 w=2.8 l=0.15
X92 t_Xrx_Xpi_Xpi_cb7 c7 vss vss sky130_fd_pr__nfet_01v8_lvt w=1 l=0.15
X93 t_Xrx_Xpi_Xpi_cb7 c7 vdd vdd sky130_fd_pr__pfet_01v8 w=2.8 l=0.15
X94 t_Xrx_Xpi_Xpi_cb0 a0 t_Xrx_Xpi_Xpi_Xch_d_Xmap_m vss sky130_fd_pr__nfet_01v8_lvt w=1 l=0.15
X95 t_Xrx_Xpi_Xpi_cb0 t_Xrx_Xpi_Xpi_ab0 t_Xrx_Xpi_Xpi_Xch_d_Xmap_m vdd sky130_fd_pr__pfet_01v8_lvt w=1.8 l=0.35
X96 t_Xrx_Xpi_Xpi_cb2 a2 t_Xrx_Xpi_Xpi_Xch_d_Xmap_m vss sky130_fd_pr__nfet_01v8_lvt w=1 l=0.15
X97 t_Xrx_Xpi_Xpi_cb2 t_Xrx_Xpi_Xpi_ab2 t_Xrx_Xpi_Xpi_Xch_d_Xmap_m vdd sky130_fd_pr__pfet_01v8_lvt w=1.8 l=0.35
X98 t_Xrx_Xpi_Xpi_cb4 a4 t_Xrx_Xpi_Xpi_Xch_d_Xmap_m vss sky130_fd_pr__nfet_01v8_lvt w=1 l=0.15
X99 t_Xrx_Xpi_Xpi_cb4 t_Xrx_Xpi_Xpi_ab4 t_Xrx_Xpi_Xpi_Xch_d_Xmap_m vdd sky130_fd_pr__pfet_01v8_lvt w=1.8 l=0.35
X100 t_Xrx_Xpi_Xpi_cb6 a6 t_Xrx_Xpi_Xpi_Xch_d_Xmap_m vss sky130_fd_pr__nfet_01v8_lvt w=1 l=0.15
X101 t_Xrx_Xpi_Xpi_cb6 t_Xrx_Xpi_Xpi_ab6 t_Xrx_Xpi_Xpi_Xch_d_Xmap_m vdd sky130_fd_pr__pfet_01v8_lvt w=1.8 l=0.35
X102 t_Xrx_Xpi_Xpi_Xch_d_cap t_Xrx_Xpi_Xpi_Xch_d_Xmap_m vss vss sky130_fd_pr__nfet_01v8_lvt w=1.4 l=0.15
X103 t_Xrx_Xpi_Xpi_Xch_d_cap t_Xrx_Xpi_Xpi_Xch_d_Xmap_m vdd vdd sky130_fd_pr__pfet_01v8 w=3.3 l=0.15
X104 t_Xrx_Xpi_Xpi_cb4 a0 t_Xrx_Xpi_Xpi_Xch_d_Xman_m vss sky130_fd_pr__nfet_01v8_lvt w=1 l=0.15
X105 t_Xrx_Xpi_Xpi_cb4 t_Xrx_Xpi_Xpi_ab0 t_Xrx_Xpi_Xpi_Xch_d_Xman_m vdd sky130_fd_pr__pfet_01v8_lvt w=1.8 l=0.35
X106 t_Xrx_Xpi_Xpi_cb6 a2 t_Xrx_Xpi_Xpi_Xch_d_Xman_m vss sky130_fd_pr__nfet_01v8_lvt w=1 l=0.15
X107 t_Xrx_Xpi_Xpi_cb6 t_Xrx_Xpi_Xpi_ab2 t_Xrx_Xpi_Xpi_Xch_d_Xman_m vdd sky130_fd_pr__pfet_01v8_lvt w=1.8 l=0.35
X108 t_Xrx_Xpi_Xpi_cb0 a4 t_Xrx_Xpi_Xpi_Xch_d_Xman_m vss sky130_fd_pr__nfet_01v8_lvt w=1 l=0.15
X109 t_Xrx_Xpi_Xpi_cb0 t_Xrx_Xpi_Xpi_ab4 t_Xrx_Xpi_Xpi_Xch_d_Xman_m vdd sky130_fd_pr__pfet_01v8_lvt w=1.8 l=0.35
X110 t_Xrx_Xpi_Xpi_cb2 a6 t_Xrx_Xpi_Xpi_Xch_d_Xman_m vss sky130_fd_pr__nfet_01v8_lvt w=1 l=0.15
X111 t_Xrx_Xpi_Xpi_cb2 t_Xrx_Xpi_Xpi_ab6 t_Xrx_Xpi_Xpi_Xch_d_Xman_m vdd sky130_fd_pr__pfet_01v8_lvt w=1.8 l=0.35
X112 t_Xrx_Xpi_Xpi_Xch_d_can t_Xrx_Xpi_Xpi_Xch_d_Xman_m vss vss sky130_fd_pr__nfet_01v8_lvt w=1.4 l=0.15
X113 t_Xrx_Xpi_Xpi_Xch_d_can t_Xrx_Xpi_Xpi_Xch_d_Xman_m vdd vdd sky130_fd_pr__pfet_01v8 w=3.3 l=0.15
X114 t_Xrx_Xpi_Xpi_cb1 b1 t_Xrx_Xpi_Xpi_Xch_d_Xmbp_m vss sky130_fd_pr__nfet_01v8_lvt w=1 l=0.15
X115 t_Xrx_Xpi_Xpi_cb1 t_Xrx_Xpi_Xpi_bb1 t_Xrx_Xpi_Xpi_Xch_d_Xmbp_m vdd sky130_fd_pr__pfet_01v8_lvt w=1.8 l=0.35
X116 t_Xrx_Xpi_Xpi_cb3 b3 t_Xrx_Xpi_Xpi_Xch_d_Xmbp_m vss sky130_fd_pr__nfet_01v8_lvt w=1 l=0.15
X117 t_Xrx_Xpi_Xpi_cb3 t_Xrx_Xpi_Xpi_bb3 t_Xrx_Xpi_Xpi_Xch_d_Xmbp_m vdd sky130_fd_pr__pfet_01v8_lvt w=1.8 l=0.35
X118 t_Xrx_Xpi_Xpi_cb5 b5 t_Xrx_Xpi_Xpi_Xch_d_Xmbp_m vss sky130_fd_pr__nfet_01v8_lvt w=1 l=0.15
X119 t_Xrx_Xpi_Xpi_cb5 t_Xrx_Xpi_Xpi_bb5 t_Xrx_Xpi_Xpi_Xch_d_Xmbp_m vdd sky130_fd_pr__pfet_01v8_lvt w=1.8 l=0.35
X120 t_Xrx_Xpi_Xpi_cb7 b7 t_Xrx_Xpi_Xpi_Xch_d_Xmbp_m vss sky130_fd_pr__nfet_01v8_lvt w=1 l=0.15
X121 t_Xrx_Xpi_Xpi_cb7 t_Xrx_Xpi_Xpi_bb7 t_Xrx_Xpi_Xpi_Xch_d_Xmbp_m vdd sky130_fd_pr__pfet_01v8_lvt w=1.8 l=0.35
X122 t_Xrx_Xpi_Xpi_Xch_d_cbp t_Xrx_Xpi_Xpi_Xch_d_Xmbp_m vss vss sky130_fd_pr__nfet_01v8_lvt w=1.4 l=0.15
X123 t_Xrx_Xpi_Xpi_Xch_d_cbp t_Xrx_Xpi_Xpi_Xch_d_Xmbp_m vdd vdd sky130_fd_pr__pfet_01v8 w=3.3 l=0.15
X124 t_Xrx_Xpi_Xpi_cb5 b1 t_Xrx_Xpi_Xpi_Xch_d_Xmbn_m vss sky130_fd_pr__nfet_01v8_lvt w=1 l=0.15
X125 t_Xrx_Xpi_Xpi_cb5 t_Xrx_Xpi_Xpi_bb1 t_Xrx_Xpi_Xpi_Xch_d_Xmbn_m vdd sky130_fd_pr__pfet_01v8_lvt w=1.8 l=0.35
X126 t_Xrx_Xpi_Xpi_cb7 b3 t_Xrx_Xpi_Xpi_Xch_d_Xmbn_m vss sky130_fd_pr__nfet_01v8_lvt w=1 l=0.15
X127 t_Xrx_Xpi_Xpi_cb7 t_Xrx_Xpi_Xpi_bb3 t_Xrx_Xpi_Xpi_Xch_d_Xmbn_m vdd sky130_fd_pr__pfet_01v8_lvt w=1.8 l=0.35
X128 t_Xrx_Xpi_Xpi_cb1 b5 t_Xrx_Xpi_Xpi_Xch_d_Xmbn_m vss sky130_fd_pr__nfet_01v8_lvt w=1 l=0.15
X129 t_Xrx_Xpi_Xpi_cb1 t_Xrx_Xpi_Xpi_bb5 t_Xrx_Xpi_Xpi_Xch_d_Xmbn_m vdd sky130_fd_pr__pfet_01v8_lvt w=1.8 l=0.35
X130 t_Xrx_Xpi_Xpi_cb3 b7 t_Xrx_Xpi_Xpi_Xch_d_Xmbn_m vss sky130_fd_pr__nfet_01v8_lvt w=1 l=0.15
X131 t_Xrx_Xpi_Xpi_cb3 t_Xrx_Xpi_Xpi_bb7 t_Xrx_Xpi_Xpi_Xch_d_Xmbn_m vdd sky130_fd_pr__pfet_01v8_lvt w=1.8 l=0.35
X132 t_Xrx_Xpi_Xpi_Xch_d_cbn t_Xrx_Xpi_Xpi_Xch_d_Xmbn_m vss vss sky130_fd_pr__nfet_01v8_lvt w=1.4 l=0.15
X133 t_Xrx_Xpi_Xpi_Xch_d_cbn t_Xrx_Xpi_Xpi_Xch_d_Xmbn_m vdd vdd sky130_fd_pr__pfet_01v8 w=3.3 l=0.15
X134 t_Xrx_Xpi_Xpi_Xch_d_cap t_Xrx_Xpi_Xpi_fb0 t_Xrx_Xpi_Xpi_Xch_d_Xmixp_Xs0_sel vss sky130_fd_pr__nfet_01v8_lvt w=0.42 l=0.15
X135 t_Xrx_Xpi_Xpi_Xch_d_cap f0 t_Xrx_Xpi_Xpi_Xch_d_Xmixp_Xs0_sel vdd sky130_fd_pr__pfet_01v8_lvt w=0.75 l=0.35
X136 t_Xrx_Xpi_Xpi_Xch_d_cbp f0 t_Xrx_Xpi_Xpi_Xch_d_Xmixp_Xs0_sel vss sky130_fd_pr__nfet_01v8_lvt w=0.42 l=0.15
X137 t_Xrx_Xpi_Xpi_Xch_d_cbp t_Xrx_Xpi_Xpi_fb0 t_Xrx_Xpi_Xpi_Xch_d_Xmixp_Xs0_sel vdd sky130_fd_pr__pfet_01v8_lvt w=0.75 l=0.35
X138 t_Xrx_Xpi_Xpi_Xch_d_Xmixp_Xs0_drv t_Xrx_Xpi_Xpi_Xch_d_Xmixp_Xs0_sel vss vss sky130_fd_pr__nfet_01v8_lvt w=0.45 l=0.15
X139 t_Xrx_Xpi_Xpi_Xch_d_Xmixp_Xs0_drv t_Xrx_Xpi_Xpi_Xch_d_Xmixp_Xs0_sel vdd vdd sky130_fd_pr__pfet_01v8 w=1.35 l=0.15
X140 t_Xrx_Xpi_Xpi_Xch_d_Xmixp_Xs0_drv t_Xrx_Xpi_Xpi_Xch_d_mixp vss sky130_fd_pr__res_high_po_0p69 l=10.8
X141 t_Xrx_Xpi_Xpi_Xch_d_cap f0 t_Xrx_Xpi_Xpi_Xch_d_Xmixp_Xs0_dum vss sky130_fd_pr__nfet_01v8_lvt w=0.42 l=0.15
X142 t_Xrx_Xpi_Xpi_Xch_d_cap t_Xrx_Xpi_Xpi_fb0 t_Xrx_Xpi_Xpi_Xch_d_Xmixp_Xs0_dum vdd sky130_fd_pr__pfet_01v8_lvt w=0.75 l=0.35
X143 t_Xrx_Xpi_Xpi_Xch_d_cbp t_Xrx_Xpi_Xpi_fb0 t_Xrx_Xpi_Xpi_Xch_d_Xmixp_Xs0_dum vss sky130_fd_pr__nfet_01v8_lvt w=0.42 l=0.15
X144 t_Xrx_Xpi_Xpi_Xch_d_cbp f0 t_Xrx_Xpi_Xpi_Xch_d_Xmixp_Xs0_dum vdd sky130_fd_pr__pfet_01v8_lvt w=0.75 l=0.35
X145 vss t_Xrx_Xpi_Xpi_Xch_d_Xmixp_Xs0_dum vss vss sky130_fd_pr__nfet_01v8_lvt w=0.45 l=0.15
X146 vdd t_Xrx_Xpi_Xpi_Xch_d_Xmixp_Xs0_dum vdd vdd sky130_fd_pr__pfet_01v8 w=1.35 l=0.15
X147 t_Xrx_Xpi_Xpi_Xch_d_cap t_Xrx_Xpi_Xpi_fb1 t_Xrx_Xpi_Xpi_Xch_d_Xmixp_Xs1_sel vss sky130_fd_pr__nfet_01v8_lvt w=0.42 l=0.15
X148 t_Xrx_Xpi_Xpi_Xch_d_cap f1 t_Xrx_Xpi_Xpi_Xch_d_Xmixp_Xs1_sel vdd sky130_fd_pr__pfet_01v8_lvt w=0.75 l=0.35
X149 t_Xrx_Xpi_Xpi_Xch_d_cbp f1 t_Xrx_Xpi_Xpi_Xch_d_Xmixp_Xs1_sel vss sky130_fd_pr__nfet_01v8_lvt w=0.42 l=0.15
X150 t_Xrx_Xpi_Xpi_Xch_d_cbp t_Xrx_Xpi_Xpi_fb1 t_Xrx_Xpi_Xpi_Xch_d_Xmixp_Xs1_sel vdd sky130_fd_pr__pfet_01v8_lvt w=0.75 l=0.35
X151 t_Xrx_Xpi_Xpi_Xch_d_Xmixp_Xs1_drv t_Xrx_Xpi_Xpi_Xch_d_Xmixp_Xs1_sel vss vss sky130_fd_pr__nfet_01v8_lvt w=0.45 l=0.15
X152 t_Xrx_Xpi_Xpi_Xch_d_Xmixp_Xs1_drv t_Xrx_Xpi_Xpi_Xch_d_Xmixp_Xs1_sel vdd vdd sky130_fd_pr__pfet_01v8 w=1.35 l=0.15
X153 t_Xrx_Xpi_Xpi_Xch_d_Xmixp_Xs1_drv t_Xrx_Xpi_Xpi_Xch_d_mixp vss sky130_fd_pr__res_high_po_0p69 l=10.8
X154 t_Xrx_Xpi_Xpi_Xch_d_cap f1 t_Xrx_Xpi_Xpi_Xch_d_Xmixp_Xs1_dum vss sky130_fd_pr__nfet_01v8_lvt w=0.42 l=0.15
X155 t_Xrx_Xpi_Xpi_Xch_d_cap t_Xrx_Xpi_Xpi_fb1 t_Xrx_Xpi_Xpi_Xch_d_Xmixp_Xs1_dum vdd sky130_fd_pr__pfet_01v8_lvt w=0.75 l=0.35
X156 t_Xrx_Xpi_Xpi_Xch_d_cbp t_Xrx_Xpi_Xpi_fb1 t_Xrx_Xpi_Xpi_Xch_d_Xmixp_Xs1_dum vss sky130_fd_pr__nfet_01v8_lvt w=0.42 l=0.15
X157 t_Xrx_Xpi_Xpi_Xch_d_cbp f1 t_Xrx_Xpi_Xpi_Xch_d_Xmixp_Xs1_dum vdd sky130_fd_pr__pfet_01v8_lvt w=0.75 l=0.35
X158 vss t_Xrx_Xpi_Xpi_Xch_d_Xmixp_Xs1_dum vss vss sky130_fd_pr__nfet_01v8_lvt w=0.45 l=0.15
X159 vdd t_Xrx_Xpi_Xpi_Xch_d_Xmixp_Xs1_dum vdd vdd sky130_fd_pr__pfet_01v8 w=1.35 l=0.15
X160 t_Xrx_Xpi_Xpi_Xch_d_cap t_Xrx_Xpi_Xpi_fb2 t_Xrx_Xpi_Xpi_Xch_d_Xmixp_Xs2_sel vss sky130_fd_pr__nfet_01v8_lvt w=0.42 l=0.15
X161 t_Xrx_Xpi_Xpi_Xch_d_cap f2 t_Xrx_Xpi_Xpi_Xch_d_Xmixp_Xs2_sel vdd sky130_fd_pr__pfet_01v8_lvt w=0.75 l=0.35
X162 t_Xrx_Xpi_Xpi_Xch_d_cbp f2 t_Xrx_Xpi_Xpi_Xch_d_Xmixp_Xs2_sel vss sky130_fd_pr__nfet_01v8_lvt w=0.42 l=0.15
X163 t_Xrx_Xpi_Xpi_Xch_d_cbp t_Xrx_Xpi_Xpi_fb2 t_Xrx_Xpi_Xpi_Xch_d_Xmixp_Xs2_sel vdd sky130_fd_pr__pfet_01v8_lvt w=0.75 l=0.35
X164 t_Xrx_Xpi_Xpi_Xch_d_Xmixp_Xs2_drv t_Xrx_Xpi_Xpi_Xch_d_Xmixp_Xs2_sel vss vss sky130_fd_pr__nfet_01v8_lvt w=0.45 l=0.15
X165 t_Xrx_Xpi_Xpi_Xch_d_Xmixp_Xs2_drv t_Xrx_Xpi_Xpi_Xch_d_Xmixp_Xs2_sel vdd vdd sky130_fd_pr__pfet_01v8 w=1.35 l=0.15
X166 t_Xrx_Xpi_Xpi_Xch_d_Xmixp_Xs2_drv t_Xrx_Xpi_Xpi_Xch_d_mixp vss sky130_fd_pr__res_high_po_0p69 l=10.8
X167 t_Xrx_Xpi_Xpi_Xch_d_cap f2 t_Xrx_Xpi_Xpi_Xch_d_Xmixp_Xs2_dum vss sky130_fd_pr__nfet_01v8_lvt w=0.42 l=0.15
X168 t_Xrx_Xpi_Xpi_Xch_d_cap t_Xrx_Xpi_Xpi_fb2 t_Xrx_Xpi_Xpi_Xch_d_Xmixp_Xs2_dum vdd sky130_fd_pr__pfet_01v8_lvt w=0.75 l=0.35
X169 t_Xrx_Xpi_Xpi_Xch_d_cbp t_Xrx_Xpi_Xpi_fb2 t_Xrx_Xpi_Xpi_Xch_d_Xmixp_Xs2_dum vss sky130_fd_pr__nfet_01v8_lvt w=0.42 l=0.15
X170 t_Xrx_Xpi_Xpi_Xch_d_cbp f2 t_Xrx_Xpi_Xpi_Xch_d_Xmixp_Xs2_dum vdd sky130_fd_pr__pfet_01v8_lvt w=0.75 l=0.35
X171 vss t_Xrx_Xpi_Xpi_Xch_d_Xmixp_Xs2_dum vss vss sky130_fd_pr__nfet_01v8_lvt w=0.45 l=0.15
X172 vdd t_Xrx_Xpi_Xpi_Xch_d_Xmixp_Xs2_dum vdd vdd sky130_fd_pr__pfet_01v8 w=1.35 l=0.15
X173 t_Xrx_Xpi_Xpi_Xch_d_cap t_Xrx_Xpi_Xpi_fb3 t_Xrx_Xpi_Xpi_Xch_d_Xmixp_Xs3_sel vss sky130_fd_pr__nfet_01v8_lvt w=0.42 l=0.15
X174 t_Xrx_Xpi_Xpi_Xch_d_cap f3 t_Xrx_Xpi_Xpi_Xch_d_Xmixp_Xs3_sel vdd sky130_fd_pr__pfet_01v8_lvt w=0.75 l=0.35
X175 t_Xrx_Xpi_Xpi_Xch_d_cbp f3 t_Xrx_Xpi_Xpi_Xch_d_Xmixp_Xs3_sel vss sky130_fd_pr__nfet_01v8_lvt w=0.42 l=0.15
X176 t_Xrx_Xpi_Xpi_Xch_d_cbp t_Xrx_Xpi_Xpi_fb3 t_Xrx_Xpi_Xpi_Xch_d_Xmixp_Xs3_sel vdd sky130_fd_pr__pfet_01v8_lvt w=0.75 l=0.35
X177 t_Xrx_Xpi_Xpi_Xch_d_Xmixp_Xs3_drv t_Xrx_Xpi_Xpi_Xch_d_Xmixp_Xs3_sel vss vss sky130_fd_pr__nfet_01v8_lvt w=0.45 l=0.15
X178 t_Xrx_Xpi_Xpi_Xch_d_Xmixp_Xs3_drv t_Xrx_Xpi_Xpi_Xch_d_Xmixp_Xs3_sel vdd vdd sky130_fd_pr__pfet_01v8 w=1.35 l=0.15
X179 t_Xrx_Xpi_Xpi_Xch_d_Xmixp_Xs3_drv t_Xrx_Xpi_Xpi_Xch_d_mixp vss sky130_fd_pr__res_high_po_0p69 l=10.8
X180 t_Xrx_Xpi_Xpi_Xch_d_cap f3 t_Xrx_Xpi_Xpi_Xch_d_Xmixp_Xs3_dum vss sky130_fd_pr__nfet_01v8_lvt w=0.42 l=0.15
X181 t_Xrx_Xpi_Xpi_Xch_d_cap t_Xrx_Xpi_Xpi_fb3 t_Xrx_Xpi_Xpi_Xch_d_Xmixp_Xs3_dum vdd sky130_fd_pr__pfet_01v8_lvt w=0.75 l=0.35
X182 t_Xrx_Xpi_Xpi_Xch_d_cbp t_Xrx_Xpi_Xpi_fb3 t_Xrx_Xpi_Xpi_Xch_d_Xmixp_Xs3_dum vss sky130_fd_pr__nfet_01v8_lvt w=0.42 l=0.15
X183 t_Xrx_Xpi_Xpi_Xch_d_cbp f3 t_Xrx_Xpi_Xpi_Xch_d_Xmixp_Xs3_dum vdd sky130_fd_pr__pfet_01v8_lvt w=0.75 l=0.35
X184 vss t_Xrx_Xpi_Xpi_Xch_d_Xmixp_Xs3_dum vss vss sky130_fd_pr__nfet_01v8_lvt w=0.45 l=0.15
X185 vdd t_Xrx_Xpi_Xpi_Xch_d_Xmixp_Xs3_dum vdd vdd sky130_fd_pr__pfet_01v8 w=1.35 l=0.15
X186 t_Xrx_Xpi_Xpi_Xch_d_cap t_Xrx_Xpi_Xpi_fb4 t_Xrx_Xpi_Xpi_Xch_d_Xmixp_Xs4_sel vss sky130_fd_pr__nfet_01v8_lvt w=0.42 l=0.15
X187 t_Xrx_Xpi_Xpi_Xch_d_cap f4 t_Xrx_Xpi_Xpi_Xch_d_Xmixp_Xs4_sel vdd sky130_fd_pr__pfet_01v8_lvt w=0.75 l=0.35
X188 t_Xrx_Xpi_Xpi_Xch_d_cbp f4 t_Xrx_Xpi_Xpi_Xch_d_Xmixp_Xs4_sel vss sky130_fd_pr__nfet_01v8_lvt w=0.42 l=0.15
X189 t_Xrx_Xpi_Xpi_Xch_d_cbp t_Xrx_Xpi_Xpi_fb4 t_Xrx_Xpi_Xpi_Xch_d_Xmixp_Xs4_sel vdd sky130_fd_pr__pfet_01v8_lvt w=0.75 l=0.35
X190 t_Xrx_Xpi_Xpi_Xch_d_Xmixp_Xs4_drv t_Xrx_Xpi_Xpi_Xch_d_Xmixp_Xs4_sel vss vss sky130_fd_pr__nfet_01v8_lvt w=0.45 l=0.15
X191 t_Xrx_Xpi_Xpi_Xch_d_Xmixp_Xs4_drv t_Xrx_Xpi_Xpi_Xch_d_Xmixp_Xs4_sel vdd vdd sky130_fd_pr__pfet_01v8 w=1.35 l=0.15
X192 t_Xrx_Xpi_Xpi_Xch_d_Xmixp_Xs4_drv t_Xrx_Xpi_Xpi_Xch_d_mixp vss sky130_fd_pr__res_high_po_0p69 l=10.8
X193 t_Xrx_Xpi_Xpi_Xch_d_cap f4 t_Xrx_Xpi_Xpi_Xch_d_Xmixp_Xs4_dum vss sky130_fd_pr__nfet_01v8_lvt w=0.42 l=0.15
X194 t_Xrx_Xpi_Xpi_Xch_d_cap t_Xrx_Xpi_Xpi_fb4 t_Xrx_Xpi_Xpi_Xch_d_Xmixp_Xs4_dum vdd sky130_fd_pr__pfet_01v8_lvt w=0.75 l=0.35
X195 t_Xrx_Xpi_Xpi_Xch_d_cbp t_Xrx_Xpi_Xpi_fb4 t_Xrx_Xpi_Xpi_Xch_d_Xmixp_Xs4_dum vss sky130_fd_pr__nfet_01v8_lvt w=0.42 l=0.15
X196 t_Xrx_Xpi_Xpi_Xch_d_cbp f4 t_Xrx_Xpi_Xpi_Xch_d_Xmixp_Xs4_dum vdd sky130_fd_pr__pfet_01v8_lvt w=0.75 l=0.35
X197 vss t_Xrx_Xpi_Xpi_Xch_d_Xmixp_Xs4_dum vss vss sky130_fd_pr__nfet_01v8_lvt w=0.45 l=0.15
X198 vdd t_Xrx_Xpi_Xpi_Xch_d_Xmixp_Xs4_dum vdd vdd sky130_fd_pr__pfet_01v8 w=1.35 l=0.15
X199 t_Xrx_Xpi_Xpi_Xch_d_cap t_Xrx_Xpi_Xpi_fb5 t_Xrx_Xpi_Xpi_Xch_d_Xmixp_Xs5_sel vss sky130_fd_pr__nfet_01v8_lvt w=0.42 l=0.15
X200 t_Xrx_Xpi_Xpi_Xch_d_cap f5 t_Xrx_Xpi_Xpi_Xch_d_Xmixp_Xs5_sel vdd sky130_fd_pr__pfet_01v8_lvt w=0.75 l=0.35
X201 t_Xrx_Xpi_Xpi_Xch_d_cbp f5 t_Xrx_Xpi_Xpi_Xch_d_Xmixp_Xs5_sel vss sky130_fd_pr__nfet_01v8_lvt w=0.42 l=0.15
X202 t_Xrx_Xpi_Xpi_Xch_d_cbp t_Xrx_Xpi_Xpi_fb5 t_Xrx_Xpi_Xpi_Xch_d_Xmixp_Xs5_sel vdd sky130_fd_pr__pfet_01v8_lvt w=0.75 l=0.35
X203 t_Xrx_Xpi_Xpi_Xch_d_Xmixp_Xs5_drv t_Xrx_Xpi_Xpi_Xch_d_Xmixp_Xs5_sel vss vss sky130_fd_pr__nfet_01v8_lvt w=0.45 l=0.15
X204 t_Xrx_Xpi_Xpi_Xch_d_Xmixp_Xs5_drv t_Xrx_Xpi_Xpi_Xch_d_Xmixp_Xs5_sel vdd vdd sky130_fd_pr__pfet_01v8 w=1.35 l=0.15
X205 t_Xrx_Xpi_Xpi_Xch_d_Xmixp_Xs5_drv t_Xrx_Xpi_Xpi_Xch_d_mixp vss sky130_fd_pr__res_high_po_0p69 l=10.8
X206 t_Xrx_Xpi_Xpi_Xch_d_cap f5 t_Xrx_Xpi_Xpi_Xch_d_Xmixp_Xs5_dum vss sky130_fd_pr__nfet_01v8_lvt w=0.42 l=0.15
X207 t_Xrx_Xpi_Xpi_Xch_d_cap t_Xrx_Xpi_Xpi_fb5 t_Xrx_Xpi_Xpi_Xch_d_Xmixp_Xs5_dum vdd sky130_fd_pr__pfet_01v8_lvt w=0.75 l=0.35
X208 t_Xrx_Xpi_Xpi_Xch_d_cbp t_Xrx_Xpi_Xpi_fb5 t_Xrx_Xpi_Xpi_Xch_d_Xmixp_Xs5_dum vss sky130_fd_pr__nfet_01v8_lvt w=0.42 l=0.15
X209 t_Xrx_Xpi_Xpi_Xch_d_cbp f5 t_Xrx_Xpi_Xpi_Xch_d_Xmixp_Xs5_dum vdd sky130_fd_pr__pfet_01v8_lvt w=0.75 l=0.35
X210 vss t_Xrx_Xpi_Xpi_Xch_d_Xmixp_Xs5_dum vss vss sky130_fd_pr__nfet_01v8_lvt w=0.45 l=0.15
X211 vdd t_Xrx_Xpi_Xpi_Xch_d_Xmixp_Xs5_dum vdd vdd sky130_fd_pr__pfet_01v8 w=1.35 l=0.15
X212 t_Xrx_Xpi_Xpi_Xch_d_cap t_Xrx_Xpi_Xpi_fb6 t_Xrx_Xpi_Xpi_Xch_d_Xmixp_Xs6_sel vss sky130_fd_pr__nfet_01v8_lvt w=0.42 l=0.15
X213 t_Xrx_Xpi_Xpi_Xch_d_cap f6 t_Xrx_Xpi_Xpi_Xch_d_Xmixp_Xs6_sel vdd sky130_fd_pr__pfet_01v8_lvt w=0.75 l=0.35
X214 t_Xrx_Xpi_Xpi_Xch_d_cbp f6 t_Xrx_Xpi_Xpi_Xch_d_Xmixp_Xs6_sel vss sky130_fd_pr__nfet_01v8_lvt w=0.42 l=0.15
X215 t_Xrx_Xpi_Xpi_Xch_d_cbp t_Xrx_Xpi_Xpi_fb6 t_Xrx_Xpi_Xpi_Xch_d_Xmixp_Xs6_sel vdd sky130_fd_pr__pfet_01v8_lvt w=0.75 l=0.35
X216 t_Xrx_Xpi_Xpi_Xch_d_Xmixp_Xs6_drv t_Xrx_Xpi_Xpi_Xch_d_Xmixp_Xs6_sel vss vss sky130_fd_pr__nfet_01v8_lvt w=0.45 l=0.15
X217 t_Xrx_Xpi_Xpi_Xch_d_Xmixp_Xs6_drv t_Xrx_Xpi_Xpi_Xch_d_Xmixp_Xs6_sel vdd vdd sky130_fd_pr__pfet_01v8 w=1.35 l=0.15
X218 t_Xrx_Xpi_Xpi_Xch_d_Xmixp_Xs6_drv t_Xrx_Xpi_Xpi_Xch_d_mixp vss sky130_fd_pr__res_high_po_0p69 l=10.8
X219 t_Xrx_Xpi_Xpi_Xch_d_cap f6 t_Xrx_Xpi_Xpi_Xch_d_Xmixp_Xs6_dum vss sky130_fd_pr__nfet_01v8_lvt w=0.42 l=0.15
X220 t_Xrx_Xpi_Xpi_Xch_d_cap t_Xrx_Xpi_Xpi_fb6 t_Xrx_Xpi_Xpi_Xch_d_Xmixp_Xs6_dum vdd sky130_fd_pr__pfet_01v8_lvt w=0.75 l=0.35
X221 t_Xrx_Xpi_Xpi_Xch_d_cbp t_Xrx_Xpi_Xpi_fb6 t_Xrx_Xpi_Xpi_Xch_d_Xmixp_Xs6_dum vss sky130_fd_pr__nfet_01v8_lvt w=0.42 l=0.15
X222 t_Xrx_Xpi_Xpi_Xch_d_cbp f6 t_Xrx_Xpi_Xpi_Xch_d_Xmixp_Xs6_dum vdd sky130_fd_pr__pfet_01v8_lvt w=0.75 l=0.35
X223 vss t_Xrx_Xpi_Xpi_Xch_d_Xmixp_Xs6_dum vss vss sky130_fd_pr__nfet_01v8_lvt w=0.45 l=0.15
X224 vdd t_Xrx_Xpi_Xpi_Xch_d_Xmixp_Xs6_dum vdd vdd sky130_fd_pr__pfet_01v8 w=1.35 l=0.15
X225 t_Xrx_Xpi_Xpi_Xch_d_cap t_Xrx_Xpi_Xpi_fb7 t_Xrx_Xpi_Xpi_Xch_d_Xmixp_Xs7_sel vss sky130_fd_pr__nfet_01v8_lvt w=0.42 l=0.15
X226 t_Xrx_Xpi_Xpi_Xch_d_cap f7 t_Xrx_Xpi_Xpi_Xch_d_Xmixp_Xs7_sel vdd sky130_fd_pr__pfet_01v8_lvt w=0.75 l=0.35
X227 t_Xrx_Xpi_Xpi_Xch_d_cbp f7 t_Xrx_Xpi_Xpi_Xch_d_Xmixp_Xs7_sel vss sky130_fd_pr__nfet_01v8_lvt w=0.42 l=0.15
X228 t_Xrx_Xpi_Xpi_Xch_d_cbp t_Xrx_Xpi_Xpi_fb7 t_Xrx_Xpi_Xpi_Xch_d_Xmixp_Xs7_sel vdd sky130_fd_pr__pfet_01v8_lvt w=0.75 l=0.35
X229 t_Xrx_Xpi_Xpi_Xch_d_Xmixp_Xs7_drv t_Xrx_Xpi_Xpi_Xch_d_Xmixp_Xs7_sel vss vss sky130_fd_pr__nfet_01v8_lvt w=0.45 l=0.15
X230 t_Xrx_Xpi_Xpi_Xch_d_Xmixp_Xs7_drv t_Xrx_Xpi_Xpi_Xch_d_Xmixp_Xs7_sel vdd vdd sky130_fd_pr__pfet_01v8 w=1.35 l=0.15
X231 t_Xrx_Xpi_Xpi_Xch_d_Xmixp_Xs7_drv t_Xrx_Xpi_Xpi_Xch_d_mixp vss sky130_fd_pr__res_high_po_0p69 l=10.8
X232 t_Xrx_Xpi_Xpi_Xch_d_cap f7 t_Xrx_Xpi_Xpi_Xch_d_Xmixp_Xs7_dum vss sky130_fd_pr__nfet_01v8_lvt w=0.42 l=0.15
X233 t_Xrx_Xpi_Xpi_Xch_d_cap t_Xrx_Xpi_Xpi_fb7 t_Xrx_Xpi_Xpi_Xch_d_Xmixp_Xs7_dum vdd sky130_fd_pr__pfet_01v8_lvt w=0.75 l=0.35
X234 t_Xrx_Xpi_Xpi_Xch_d_cbp t_Xrx_Xpi_Xpi_fb7 t_Xrx_Xpi_Xpi_Xch_d_Xmixp_Xs7_dum vss sky130_fd_pr__nfet_01v8_lvt w=0.42 l=0.15
X235 t_Xrx_Xpi_Xpi_Xch_d_cbp f7 t_Xrx_Xpi_Xpi_Xch_d_Xmixp_Xs7_dum vdd sky130_fd_pr__pfet_01v8_lvt w=0.75 l=0.35
X236 vss t_Xrx_Xpi_Xpi_Xch_d_Xmixp_Xs7_dum vss vss sky130_fd_pr__nfet_01v8_lvt w=0.45 l=0.15
X237 vdd t_Xrx_Xpi_Xpi_Xch_d_Xmixp_Xs7_dum vdd vdd sky130_fd_pr__pfet_01v8 w=1.35 l=0.15
X238 t_Xrx_Xpi_Xpi_Xch_d_mixp vss sky130_fd_pr__cap_mim_m3_1 w=4.1 l=4.1
X239 t_Xrx_Xpi_Xpi_Xch_d_can t_Xrx_Xpi_Xpi_fb0 t_Xrx_Xpi_Xpi_Xch_d_Xmixn_Xs0_sel vss sky130_fd_pr__nfet_01v8_lvt w=0.42 l=0.15
X240 t_Xrx_Xpi_Xpi_Xch_d_can f0 t_Xrx_Xpi_Xpi_Xch_d_Xmixn_Xs0_sel vdd sky130_fd_pr__pfet_01v8_lvt w=0.75 l=0.35
X241 t_Xrx_Xpi_Xpi_Xch_d_cbn f0 t_Xrx_Xpi_Xpi_Xch_d_Xmixn_Xs0_sel vss sky130_fd_pr__nfet_01v8_lvt w=0.42 l=0.15
X242 t_Xrx_Xpi_Xpi_Xch_d_cbn t_Xrx_Xpi_Xpi_fb0 t_Xrx_Xpi_Xpi_Xch_d_Xmixn_Xs0_sel vdd sky130_fd_pr__pfet_01v8_lvt w=0.75 l=0.35
X243 t_Xrx_Xpi_Xpi_Xch_d_Xmixn_Xs0_drv t_Xrx_Xpi_Xpi_Xch_d_Xmixn_Xs0_sel vss vss sky130_fd_pr__nfet_01v8_lvt w=0.45 l=0.15
X244 t_Xrx_Xpi_Xpi_Xch_d_Xmixn_Xs0_drv t_Xrx_Xpi_Xpi_Xch_d_Xmixn_Xs0_sel vdd vdd sky130_fd_pr__pfet_01v8 w=1.35 l=0.15
X245 t_Xrx_Xpi_Xpi_Xch_d_Xmixn_Xs0_drv t_Xrx_Xpi_Xpi_Xch_d_mixn vss sky130_fd_pr__res_high_po_0p69 l=10.8
X246 t_Xrx_Xpi_Xpi_Xch_d_can f0 t_Xrx_Xpi_Xpi_Xch_d_Xmixn_Xs0_dum vss sky130_fd_pr__nfet_01v8_lvt w=0.42 l=0.15
X247 t_Xrx_Xpi_Xpi_Xch_d_can t_Xrx_Xpi_Xpi_fb0 t_Xrx_Xpi_Xpi_Xch_d_Xmixn_Xs0_dum vdd sky130_fd_pr__pfet_01v8_lvt w=0.75 l=0.35
X248 t_Xrx_Xpi_Xpi_Xch_d_cbn t_Xrx_Xpi_Xpi_fb0 t_Xrx_Xpi_Xpi_Xch_d_Xmixn_Xs0_dum vss sky130_fd_pr__nfet_01v8_lvt w=0.42 l=0.15
X249 t_Xrx_Xpi_Xpi_Xch_d_cbn f0 t_Xrx_Xpi_Xpi_Xch_d_Xmixn_Xs0_dum vdd sky130_fd_pr__pfet_01v8_lvt w=0.75 l=0.35
X250 vss t_Xrx_Xpi_Xpi_Xch_d_Xmixn_Xs0_dum vss vss sky130_fd_pr__nfet_01v8_lvt w=0.45 l=0.15
X251 vdd t_Xrx_Xpi_Xpi_Xch_d_Xmixn_Xs0_dum vdd vdd sky130_fd_pr__pfet_01v8 w=1.35 l=0.15
X252 t_Xrx_Xpi_Xpi_Xch_d_can t_Xrx_Xpi_Xpi_fb1 t_Xrx_Xpi_Xpi_Xch_d_Xmixn_Xs1_sel vss sky130_fd_pr__nfet_01v8_lvt w=0.42 l=0.15
X253 t_Xrx_Xpi_Xpi_Xch_d_can f1 t_Xrx_Xpi_Xpi_Xch_d_Xmixn_Xs1_sel vdd sky130_fd_pr__pfet_01v8_lvt w=0.75 l=0.35
X254 t_Xrx_Xpi_Xpi_Xch_d_cbn f1 t_Xrx_Xpi_Xpi_Xch_d_Xmixn_Xs1_sel vss sky130_fd_pr__nfet_01v8_lvt w=0.42 l=0.15
X255 t_Xrx_Xpi_Xpi_Xch_d_cbn t_Xrx_Xpi_Xpi_fb1 t_Xrx_Xpi_Xpi_Xch_d_Xmixn_Xs1_sel vdd sky130_fd_pr__pfet_01v8_lvt w=0.75 l=0.35
X256 t_Xrx_Xpi_Xpi_Xch_d_Xmixn_Xs1_drv t_Xrx_Xpi_Xpi_Xch_d_Xmixn_Xs1_sel vss vss sky130_fd_pr__nfet_01v8_lvt w=0.45 l=0.15
X257 t_Xrx_Xpi_Xpi_Xch_d_Xmixn_Xs1_drv t_Xrx_Xpi_Xpi_Xch_d_Xmixn_Xs1_sel vdd vdd sky130_fd_pr__pfet_01v8 w=1.35 l=0.15
X258 t_Xrx_Xpi_Xpi_Xch_d_Xmixn_Xs1_drv t_Xrx_Xpi_Xpi_Xch_d_mixn vss sky130_fd_pr__res_high_po_0p69 l=10.8
X259 t_Xrx_Xpi_Xpi_Xch_d_can f1 t_Xrx_Xpi_Xpi_Xch_d_Xmixn_Xs1_dum vss sky130_fd_pr__nfet_01v8_lvt w=0.42 l=0.15
X260 t_Xrx_Xpi_Xpi_Xch_d_can t_Xrx_Xpi_Xpi_fb1 t_Xrx_Xpi_Xpi_Xch_d_Xmixn_Xs1_dum vdd sky130_fd_pr__pfet_01v8_lvt w=0.75 l=0.35
X261 t_Xrx_Xpi_Xpi_Xch_d_cbn t_Xrx_Xpi_Xpi_fb1 t_Xrx_Xpi_Xpi_Xch_d_Xmixn_Xs1_dum vss sky130_fd_pr__nfet_01v8_lvt w=0.42 l=0.15
X262 t_Xrx_Xpi_Xpi_Xch_d_cbn f1 t_Xrx_Xpi_Xpi_Xch_d_Xmixn_Xs1_dum vdd sky130_fd_pr__pfet_01v8_lvt w=0.75 l=0.35
X263 vss t_Xrx_Xpi_Xpi_Xch_d_Xmixn_Xs1_dum vss vss sky130_fd_pr__nfet_01v8_lvt w=0.45 l=0.15
X264 vdd t_Xrx_Xpi_Xpi_Xch_d_Xmixn_Xs1_dum vdd vdd sky130_fd_pr__pfet_01v8 w=1.35 l=0.15
X265 t_Xrx_Xpi_Xpi_Xch_d_can t_Xrx_Xpi_Xpi_fb2 t_Xrx_Xpi_Xpi_Xch_d_Xmixn_Xs2_sel vss sky130_fd_pr__nfet_01v8_lvt w=0.42 l=0.15
X266 t_Xrx_Xpi_Xpi_Xch_d_can f2 t_Xrx_Xpi_Xpi_Xch_d_Xmixn_Xs2_sel vdd sky130_fd_pr__pfet_01v8_lvt w=0.75 l=0.35
X267 t_Xrx_Xpi_Xpi_Xch_d_cbn f2 t_Xrx_Xpi_Xpi_Xch_d_Xmixn_Xs2_sel vss sky130_fd_pr__nfet_01v8_lvt w=0.42 l=0.15
X268 t_Xrx_Xpi_Xpi_Xch_d_cbn t_Xrx_Xpi_Xpi_fb2 t_Xrx_Xpi_Xpi_Xch_d_Xmixn_Xs2_sel vdd sky130_fd_pr__pfet_01v8_lvt w=0.75 l=0.35
X269 t_Xrx_Xpi_Xpi_Xch_d_Xmixn_Xs2_drv t_Xrx_Xpi_Xpi_Xch_d_Xmixn_Xs2_sel vss vss sky130_fd_pr__nfet_01v8_lvt w=0.45 l=0.15
X270 t_Xrx_Xpi_Xpi_Xch_d_Xmixn_Xs2_drv t_Xrx_Xpi_Xpi_Xch_d_Xmixn_Xs2_sel vdd vdd sky130_fd_pr__pfet_01v8 w=1.35 l=0.15
X271 t_Xrx_Xpi_Xpi_Xch_d_Xmixn_Xs2_drv t_Xrx_Xpi_Xpi_Xch_d_mixn vss sky130_fd_pr__res_high_po_0p69 l=10.8
X272 t_Xrx_Xpi_Xpi_Xch_d_can f2 t_Xrx_Xpi_Xpi_Xch_d_Xmixn_Xs2_dum vss sky130_fd_pr__nfet_01v8_lvt w=0.42 l=0.15
X273 t_Xrx_Xpi_Xpi_Xch_d_can t_Xrx_Xpi_Xpi_fb2 t_Xrx_Xpi_Xpi_Xch_d_Xmixn_Xs2_dum vdd sky130_fd_pr__pfet_01v8_lvt w=0.75 l=0.35
X274 t_Xrx_Xpi_Xpi_Xch_d_cbn t_Xrx_Xpi_Xpi_fb2 t_Xrx_Xpi_Xpi_Xch_d_Xmixn_Xs2_dum vss sky130_fd_pr__nfet_01v8_lvt w=0.42 l=0.15
X275 t_Xrx_Xpi_Xpi_Xch_d_cbn f2 t_Xrx_Xpi_Xpi_Xch_d_Xmixn_Xs2_dum vdd sky130_fd_pr__pfet_01v8_lvt w=0.75 l=0.35
X276 vss t_Xrx_Xpi_Xpi_Xch_d_Xmixn_Xs2_dum vss vss sky130_fd_pr__nfet_01v8_lvt w=0.45 l=0.15
X277 vdd t_Xrx_Xpi_Xpi_Xch_d_Xmixn_Xs2_dum vdd vdd sky130_fd_pr__pfet_01v8 w=1.35 l=0.15
X278 t_Xrx_Xpi_Xpi_Xch_d_can t_Xrx_Xpi_Xpi_fb3 t_Xrx_Xpi_Xpi_Xch_d_Xmixn_Xs3_sel vss sky130_fd_pr__nfet_01v8_lvt w=0.42 l=0.15
X279 t_Xrx_Xpi_Xpi_Xch_d_can f3 t_Xrx_Xpi_Xpi_Xch_d_Xmixn_Xs3_sel vdd sky130_fd_pr__pfet_01v8_lvt w=0.75 l=0.35
X280 t_Xrx_Xpi_Xpi_Xch_d_cbn f3 t_Xrx_Xpi_Xpi_Xch_d_Xmixn_Xs3_sel vss sky130_fd_pr__nfet_01v8_lvt w=0.42 l=0.15
X281 t_Xrx_Xpi_Xpi_Xch_d_cbn t_Xrx_Xpi_Xpi_fb3 t_Xrx_Xpi_Xpi_Xch_d_Xmixn_Xs3_sel vdd sky130_fd_pr__pfet_01v8_lvt w=0.75 l=0.35
X282 t_Xrx_Xpi_Xpi_Xch_d_Xmixn_Xs3_drv t_Xrx_Xpi_Xpi_Xch_d_Xmixn_Xs3_sel vss vss sky130_fd_pr__nfet_01v8_lvt w=0.45 l=0.15
X283 t_Xrx_Xpi_Xpi_Xch_d_Xmixn_Xs3_drv t_Xrx_Xpi_Xpi_Xch_d_Xmixn_Xs3_sel vdd vdd sky130_fd_pr__pfet_01v8 w=1.35 l=0.15
X284 t_Xrx_Xpi_Xpi_Xch_d_Xmixn_Xs3_drv t_Xrx_Xpi_Xpi_Xch_d_mixn vss sky130_fd_pr__res_high_po_0p69 l=10.8
X285 t_Xrx_Xpi_Xpi_Xch_d_can f3 t_Xrx_Xpi_Xpi_Xch_d_Xmixn_Xs3_dum vss sky130_fd_pr__nfet_01v8_lvt w=0.42 l=0.15
X286 t_Xrx_Xpi_Xpi_Xch_d_can t_Xrx_Xpi_Xpi_fb3 t_Xrx_Xpi_Xpi_Xch_d_Xmixn_Xs3_dum vdd sky130_fd_pr__pfet_01v8_lvt w=0.75 l=0.35
X287 t_Xrx_Xpi_Xpi_Xch_d_cbn t_Xrx_Xpi_Xpi_fb3 t_Xrx_Xpi_Xpi_Xch_d_Xmixn_Xs3_dum vss sky130_fd_pr__nfet_01v8_lvt w=0.42 l=0.15
X288 t_Xrx_Xpi_Xpi_Xch_d_cbn f3 t_Xrx_Xpi_Xpi_Xch_d_Xmixn_Xs3_dum vdd sky130_fd_pr__pfet_01v8_lvt w=0.75 l=0.35
X289 vss t_Xrx_Xpi_Xpi_Xch_d_Xmixn_Xs3_dum vss vss sky130_fd_pr__nfet_01v8_lvt w=0.45 l=0.15
X290 vdd t_Xrx_Xpi_Xpi_Xch_d_Xmixn_Xs3_dum vdd vdd sky130_fd_pr__pfet_01v8 w=1.35 l=0.15
X291 t_Xrx_Xpi_Xpi_Xch_d_can t_Xrx_Xpi_Xpi_fb4 t_Xrx_Xpi_Xpi_Xch_d_Xmixn_Xs4_sel vss sky130_fd_pr__nfet_01v8_lvt w=0.42 l=0.15
X292 t_Xrx_Xpi_Xpi_Xch_d_can f4 t_Xrx_Xpi_Xpi_Xch_d_Xmixn_Xs4_sel vdd sky130_fd_pr__pfet_01v8_lvt w=0.75 l=0.35
X293 t_Xrx_Xpi_Xpi_Xch_d_cbn f4 t_Xrx_Xpi_Xpi_Xch_d_Xmixn_Xs4_sel vss sky130_fd_pr__nfet_01v8_lvt w=0.42 l=0.15
X294 t_Xrx_Xpi_Xpi_Xch_d_cbn t_Xrx_Xpi_Xpi_fb4 t_Xrx_Xpi_Xpi_Xch_d_Xmixn_Xs4_sel vdd sky130_fd_pr__pfet_01v8_lvt w=0.75 l=0.35
X295 t_Xrx_Xpi_Xpi_Xch_d_Xmixn_Xs4_drv t_Xrx_Xpi_Xpi_Xch_d_Xmixn_Xs4_sel vss vss sky130_fd_pr__nfet_01v8_lvt w=0.45 l=0.15
X296 t_Xrx_Xpi_Xpi_Xch_d_Xmixn_Xs4_drv t_Xrx_Xpi_Xpi_Xch_d_Xmixn_Xs4_sel vdd vdd sky130_fd_pr__pfet_01v8 w=1.35 l=0.15
X297 t_Xrx_Xpi_Xpi_Xch_d_Xmixn_Xs4_drv t_Xrx_Xpi_Xpi_Xch_d_mixn vss sky130_fd_pr__res_high_po_0p69 l=10.8
X298 t_Xrx_Xpi_Xpi_Xch_d_can f4 t_Xrx_Xpi_Xpi_Xch_d_Xmixn_Xs4_dum vss sky130_fd_pr__nfet_01v8_lvt w=0.42 l=0.15
X299 t_Xrx_Xpi_Xpi_Xch_d_can t_Xrx_Xpi_Xpi_fb4 t_Xrx_Xpi_Xpi_Xch_d_Xmixn_Xs4_dum vdd sky130_fd_pr__pfet_01v8_lvt w=0.75 l=0.35
X300 t_Xrx_Xpi_Xpi_Xch_d_cbn t_Xrx_Xpi_Xpi_fb4 t_Xrx_Xpi_Xpi_Xch_d_Xmixn_Xs4_dum vss sky130_fd_pr__nfet_01v8_lvt w=0.42 l=0.15
X301 t_Xrx_Xpi_Xpi_Xch_d_cbn f4 t_Xrx_Xpi_Xpi_Xch_d_Xmixn_Xs4_dum vdd sky130_fd_pr__pfet_01v8_lvt w=0.75 l=0.35
X302 vss t_Xrx_Xpi_Xpi_Xch_d_Xmixn_Xs4_dum vss vss sky130_fd_pr__nfet_01v8_lvt w=0.45 l=0.15
X303 vdd t_Xrx_Xpi_Xpi_Xch_d_Xmixn_Xs4_dum vdd vdd sky130_fd_pr__pfet_01v8 w=1.35 l=0.15
X304 t_Xrx_Xpi_Xpi_Xch_d_can t_Xrx_Xpi_Xpi_fb5 t_Xrx_Xpi_Xpi_Xch_d_Xmixn_Xs5_sel vss sky130_fd_pr__nfet_01v8_lvt w=0.42 l=0.15
X305 t_Xrx_Xpi_Xpi_Xch_d_can f5 t_Xrx_Xpi_Xpi_Xch_d_Xmixn_Xs5_sel vdd sky130_fd_pr__pfet_01v8_lvt w=0.75 l=0.35
X306 t_Xrx_Xpi_Xpi_Xch_d_cbn f5 t_Xrx_Xpi_Xpi_Xch_d_Xmixn_Xs5_sel vss sky130_fd_pr__nfet_01v8_lvt w=0.42 l=0.15
X307 t_Xrx_Xpi_Xpi_Xch_d_cbn t_Xrx_Xpi_Xpi_fb5 t_Xrx_Xpi_Xpi_Xch_d_Xmixn_Xs5_sel vdd sky130_fd_pr__pfet_01v8_lvt w=0.75 l=0.35
X308 t_Xrx_Xpi_Xpi_Xch_d_Xmixn_Xs5_drv t_Xrx_Xpi_Xpi_Xch_d_Xmixn_Xs5_sel vss vss sky130_fd_pr__nfet_01v8_lvt w=0.45 l=0.15
X309 t_Xrx_Xpi_Xpi_Xch_d_Xmixn_Xs5_drv t_Xrx_Xpi_Xpi_Xch_d_Xmixn_Xs5_sel vdd vdd sky130_fd_pr__pfet_01v8 w=1.35 l=0.15
X310 t_Xrx_Xpi_Xpi_Xch_d_Xmixn_Xs5_drv t_Xrx_Xpi_Xpi_Xch_d_mixn vss sky130_fd_pr__res_high_po_0p69 l=10.8
X311 t_Xrx_Xpi_Xpi_Xch_d_can f5 t_Xrx_Xpi_Xpi_Xch_d_Xmixn_Xs5_dum vss sky130_fd_pr__nfet_01v8_lvt w=0.42 l=0.15
X312 t_Xrx_Xpi_Xpi_Xch_d_can t_Xrx_Xpi_Xpi_fb5 t_Xrx_Xpi_Xpi_Xch_d_Xmixn_Xs5_dum vdd sky130_fd_pr__pfet_01v8_lvt w=0.75 l=0.35
X313 t_Xrx_Xpi_Xpi_Xch_d_cbn t_Xrx_Xpi_Xpi_fb5 t_Xrx_Xpi_Xpi_Xch_d_Xmixn_Xs5_dum vss sky130_fd_pr__nfet_01v8_lvt w=0.42 l=0.15
X314 t_Xrx_Xpi_Xpi_Xch_d_cbn f5 t_Xrx_Xpi_Xpi_Xch_d_Xmixn_Xs5_dum vdd sky130_fd_pr__pfet_01v8_lvt w=0.75 l=0.35
X315 vss t_Xrx_Xpi_Xpi_Xch_d_Xmixn_Xs5_dum vss vss sky130_fd_pr__nfet_01v8_lvt w=0.45 l=0.15
X316 vdd t_Xrx_Xpi_Xpi_Xch_d_Xmixn_Xs5_dum vdd vdd sky130_fd_pr__pfet_01v8 w=1.35 l=0.15
X317 t_Xrx_Xpi_Xpi_Xch_d_can t_Xrx_Xpi_Xpi_fb6 t_Xrx_Xpi_Xpi_Xch_d_Xmixn_Xs6_sel vss sky130_fd_pr__nfet_01v8_lvt w=0.42 l=0.15
X318 t_Xrx_Xpi_Xpi_Xch_d_can f6 t_Xrx_Xpi_Xpi_Xch_d_Xmixn_Xs6_sel vdd sky130_fd_pr__pfet_01v8_lvt w=0.75 l=0.35
X319 t_Xrx_Xpi_Xpi_Xch_d_cbn f6 t_Xrx_Xpi_Xpi_Xch_d_Xmixn_Xs6_sel vss sky130_fd_pr__nfet_01v8_lvt w=0.42 l=0.15
X320 t_Xrx_Xpi_Xpi_Xch_d_cbn t_Xrx_Xpi_Xpi_fb6 t_Xrx_Xpi_Xpi_Xch_d_Xmixn_Xs6_sel vdd sky130_fd_pr__pfet_01v8_lvt w=0.75 l=0.35
X321 t_Xrx_Xpi_Xpi_Xch_d_Xmixn_Xs6_drv t_Xrx_Xpi_Xpi_Xch_d_Xmixn_Xs6_sel vss vss sky130_fd_pr__nfet_01v8_lvt w=0.45 l=0.15
X322 t_Xrx_Xpi_Xpi_Xch_d_Xmixn_Xs6_drv t_Xrx_Xpi_Xpi_Xch_d_Xmixn_Xs6_sel vdd vdd sky130_fd_pr__pfet_01v8 w=1.35 l=0.15
X323 t_Xrx_Xpi_Xpi_Xch_d_Xmixn_Xs6_drv t_Xrx_Xpi_Xpi_Xch_d_mixn vss sky130_fd_pr__res_high_po_0p69 l=10.8
X324 t_Xrx_Xpi_Xpi_Xch_d_can f6 t_Xrx_Xpi_Xpi_Xch_d_Xmixn_Xs6_dum vss sky130_fd_pr__nfet_01v8_lvt w=0.42 l=0.15
X325 t_Xrx_Xpi_Xpi_Xch_d_can t_Xrx_Xpi_Xpi_fb6 t_Xrx_Xpi_Xpi_Xch_d_Xmixn_Xs6_dum vdd sky130_fd_pr__pfet_01v8_lvt w=0.75 l=0.35
X326 t_Xrx_Xpi_Xpi_Xch_d_cbn t_Xrx_Xpi_Xpi_fb6 t_Xrx_Xpi_Xpi_Xch_d_Xmixn_Xs6_dum vss sky130_fd_pr__nfet_01v8_lvt w=0.42 l=0.15
X327 t_Xrx_Xpi_Xpi_Xch_d_cbn f6 t_Xrx_Xpi_Xpi_Xch_d_Xmixn_Xs6_dum vdd sky130_fd_pr__pfet_01v8_lvt w=0.75 l=0.35
X328 vss t_Xrx_Xpi_Xpi_Xch_d_Xmixn_Xs6_dum vss vss sky130_fd_pr__nfet_01v8_lvt w=0.45 l=0.15
X329 vdd t_Xrx_Xpi_Xpi_Xch_d_Xmixn_Xs6_dum vdd vdd sky130_fd_pr__pfet_01v8 w=1.35 l=0.15
X330 t_Xrx_Xpi_Xpi_Xch_d_can t_Xrx_Xpi_Xpi_fb7 t_Xrx_Xpi_Xpi_Xch_d_Xmixn_Xs7_sel vss sky130_fd_pr__nfet_01v8_lvt w=0.42 l=0.15
X331 t_Xrx_Xpi_Xpi_Xch_d_can f7 t_Xrx_Xpi_Xpi_Xch_d_Xmixn_Xs7_sel vdd sky130_fd_pr__pfet_01v8_lvt w=0.75 l=0.35
X332 t_Xrx_Xpi_Xpi_Xch_d_cbn f7 t_Xrx_Xpi_Xpi_Xch_d_Xmixn_Xs7_sel vss sky130_fd_pr__nfet_01v8_lvt w=0.42 l=0.15
X333 t_Xrx_Xpi_Xpi_Xch_d_cbn t_Xrx_Xpi_Xpi_fb7 t_Xrx_Xpi_Xpi_Xch_d_Xmixn_Xs7_sel vdd sky130_fd_pr__pfet_01v8_lvt w=0.75 l=0.35
X334 t_Xrx_Xpi_Xpi_Xch_d_Xmixn_Xs7_drv t_Xrx_Xpi_Xpi_Xch_d_Xmixn_Xs7_sel vss vss sky130_fd_pr__nfet_01v8_lvt w=0.45 l=0.15
X335 t_Xrx_Xpi_Xpi_Xch_d_Xmixn_Xs7_drv t_Xrx_Xpi_Xpi_Xch_d_Xmixn_Xs7_sel vdd vdd sky130_fd_pr__pfet_01v8 w=1.35 l=0.15
X336 t_Xrx_Xpi_Xpi_Xch_d_Xmixn_Xs7_drv t_Xrx_Xpi_Xpi_Xch_d_mixn vss sky130_fd_pr__res_high_po_0p69 l=10.8
X337 t_Xrx_Xpi_Xpi_Xch_d_can f7 t_Xrx_Xpi_Xpi_Xch_d_Xmixn_Xs7_dum vss sky130_fd_pr__nfet_01v8_lvt w=0.42 l=0.15
X338 t_Xrx_Xpi_Xpi_Xch_d_can t_Xrx_Xpi_Xpi_fb7 t_Xrx_Xpi_Xpi_Xch_d_Xmixn_Xs7_dum vdd sky130_fd_pr__pfet_01v8_lvt w=0.75 l=0.35
X339 t_Xrx_Xpi_Xpi_Xch_d_cbn t_Xrx_Xpi_Xpi_fb7 t_Xrx_Xpi_Xpi_Xch_d_Xmixn_Xs7_dum vss sky130_fd_pr__nfet_01v8_lvt w=0.42 l=0.15
X340 t_Xrx_Xpi_Xpi_Xch_d_cbn f7 t_Xrx_Xpi_Xpi_Xch_d_Xmixn_Xs7_dum vdd sky130_fd_pr__pfet_01v8_lvt w=0.75 l=0.35
X341 vss t_Xrx_Xpi_Xpi_Xch_d_Xmixn_Xs7_dum vss vss sky130_fd_pr__nfet_01v8_lvt w=0.45 l=0.15
X342 vdd t_Xrx_Xpi_Xpi_Xch_d_Xmixn_Xs7_dum vdd vdd sky130_fd_pr__pfet_01v8 w=1.35 l=0.15
X343 t_Xrx_Xpi_Xpi_Xch_d_mixn vss sky130_fd_pr__cap_mim_m3_1 w=4.1 l=4.1
X344 t_Xrx_Xpi_Xpi_Xch_d_mixp t_Xrx_Xpi_Xpi_Xch_d_Xrec_acp sky130_fd_pr__cap_mim_m3_1 w=4.1 l=4.1
X345 t_Xrx_Xpi_Xpi_Xch_d_mixn t_Xrx_Xpi_Xpi_Xch_d_Xrec_acn sky130_fd_pr__cap_mim_m3_1 w=4.1 l=4.1
X346 t_Xrx_Xpi_Xpi_Xch_d_Xrec_acp t_Xrx_Xpi_Xpi_Xch_d_r1p vss sky130_fd_pr__res_high_po_0p35 l=10.5
X347 t_Xrx_Xpi_Xpi_Xch_d_Xrec_acn t_Xrx_Xpi_Xpi_Xch_d_r1n vss sky130_fd_pr__res_high_po_0p35 l=10.5
X348 t_Xrx_Xpi_Xpi_Xch_d_r1p t_Xrx_Xpi_Xpi_Xch_d_Xrec_acp vss vss sky130_fd_pr__nfet_01v8_lvt w=0.8 l=0.15
X349 t_Xrx_Xpi_Xpi_Xch_d_r1p t_Xrx_Xpi_Xpi_Xch_d_Xrec_acp vdd vdd sky130_fd_pr__pfet_01v8_lvt w=2.6 l=0.35
X350 t_Xrx_Xpi_Xpi_Xch_d_r1n t_Xrx_Xpi_Xpi_Xch_d_Xrec_acn vss vss sky130_fd_pr__nfet_01v8_lvt w=0.8 l=0.15
X351 t_Xrx_Xpi_Xpi_Xch_d_r1n t_Xrx_Xpi_Xpi_Xch_d_Xrec_acn vdd vdd sky130_fd_pr__pfet_01v8_lvt w=2.6 l=0.35
X352 t_Xrx_dp t_Xrx_Xpi_Xpi_Xch_d_r1n vss vss sky130_fd_pr__nfet_01v8_lvt w=0.95 l=0.15
X353 t_Xrx_dp t_Xrx_Xpi_Xpi_Xch_d_r1n vdd vdd sky130_fd_pr__pfet_01v8_lvt w=3.1 l=0.35
X354 t_Xrx_dn t_Xrx_Xpi_Xpi_Xch_d_r1p vss vss sky130_fd_pr__nfet_01v8_lvt w=0.95 l=0.15
X355 t_Xrx_dn t_Xrx_Xpi_Xpi_Xch_d_r1p vdd vdd sky130_fd_pr__pfet_01v8_lvt w=3.1 l=0.35
X356 t_Xrx_Xpi_Xpi_cb2 a0 t_Xrx_Xpi_Xpi_Xch_e_Xmap_m vss sky130_fd_pr__nfet_01v8_lvt w=1 l=0.15
X357 t_Xrx_Xpi_Xpi_cb2 t_Xrx_Xpi_Xpi_ab0 t_Xrx_Xpi_Xpi_Xch_e_Xmap_m vdd sky130_fd_pr__pfet_01v8_lvt w=1.8 l=0.35
X358 t_Xrx_Xpi_Xpi_cb4 a2 t_Xrx_Xpi_Xpi_Xch_e_Xmap_m vss sky130_fd_pr__nfet_01v8_lvt w=1 l=0.15
X359 t_Xrx_Xpi_Xpi_cb4 t_Xrx_Xpi_Xpi_ab2 t_Xrx_Xpi_Xpi_Xch_e_Xmap_m vdd sky130_fd_pr__pfet_01v8_lvt w=1.8 l=0.35
X360 t_Xrx_Xpi_Xpi_cb6 a4 t_Xrx_Xpi_Xpi_Xch_e_Xmap_m vss sky130_fd_pr__nfet_01v8_lvt w=1 l=0.15
X361 t_Xrx_Xpi_Xpi_cb6 t_Xrx_Xpi_Xpi_ab4 t_Xrx_Xpi_Xpi_Xch_e_Xmap_m vdd sky130_fd_pr__pfet_01v8_lvt w=1.8 l=0.35
X362 t_Xrx_Xpi_Xpi_cb0 a6 t_Xrx_Xpi_Xpi_Xch_e_Xmap_m vss sky130_fd_pr__nfet_01v8_lvt w=1 l=0.15
X363 t_Xrx_Xpi_Xpi_cb0 t_Xrx_Xpi_Xpi_ab6 t_Xrx_Xpi_Xpi_Xch_e_Xmap_m vdd sky130_fd_pr__pfet_01v8_lvt w=1.8 l=0.35
X364 t_Xrx_Xpi_Xpi_Xch_e_cap t_Xrx_Xpi_Xpi_Xch_e_Xmap_m vss vss sky130_fd_pr__nfet_01v8_lvt w=1.4 l=0.15
X365 t_Xrx_Xpi_Xpi_Xch_e_cap t_Xrx_Xpi_Xpi_Xch_e_Xmap_m vdd vdd sky130_fd_pr__pfet_01v8 w=3.3 l=0.15
X366 t_Xrx_Xpi_Xpi_cb6 a0 t_Xrx_Xpi_Xpi_Xch_e_Xman_m vss sky130_fd_pr__nfet_01v8_lvt w=1 l=0.15
X367 t_Xrx_Xpi_Xpi_cb6 t_Xrx_Xpi_Xpi_ab0 t_Xrx_Xpi_Xpi_Xch_e_Xman_m vdd sky130_fd_pr__pfet_01v8_lvt w=1.8 l=0.35
X368 t_Xrx_Xpi_Xpi_cb0 a2 t_Xrx_Xpi_Xpi_Xch_e_Xman_m vss sky130_fd_pr__nfet_01v8_lvt w=1 l=0.15
X369 t_Xrx_Xpi_Xpi_cb0 t_Xrx_Xpi_Xpi_ab2 t_Xrx_Xpi_Xpi_Xch_e_Xman_m vdd sky130_fd_pr__pfet_01v8_lvt w=1.8 l=0.35
X370 t_Xrx_Xpi_Xpi_cb2 a4 t_Xrx_Xpi_Xpi_Xch_e_Xman_m vss sky130_fd_pr__nfet_01v8_lvt w=1 l=0.15
X371 t_Xrx_Xpi_Xpi_cb2 t_Xrx_Xpi_Xpi_ab4 t_Xrx_Xpi_Xpi_Xch_e_Xman_m vdd sky130_fd_pr__pfet_01v8_lvt w=1.8 l=0.35
X372 t_Xrx_Xpi_Xpi_cb4 a6 t_Xrx_Xpi_Xpi_Xch_e_Xman_m vss sky130_fd_pr__nfet_01v8_lvt w=1 l=0.15
X373 t_Xrx_Xpi_Xpi_cb4 t_Xrx_Xpi_Xpi_ab6 t_Xrx_Xpi_Xpi_Xch_e_Xman_m vdd sky130_fd_pr__pfet_01v8_lvt w=1.8 l=0.35
X374 t_Xrx_Xpi_Xpi_Xch_e_can t_Xrx_Xpi_Xpi_Xch_e_Xman_m vss vss sky130_fd_pr__nfet_01v8_lvt w=1.4 l=0.15
X375 t_Xrx_Xpi_Xpi_Xch_e_can t_Xrx_Xpi_Xpi_Xch_e_Xman_m vdd vdd sky130_fd_pr__pfet_01v8 w=3.3 l=0.15
X376 t_Xrx_Xpi_Xpi_cb3 b1 t_Xrx_Xpi_Xpi_Xch_e_Xmbp_m vss sky130_fd_pr__nfet_01v8_lvt w=1 l=0.15
X377 t_Xrx_Xpi_Xpi_cb3 t_Xrx_Xpi_Xpi_bb1 t_Xrx_Xpi_Xpi_Xch_e_Xmbp_m vdd sky130_fd_pr__pfet_01v8_lvt w=1.8 l=0.35
X378 t_Xrx_Xpi_Xpi_cb5 b3 t_Xrx_Xpi_Xpi_Xch_e_Xmbp_m vss sky130_fd_pr__nfet_01v8_lvt w=1 l=0.15
X379 t_Xrx_Xpi_Xpi_cb5 t_Xrx_Xpi_Xpi_bb3 t_Xrx_Xpi_Xpi_Xch_e_Xmbp_m vdd sky130_fd_pr__pfet_01v8_lvt w=1.8 l=0.35
X380 t_Xrx_Xpi_Xpi_cb7 b5 t_Xrx_Xpi_Xpi_Xch_e_Xmbp_m vss sky130_fd_pr__nfet_01v8_lvt w=1 l=0.15
X381 t_Xrx_Xpi_Xpi_cb7 t_Xrx_Xpi_Xpi_bb5 t_Xrx_Xpi_Xpi_Xch_e_Xmbp_m vdd sky130_fd_pr__pfet_01v8_lvt w=1.8 l=0.35
X382 t_Xrx_Xpi_Xpi_cb1 b7 t_Xrx_Xpi_Xpi_Xch_e_Xmbp_m vss sky130_fd_pr__nfet_01v8_lvt w=1 l=0.15
X383 t_Xrx_Xpi_Xpi_cb1 t_Xrx_Xpi_Xpi_bb7 t_Xrx_Xpi_Xpi_Xch_e_Xmbp_m vdd sky130_fd_pr__pfet_01v8_lvt w=1.8 l=0.35
X384 t_Xrx_Xpi_Xpi_Xch_e_cbp t_Xrx_Xpi_Xpi_Xch_e_Xmbp_m vss vss sky130_fd_pr__nfet_01v8_lvt w=1.4 l=0.15
X385 t_Xrx_Xpi_Xpi_Xch_e_cbp t_Xrx_Xpi_Xpi_Xch_e_Xmbp_m vdd vdd sky130_fd_pr__pfet_01v8 w=3.3 l=0.15
X386 t_Xrx_Xpi_Xpi_cb7 b1 t_Xrx_Xpi_Xpi_Xch_e_Xmbn_m vss sky130_fd_pr__nfet_01v8_lvt w=1 l=0.15
X387 t_Xrx_Xpi_Xpi_cb7 t_Xrx_Xpi_Xpi_bb1 t_Xrx_Xpi_Xpi_Xch_e_Xmbn_m vdd sky130_fd_pr__pfet_01v8_lvt w=1.8 l=0.35
X388 t_Xrx_Xpi_Xpi_cb1 b3 t_Xrx_Xpi_Xpi_Xch_e_Xmbn_m vss sky130_fd_pr__nfet_01v8_lvt w=1 l=0.15
X389 t_Xrx_Xpi_Xpi_cb1 t_Xrx_Xpi_Xpi_bb3 t_Xrx_Xpi_Xpi_Xch_e_Xmbn_m vdd sky130_fd_pr__pfet_01v8_lvt w=1.8 l=0.35
X390 t_Xrx_Xpi_Xpi_cb3 b5 t_Xrx_Xpi_Xpi_Xch_e_Xmbn_m vss sky130_fd_pr__nfet_01v8_lvt w=1 l=0.15
X391 t_Xrx_Xpi_Xpi_cb3 t_Xrx_Xpi_Xpi_bb5 t_Xrx_Xpi_Xpi_Xch_e_Xmbn_m vdd sky130_fd_pr__pfet_01v8_lvt w=1.8 l=0.35
X392 t_Xrx_Xpi_Xpi_cb5 b7 t_Xrx_Xpi_Xpi_Xch_e_Xmbn_m vss sky130_fd_pr__nfet_01v8_lvt w=1 l=0.15
X393 t_Xrx_Xpi_Xpi_cb5 t_Xrx_Xpi_Xpi_bb7 t_Xrx_Xpi_Xpi_Xch_e_Xmbn_m vdd sky130_fd_pr__pfet_01v8_lvt w=1.8 l=0.35
X394 t_Xrx_Xpi_Xpi_Xch_e_cbn t_Xrx_Xpi_Xpi_Xch_e_Xmbn_m vss vss sky130_fd_pr__nfet_01v8_lvt w=1.4 l=0.15
X395 t_Xrx_Xpi_Xpi_Xch_e_cbn t_Xrx_Xpi_Xpi_Xch_e_Xmbn_m vdd vdd sky130_fd_pr__pfet_01v8 w=3.3 l=0.15
X396 t_Xrx_Xpi_Xpi_Xch_e_cap t_Xrx_Xpi_Xpi_fb0 t_Xrx_Xpi_Xpi_Xch_e_Xmixp_Xs0_sel vss sky130_fd_pr__nfet_01v8_lvt w=0.42 l=0.15
X397 t_Xrx_Xpi_Xpi_Xch_e_cap f0 t_Xrx_Xpi_Xpi_Xch_e_Xmixp_Xs0_sel vdd sky130_fd_pr__pfet_01v8_lvt w=0.75 l=0.35
X398 t_Xrx_Xpi_Xpi_Xch_e_cbp f0 t_Xrx_Xpi_Xpi_Xch_e_Xmixp_Xs0_sel vss sky130_fd_pr__nfet_01v8_lvt w=0.42 l=0.15
X399 t_Xrx_Xpi_Xpi_Xch_e_cbp t_Xrx_Xpi_Xpi_fb0 t_Xrx_Xpi_Xpi_Xch_e_Xmixp_Xs0_sel vdd sky130_fd_pr__pfet_01v8_lvt w=0.75 l=0.35
X400 t_Xrx_Xpi_Xpi_Xch_e_Xmixp_Xs0_drv t_Xrx_Xpi_Xpi_Xch_e_Xmixp_Xs0_sel vss vss sky130_fd_pr__nfet_01v8_lvt w=0.45 l=0.15
X401 t_Xrx_Xpi_Xpi_Xch_e_Xmixp_Xs0_drv t_Xrx_Xpi_Xpi_Xch_e_Xmixp_Xs0_sel vdd vdd sky130_fd_pr__pfet_01v8 w=1.35 l=0.15
X402 t_Xrx_Xpi_Xpi_Xch_e_Xmixp_Xs0_drv t_Xrx_Xpi_Xpi_Xch_e_mixp vss sky130_fd_pr__res_high_po_0p69 l=10.8
X403 t_Xrx_Xpi_Xpi_Xch_e_cap f0 t_Xrx_Xpi_Xpi_Xch_e_Xmixp_Xs0_dum vss sky130_fd_pr__nfet_01v8_lvt w=0.42 l=0.15
X404 t_Xrx_Xpi_Xpi_Xch_e_cap t_Xrx_Xpi_Xpi_fb0 t_Xrx_Xpi_Xpi_Xch_e_Xmixp_Xs0_dum vdd sky130_fd_pr__pfet_01v8_lvt w=0.75 l=0.35
X405 t_Xrx_Xpi_Xpi_Xch_e_cbp t_Xrx_Xpi_Xpi_fb0 t_Xrx_Xpi_Xpi_Xch_e_Xmixp_Xs0_dum vss sky130_fd_pr__nfet_01v8_lvt w=0.42 l=0.15
X406 t_Xrx_Xpi_Xpi_Xch_e_cbp f0 t_Xrx_Xpi_Xpi_Xch_e_Xmixp_Xs0_dum vdd sky130_fd_pr__pfet_01v8_lvt w=0.75 l=0.35
X407 vss t_Xrx_Xpi_Xpi_Xch_e_Xmixp_Xs0_dum vss vss sky130_fd_pr__nfet_01v8_lvt w=0.45 l=0.15
X408 vdd t_Xrx_Xpi_Xpi_Xch_e_Xmixp_Xs0_dum vdd vdd sky130_fd_pr__pfet_01v8 w=1.35 l=0.15
X409 t_Xrx_Xpi_Xpi_Xch_e_cap t_Xrx_Xpi_Xpi_fb1 t_Xrx_Xpi_Xpi_Xch_e_Xmixp_Xs1_sel vss sky130_fd_pr__nfet_01v8_lvt w=0.42 l=0.15
X410 t_Xrx_Xpi_Xpi_Xch_e_cap f1 t_Xrx_Xpi_Xpi_Xch_e_Xmixp_Xs1_sel vdd sky130_fd_pr__pfet_01v8_lvt w=0.75 l=0.35
X411 t_Xrx_Xpi_Xpi_Xch_e_cbp f1 t_Xrx_Xpi_Xpi_Xch_e_Xmixp_Xs1_sel vss sky130_fd_pr__nfet_01v8_lvt w=0.42 l=0.15
X412 t_Xrx_Xpi_Xpi_Xch_e_cbp t_Xrx_Xpi_Xpi_fb1 t_Xrx_Xpi_Xpi_Xch_e_Xmixp_Xs1_sel vdd sky130_fd_pr__pfet_01v8_lvt w=0.75 l=0.35
X413 t_Xrx_Xpi_Xpi_Xch_e_Xmixp_Xs1_drv t_Xrx_Xpi_Xpi_Xch_e_Xmixp_Xs1_sel vss vss sky130_fd_pr__nfet_01v8_lvt w=0.45 l=0.15
X414 t_Xrx_Xpi_Xpi_Xch_e_Xmixp_Xs1_drv t_Xrx_Xpi_Xpi_Xch_e_Xmixp_Xs1_sel vdd vdd sky130_fd_pr__pfet_01v8 w=1.35 l=0.15
X415 t_Xrx_Xpi_Xpi_Xch_e_Xmixp_Xs1_drv t_Xrx_Xpi_Xpi_Xch_e_mixp vss sky130_fd_pr__res_high_po_0p69 l=10.8
X416 t_Xrx_Xpi_Xpi_Xch_e_cap f1 t_Xrx_Xpi_Xpi_Xch_e_Xmixp_Xs1_dum vss sky130_fd_pr__nfet_01v8_lvt w=0.42 l=0.15
X417 t_Xrx_Xpi_Xpi_Xch_e_cap t_Xrx_Xpi_Xpi_fb1 t_Xrx_Xpi_Xpi_Xch_e_Xmixp_Xs1_dum vdd sky130_fd_pr__pfet_01v8_lvt w=0.75 l=0.35
X418 t_Xrx_Xpi_Xpi_Xch_e_cbp t_Xrx_Xpi_Xpi_fb1 t_Xrx_Xpi_Xpi_Xch_e_Xmixp_Xs1_dum vss sky130_fd_pr__nfet_01v8_lvt w=0.42 l=0.15
X419 t_Xrx_Xpi_Xpi_Xch_e_cbp f1 t_Xrx_Xpi_Xpi_Xch_e_Xmixp_Xs1_dum vdd sky130_fd_pr__pfet_01v8_lvt w=0.75 l=0.35
X420 vss t_Xrx_Xpi_Xpi_Xch_e_Xmixp_Xs1_dum vss vss sky130_fd_pr__nfet_01v8_lvt w=0.45 l=0.15
X421 vdd t_Xrx_Xpi_Xpi_Xch_e_Xmixp_Xs1_dum vdd vdd sky130_fd_pr__pfet_01v8 w=1.35 l=0.15
X422 t_Xrx_Xpi_Xpi_Xch_e_cap t_Xrx_Xpi_Xpi_fb2 t_Xrx_Xpi_Xpi_Xch_e_Xmixp_Xs2_sel vss sky130_fd_pr__nfet_01v8_lvt w=0.42 l=0.15
X423 t_Xrx_Xpi_Xpi_Xch_e_cap f2 t_Xrx_Xpi_Xpi_Xch_e_Xmixp_Xs2_sel vdd sky130_fd_pr__pfet_01v8_lvt w=0.75 l=0.35
X424 t_Xrx_Xpi_Xpi_Xch_e_cbp f2 t_Xrx_Xpi_Xpi_Xch_e_Xmixp_Xs2_sel vss sky130_fd_pr__nfet_01v8_lvt w=0.42 l=0.15
X425 t_Xrx_Xpi_Xpi_Xch_e_cbp t_Xrx_Xpi_Xpi_fb2 t_Xrx_Xpi_Xpi_Xch_e_Xmixp_Xs2_sel vdd sky130_fd_pr__pfet_01v8_lvt w=0.75 l=0.35
X426 t_Xrx_Xpi_Xpi_Xch_e_Xmixp_Xs2_drv t_Xrx_Xpi_Xpi_Xch_e_Xmixp_Xs2_sel vss vss sky130_fd_pr__nfet_01v8_lvt w=0.45 l=0.15
X427 t_Xrx_Xpi_Xpi_Xch_e_Xmixp_Xs2_drv t_Xrx_Xpi_Xpi_Xch_e_Xmixp_Xs2_sel vdd vdd sky130_fd_pr__pfet_01v8 w=1.35 l=0.15
X428 t_Xrx_Xpi_Xpi_Xch_e_Xmixp_Xs2_drv t_Xrx_Xpi_Xpi_Xch_e_mixp vss sky130_fd_pr__res_high_po_0p69 l=10.8
X429 t_Xrx_Xpi_Xpi_Xch_e_cap f2 t_Xrx_Xpi_Xpi_Xch_e_Xmixp_Xs2_dum vss sky130_fd_pr__nfet_01v8_lvt w=0.42 l=0.15
X430 t_Xrx_Xpi_Xpi_Xch_e_cap t_Xrx_Xpi_Xpi_fb2 t_Xrx_Xpi_Xpi_Xch_e_Xmixp_Xs2_dum vdd sky130_fd_pr__pfet_01v8_lvt w=0.75 l=0.35
X431 t_Xrx_Xpi_Xpi_Xch_e_cbp t_Xrx_Xpi_Xpi_fb2 t_Xrx_Xpi_Xpi_Xch_e_Xmixp_Xs2_dum vss sky130_fd_pr__nfet_01v8_lvt w=0.42 l=0.15
X432 t_Xrx_Xpi_Xpi_Xch_e_cbp f2 t_Xrx_Xpi_Xpi_Xch_e_Xmixp_Xs2_dum vdd sky130_fd_pr__pfet_01v8_lvt w=0.75 l=0.35
X433 vss t_Xrx_Xpi_Xpi_Xch_e_Xmixp_Xs2_dum vss vss sky130_fd_pr__nfet_01v8_lvt w=0.45 l=0.15
X434 vdd t_Xrx_Xpi_Xpi_Xch_e_Xmixp_Xs2_dum vdd vdd sky130_fd_pr__pfet_01v8 w=1.35 l=0.15
X435 t_Xrx_Xpi_Xpi_Xch_e_cap t_Xrx_Xpi_Xpi_fb3 t_Xrx_Xpi_Xpi_Xch_e_Xmixp_Xs3_sel vss sky130_fd_pr__nfet_01v8_lvt w=0.42 l=0.15
X436 t_Xrx_Xpi_Xpi_Xch_e_cap f3 t_Xrx_Xpi_Xpi_Xch_e_Xmixp_Xs3_sel vdd sky130_fd_pr__pfet_01v8_lvt w=0.75 l=0.35
X437 t_Xrx_Xpi_Xpi_Xch_e_cbp f3 t_Xrx_Xpi_Xpi_Xch_e_Xmixp_Xs3_sel vss sky130_fd_pr__nfet_01v8_lvt w=0.42 l=0.15
X438 t_Xrx_Xpi_Xpi_Xch_e_cbp t_Xrx_Xpi_Xpi_fb3 t_Xrx_Xpi_Xpi_Xch_e_Xmixp_Xs3_sel vdd sky130_fd_pr__pfet_01v8_lvt w=0.75 l=0.35
X439 t_Xrx_Xpi_Xpi_Xch_e_Xmixp_Xs3_drv t_Xrx_Xpi_Xpi_Xch_e_Xmixp_Xs3_sel vss vss sky130_fd_pr__nfet_01v8_lvt w=0.45 l=0.15
X440 t_Xrx_Xpi_Xpi_Xch_e_Xmixp_Xs3_drv t_Xrx_Xpi_Xpi_Xch_e_Xmixp_Xs3_sel vdd vdd sky130_fd_pr__pfet_01v8 w=1.35 l=0.15
X441 t_Xrx_Xpi_Xpi_Xch_e_Xmixp_Xs3_drv t_Xrx_Xpi_Xpi_Xch_e_mixp vss sky130_fd_pr__res_high_po_0p69 l=10.8
X442 t_Xrx_Xpi_Xpi_Xch_e_cap f3 t_Xrx_Xpi_Xpi_Xch_e_Xmixp_Xs3_dum vss sky130_fd_pr__nfet_01v8_lvt w=0.42 l=0.15
X443 t_Xrx_Xpi_Xpi_Xch_e_cap t_Xrx_Xpi_Xpi_fb3 t_Xrx_Xpi_Xpi_Xch_e_Xmixp_Xs3_dum vdd sky130_fd_pr__pfet_01v8_lvt w=0.75 l=0.35
X444 t_Xrx_Xpi_Xpi_Xch_e_cbp t_Xrx_Xpi_Xpi_fb3 t_Xrx_Xpi_Xpi_Xch_e_Xmixp_Xs3_dum vss sky130_fd_pr__nfet_01v8_lvt w=0.42 l=0.15
X445 t_Xrx_Xpi_Xpi_Xch_e_cbp f3 t_Xrx_Xpi_Xpi_Xch_e_Xmixp_Xs3_dum vdd sky130_fd_pr__pfet_01v8_lvt w=0.75 l=0.35
X446 vss t_Xrx_Xpi_Xpi_Xch_e_Xmixp_Xs3_dum vss vss sky130_fd_pr__nfet_01v8_lvt w=0.45 l=0.15
X447 vdd t_Xrx_Xpi_Xpi_Xch_e_Xmixp_Xs3_dum vdd vdd sky130_fd_pr__pfet_01v8 w=1.35 l=0.15
X448 t_Xrx_Xpi_Xpi_Xch_e_cap t_Xrx_Xpi_Xpi_fb4 t_Xrx_Xpi_Xpi_Xch_e_Xmixp_Xs4_sel vss sky130_fd_pr__nfet_01v8_lvt w=0.42 l=0.15
X449 t_Xrx_Xpi_Xpi_Xch_e_cap f4 t_Xrx_Xpi_Xpi_Xch_e_Xmixp_Xs4_sel vdd sky130_fd_pr__pfet_01v8_lvt w=0.75 l=0.35
X450 t_Xrx_Xpi_Xpi_Xch_e_cbp f4 t_Xrx_Xpi_Xpi_Xch_e_Xmixp_Xs4_sel vss sky130_fd_pr__nfet_01v8_lvt w=0.42 l=0.15
X451 t_Xrx_Xpi_Xpi_Xch_e_cbp t_Xrx_Xpi_Xpi_fb4 t_Xrx_Xpi_Xpi_Xch_e_Xmixp_Xs4_sel vdd sky130_fd_pr__pfet_01v8_lvt w=0.75 l=0.35
X452 t_Xrx_Xpi_Xpi_Xch_e_Xmixp_Xs4_drv t_Xrx_Xpi_Xpi_Xch_e_Xmixp_Xs4_sel vss vss sky130_fd_pr__nfet_01v8_lvt w=0.45 l=0.15
X453 t_Xrx_Xpi_Xpi_Xch_e_Xmixp_Xs4_drv t_Xrx_Xpi_Xpi_Xch_e_Xmixp_Xs4_sel vdd vdd sky130_fd_pr__pfet_01v8 w=1.35 l=0.15
X454 t_Xrx_Xpi_Xpi_Xch_e_Xmixp_Xs4_drv t_Xrx_Xpi_Xpi_Xch_e_mixp vss sky130_fd_pr__res_high_po_0p69 l=10.8
X455 t_Xrx_Xpi_Xpi_Xch_e_cap f4 t_Xrx_Xpi_Xpi_Xch_e_Xmixp_Xs4_dum vss sky130_fd_pr__nfet_01v8_lvt w=0.42 l=0.15
X456 t_Xrx_Xpi_Xpi_Xch_e_cap t_Xrx_Xpi_Xpi_fb4 t_Xrx_Xpi_Xpi_Xch_e_Xmixp_Xs4_dum vdd sky130_fd_pr__pfet_01v8_lvt w=0.75 l=0.35
X457 t_Xrx_Xpi_Xpi_Xch_e_cbp t_Xrx_Xpi_Xpi_fb4 t_Xrx_Xpi_Xpi_Xch_e_Xmixp_Xs4_dum vss sky130_fd_pr__nfet_01v8_lvt w=0.42 l=0.15
X458 t_Xrx_Xpi_Xpi_Xch_e_cbp f4 t_Xrx_Xpi_Xpi_Xch_e_Xmixp_Xs4_dum vdd sky130_fd_pr__pfet_01v8_lvt w=0.75 l=0.35
X459 vss t_Xrx_Xpi_Xpi_Xch_e_Xmixp_Xs4_dum vss vss sky130_fd_pr__nfet_01v8_lvt w=0.45 l=0.15
X460 vdd t_Xrx_Xpi_Xpi_Xch_e_Xmixp_Xs4_dum vdd vdd sky130_fd_pr__pfet_01v8 w=1.35 l=0.15
X461 t_Xrx_Xpi_Xpi_Xch_e_cap t_Xrx_Xpi_Xpi_fb5 t_Xrx_Xpi_Xpi_Xch_e_Xmixp_Xs5_sel vss sky130_fd_pr__nfet_01v8_lvt w=0.42 l=0.15
X462 t_Xrx_Xpi_Xpi_Xch_e_cap f5 t_Xrx_Xpi_Xpi_Xch_e_Xmixp_Xs5_sel vdd sky130_fd_pr__pfet_01v8_lvt w=0.75 l=0.35
X463 t_Xrx_Xpi_Xpi_Xch_e_cbp f5 t_Xrx_Xpi_Xpi_Xch_e_Xmixp_Xs5_sel vss sky130_fd_pr__nfet_01v8_lvt w=0.42 l=0.15
X464 t_Xrx_Xpi_Xpi_Xch_e_cbp t_Xrx_Xpi_Xpi_fb5 t_Xrx_Xpi_Xpi_Xch_e_Xmixp_Xs5_sel vdd sky130_fd_pr__pfet_01v8_lvt w=0.75 l=0.35
X465 t_Xrx_Xpi_Xpi_Xch_e_Xmixp_Xs5_drv t_Xrx_Xpi_Xpi_Xch_e_Xmixp_Xs5_sel vss vss sky130_fd_pr__nfet_01v8_lvt w=0.45 l=0.15
X466 t_Xrx_Xpi_Xpi_Xch_e_Xmixp_Xs5_drv t_Xrx_Xpi_Xpi_Xch_e_Xmixp_Xs5_sel vdd vdd sky130_fd_pr__pfet_01v8 w=1.35 l=0.15
X467 t_Xrx_Xpi_Xpi_Xch_e_Xmixp_Xs5_drv t_Xrx_Xpi_Xpi_Xch_e_mixp vss sky130_fd_pr__res_high_po_0p69 l=10.8
X468 t_Xrx_Xpi_Xpi_Xch_e_cap f5 t_Xrx_Xpi_Xpi_Xch_e_Xmixp_Xs5_dum vss sky130_fd_pr__nfet_01v8_lvt w=0.42 l=0.15
X469 t_Xrx_Xpi_Xpi_Xch_e_cap t_Xrx_Xpi_Xpi_fb5 t_Xrx_Xpi_Xpi_Xch_e_Xmixp_Xs5_dum vdd sky130_fd_pr__pfet_01v8_lvt w=0.75 l=0.35
X470 t_Xrx_Xpi_Xpi_Xch_e_cbp t_Xrx_Xpi_Xpi_fb5 t_Xrx_Xpi_Xpi_Xch_e_Xmixp_Xs5_dum vss sky130_fd_pr__nfet_01v8_lvt w=0.42 l=0.15
X471 t_Xrx_Xpi_Xpi_Xch_e_cbp f5 t_Xrx_Xpi_Xpi_Xch_e_Xmixp_Xs5_dum vdd sky130_fd_pr__pfet_01v8_lvt w=0.75 l=0.35
X472 vss t_Xrx_Xpi_Xpi_Xch_e_Xmixp_Xs5_dum vss vss sky130_fd_pr__nfet_01v8_lvt w=0.45 l=0.15
X473 vdd t_Xrx_Xpi_Xpi_Xch_e_Xmixp_Xs5_dum vdd vdd sky130_fd_pr__pfet_01v8 w=1.35 l=0.15
X474 t_Xrx_Xpi_Xpi_Xch_e_cap t_Xrx_Xpi_Xpi_fb6 t_Xrx_Xpi_Xpi_Xch_e_Xmixp_Xs6_sel vss sky130_fd_pr__nfet_01v8_lvt w=0.42 l=0.15
X475 t_Xrx_Xpi_Xpi_Xch_e_cap f6 t_Xrx_Xpi_Xpi_Xch_e_Xmixp_Xs6_sel vdd sky130_fd_pr__pfet_01v8_lvt w=0.75 l=0.35
X476 t_Xrx_Xpi_Xpi_Xch_e_cbp f6 t_Xrx_Xpi_Xpi_Xch_e_Xmixp_Xs6_sel vss sky130_fd_pr__nfet_01v8_lvt w=0.42 l=0.15
X477 t_Xrx_Xpi_Xpi_Xch_e_cbp t_Xrx_Xpi_Xpi_fb6 t_Xrx_Xpi_Xpi_Xch_e_Xmixp_Xs6_sel vdd sky130_fd_pr__pfet_01v8_lvt w=0.75 l=0.35
X478 t_Xrx_Xpi_Xpi_Xch_e_Xmixp_Xs6_drv t_Xrx_Xpi_Xpi_Xch_e_Xmixp_Xs6_sel vss vss sky130_fd_pr__nfet_01v8_lvt w=0.45 l=0.15
X479 t_Xrx_Xpi_Xpi_Xch_e_Xmixp_Xs6_drv t_Xrx_Xpi_Xpi_Xch_e_Xmixp_Xs6_sel vdd vdd sky130_fd_pr__pfet_01v8 w=1.35 l=0.15
X480 t_Xrx_Xpi_Xpi_Xch_e_Xmixp_Xs6_drv t_Xrx_Xpi_Xpi_Xch_e_mixp vss sky130_fd_pr__res_high_po_0p69 l=10.8
X481 t_Xrx_Xpi_Xpi_Xch_e_cap f6 t_Xrx_Xpi_Xpi_Xch_e_Xmixp_Xs6_dum vss sky130_fd_pr__nfet_01v8_lvt w=0.42 l=0.15
X482 t_Xrx_Xpi_Xpi_Xch_e_cap t_Xrx_Xpi_Xpi_fb6 t_Xrx_Xpi_Xpi_Xch_e_Xmixp_Xs6_dum vdd sky130_fd_pr__pfet_01v8_lvt w=0.75 l=0.35
X483 t_Xrx_Xpi_Xpi_Xch_e_cbp t_Xrx_Xpi_Xpi_fb6 t_Xrx_Xpi_Xpi_Xch_e_Xmixp_Xs6_dum vss sky130_fd_pr__nfet_01v8_lvt w=0.42 l=0.15
X484 t_Xrx_Xpi_Xpi_Xch_e_cbp f6 t_Xrx_Xpi_Xpi_Xch_e_Xmixp_Xs6_dum vdd sky130_fd_pr__pfet_01v8_lvt w=0.75 l=0.35
X485 vss t_Xrx_Xpi_Xpi_Xch_e_Xmixp_Xs6_dum vss vss sky130_fd_pr__nfet_01v8_lvt w=0.45 l=0.15
X486 vdd t_Xrx_Xpi_Xpi_Xch_e_Xmixp_Xs6_dum vdd vdd sky130_fd_pr__pfet_01v8 w=1.35 l=0.15
X487 t_Xrx_Xpi_Xpi_Xch_e_cap t_Xrx_Xpi_Xpi_fb7 t_Xrx_Xpi_Xpi_Xch_e_Xmixp_Xs7_sel vss sky130_fd_pr__nfet_01v8_lvt w=0.42 l=0.15
X488 t_Xrx_Xpi_Xpi_Xch_e_cap f7 t_Xrx_Xpi_Xpi_Xch_e_Xmixp_Xs7_sel vdd sky130_fd_pr__pfet_01v8_lvt w=0.75 l=0.35
X489 t_Xrx_Xpi_Xpi_Xch_e_cbp f7 t_Xrx_Xpi_Xpi_Xch_e_Xmixp_Xs7_sel vss sky130_fd_pr__nfet_01v8_lvt w=0.42 l=0.15
X490 t_Xrx_Xpi_Xpi_Xch_e_cbp t_Xrx_Xpi_Xpi_fb7 t_Xrx_Xpi_Xpi_Xch_e_Xmixp_Xs7_sel vdd sky130_fd_pr__pfet_01v8_lvt w=0.75 l=0.35
X491 t_Xrx_Xpi_Xpi_Xch_e_Xmixp_Xs7_drv t_Xrx_Xpi_Xpi_Xch_e_Xmixp_Xs7_sel vss vss sky130_fd_pr__nfet_01v8_lvt w=0.45 l=0.15
X492 t_Xrx_Xpi_Xpi_Xch_e_Xmixp_Xs7_drv t_Xrx_Xpi_Xpi_Xch_e_Xmixp_Xs7_sel vdd vdd sky130_fd_pr__pfet_01v8 w=1.35 l=0.15
X493 t_Xrx_Xpi_Xpi_Xch_e_Xmixp_Xs7_drv t_Xrx_Xpi_Xpi_Xch_e_mixp vss sky130_fd_pr__res_high_po_0p69 l=10.8
X494 t_Xrx_Xpi_Xpi_Xch_e_cap f7 t_Xrx_Xpi_Xpi_Xch_e_Xmixp_Xs7_dum vss sky130_fd_pr__nfet_01v8_lvt w=0.42 l=0.15
X495 t_Xrx_Xpi_Xpi_Xch_e_cap t_Xrx_Xpi_Xpi_fb7 t_Xrx_Xpi_Xpi_Xch_e_Xmixp_Xs7_dum vdd sky130_fd_pr__pfet_01v8_lvt w=0.75 l=0.35
X496 t_Xrx_Xpi_Xpi_Xch_e_cbp t_Xrx_Xpi_Xpi_fb7 t_Xrx_Xpi_Xpi_Xch_e_Xmixp_Xs7_dum vss sky130_fd_pr__nfet_01v8_lvt w=0.42 l=0.15
X497 t_Xrx_Xpi_Xpi_Xch_e_cbp f7 t_Xrx_Xpi_Xpi_Xch_e_Xmixp_Xs7_dum vdd sky130_fd_pr__pfet_01v8_lvt w=0.75 l=0.35
X498 vss t_Xrx_Xpi_Xpi_Xch_e_Xmixp_Xs7_dum vss vss sky130_fd_pr__nfet_01v8_lvt w=0.45 l=0.15
X499 vdd t_Xrx_Xpi_Xpi_Xch_e_Xmixp_Xs7_dum vdd vdd sky130_fd_pr__pfet_01v8 w=1.35 l=0.15
X500 t_Xrx_Xpi_Xpi_Xch_e_mixp vss sky130_fd_pr__cap_mim_m3_1 w=4.1 l=4.1
X501 t_Xrx_Xpi_Xpi_Xch_e_can t_Xrx_Xpi_Xpi_fb0 t_Xrx_Xpi_Xpi_Xch_e_Xmixn_Xs0_sel vss sky130_fd_pr__nfet_01v8_lvt w=0.42 l=0.15
X502 t_Xrx_Xpi_Xpi_Xch_e_can f0 t_Xrx_Xpi_Xpi_Xch_e_Xmixn_Xs0_sel vdd sky130_fd_pr__pfet_01v8_lvt w=0.75 l=0.35
X503 t_Xrx_Xpi_Xpi_Xch_e_cbn f0 t_Xrx_Xpi_Xpi_Xch_e_Xmixn_Xs0_sel vss sky130_fd_pr__nfet_01v8_lvt w=0.42 l=0.15
X504 t_Xrx_Xpi_Xpi_Xch_e_cbn t_Xrx_Xpi_Xpi_fb0 t_Xrx_Xpi_Xpi_Xch_e_Xmixn_Xs0_sel vdd sky130_fd_pr__pfet_01v8_lvt w=0.75 l=0.35
X505 t_Xrx_Xpi_Xpi_Xch_e_Xmixn_Xs0_drv t_Xrx_Xpi_Xpi_Xch_e_Xmixn_Xs0_sel vss vss sky130_fd_pr__nfet_01v8_lvt w=0.45 l=0.15
X506 t_Xrx_Xpi_Xpi_Xch_e_Xmixn_Xs0_drv t_Xrx_Xpi_Xpi_Xch_e_Xmixn_Xs0_sel vdd vdd sky130_fd_pr__pfet_01v8 w=1.35 l=0.15
X507 t_Xrx_Xpi_Xpi_Xch_e_Xmixn_Xs0_drv t_Xrx_Xpi_Xpi_Xch_e_mixn vss sky130_fd_pr__res_high_po_0p69 l=10.8
X508 t_Xrx_Xpi_Xpi_Xch_e_can f0 t_Xrx_Xpi_Xpi_Xch_e_Xmixn_Xs0_dum vss sky130_fd_pr__nfet_01v8_lvt w=0.42 l=0.15
X509 t_Xrx_Xpi_Xpi_Xch_e_can t_Xrx_Xpi_Xpi_fb0 t_Xrx_Xpi_Xpi_Xch_e_Xmixn_Xs0_dum vdd sky130_fd_pr__pfet_01v8_lvt w=0.75 l=0.35
X510 t_Xrx_Xpi_Xpi_Xch_e_cbn t_Xrx_Xpi_Xpi_fb0 t_Xrx_Xpi_Xpi_Xch_e_Xmixn_Xs0_dum vss sky130_fd_pr__nfet_01v8_lvt w=0.42 l=0.15
X511 t_Xrx_Xpi_Xpi_Xch_e_cbn f0 t_Xrx_Xpi_Xpi_Xch_e_Xmixn_Xs0_dum vdd sky130_fd_pr__pfet_01v8_lvt w=0.75 l=0.35
X512 vss t_Xrx_Xpi_Xpi_Xch_e_Xmixn_Xs0_dum vss vss sky130_fd_pr__nfet_01v8_lvt w=0.45 l=0.15
X513 vdd t_Xrx_Xpi_Xpi_Xch_e_Xmixn_Xs0_dum vdd vdd sky130_fd_pr__pfet_01v8 w=1.35 l=0.15
X514 t_Xrx_Xpi_Xpi_Xch_e_can t_Xrx_Xpi_Xpi_fb1 t_Xrx_Xpi_Xpi_Xch_e_Xmixn_Xs1_sel vss sky130_fd_pr__nfet_01v8_lvt w=0.42 l=0.15
X515 t_Xrx_Xpi_Xpi_Xch_e_can f1 t_Xrx_Xpi_Xpi_Xch_e_Xmixn_Xs1_sel vdd sky130_fd_pr__pfet_01v8_lvt w=0.75 l=0.35
X516 t_Xrx_Xpi_Xpi_Xch_e_cbn f1 t_Xrx_Xpi_Xpi_Xch_e_Xmixn_Xs1_sel vss sky130_fd_pr__nfet_01v8_lvt w=0.42 l=0.15
X517 t_Xrx_Xpi_Xpi_Xch_e_cbn t_Xrx_Xpi_Xpi_fb1 t_Xrx_Xpi_Xpi_Xch_e_Xmixn_Xs1_sel vdd sky130_fd_pr__pfet_01v8_lvt w=0.75 l=0.35
X518 t_Xrx_Xpi_Xpi_Xch_e_Xmixn_Xs1_drv t_Xrx_Xpi_Xpi_Xch_e_Xmixn_Xs1_sel vss vss sky130_fd_pr__nfet_01v8_lvt w=0.45 l=0.15
X519 t_Xrx_Xpi_Xpi_Xch_e_Xmixn_Xs1_drv t_Xrx_Xpi_Xpi_Xch_e_Xmixn_Xs1_sel vdd vdd sky130_fd_pr__pfet_01v8 w=1.35 l=0.15
X520 t_Xrx_Xpi_Xpi_Xch_e_Xmixn_Xs1_drv t_Xrx_Xpi_Xpi_Xch_e_mixn vss sky130_fd_pr__res_high_po_0p69 l=10.8
X521 t_Xrx_Xpi_Xpi_Xch_e_can f1 t_Xrx_Xpi_Xpi_Xch_e_Xmixn_Xs1_dum vss sky130_fd_pr__nfet_01v8_lvt w=0.42 l=0.15
X522 t_Xrx_Xpi_Xpi_Xch_e_can t_Xrx_Xpi_Xpi_fb1 t_Xrx_Xpi_Xpi_Xch_e_Xmixn_Xs1_dum vdd sky130_fd_pr__pfet_01v8_lvt w=0.75 l=0.35
X523 t_Xrx_Xpi_Xpi_Xch_e_cbn t_Xrx_Xpi_Xpi_fb1 t_Xrx_Xpi_Xpi_Xch_e_Xmixn_Xs1_dum vss sky130_fd_pr__nfet_01v8_lvt w=0.42 l=0.15
X524 t_Xrx_Xpi_Xpi_Xch_e_cbn f1 t_Xrx_Xpi_Xpi_Xch_e_Xmixn_Xs1_dum vdd sky130_fd_pr__pfet_01v8_lvt w=0.75 l=0.35
X525 vss t_Xrx_Xpi_Xpi_Xch_e_Xmixn_Xs1_dum vss vss sky130_fd_pr__nfet_01v8_lvt w=0.45 l=0.15
X526 vdd t_Xrx_Xpi_Xpi_Xch_e_Xmixn_Xs1_dum vdd vdd sky130_fd_pr__pfet_01v8 w=1.35 l=0.15
X527 t_Xrx_Xpi_Xpi_Xch_e_can t_Xrx_Xpi_Xpi_fb2 t_Xrx_Xpi_Xpi_Xch_e_Xmixn_Xs2_sel vss sky130_fd_pr__nfet_01v8_lvt w=0.42 l=0.15
X528 t_Xrx_Xpi_Xpi_Xch_e_can f2 t_Xrx_Xpi_Xpi_Xch_e_Xmixn_Xs2_sel vdd sky130_fd_pr__pfet_01v8_lvt w=0.75 l=0.35
X529 t_Xrx_Xpi_Xpi_Xch_e_cbn f2 t_Xrx_Xpi_Xpi_Xch_e_Xmixn_Xs2_sel vss sky130_fd_pr__nfet_01v8_lvt w=0.42 l=0.15
X530 t_Xrx_Xpi_Xpi_Xch_e_cbn t_Xrx_Xpi_Xpi_fb2 t_Xrx_Xpi_Xpi_Xch_e_Xmixn_Xs2_sel vdd sky130_fd_pr__pfet_01v8_lvt w=0.75 l=0.35
X531 t_Xrx_Xpi_Xpi_Xch_e_Xmixn_Xs2_drv t_Xrx_Xpi_Xpi_Xch_e_Xmixn_Xs2_sel vss vss sky130_fd_pr__nfet_01v8_lvt w=0.45 l=0.15
X532 t_Xrx_Xpi_Xpi_Xch_e_Xmixn_Xs2_drv t_Xrx_Xpi_Xpi_Xch_e_Xmixn_Xs2_sel vdd vdd sky130_fd_pr__pfet_01v8 w=1.35 l=0.15
X533 t_Xrx_Xpi_Xpi_Xch_e_Xmixn_Xs2_drv t_Xrx_Xpi_Xpi_Xch_e_mixn vss sky130_fd_pr__res_high_po_0p69 l=10.8
X534 t_Xrx_Xpi_Xpi_Xch_e_can f2 t_Xrx_Xpi_Xpi_Xch_e_Xmixn_Xs2_dum vss sky130_fd_pr__nfet_01v8_lvt w=0.42 l=0.15
X535 t_Xrx_Xpi_Xpi_Xch_e_can t_Xrx_Xpi_Xpi_fb2 t_Xrx_Xpi_Xpi_Xch_e_Xmixn_Xs2_dum vdd sky130_fd_pr__pfet_01v8_lvt w=0.75 l=0.35
X536 t_Xrx_Xpi_Xpi_Xch_e_cbn t_Xrx_Xpi_Xpi_fb2 t_Xrx_Xpi_Xpi_Xch_e_Xmixn_Xs2_dum vss sky130_fd_pr__nfet_01v8_lvt w=0.42 l=0.15
X537 t_Xrx_Xpi_Xpi_Xch_e_cbn f2 t_Xrx_Xpi_Xpi_Xch_e_Xmixn_Xs2_dum vdd sky130_fd_pr__pfet_01v8_lvt w=0.75 l=0.35
X538 vss t_Xrx_Xpi_Xpi_Xch_e_Xmixn_Xs2_dum vss vss sky130_fd_pr__nfet_01v8_lvt w=0.45 l=0.15
X539 vdd t_Xrx_Xpi_Xpi_Xch_e_Xmixn_Xs2_dum vdd vdd sky130_fd_pr__pfet_01v8 w=1.35 l=0.15
X540 t_Xrx_Xpi_Xpi_Xch_e_can t_Xrx_Xpi_Xpi_fb3 t_Xrx_Xpi_Xpi_Xch_e_Xmixn_Xs3_sel vss sky130_fd_pr__nfet_01v8_lvt w=0.42 l=0.15
X541 t_Xrx_Xpi_Xpi_Xch_e_can f3 t_Xrx_Xpi_Xpi_Xch_e_Xmixn_Xs3_sel vdd sky130_fd_pr__pfet_01v8_lvt w=0.75 l=0.35
X542 t_Xrx_Xpi_Xpi_Xch_e_cbn f3 t_Xrx_Xpi_Xpi_Xch_e_Xmixn_Xs3_sel vss sky130_fd_pr__nfet_01v8_lvt w=0.42 l=0.15
X543 t_Xrx_Xpi_Xpi_Xch_e_cbn t_Xrx_Xpi_Xpi_fb3 t_Xrx_Xpi_Xpi_Xch_e_Xmixn_Xs3_sel vdd sky130_fd_pr__pfet_01v8_lvt w=0.75 l=0.35
X544 t_Xrx_Xpi_Xpi_Xch_e_Xmixn_Xs3_drv t_Xrx_Xpi_Xpi_Xch_e_Xmixn_Xs3_sel vss vss sky130_fd_pr__nfet_01v8_lvt w=0.45 l=0.15
X545 t_Xrx_Xpi_Xpi_Xch_e_Xmixn_Xs3_drv t_Xrx_Xpi_Xpi_Xch_e_Xmixn_Xs3_sel vdd vdd sky130_fd_pr__pfet_01v8 w=1.35 l=0.15
X546 t_Xrx_Xpi_Xpi_Xch_e_Xmixn_Xs3_drv t_Xrx_Xpi_Xpi_Xch_e_mixn vss sky130_fd_pr__res_high_po_0p69 l=10.8
X547 t_Xrx_Xpi_Xpi_Xch_e_can f3 t_Xrx_Xpi_Xpi_Xch_e_Xmixn_Xs3_dum vss sky130_fd_pr__nfet_01v8_lvt w=0.42 l=0.15
X548 t_Xrx_Xpi_Xpi_Xch_e_can t_Xrx_Xpi_Xpi_fb3 t_Xrx_Xpi_Xpi_Xch_e_Xmixn_Xs3_dum vdd sky130_fd_pr__pfet_01v8_lvt w=0.75 l=0.35
X549 t_Xrx_Xpi_Xpi_Xch_e_cbn t_Xrx_Xpi_Xpi_fb3 t_Xrx_Xpi_Xpi_Xch_e_Xmixn_Xs3_dum vss sky130_fd_pr__nfet_01v8_lvt w=0.42 l=0.15
X550 t_Xrx_Xpi_Xpi_Xch_e_cbn f3 t_Xrx_Xpi_Xpi_Xch_e_Xmixn_Xs3_dum vdd sky130_fd_pr__pfet_01v8_lvt w=0.75 l=0.35
X551 vss t_Xrx_Xpi_Xpi_Xch_e_Xmixn_Xs3_dum vss vss sky130_fd_pr__nfet_01v8_lvt w=0.45 l=0.15
X552 vdd t_Xrx_Xpi_Xpi_Xch_e_Xmixn_Xs3_dum vdd vdd sky130_fd_pr__pfet_01v8 w=1.35 l=0.15
X553 t_Xrx_Xpi_Xpi_Xch_e_can t_Xrx_Xpi_Xpi_fb4 t_Xrx_Xpi_Xpi_Xch_e_Xmixn_Xs4_sel vss sky130_fd_pr__nfet_01v8_lvt w=0.42 l=0.15
X554 t_Xrx_Xpi_Xpi_Xch_e_can f4 t_Xrx_Xpi_Xpi_Xch_e_Xmixn_Xs4_sel vdd sky130_fd_pr__pfet_01v8_lvt w=0.75 l=0.35
X555 t_Xrx_Xpi_Xpi_Xch_e_cbn f4 t_Xrx_Xpi_Xpi_Xch_e_Xmixn_Xs4_sel vss sky130_fd_pr__nfet_01v8_lvt w=0.42 l=0.15
X556 t_Xrx_Xpi_Xpi_Xch_e_cbn t_Xrx_Xpi_Xpi_fb4 t_Xrx_Xpi_Xpi_Xch_e_Xmixn_Xs4_sel vdd sky130_fd_pr__pfet_01v8_lvt w=0.75 l=0.35
X557 t_Xrx_Xpi_Xpi_Xch_e_Xmixn_Xs4_drv t_Xrx_Xpi_Xpi_Xch_e_Xmixn_Xs4_sel vss vss sky130_fd_pr__nfet_01v8_lvt w=0.45 l=0.15
X558 t_Xrx_Xpi_Xpi_Xch_e_Xmixn_Xs4_drv t_Xrx_Xpi_Xpi_Xch_e_Xmixn_Xs4_sel vdd vdd sky130_fd_pr__pfet_01v8 w=1.35 l=0.15
X559 t_Xrx_Xpi_Xpi_Xch_e_Xmixn_Xs4_drv t_Xrx_Xpi_Xpi_Xch_e_mixn vss sky130_fd_pr__res_high_po_0p69 l=10.8
X560 t_Xrx_Xpi_Xpi_Xch_e_can f4 t_Xrx_Xpi_Xpi_Xch_e_Xmixn_Xs4_dum vss sky130_fd_pr__nfet_01v8_lvt w=0.42 l=0.15
X561 t_Xrx_Xpi_Xpi_Xch_e_can t_Xrx_Xpi_Xpi_fb4 t_Xrx_Xpi_Xpi_Xch_e_Xmixn_Xs4_dum vdd sky130_fd_pr__pfet_01v8_lvt w=0.75 l=0.35
X562 t_Xrx_Xpi_Xpi_Xch_e_cbn t_Xrx_Xpi_Xpi_fb4 t_Xrx_Xpi_Xpi_Xch_e_Xmixn_Xs4_dum vss sky130_fd_pr__nfet_01v8_lvt w=0.42 l=0.15
X563 t_Xrx_Xpi_Xpi_Xch_e_cbn f4 t_Xrx_Xpi_Xpi_Xch_e_Xmixn_Xs4_dum vdd sky130_fd_pr__pfet_01v8_lvt w=0.75 l=0.35
X564 vss t_Xrx_Xpi_Xpi_Xch_e_Xmixn_Xs4_dum vss vss sky130_fd_pr__nfet_01v8_lvt w=0.45 l=0.15
X565 vdd t_Xrx_Xpi_Xpi_Xch_e_Xmixn_Xs4_dum vdd vdd sky130_fd_pr__pfet_01v8 w=1.35 l=0.15
X566 t_Xrx_Xpi_Xpi_Xch_e_can t_Xrx_Xpi_Xpi_fb5 t_Xrx_Xpi_Xpi_Xch_e_Xmixn_Xs5_sel vss sky130_fd_pr__nfet_01v8_lvt w=0.42 l=0.15
X567 t_Xrx_Xpi_Xpi_Xch_e_can f5 t_Xrx_Xpi_Xpi_Xch_e_Xmixn_Xs5_sel vdd sky130_fd_pr__pfet_01v8_lvt w=0.75 l=0.35
X568 t_Xrx_Xpi_Xpi_Xch_e_cbn f5 t_Xrx_Xpi_Xpi_Xch_e_Xmixn_Xs5_sel vss sky130_fd_pr__nfet_01v8_lvt w=0.42 l=0.15
X569 t_Xrx_Xpi_Xpi_Xch_e_cbn t_Xrx_Xpi_Xpi_fb5 t_Xrx_Xpi_Xpi_Xch_e_Xmixn_Xs5_sel vdd sky130_fd_pr__pfet_01v8_lvt w=0.75 l=0.35
X570 t_Xrx_Xpi_Xpi_Xch_e_Xmixn_Xs5_drv t_Xrx_Xpi_Xpi_Xch_e_Xmixn_Xs5_sel vss vss sky130_fd_pr__nfet_01v8_lvt w=0.45 l=0.15
X571 t_Xrx_Xpi_Xpi_Xch_e_Xmixn_Xs5_drv t_Xrx_Xpi_Xpi_Xch_e_Xmixn_Xs5_sel vdd vdd sky130_fd_pr__pfet_01v8 w=1.35 l=0.15
X572 t_Xrx_Xpi_Xpi_Xch_e_Xmixn_Xs5_drv t_Xrx_Xpi_Xpi_Xch_e_mixn vss sky130_fd_pr__res_high_po_0p69 l=10.8
X573 t_Xrx_Xpi_Xpi_Xch_e_can f5 t_Xrx_Xpi_Xpi_Xch_e_Xmixn_Xs5_dum vss sky130_fd_pr__nfet_01v8_lvt w=0.42 l=0.15
X574 t_Xrx_Xpi_Xpi_Xch_e_can t_Xrx_Xpi_Xpi_fb5 t_Xrx_Xpi_Xpi_Xch_e_Xmixn_Xs5_dum vdd sky130_fd_pr__pfet_01v8_lvt w=0.75 l=0.35
X575 t_Xrx_Xpi_Xpi_Xch_e_cbn t_Xrx_Xpi_Xpi_fb5 t_Xrx_Xpi_Xpi_Xch_e_Xmixn_Xs5_dum vss sky130_fd_pr__nfet_01v8_lvt w=0.42 l=0.15
X576 t_Xrx_Xpi_Xpi_Xch_e_cbn f5 t_Xrx_Xpi_Xpi_Xch_e_Xmixn_Xs5_dum vdd sky130_fd_pr__pfet_01v8_lvt w=0.75 l=0.35
X577 vss t_Xrx_Xpi_Xpi_Xch_e_Xmixn_Xs5_dum vss vss sky130_fd_pr__nfet_01v8_lvt w=0.45 l=0.15
X578 vdd t_Xrx_Xpi_Xpi_Xch_e_Xmixn_Xs5_dum vdd vdd sky130_fd_pr__pfet_01v8 w=1.35 l=0.15
X579 t_Xrx_Xpi_Xpi_Xch_e_can t_Xrx_Xpi_Xpi_fb6 t_Xrx_Xpi_Xpi_Xch_e_Xmixn_Xs6_sel vss sky130_fd_pr__nfet_01v8_lvt w=0.42 l=0.15
X580 t_Xrx_Xpi_Xpi_Xch_e_can f6 t_Xrx_Xpi_Xpi_Xch_e_Xmixn_Xs6_sel vdd sky130_fd_pr__pfet_01v8_lvt w=0.75 l=0.35
X581 t_Xrx_Xpi_Xpi_Xch_e_cbn f6 t_Xrx_Xpi_Xpi_Xch_e_Xmixn_Xs6_sel vss sky130_fd_pr__nfet_01v8_lvt w=0.42 l=0.15
X582 t_Xrx_Xpi_Xpi_Xch_e_cbn t_Xrx_Xpi_Xpi_fb6 t_Xrx_Xpi_Xpi_Xch_e_Xmixn_Xs6_sel vdd sky130_fd_pr__pfet_01v8_lvt w=0.75 l=0.35
X583 t_Xrx_Xpi_Xpi_Xch_e_Xmixn_Xs6_drv t_Xrx_Xpi_Xpi_Xch_e_Xmixn_Xs6_sel vss vss sky130_fd_pr__nfet_01v8_lvt w=0.45 l=0.15
X584 t_Xrx_Xpi_Xpi_Xch_e_Xmixn_Xs6_drv t_Xrx_Xpi_Xpi_Xch_e_Xmixn_Xs6_sel vdd vdd sky130_fd_pr__pfet_01v8 w=1.35 l=0.15
X585 t_Xrx_Xpi_Xpi_Xch_e_Xmixn_Xs6_drv t_Xrx_Xpi_Xpi_Xch_e_mixn vss sky130_fd_pr__res_high_po_0p69 l=10.8
X586 t_Xrx_Xpi_Xpi_Xch_e_can f6 t_Xrx_Xpi_Xpi_Xch_e_Xmixn_Xs6_dum vss sky130_fd_pr__nfet_01v8_lvt w=0.42 l=0.15
X587 t_Xrx_Xpi_Xpi_Xch_e_can t_Xrx_Xpi_Xpi_fb6 t_Xrx_Xpi_Xpi_Xch_e_Xmixn_Xs6_dum vdd sky130_fd_pr__pfet_01v8_lvt w=0.75 l=0.35
X588 t_Xrx_Xpi_Xpi_Xch_e_cbn t_Xrx_Xpi_Xpi_fb6 t_Xrx_Xpi_Xpi_Xch_e_Xmixn_Xs6_dum vss sky130_fd_pr__nfet_01v8_lvt w=0.42 l=0.15
X589 t_Xrx_Xpi_Xpi_Xch_e_cbn f6 t_Xrx_Xpi_Xpi_Xch_e_Xmixn_Xs6_dum vdd sky130_fd_pr__pfet_01v8_lvt w=0.75 l=0.35
X590 vss t_Xrx_Xpi_Xpi_Xch_e_Xmixn_Xs6_dum vss vss sky130_fd_pr__nfet_01v8_lvt w=0.45 l=0.15
X591 vdd t_Xrx_Xpi_Xpi_Xch_e_Xmixn_Xs6_dum vdd vdd sky130_fd_pr__pfet_01v8 w=1.35 l=0.15
X592 t_Xrx_Xpi_Xpi_Xch_e_can t_Xrx_Xpi_Xpi_fb7 t_Xrx_Xpi_Xpi_Xch_e_Xmixn_Xs7_sel vss sky130_fd_pr__nfet_01v8_lvt w=0.42 l=0.15
X593 t_Xrx_Xpi_Xpi_Xch_e_can f7 t_Xrx_Xpi_Xpi_Xch_e_Xmixn_Xs7_sel vdd sky130_fd_pr__pfet_01v8_lvt w=0.75 l=0.35
X594 t_Xrx_Xpi_Xpi_Xch_e_cbn f7 t_Xrx_Xpi_Xpi_Xch_e_Xmixn_Xs7_sel vss sky130_fd_pr__nfet_01v8_lvt w=0.42 l=0.15
X595 t_Xrx_Xpi_Xpi_Xch_e_cbn t_Xrx_Xpi_Xpi_fb7 t_Xrx_Xpi_Xpi_Xch_e_Xmixn_Xs7_sel vdd sky130_fd_pr__pfet_01v8_lvt w=0.75 l=0.35
X596 t_Xrx_Xpi_Xpi_Xch_e_Xmixn_Xs7_drv t_Xrx_Xpi_Xpi_Xch_e_Xmixn_Xs7_sel vss vss sky130_fd_pr__nfet_01v8_lvt w=0.45 l=0.15
X597 t_Xrx_Xpi_Xpi_Xch_e_Xmixn_Xs7_drv t_Xrx_Xpi_Xpi_Xch_e_Xmixn_Xs7_sel vdd vdd sky130_fd_pr__pfet_01v8 w=1.35 l=0.15
X598 t_Xrx_Xpi_Xpi_Xch_e_Xmixn_Xs7_drv t_Xrx_Xpi_Xpi_Xch_e_mixn vss sky130_fd_pr__res_high_po_0p69 l=10.8
X599 t_Xrx_Xpi_Xpi_Xch_e_can f7 t_Xrx_Xpi_Xpi_Xch_e_Xmixn_Xs7_dum vss sky130_fd_pr__nfet_01v8_lvt w=0.42 l=0.15
X600 t_Xrx_Xpi_Xpi_Xch_e_can t_Xrx_Xpi_Xpi_fb7 t_Xrx_Xpi_Xpi_Xch_e_Xmixn_Xs7_dum vdd sky130_fd_pr__pfet_01v8_lvt w=0.75 l=0.35
X601 t_Xrx_Xpi_Xpi_Xch_e_cbn t_Xrx_Xpi_Xpi_fb7 t_Xrx_Xpi_Xpi_Xch_e_Xmixn_Xs7_dum vss sky130_fd_pr__nfet_01v8_lvt w=0.42 l=0.15
X602 t_Xrx_Xpi_Xpi_Xch_e_cbn f7 t_Xrx_Xpi_Xpi_Xch_e_Xmixn_Xs7_dum vdd sky130_fd_pr__pfet_01v8_lvt w=0.75 l=0.35
X603 vss t_Xrx_Xpi_Xpi_Xch_e_Xmixn_Xs7_dum vss vss sky130_fd_pr__nfet_01v8_lvt w=0.45 l=0.15
X604 vdd t_Xrx_Xpi_Xpi_Xch_e_Xmixn_Xs7_dum vdd vdd sky130_fd_pr__pfet_01v8 w=1.35 l=0.15
X605 t_Xrx_Xpi_Xpi_Xch_e_mixn vss sky130_fd_pr__cap_mim_m3_1 w=4.1 l=4.1
X606 t_Xrx_Xpi_Xpi_Xch_e_mixp t_Xrx_Xpi_Xpi_Xch_e_Xrec_acp sky130_fd_pr__cap_mim_m3_1 w=4.1 l=4.1
X607 t_Xrx_Xpi_Xpi_Xch_e_mixn t_Xrx_Xpi_Xpi_Xch_e_Xrec_acn sky130_fd_pr__cap_mim_m3_1 w=4.1 l=4.1
X608 t_Xrx_Xpi_Xpi_Xch_e_Xrec_acp t_Xrx_Xpi_Xpi_Xch_e_r1p vss sky130_fd_pr__res_high_po_0p35 l=10.5
X609 t_Xrx_Xpi_Xpi_Xch_e_Xrec_acn t_Xrx_Xpi_Xpi_Xch_e_r1n vss sky130_fd_pr__res_high_po_0p35 l=10.5
X610 t_Xrx_Xpi_Xpi_Xch_e_r1p t_Xrx_Xpi_Xpi_Xch_e_Xrec_acp vss vss sky130_fd_pr__nfet_01v8_lvt w=0.8 l=0.15
X611 t_Xrx_Xpi_Xpi_Xch_e_r1p t_Xrx_Xpi_Xpi_Xch_e_Xrec_acp vdd vdd sky130_fd_pr__pfet_01v8_lvt w=2.6 l=0.35
X612 t_Xrx_Xpi_Xpi_Xch_e_r1n t_Xrx_Xpi_Xpi_Xch_e_Xrec_acn vss vss sky130_fd_pr__nfet_01v8_lvt w=0.8 l=0.15
X613 t_Xrx_Xpi_Xpi_Xch_e_r1n t_Xrx_Xpi_Xpi_Xch_e_Xrec_acn vdd vdd sky130_fd_pr__pfet_01v8_lvt w=2.6 l=0.35
X614 t_Xrx_ep t_Xrx_Xpi_Xpi_Xch_e_r1n vss vss sky130_fd_pr__nfet_01v8_lvt w=0.95 l=0.15
X615 t_Xrx_ep t_Xrx_Xpi_Xpi_Xch_e_r1n vdd vdd sky130_fd_pr__pfet_01v8_lvt w=3.1 l=0.35
X616 t_Xrx_en t_Xrx_Xpi_Xpi_Xch_e_r1p vss vss sky130_fd_pr__nfet_01v8_lvt w=0.95 l=0.15
X617 t_Xrx_en t_Xrx_Xpi_Xpi_Xch_e_r1p vdd vdd sky130_fd_pr__pfet_01v8_lvt w=3.1 l=0.35
X618 t_Xrx_Xpi_Xdiv_rst rst_n vss vss sky130_fd_pr__nfet_01v8 w=0.6 l=0.18
X619 t_Xrx_Xpi_Xdiv_rst rst_n vdd vdd sky130_fd_pr__pfet_01v8 w=1.2 l=0.18
X620 t_Xrx_Xpi_Xdiv_dp_ckb t_Xrx_dp t_Xrx_Xpi_Xdiv_Xg_dpb_mid vss sky130_fd_pr__nfet_01v8_lvt w=1.1 l=0.15
X621 t_Xrx_Xpi_Xdiv_Xg_dpb_mid rst_n vss vss sky130_fd_pr__nfet_01v8_lvt w=1.1 l=0.15
X622 t_Xrx_Xpi_Xdiv_dp_ckb t_Xrx_dp vdd vdd sky130_fd_pr__pfet_01v8 w=2 l=0.15
X623 t_Xrx_Xpi_Xdiv_dp_ckb rst_n vdd vdd sky130_fd_pr__pfet_01v8 w=2 l=0.15
X624 t_Xrx_Xpi_Xdiv_dn_ckb t_Xrx_dn t_Xrx_Xpi_Xdiv_Xg_dnb_mid vss sky130_fd_pr__nfet_01v8_lvt w=1.1 l=0.15
X625 t_Xrx_Xpi_Xdiv_Xg_dnb_mid rst_n vss vss sky130_fd_pr__nfet_01v8_lvt w=1.1 l=0.15
X626 t_Xrx_Xpi_Xdiv_dn_ckb t_Xrx_dn vdd vdd sky130_fd_pr__pfet_01v8 w=2 l=0.15
X627 t_Xrx_Xpi_Xdiv_dn_ckb rst_n vdd vdd sky130_fd_pr__pfet_01v8 w=2 l=0.15
X628 t_Xrx_Xpi_Xdiv_ep_ckb t_Xrx_ep t_Xrx_Xpi_Xdiv_Xg_epb_mid vss sky130_fd_pr__nfet_01v8_lvt w=1.1 l=0.15
X629 t_Xrx_Xpi_Xdiv_Xg_epb_mid rst_n vss vss sky130_fd_pr__nfet_01v8_lvt w=1.1 l=0.15
X630 t_Xrx_Xpi_Xdiv_ep_ckb t_Xrx_ep vdd vdd sky130_fd_pr__pfet_01v8 w=2 l=0.15
X631 t_Xrx_Xpi_Xdiv_ep_ckb rst_n vdd vdd sky130_fd_pr__pfet_01v8 w=2 l=0.15
X632 t_Xrx_Xpi_Xdiv_en_ckb t_Xrx_en t_Xrx_Xpi_Xdiv_Xg_enb_mid vss sky130_fd_pr__nfet_01v8_lvt w=1.1 l=0.15
X633 t_Xrx_Xpi_Xdiv_Xg_enb_mid rst_n vss vss sky130_fd_pr__nfet_01v8_lvt w=1.1 l=0.15
X634 t_Xrx_Xpi_Xdiv_en_ckb t_Xrx_en vdd vdd sky130_fd_pr__pfet_01v8 w=2 l=0.15
X635 t_Xrx_Xpi_Xdiv_en_ckb rst_n vdd vdd sky130_fd_pr__pfet_01v8 w=2 l=0.15
X636 t_Xrx_Xpi_Xdiv_dp_ck t_Xrx_Xpi_Xdiv_dp_ckb vss vss sky130_fd_pr__nfet_01v8_lvt w=1 l=0.15
X637 t_Xrx_Xpi_Xdiv_dp_ck t_Xrx_Xpi_Xdiv_dp_ckb vdd vdd sky130_fd_pr__pfet_01v8 w=2.7 l=0.15
X638 t_Xrx_Xpi_Xdiv_dn_ck t_Xrx_Xpi_Xdiv_dn_ckb vss vss sky130_fd_pr__nfet_01v8_lvt w=1 l=0.15
X639 t_Xrx_Xpi_Xdiv_dn_ck t_Xrx_Xpi_Xdiv_dn_ckb vdd vdd sky130_fd_pr__pfet_01v8 w=2.7 l=0.15
X640 t_Xrx_Xpi_Xdiv_ep_ck t_Xrx_Xpi_Xdiv_ep_ckb vss vss sky130_fd_pr__nfet_01v8_lvt w=1 l=0.15
X641 t_Xrx_Xpi_Xdiv_ep_ck t_Xrx_Xpi_Xdiv_ep_ckb vdd vdd sky130_fd_pr__pfet_01v8 w=2.7 l=0.15
X642 t_Xrx_Xpi_Xdiv_en_ck t_Xrx_Xpi_Xdiv_en_ckb vss vss sky130_fd_pr__nfet_01v8_lvt w=1 l=0.15
X643 t_Xrx_Xpi_Xdiv_en_ck t_Xrx_Xpi_Xdiv_en_ckb vdd vdd sky130_fd_pr__pfet_01v8 w=2.7 l=0.15
X644 t_Xrx_Xpi_Xdiv_d3 t_Xrx_Xpi_Xdiv_dp_ck t_Xrx_Xpi_Xdiv_Xld0_int_p vss sky130_fd_pr__nfet_01v8_lvt w=1 l=0.15
X645 t_Xrx_Xpi_Xdiv_d3 t_Xrx_Xpi_Xdiv_dp_ckb t_Xrx_Xpi_Xdiv_Xld0_int_p vdd sky130_fd_pr__pfet_01v8 w=2.4 l=0.15
X646 t_Xrx_Xpi_Xdiv_d1 t_Xrx_Xpi_Xdiv_dp_ck t_Xrx_Xpi_Xdiv_Xld0_int_n vss sky130_fd_pr__nfet_01v8_lvt w=1 l=0.15
X647 t_Xrx_Xpi_Xdiv_d1 t_Xrx_Xpi_Xdiv_dp_ckb t_Xrx_Xpi_Xdiv_Xld0_int_n vdd sky130_fd_pr__pfet_01v8 w=2.4 l=0.15
X648 t_Xrx_Xpi_Xdiv_Xld0_int_p t_Xrx_Xpi_Xdiv_Xld0_int_n vdd vdd sky130_fd_pr__pfet_01v8 w=0.5 l=0.15
X649 t_Xrx_Xpi_Xdiv_Xld0_int_p t_Xrx_Xpi_Xdiv_Xld0_int_n vss vss sky130_fd_pr__nfet_01v8_lvt w=0.42 l=0.15
X650 t_Xrx_Xpi_Xdiv_Xld0_int_n t_Xrx_Xpi_Xdiv_Xld0_int_p vdd vdd sky130_fd_pr__pfet_01v8 w=0.5 l=0.15
X651 t_Xrx_Xpi_Xdiv_Xld0_int_n t_Xrx_Xpi_Xdiv_Xld0_int_p vss vss sky130_fd_pr__nfet_01v8_lvt w=0.42 l=0.15
X652 t_Xrx_Xpi_Xdiv_Xld0_int_p t_Xrx_Xpi_Xdiv_rst vss vss sky130_fd_pr__nfet_01v8 w=1 l=0.18
X653 t_Xrx_Xpi_Xdiv_Xld0_int_n rst_n vdd vdd sky130_fd_pr__pfet_01v8 w=1.8 l=0.18
X654 t_Xrx_Xpi_Xdiv_d0 t_Xrx_Xpi_Xdiv_Xld0_int_n vss vss sky130_fd_pr__nfet_01v8_lvt w=1.25 l=0.15
X655 t_Xrx_Xpi_Xdiv_d0 t_Xrx_Xpi_Xdiv_Xld0_int_n vdd vdd sky130_fd_pr__pfet_01v8 w=3.3 l=0.15
X656 t_Xrx_Xpi_Xdiv_d2 t_Xrx_Xpi_Xdiv_Xld0_int_p vss vss sky130_fd_pr__nfet_01v8_lvt w=1.25 l=0.15
X657 t_Xrx_Xpi_Xdiv_d2 t_Xrx_Xpi_Xdiv_Xld0_int_p vdd vdd sky130_fd_pr__pfet_01v8 w=3.3 l=0.15
X658 t_Xrx_Xpi_Xdiv_d2 t_Xrx_Xpi_Xdiv_d0 vss vss sky130_fd_pr__nfet_01v8_lvt w=0.42 l=0.15
X659 t_Xrx_Xpi_Xdiv_d2 t_Xrx_Xpi_Xdiv_d0 vdd vdd sky130_fd_pr__pfet_01v8 w=1 l=0.15
X660 t_Xrx_Xpi_Xdiv_d0 t_Xrx_Xpi_Xdiv_d2 vss vss sky130_fd_pr__nfet_01v8_lvt w=0.42 l=0.15
X661 t_Xrx_Xpi_Xdiv_d0 t_Xrx_Xpi_Xdiv_d2 vdd vdd sky130_fd_pr__pfet_01v8 w=1 l=0.15
X662 t_Xrx_Xpi_Xdiv_d0 t_Xrx_Xpi_Xdiv_dn_ck t_Xrx_Xpi_Xdiv_Xld1_int_p vss sky130_fd_pr__nfet_01v8_lvt w=1 l=0.15
X663 t_Xrx_Xpi_Xdiv_d0 t_Xrx_Xpi_Xdiv_dn_ckb t_Xrx_Xpi_Xdiv_Xld1_int_p vdd sky130_fd_pr__pfet_01v8 w=2.4 l=0.15
X664 t_Xrx_Xpi_Xdiv_d2 t_Xrx_Xpi_Xdiv_dn_ck t_Xrx_Xpi_Xdiv_Xld1_int_n vss sky130_fd_pr__nfet_01v8_lvt w=1 l=0.15
X665 t_Xrx_Xpi_Xdiv_d2 t_Xrx_Xpi_Xdiv_dn_ckb t_Xrx_Xpi_Xdiv_Xld1_int_n vdd sky130_fd_pr__pfet_01v8 w=2.4 l=0.15
X666 t_Xrx_Xpi_Xdiv_Xld1_int_p t_Xrx_Xpi_Xdiv_Xld1_int_n vdd vdd sky130_fd_pr__pfet_01v8 w=0.5 l=0.15
X667 t_Xrx_Xpi_Xdiv_Xld1_int_p t_Xrx_Xpi_Xdiv_Xld1_int_n vss vss sky130_fd_pr__nfet_01v8_lvt w=0.42 l=0.15
X668 t_Xrx_Xpi_Xdiv_Xld1_int_n t_Xrx_Xpi_Xdiv_Xld1_int_p vdd vdd sky130_fd_pr__pfet_01v8 w=0.5 l=0.15
X669 t_Xrx_Xpi_Xdiv_Xld1_int_n t_Xrx_Xpi_Xdiv_Xld1_int_p vss vss sky130_fd_pr__nfet_01v8_lvt w=0.42 l=0.15
X670 t_Xrx_Xpi_Xdiv_Xld1_int_p t_Xrx_Xpi_Xdiv_rst vss vss sky130_fd_pr__nfet_01v8 w=1 l=0.18
X671 t_Xrx_Xpi_Xdiv_Xld1_int_n rst_n vdd vdd sky130_fd_pr__pfet_01v8 w=1.8 l=0.18
X672 t_Xrx_Xpi_Xdiv_d1 t_Xrx_Xpi_Xdiv_Xld1_int_n vss vss sky130_fd_pr__nfet_01v8_lvt w=1.25 l=0.15
X673 t_Xrx_Xpi_Xdiv_d1 t_Xrx_Xpi_Xdiv_Xld1_int_n vdd vdd sky130_fd_pr__pfet_01v8 w=3.3 l=0.15
X674 t_Xrx_Xpi_Xdiv_d3 t_Xrx_Xpi_Xdiv_Xld1_int_p vss vss sky130_fd_pr__nfet_01v8_lvt w=1.25 l=0.15
X675 t_Xrx_Xpi_Xdiv_d3 t_Xrx_Xpi_Xdiv_Xld1_int_p vdd vdd sky130_fd_pr__pfet_01v8 w=3.3 l=0.15
X676 t_Xrx_Xpi_Xdiv_d3 t_Xrx_Xpi_Xdiv_d1 vss vss sky130_fd_pr__nfet_01v8_lvt w=0.42 l=0.15
X677 t_Xrx_Xpi_Xdiv_d3 t_Xrx_Xpi_Xdiv_d1 vdd vdd sky130_fd_pr__pfet_01v8 w=1 l=0.15
X678 t_Xrx_Xpi_Xdiv_d1 t_Xrx_Xpi_Xdiv_d3 vss vss sky130_fd_pr__nfet_01v8_lvt w=0.42 l=0.15
X679 t_Xrx_Xpi_Xdiv_d1 t_Xrx_Xpi_Xdiv_d3 vdd vdd sky130_fd_pr__pfet_01v8 w=1 l=0.15
X680 t_Xrx_Xpi_Xdiv_d0 t_Xrx_Xpi_Xdiv_ep_ck t_Xrx_Xpi_Xdiv_Xle0_int_p vss sky130_fd_pr__nfet_01v8_lvt w=1 l=0.15
X681 t_Xrx_Xpi_Xdiv_d0 t_Xrx_Xpi_Xdiv_ep_ckb t_Xrx_Xpi_Xdiv_Xle0_int_p vdd sky130_fd_pr__pfet_01v8 w=2.4 l=0.15
X682 t_Xrx_Xpi_Xdiv_d2 t_Xrx_Xpi_Xdiv_ep_ck t_Xrx_Xpi_Xdiv_Xle0_int_n vss sky130_fd_pr__nfet_01v8_lvt w=1 l=0.15
X683 t_Xrx_Xpi_Xdiv_d2 t_Xrx_Xpi_Xdiv_ep_ckb t_Xrx_Xpi_Xdiv_Xle0_int_n vdd sky130_fd_pr__pfet_01v8 w=2.4 l=0.15
X684 t_Xrx_Xpi_Xdiv_Xle0_int_p t_Xrx_Xpi_Xdiv_Xle0_int_n vdd vdd sky130_fd_pr__pfet_01v8 w=0.5 l=0.15
X685 t_Xrx_Xpi_Xdiv_Xle0_int_p t_Xrx_Xpi_Xdiv_Xle0_int_n vss vss sky130_fd_pr__nfet_01v8_lvt w=0.42 l=0.15
X686 t_Xrx_Xpi_Xdiv_Xle0_int_n t_Xrx_Xpi_Xdiv_Xle0_int_p vdd vdd sky130_fd_pr__pfet_01v8 w=0.5 l=0.15
X687 t_Xrx_Xpi_Xdiv_Xle0_int_n t_Xrx_Xpi_Xdiv_Xle0_int_p vss vss sky130_fd_pr__nfet_01v8_lvt w=0.42 l=0.15
X688 t_Xrx_Xpi_Xdiv_Xle0_int_p t_Xrx_Xpi_Xdiv_rst vss vss sky130_fd_pr__nfet_01v8 w=1 l=0.18
X689 t_Xrx_Xpi_Xdiv_Xle0_int_n rst_n vdd vdd sky130_fd_pr__pfet_01v8 w=1.8 l=0.18
X690 t_Xrx_Xpi_Xdiv_e0 t_Xrx_Xpi_Xdiv_Xle0_int_n vss vss sky130_fd_pr__nfet_01v8_lvt w=1.25 l=0.15
X691 t_Xrx_Xpi_Xdiv_e0 t_Xrx_Xpi_Xdiv_Xle0_int_n vdd vdd sky130_fd_pr__pfet_01v8 w=3.3 l=0.15
X692 t_Xrx_Xpi_Xdiv_e2 t_Xrx_Xpi_Xdiv_Xle0_int_p vss vss sky130_fd_pr__nfet_01v8_lvt w=1.25 l=0.15
X693 t_Xrx_Xpi_Xdiv_e2 t_Xrx_Xpi_Xdiv_Xle0_int_p vdd vdd sky130_fd_pr__pfet_01v8 w=3.3 l=0.15
X694 t_Xrx_Xpi_Xdiv_e2 t_Xrx_Xpi_Xdiv_e0 vss vss sky130_fd_pr__nfet_01v8_lvt w=0.42 l=0.15
X695 t_Xrx_Xpi_Xdiv_e2 t_Xrx_Xpi_Xdiv_e0 vdd vdd sky130_fd_pr__pfet_01v8 w=1 l=0.15
X696 t_Xrx_Xpi_Xdiv_e0 t_Xrx_Xpi_Xdiv_e2 vss vss sky130_fd_pr__nfet_01v8_lvt w=0.42 l=0.15
X697 t_Xrx_Xpi_Xdiv_e0 t_Xrx_Xpi_Xdiv_e2 vdd vdd sky130_fd_pr__pfet_01v8 w=1 l=0.15
X698 t_Xrx_Xpi_Xdiv_d1 t_Xrx_Xpi_Xdiv_en_ck t_Xrx_Xpi_Xdiv_Xle1_int_p vss sky130_fd_pr__nfet_01v8_lvt w=1 l=0.15
X699 t_Xrx_Xpi_Xdiv_d1 t_Xrx_Xpi_Xdiv_en_ckb t_Xrx_Xpi_Xdiv_Xle1_int_p vdd sky130_fd_pr__pfet_01v8 w=2.4 l=0.15
X700 t_Xrx_Xpi_Xdiv_d3 t_Xrx_Xpi_Xdiv_en_ck t_Xrx_Xpi_Xdiv_Xle1_int_n vss sky130_fd_pr__nfet_01v8_lvt w=1 l=0.15
X701 t_Xrx_Xpi_Xdiv_d3 t_Xrx_Xpi_Xdiv_en_ckb t_Xrx_Xpi_Xdiv_Xle1_int_n vdd sky130_fd_pr__pfet_01v8 w=2.4 l=0.15
X702 t_Xrx_Xpi_Xdiv_Xle1_int_p t_Xrx_Xpi_Xdiv_Xle1_int_n vdd vdd sky130_fd_pr__pfet_01v8 w=0.5 l=0.15
X703 t_Xrx_Xpi_Xdiv_Xle1_int_p t_Xrx_Xpi_Xdiv_Xle1_int_n vss vss sky130_fd_pr__nfet_01v8_lvt w=0.42 l=0.15
X704 t_Xrx_Xpi_Xdiv_Xle1_int_n t_Xrx_Xpi_Xdiv_Xle1_int_p vdd vdd sky130_fd_pr__pfet_01v8 w=0.5 l=0.15
X705 t_Xrx_Xpi_Xdiv_Xle1_int_n t_Xrx_Xpi_Xdiv_Xle1_int_p vss vss sky130_fd_pr__nfet_01v8_lvt w=0.42 l=0.15
X706 t_Xrx_Xpi_Xdiv_Xle1_int_p t_Xrx_Xpi_Xdiv_rst vss vss sky130_fd_pr__nfet_01v8 w=1 l=0.18
X707 t_Xrx_Xpi_Xdiv_Xle1_int_n rst_n vdd vdd sky130_fd_pr__pfet_01v8 w=1.8 l=0.18
X708 t_Xrx_Xpi_Xdiv_e1 t_Xrx_Xpi_Xdiv_Xle1_int_n vss vss sky130_fd_pr__nfet_01v8_lvt w=1.25 l=0.15
X709 t_Xrx_Xpi_Xdiv_e1 t_Xrx_Xpi_Xdiv_Xle1_int_n vdd vdd sky130_fd_pr__pfet_01v8 w=3.3 l=0.15
X710 t_Xrx_Xpi_Xdiv_e3 t_Xrx_Xpi_Xdiv_Xle1_int_p vss vss sky130_fd_pr__nfet_01v8_lvt w=1.25 l=0.15
X711 t_Xrx_Xpi_Xdiv_e3 t_Xrx_Xpi_Xdiv_Xle1_int_p vdd vdd sky130_fd_pr__pfet_01v8 w=3.3 l=0.15
X712 t_Xrx_Xpi_Xdiv_e3 t_Xrx_Xpi_Xdiv_e1 vss vss sky130_fd_pr__nfet_01v8_lvt w=0.42 l=0.15
X713 t_Xrx_Xpi_Xdiv_e3 t_Xrx_Xpi_Xdiv_e1 vdd vdd sky130_fd_pr__pfet_01v8 w=1 l=0.15
X714 t_Xrx_Xpi_Xdiv_e1 t_Xrx_Xpi_Xdiv_e3 vss vss sky130_fd_pr__nfet_01v8_lvt w=0.42 l=0.15
X715 t_Xrx_Xpi_Xdiv_e1 t_Xrx_Xpi_Xdiv_e3 vdd vdd sky130_fd_pr__pfet_01v8 w=1 l=0.15
X716 t_Xrx_Xpi_Xdiv_e0 vss vss vss sky130_fd_pr__nfet_01v8_lvt w=1 l=0.15
X717 t_Xrx_Xpi_Xdiv_e0 vdd vdd vdd sky130_fd_pr__pfet_01v8 w=2.4 l=0.15
X718 t_Xrx_Xpi_Xdiv_e2 vss vss vss sky130_fd_pr__nfet_01v8_lvt w=1 l=0.15
X719 t_Xrx_Xpi_Xdiv_e2 vdd vdd vdd sky130_fd_pr__pfet_01v8 w=2.4 l=0.15
X720 t_Xrx_Xpi_Xdiv_e0 vss vss vss sky130_fd_pr__nfet_01v8_lvt w=1 l=0.15
X721 t_Xrx_Xpi_Xdiv_e0 vdd vdd vdd sky130_fd_pr__pfet_01v8 w=2.4 l=0.15
X722 t_Xrx_Xpi_Xdiv_e2 vss vss vss sky130_fd_pr__nfet_01v8_lvt w=1 l=0.15
X723 t_Xrx_Xpi_Xdiv_e2 vdd vdd vdd sky130_fd_pr__pfet_01v8 w=2.4 l=0.15
X724 t_Xrx_Xpi_Xdiv_e1 vss vss vss sky130_fd_pr__nfet_01v8_lvt w=1 l=0.15
X725 t_Xrx_Xpi_Xdiv_e1 vdd vdd vdd sky130_fd_pr__pfet_01v8 w=2.4 l=0.15
X726 t_Xrx_Xpi_Xdiv_e3 vss vss vss sky130_fd_pr__nfet_01v8_lvt w=1 l=0.15
X727 t_Xrx_Xpi_Xdiv_e3 vdd vdd vdd sky130_fd_pr__pfet_01v8 w=2.4 l=0.15
X728 t_Xrx_Xpi_Xdiv_e1 vss vss vss sky130_fd_pr__nfet_01v8_lvt w=1 l=0.15
X729 t_Xrx_Xpi_Xdiv_e1 vdd vdd vdd sky130_fd_pr__pfet_01v8 w=2.4 l=0.15
X730 t_Xrx_Xpi_Xdiv_e3 vss vss vss sky130_fd_pr__nfet_01v8_lvt w=1 l=0.15
X731 t_Xrx_Xpi_Xdiv_e3 vdd vdd vdd sky130_fd_pr__pfet_01v8 w=2.4 l=0.15
X732 t_Xrx_ckd0 t_Xrx_Xpi_Xdiv_d2 vss vss sky130_fd_pr__nfet_01v8_lvt w=2.6 l=0.15
X733 t_Xrx_ckd0 t_Xrx_Xpi_Xdiv_d2 vdd vdd sky130_fd_pr__pfet_01v8 w=6.8 l=0.15
X734 t_Xrx_ckd2 t_Xrx_Xpi_Xdiv_d0 vss vss sky130_fd_pr__nfet_01v8_lvt w=2.6 l=0.15
X735 t_Xrx_ckd2 t_Xrx_Xpi_Xdiv_d0 vdd vdd sky130_fd_pr__pfet_01v8 w=6.8 l=0.15
X736 t_Xrx_ckd1 t_Xrx_Xpi_Xdiv_d3 vss vss sky130_fd_pr__nfet_01v8_lvt w=2.6 l=0.15
X737 t_Xrx_ckd1 t_Xrx_Xpi_Xdiv_d3 vdd vdd sky130_fd_pr__pfet_01v8 w=6.8 l=0.15
X738 t_Xrx_ckd3 t_Xrx_Xpi_Xdiv_d1 vss vss sky130_fd_pr__nfet_01v8_lvt w=2.6 l=0.15
X739 t_Xrx_ckd3 t_Xrx_Xpi_Xdiv_d1 vdd vdd sky130_fd_pr__pfet_01v8 w=6.8 l=0.15
X740 t_Xrx_cke0 t_Xrx_Xpi_Xdiv_e2 vss vss sky130_fd_pr__nfet_01v8_lvt w=2.6 l=0.15
X741 t_Xrx_cke0 t_Xrx_Xpi_Xdiv_e2 vdd vdd sky130_fd_pr__pfet_01v8 w=6.8 l=0.15
X742 t_Xrx_cke2 t_Xrx_Xpi_Xdiv_e0 vss vss sky130_fd_pr__nfet_01v8_lvt w=2.6 l=0.15
X743 t_Xrx_cke2 t_Xrx_Xpi_Xdiv_e0 vdd vdd sky130_fd_pr__pfet_01v8 w=6.8 l=0.15
X744 t_Xrx_cke1 t_Xrx_Xpi_Xdiv_e3 vss vss sky130_fd_pr__nfet_01v8_lvt w=2.6 l=0.15
X745 t_Xrx_cke1 t_Xrx_Xpi_Xdiv_e3 vdd vdd sky130_fd_pr__pfet_01v8 w=6.8 l=0.15
X746 t_Xrx_cke3 t_Xrx_Xpi_Xdiv_e1 vss vss sky130_fd_pr__nfet_01v8_lvt w=2.6 l=0.15
X747 t_Xrx_cke3 t_Xrx_Xpi_Xdiv_e1 vdd vdd sky130_fd_pr__pfet_01v8 w=6.8 l=0.15
X748 t_Xrx_ckd2 t_Xrx_ckd0 vss vss sky130_fd_pr__nfet_01v8_lvt w=0.45 l=0.15
X749 t_Xrx_ckd2 t_Xrx_ckd0 vdd vdd sky130_fd_pr__pfet_01v8 w=1.1 l=0.15
X750 t_Xrx_ckd0 t_Xrx_ckd2 vss vss sky130_fd_pr__nfet_01v8_lvt w=0.45 l=0.15
X751 t_Xrx_ckd0 t_Xrx_ckd2 vdd vdd sky130_fd_pr__pfet_01v8 w=1.1 l=0.15
X752 t_Xrx_ckd3 t_Xrx_ckd1 vss vss sky130_fd_pr__nfet_01v8_lvt w=0.45 l=0.15
X753 t_Xrx_ckd3 t_Xrx_ckd1 vdd vdd sky130_fd_pr__pfet_01v8 w=1.1 l=0.15
X754 t_Xrx_ckd1 t_Xrx_ckd3 vss vss sky130_fd_pr__nfet_01v8_lvt w=0.45 l=0.15
X755 t_Xrx_ckd1 t_Xrx_ckd3 vdd vdd sky130_fd_pr__pfet_01v8 w=1.1 l=0.15
X756 t_Xrx_cke2 t_Xrx_cke0 vss vss sky130_fd_pr__nfet_01v8_lvt w=0.45 l=0.15
X757 t_Xrx_cke2 t_Xrx_cke0 vdd vdd sky130_fd_pr__pfet_01v8 w=1.1 l=0.15
X758 t_Xrx_cke0 t_Xrx_cke2 vss vss sky130_fd_pr__nfet_01v8_lvt w=0.45 l=0.15
X759 t_Xrx_cke0 t_Xrx_cke2 vdd vdd sky130_fd_pr__pfet_01v8 w=1.1 l=0.15
X760 t_Xrx_cke3 t_Xrx_cke1 vss vss sky130_fd_pr__nfet_01v8_lvt w=0.45 l=0.15
X761 t_Xrx_cke3 t_Xrx_cke1 vdd vdd sky130_fd_pr__pfet_01v8 w=1.1 l=0.15
X762 t_Xrx_cke1 t_Xrx_cke3 vss vss sky130_fd_pr__nfet_01v8_lvt w=0.45 l=0.15
X763 t_Xrx_cke1 t_Xrx_cke3 vdd vdd sky130_fd_pr__pfet_01v8 w=1.1 l=0.15
X764 t_Xrx_Xsd0_Xcomp_tb0 vss vss vss sky130_fd_pr__nfet_01v8 w=1 l=0.18
X765 t_Xrx_Xsd0_Xcomp_tb0 vss vdd vdd sky130_fd_pr__pfet_01v8 w=2 l=0.18
X766 t_Xrx_Xsd0_Xcomp_tb1 vss vss vss sky130_fd_pr__nfet_01v8 w=1 l=0.18
X767 t_Xrx_Xsd0_Xcomp_tb1 vss vdd vdd sky130_fd_pr__pfet_01v8 w=2 l=0.18
X768 t_Xrx_Xsd0_Xcomp_tb2 vss vss vss sky130_fd_pr__nfet_01v8 w=2 l=0.18
X769 t_Xrx_Xsd0_Xcomp_tb2 vss vdd vdd sky130_fd_pr__pfet_01v8 w=4 l=0.18
X770 t_Xrx_Xsd0_Xcomp_tb3 vss vss vss sky130_fd_pr__nfet_01v8 w=4 l=0.18
X771 t_Xrx_Xsd0_Xcomp_tb3 vss vdd vdd sky130_fd_pr__pfet_01v8 w=8 l=0.18
X772 t_Xrx_Xsd0_Xcomp_tb4 vss vss vss sky130_fd_pr__nfet_01v8 w=8 l=0.18
X773 t_Xrx_Xsd0_Xcomp_tb4 vss vdd vdd sky130_fd_pr__pfet_01v8 w=16 l=0.18
X774 t_Xrx_Xsd0_Xcomp_tb5 vdd vss vss sky130_fd_pr__nfet_01v8 w=16 l=0.18
X775 t_Xrx_Xsd0_Xcomp_tb5 vdd vdd vdd sky130_fd_pr__pfet_01v8 w=32 l=0.18
X776 t_Xrx_Xsd0_Xcomp_r_on vdd vss vss sky130_fd_pr__nfet_01v8 w=16 l=0.18
X777 t_Xrx_Xsd0_Xcomp_r_on vdd vdd vdd sky130_fd_pr__pfet_01v8 w=32 l=0.18
X778 t_Xrx_Xsd0_Xcomp_r_off vss vss vss sky130_fd_pr__nfet_01v8 w=16 l=0.18
X779 t_Xrx_Xsd0_Xcomp_r_off vss vdd vdd sky130_fd_pr__pfet_01v8 w=32 l=0.18
X780 t_Xrx_Xsd0_Xcomp_tail t_Xrx_ckd0 vss vss sky130_fd_pr__nfet_01v8_lvt w=7 l=0.15
X781 t_Xrx_Xsd0_Xcomp_fn ctle_p t_Xrx_Xsd0_Xcomp_tail vss sky130_fd_pr__nfet_01v8_lvt w=14 l=0.18
X782 t_Xrx_Xsd0_Xcomp_fp ctle_n t_Xrx_Xsd0_Xcomp_tail vss sky130_fd_pr__nfet_01v8_lvt w=14 l=0.18
X783 t_Xrx_Xsd0_Xcomp_fn t_Xrx_ckd0 vdd vdd sky130_fd_pr__pfet_01v8 w=3.6 l=0.15
X784 t_Xrx_Xsd0_Xcomp_fp t_Xrx_ckd0 vdd vdd sky130_fd_pr__pfet_01v8 w=3.6 l=0.15
X785 t_Xrx_Xsd0_Xcomp_fn t_Xrx_ckd0 t_Xrx_Xsd0_Xcomp_fp vdd sky130_fd_pr__pfet_01v8 w=1 l=0.18
X786 t_Xrx_Xsd0_Xcomp_tb0 t_Xrx_Xsd0_Xcomp_fn t_Xrx_Xsd0_Xcomp_tb0 vss sky130_fd_pr__nfet_01v8 w=0.45 l=0.18
X787 t_Xrx_Xsd0_Xcomp_tb1 t_Xrx_Xsd0_Xcomp_fn t_Xrx_Xsd0_Xcomp_tb1 vss sky130_fd_pr__nfet_01v8 w=0.9 l=0.18
X788 t_Xrx_Xsd0_Xcomp_tb2 t_Xrx_Xsd0_Xcomp_fn t_Xrx_Xsd0_Xcomp_tb2 vss sky130_fd_pr__nfet_01v8 w=1.8 l=0.18
X789 t_Xrx_Xsd0_Xcomp_tb3 t_Xrx_Xsd0_Xcomp_fn t_Xrx_Xsd0_Xcomp_tb3 vss sky130_fd_pr__nfet_01v8 w=3.6 l=0.18
X790 t_Xrx_Xsd0_Xcomp_tb4 t_Xrx_Xsd0_Xcomp_fn t_Xrx_Xsd0_Xcomp_tb4 vss sky130_fd_pr__nfet_01v8 w=7.2 l=0.18
X791 t_Xrx_Xsd0_Xcomp_tb5 t_Xrx_Xsd0_Xcomp_fn t_Xrx_Xsd0_Xcomp_tb5 vss sky130_fd_pr__nfet_01v8 w=14.4 l=0.18
X792 t_Xrx_Xsd0_Xcomp_r_off t_Xrx_Xsd0_Xcomp_fn t_Xrx_Xsd0_Xcomp_r_off vss sky130_fd_pr__nfet_01v8 w=0.45 l=0.18
X793 t_Xrx_Xsd0_Xcomp_r_on t_Xrx_Xsd0_Xcomp_fp t_Xrx_Xsd0_Xcomp_r_on vss sky130_fd_pr__nfet_01v8 w=14.4 l=0.18
X794 t_Xrx_Xsd0_Xcomp_r_off t_Xrx_Xsd0_Xcomp_fp t_Xrx_Xsd0_Xcomp_r_off vss sky130_fd_pr__nfet_01v8 w=14.4 l=0.18
X795 t_Xrx_Xsd0_Xcomp_vbot2 t_Xrx_ckd0 vss vss sky130_fd_pr__nfet_01v8 w=6 l=0.18
X796 t_Xrx_Xsd0_outp_b t_Xrx_Xsd0_Xcomp_fp t_Xrx_Xsd0_Xcomp_vbot2 vss sky130_fd_pr__nfet_01v8_lvt w=4.8 l=0.18
X797 t_Xrx_Xsd0_outn_b t_Xrx_Xsd0_Xcomp_fn t_Xrx_Xsd0_Xcomp_vbot2 vss sky130_fd_pr__nfet_01v8_lvt w=4.8 l=0.18
X798 t_Xrx_Xsd0_outp_b t_Xrx_Xsd0_outn_b t_Xrx_Xsd0_Xcomp_vbot2 vss sky130_fd_pr__nfet_01v8_lvt w=8 l=0.18
X799 t_Xrx_Xsd0_outn_b t_Xrx_Xsd0_outp_b t_Xrx_Xsd0_Xcomp_vbot2 vss sky130_fd_pr__nfet_01v8_lvt w=8 l=0.18
X800 t_Xrx_Xsd0_outp_b t_Xrx_Xsd0_outn_b vdd vdd sky130_fd_pr__pfet_01v8 w=9 l=0.18
X801 t_Xrx_Xsd0_outn_b t_Xrx_Xsd0_outp_b vdd vdd sky130_fd_pr__pfet_01v8 w=9 l=0.18
X802 t_Xrx_Xsd0_outp_b t_Xrx_ckd0 vdd vdd sky130_fd_pr__pfet_01v8 w=3.6 l=0.15
X803 t_Xrx_Xsd0_outn_b t_Xrx_ckd0 vdd vdd sky130_fd_pr__pfet_01v8 w=3.6 l=0.15
X804 t_Xrx_Xsd0_outp_b t_Xrx_ckd0 t_Xrx_Xsd0_outn_b vdd sky130_fd_pr__pfet_01v8 w=1 l=0.18
X805 t_Xrx_Xsd0_Xsr_sp t_Xrx_Xsd0_outp_b vss vss sky130_fd_pr__nfet_01v8_lvt w=1.5 l=0.15
X806 t_Xrx_Xsd0_Xsr_sp t_Xrx_Xsd0_outp_b vdd vdd sky130_fd_pr__pfet_01v8_lvt w=3.2 l=0.35
X807 t_Xrx_Xsd0_Xsr_sn t_Xrx_Xsd0_outn_b vss vss sky130_fd_pr__nfet_01v8_lvt w=1.5 l=0.15
X808 t_Xrx_Xsd0_Xsr_sn t_Xrx_Xsd0_outn_b vdd vdd sky130_fd_pr__pfet_01v8_lvt w=3.2 l=0.35
X809 t_Xrx_d0b t_Xrx_Xsd0_Xsr_sp vss vss sky130_fd_pr__nfet_01v8_lvt w=4.8 l=0.15
X810 t_Xrx_d0 t_Xrx_Xsd0_Xsr_sn vss vss sky130_fd_pr__nfet_01v8_lvt w=4.8 l=0.15
X811 t_Xrx_d0 t_Xrx_d0b vdd vdd sky130_fd_pr__pfet_01v8_lvt w=2.8 l=0.35
X812 t_Xrx_d0 t_Xrx_d0b vss vss sky130_fd_pr__nfet_01v8_lvt w=1 l=0.15
X813 t_Xrx_d0b t_Xrx_d0 vdd vdd sky130_fd_pr__pfet_01v8_lvt w=2.8 l=0.35
X814 t_Xrx_d0b t_Xrx_d0 vss vss sky130_fd_pr__nfet_01v8_lvt w=1 l=0.15
X815 t_Xrx_Xsd1_Xcomp_tb0 vss vss vss sky130_fd_pr__nfet_01v8 w=1 l=0.18
X816 t_Xrx_Xsd1_Xcomp_tb0 vss vdd vdd sky130_fd_pr__pfet_01v8 w=2 l=0.18
X817 t_Xrx_Xsd1_Xcomp_tb1 vss vss vss sky130_fd_pr__nfet_01v8 w=1 l=0.18
X818 t_Xrx_Xsd1_Xcomp_tb1 vss vdd vdd sky130_fd_pr__pfet_01v8 w=2 l=0.18
X819 t_Xrx_Xsd1_Xcomp_tb2 vss vss vss sky130_fd_pr__nfet_01v8 w=2 l=0.18
X820 t_Xrx_Xsd1_Xcomp_tb2 vss vdd vdd sky130_fd_pr__pfet_01v8 w=4 l=0.18
X821 t_Xrx_Xsd1_Xcomp_tb3 vss vss vss sky130_fd_pr__nfet_01v8 w=4 l=0.18
X822 t_Xrx_Xsd1_Xcomp_tb3 vss vdd vdd sky130_fd_pr__pfet_01v8 w=8 l=0.18
X823 t_Xrx_Xsd1_Xcomp_tb4 vss vss vss sky130_fd_pr__nfet_01v8 w=8 l=0.18
X824 t_Xrx_Xsd1_Xcomp_tb4 vss vdd vdd sky130_fd_pr__pfet_01v8 w=16 l=0.18
X825 t_Xrx_Xsd1_Xcomp_tb5 vdd vss vss sky130_fd_pr__nfet_01v8 w=16 l=0.18
X826 t_Xrx_Xsd1_Xcomp_tb5 vdd vdd vdd sky130_fd_pr__pfet_01v8 w=32 l=0.18
X827 t_Xrx_Xsd1_Xcomp_r_on vdd vss vss sky130_fd_pr__nfet_01v8 w=16 l=0.18
X828 t_Xrx_Xsd1_Xcomp_r_on vdd vdd vdd sky130_fd_pr__pfet_01v8 w=32 l=0.18
X829 t_Xrx_Xsd1_Xcomp_r_off vss vss vss sky130_fd_pr__nfet_01v8 w=16 l=0.18
X830 t_Xrx_Xsd1_Xcomp_r_off vss vdd vdd sky130_fd_pr__pfet_01v8 w=32 l=0.18
X831 t_Xrx_Xsd1_Xcomp_tail t_Xrx_ckd1 vss vss sky130_fd_pr__nfet_01v8_lvt w=7 l=0.15
X832 t_Xrx_Xsd1_Xcomp_fn ctle_p t_Xrx_Xsd1_Xcomp_tail vss sky130_fd_pr__nfet_01v8_lvt w=14 l=0.18
X833 t_Xrx_Xsd1_Xcomp_fp ctle_n t_Xrx_Xsd1_Xcomp_tail vss sky130_fd_pr__nfet_01v8_lvt w=14 l=0.18
X834 t_Xrx_Xsd1_Xcomp_fn t_Xrx_ckd1 vdd vdd sky130_fd_pr__pfet_01v8 w=3.6 l=0.15
X835 t_Xrx_Xsd1_Xcomp_fp t_Xrx_ckd1 vdd vdd sky130_fd_pr__pfet_01v8 w=3.6 l=0.15
X836 t_Xrx_Xsd1_Xcomp_fn t_Xrx_ckd1 t_Xrx_Xsd1_Xcomp_fp vdd sky130_fd_pr__pfet_01v8 w=1 l=0.18
X837 t_Xrx_Xsd1_Xcomp_tb0 t_Xrx_Xsd1_Xcomp_fn t_Xrx_Xsd1_Xcomp_tb0 vss sky130_fd_pr__nfet_01v8 w=0.45 l=0.18
X838 t_Xrx_Xsd1_Xcomp_tb1 t_Xrx_Xsd1_Xcomp_fn t_Xrx_Xsd1_Xcomp_tb1 vss sky130_fd_pr__nfet_01v8 w=0.9 l=0.18
X839 t_Xrx_Xsd1_Xcomp_tb2 t_Xrx_Xsd1_Xcomp_fn t_Xrx_Xsd1_Xcomp_tb2 vss sky130_fd_pr__nfet_01v8 w=1.8 l=0.18
X840 t_Xrx_Xsd1_Xcomp_tb3 t_Xrx_Xsd1_Xcomp_fn t_Xrx_Xsd1_Xcomp_tb3 vss sky130_fd_pr__nfet_01v8 w=3.6 l=0.18
X841 t_Xrx_Xsd1_Xcomp_tb4 t_Xrx_Xsd1_Xcomp_fn t_Xrx_Xsd1_Xcomp_tb4 vss sky130_fd_pr__nfet_01v8 w=7.2 l=0.18
X842 t_Xrx_Xsd1_Xcomp_tb5 t_Xrx_Xsd1_Xcomp_fn t_Xrx_Xsd1_Xcomp_tb5 vss sky130_fd_pr__nfet_01v8 w=14.4 l=0.18
X843 t_Xrx_Xsd1_Xcomp_r_off t_Xrx_Xsd1_Xcomp_fn t_Xrx_Xsd1_Xcomp_r_off vss sky130_fd_pr__nfet_01v8 w=0.45 l=0.18
X844 t_Xrx_Xsd1_Xcomp_r_on t_Xrx_Xsd1_Xcomp_fp t_Xrx_Xsd1_Xcomp_r_on vss sky130_fd_pr__nfet_01v8 w=14.4 l=0.18
X845 t_Xrx_Xsd1_Xcomp_r_off t_Xrx_Xsd1_Xcomp_fp t_Xrx_Xsd1_Xcomp_r_off vss sky130_fd_pr__nfet_01v8 w=14.4 l=0.18
X846 t_Xrx_Xsd1_Xcomp_vbot2 t_Xrx_ckd1 vss vss sky130_fd_pr__nfet_01v8 w=6 l=0.18
X847 t_Xrx_Xsd1_outp_b t_Xrx_Xsd1_Xcomp_fp t_Xrx_Xsd1_Xcomp_vbot2 vss sky130_fd_pr__nfet_01v8_lvt w=4.8 l=0.18
X848 t_Xrx_Xsd1_outn_b t_Xrx_Xsd1_Xcomp_fn t_Xrx_Xsd1_Xcomp_vbot2 vss sky130_fd_pr__nfet_01v8_lvt w=4.8 l=0.18
X849 t_Xrx_Xsd1_outp_b t_Xrx_Xsd1_outn_b t_Xrx_Xsd1_Xcomp_vbot2 vss sky130_fd_pr__nfet_01v8_lvt w=8 l=0.18
X850 t_Xrx_Xsd1_outn_b t_Xrx_Xsd1_outp_b t_Xrx_Xsd1_Xcomp_vbot2 vss sky130_fd_pr__nfet_01v8_lvt w=8 l=0.18
X851 t_Xrx_Xsd1_outp_b t_Xrx_Xsd1_outn_b vdd vdd sky130_fd_pr__pfet_01v8 w=9 l=0.18
X852 t_Xrx_Xsd1_outn_b t_Xrx_Xsd1_outp_b vdd vdd sky130_fd_pr__pfet_01v8 w=9 l=0.18
X853 t_Xrx_Xsd1_outp_b t_Xrx_ckd1 vdd vdd sky130_fd_pr__pfet_01v8 w=3.6 l=0.15
X854 t_Xrx_Xsd1_outn_b t_Xrx_ckd1 vdd vdd sky130_fd_pr__pfet_01v8 w=3.6 l=0.15
X855 t_Xrx_Xsd1_outp_b t_Xrx_ckd1 t_Xrx_Xsd1_outn_b vdd sky130_fd_pr__pfet_01v8 w=1 l=0.18
X856 t_Xrx_Xsd1_Xsr_sp t_Xrx_Xsd1_outp_b vss vss sky130_fd_pr__nfet_01v8_lvt w=1.5 l=0.15
X857 t_Xrx_Xsd1_Xsr_sp t_Xrx_Xsd1_outp_b vdd vdd sky130_fd_pr__pfet_01v8_lvt w=3.2 l=0.35
X858 t_Xrx_Xsd1_Xsr_sn t_Xrx_Xsd1_outn_b vss vss sky130_fd_pr__nfet_01v8_lvt w=1.5 l=0.15
X859 t_Xrx_Xsd1_Xsr_sn t_Xrx_Xsd1_outn_b vdd vdd sky130_fd_pr__pfet_01v8_lvt w=3.2 l=0.35
X860 t_Xrx_d1b t_Xrx_Xsd1_Xsr_sp vss vss sky130_fd_pr__nfet_01v8_lvt w=4.8 l=0.15
X861 t_Xrx_d1 t_Xrx_Xsd1_Xsr_sn vss vss sky130_fd_pr__nfet_01v8_lvt w=4.8 l=0.15
X862 t_Xrx_d1 t_Xrx_d1b vdd vdd sky130_fd_pr__pfet_01v8_lvt w=2.8 l=0.35
X863 t_Xrx_d1 t_Xrx_d1b vss vss sky130_fd_pr__nfet_01v8_lvt w=1 l=0.15
X864 t_Xrx_d1b t_Xrx_d1 vdd vdd sky130_fd_pr__pfet_01v8_lvt w=2.8 l=0.35
X865 t_Xrx_d1b t_Xrx_d1 vss vss sky130_fd_pr__nfet_01v8_lvt w=1 l=0.15
X866 t_Xrx_Xsd2_Xcomp_tb0 vss vss vss sky130_fd_pr__nfet_01v8 w=1 l=0.18
X867 t_Xrx_Xsd2_Xcomp_tb0 vss vdd vdd sky130_fd_pr__pfet_01v8 w=2 l=0.18
X868 t_Xrx_Xsd2_Xcomp_tb1 vss vss vss sky130_fd_pr__nfet_01v8 w=1 l=0.18
X869 t_Xrx_Xsd2_Xcomp_tb1 vss vdd vdd sky130_fd_pr__pfet_01v8 w=2 l=0.18
X870 t_Xrx_Xsd2_Xcomp_tb2 vss vss vss sky130_fd_pr__nfet_01v8 w=2 l=0.18
X871 t_Xrx_Xsd2_Xcomp_tb2 vss vdd vdd sky130_fd_pr__pfet_01v8 w=4 l=0.18
X872 t_Xrx_Xsd2_Xcomp_tb3 vss vss vss sky130_fd_pr__nfet_01v8 w=4 l=0.18
X873 t_Xrx_Xsd2_Xcomp_tb3 vss vdd vdd sky130_fd_pr__pfet_01v8 w=8 l=0.18
X874 t_Xrx_Xsd2_Xcomp_tb4 vss vss vss sky130_fd_pr__nfet_01v8 w=8 l=0.18
X875 t_Xrx_Xsd2_Xcomp_tb4 vss vdd vdd sky130_fd_pr__pfet_01v8 w=16 l=0.18
X876 t_Xrx_Xsd2_Xcomp_tb5 vdd vss vss sky130_fd_pr__nfet_01v8 w=16 l=0.18
X877 t_Xrx_Xsd2_Xcomp_tb5 vdd vdd vdd sky130_fd_pr__pfet_01v8 w=32 l=0.18
X878 t_Xrx_Xsd2_Xcomp_r_on vdd vss vss sky130_fd_pr__nfet_01v8 w=16 l=0.18
X879 t_Xrx_Xsd2_Xcomp_r_on vdd vdd vdd sky130_fd_pr__pfet_01v8 w=32 l=0.18
X880 t_Xrx_Xsd2_Xcomp_r_off vss vss vss sky130_fd_pr__nfet_01v8 w=16 l=0.18
X881 t_Xrx_Xsd2_Xcomp_r_off vss vdd vdd sky130_fd_pr__pfet_01v8 w=32 l=0.18
X882 t_Xrx_Xsd2_Xcomp_tail t_Xrx_ckd2 vss vss sky130_fd_pr__nfet_01v8_lvt w=7 l=0.15
X883 t_Xrx_Xsd2_Xcomp_fn ctle_p t_Xrx_Xsd2_Xcomp_tail vss sky130_fd_pr__nfet_01v8_lvt w=14 l=0.18
X884 t_Xrx_Xsd2_Xcomp_fp ctle_n t_Xrx_Xsd2_Xcomp_tail vss sky130_fd_pr__nfet_01v8_lvt w=14 l=0.18
X885 t_Xrx_Xsd2_Xcomp_fn t_Xrx_ckd2 vdd vdd sky130_fd_pr__pfet_01v8 w=3.6 l=0.15
X886 t_Xrx_Xsd2_Xcomp_fp t_Xrx_ckd2 vdd vdd sky130_fd_pr__pfet_01v8 w=3.6 l=0.15
X887 t_Xrx_Xsd2_Xcomp_fn t_Xrx_ckd2 t_Xrx_Xsd2_Xcomp_fp vdd sky130_fd_pr__pfet_01v8 w=1 l=0.18
X888 t_Xrx_Xsd2_Xcomp_tb0 t_Xrx_Xsd2_Xcomp_fn t_Xrx_Xsd2_Xcomp_tb0 vss sky130_fd_pr__nfet_01v8 w=0.45 l=0.18
X889 t_Xrx_Xsd2_Xcomp_tb1 t_Xrx_Xsd2_Xcomp_fn t_Xrx_Xsd2_Xcomp_tb1 vss sky130_fd_pr__nfet_01v8 w=0.9 l=0.18
X890 t_Xrx_Xsd2_Xcomp_tb2 t_Xrx_Xsd2_Xcomp_fn t_Xrx_Xsd2_Xcomp_tb2 vss sky130_fd_pr__nfet_01v8 w=1.8 l=0.18
X891 t_Xrx_Xsd2_Xcomp_tb3 t_Xrx_Xsd2_Xcomp_fn t_Xrx_Xsd2_Xcomp_tb3 vss sky130_fd_pr__nfet_01v8 w=3.6 l=0.18
X892 t_Xrx_Xsd2_Xcomp_tb4 t_Xrx_Xsd2_Xcomp_fn t_Xrx_Xsd2_Xcomp_tb4 vss sky130_fd_pr__nfet_01v8 w=7.2 l=0.18
X893 t_Xrx_Xsd2_Xcomp_tb5 t_Xrx_Xsd2_Xcomp_fn t_Xrx_Xsd2_Xcomp_tb5 vss sky130_fd_pr__nfet_01v8 w=14.4 l=0.18
X894 t_Xrx_Xsd2_Xcomp_r_off t_Xrx_Xsd2_Xcomp_fn t_Xrx_Xsd2_Xcomp_r_off vss sky130_fd_pr__nfet_01v8 w=0.45 l=0.18
X895 t_Xrx_Xsd2_Xcomp_r_on t_Xrx_Xsd2_Xcomp_fp t_Xrx_Xsd2_Xcomp_r_on vss sky130_fd_pr__nfet_01v8 w=14.4 l=0.18
X896 t_Xrx_Xsd2_Xcomp_r_off t_Xrx_Xsd2_Xcomp_fp t_Xrx_Xsd2_Xcomp_r_off vss sky130_fd_pr__nfet_01v8 w=14.4 l=0.18
X897 t_Xrx_Xsd2_Xcomp_vbot2 t_Xrx_ckd2 vss vss sky130_fd_pr__nfet_01v8 w=6 l=0.18
X898 t_Xrx_Xsd2_outp_b t_Xrx_Xsd2_Xcomp_fp t_Xrx_Xsd2_Xcomp_vbot2 vss sky130_fd_pr__nfet_01v8_lvt w=4.8 l=0.18
X899 t_Xrx_Xsd2_outn_b t_Xrx_Xsd2_Xcomp_fn t_Xrx_Xsd2_Xcomp_vbot2 vss sky130_fd_pr__nfet_01v8_lvt w=4.8 l=0.18
X900 t_Xrx_Xsd2_outp_b t_Xrx_Xsd2_outn_b t_Xrx_Xsd2_Xcomp_vbot2 vss sky130_fd_pr__nfet_01v8_lvt w=8 l=0.18
X901 t_Xrx_Xsd2_outn_b t_Xrx_Xsd2_outp_b t_Xrx_Xsd2_Xcomp_vbot2 vss sky130_fd_pr__nfet_01v8_lvt w=8 l=0.18
X902 t_Xrx_Xsd2_outp_b t_Xrx_Xsd2_outn_b vdd vdd sky130_fd_pr__pfet_01v8 w=9 l=0.18
X903 t_Xrx_Xsd2_outn_b t_Xrx_Xsd2_outp_b vdd vdd sky130_fd_pr__pfet_01v8 w=9 l=0.18
X904 t_Xrx_Xsd2_outp_b t_Xrx_ckd2 vdd vdd sky130_fd_pr__pfet_01v8 w=3.6 l=0.15
X905 t_Xrx_Xsd2_outn_b t_Xrx_ckd2 vdd vdd sky130_fd_pr__pfet_01v8 w=3.6 l=0.15
X906 t_Xrx_Xsd2_outp_b t_Xrx_ckd2 t_Xrx_Xsd2_outn_b vdd sky130_fd_pr__pfet_01v8 w=1 l=0.18
X907 t_Xrx_Xsd2_Xsr_sp t_Xrx_Xsd2_outp_b vss vss sky130_fd_pr__nfet_01v8_lvt w=1.5 l=0.15
X908 t_Xrx_Xsd2_Xsr_sp t_Xrx_Xsd2_outp_b vdd vdd sky130_fd_pr__pfet_01v8_lvt w=3.2 l=0.35
X909 t_Xrx_Xsd2_Xsr_sn t_Xrx_Xsd2_outn_b vss vss sky130_fd_pr__nfet_01v8_lvt w=1.5 l=0.15
X910 t_Xrx_Xsd2_Xsr_sn t_Xrx_Xsd2_outn_b vdd vdd sky130_fd_pr__pfet_01v8_lvt w=3.2 l=0.35
X911 t_Xrx_d2b t_Xrx_Xsd2_Xsr_sp vss vss sky130_fd_pr__nfet_01v8_lvt w=4.8 l=0.15
X912 t_Xrx_d2 t_Xrx_Xsd2_Xsr_sn vss vss sky130_fd_pr__nfet_01v8_lvt w=4.8 l=0.15
X913 t_Xrx_d2 t_Xrx_d2b vdd vdd sky130_fd_pr__pfet_01v8_lvt w=2.8 l=0.35
X914 t_Xrx_d2 t_Xrx_d2b vss vss sky130_fd_pr__nfet_01v8_lvt w=1 l=0.15
X915 t_Xrx_d2b t_Xrx_d2 vdd vdd sky130_fd_pr__pfet_01v8_lvt w=2.8 l=0.35
X916 t_Xrx_d2b t_Xrx_d2 vss vss sky130_fd_pr__nfet_01v8_lvt w=1 l=0.15
X917 t_Xrx_Xsd3_Xcomp_tb0 vss vss vss sky130_fd_pr__nfet_01v8 w=1 l=0.18
X918 t_Xrx_Xsd3_Xcomp_tb0 vss vdd vdd sky130_fd_pr__pfet_01v8 w=2 l=0.18
X919 t_Xrx_Xsd3_Xcomp_tb1 vss vss vss sky130_fd_pr__nfet_01v8 w=1 l=0.18
X920 t_Xrx_Xsd3_Xcomp_tb1 vss vdd vdd sky130_fd_pr__pfet_01v8 w=2 l=0.18
X921 t_Xrx_Xsd3_Xcomp_tb2 vss vss vss sky130_fd_pr__nfet_01v8 w=2 l=0.18
X922 t_Xrx_Xsd3_Xcomp_tb2 vss vdd vdd sky130_fd_pr__pfet_01v8 w=4 l=0.18
X923 t_Xrx_Xsd3_Xcomp_tb3 vss vss vss sky130_fd_pr__nfet_01v8 w=4 l=0.18
X924 t_Xrx_Xsd3_Xcomp_tb3 vss vdd vdd sky130_fd_pr__pfet_01v8 w=8 l=0.18
X925 t_Xrx_Xsd3_Xcomp_tb4 vss vss vss sky130_fd_pr__nfet_01v8 w=8 l=0.18
X926 t_Xrx_Xsd3_Xcomp_tb4 vss vdd vdd sky130_fd_pr__pfet_01v8 w=16 l=0.18
X927 t_Xrx_Xsd3_Xcomp_tb5 vdd vss vss sky130_fd_pr__nfet_01v8 w=16 l=0.18
X928 t_Xrx_Xsd3_Xcomp_tb5 vdd vdd vdd sky130_fd_pr__pfet_01v8 w=32 l=0.18
X929 t_Xrx_Xsd3_Xcomp_r_on vdd vss vss sky130_fd_pr__nfet_01v8 w=16 l=0.18
X930 t_Xrx_Xsd3_Xcomp_r_on vdd vdd vdd sky130_fd_pr__pfet_01v8 w=32 l=0.18
X931 t_Xrx_Xsd3_Xcomp_r_off vss vss vss sky130_fd_pr__nfet_01v8 w=16 l=0.18
X932 t_Xrx_Xsd3_Xcomp_r_off vss vdd vdd sky130_fd_pr__pfet_01v8 w=32 l=0.18
X933 t_Xrx_Xsd3_Xcomp_tail t_Xrx_ckd3 vss vss sky130_fd_pr__nfet_01v8_lvt w=7 l=0.15
X934 t_Xrx_Xsd3_Xcomp_fn ctle_p t_Xrx_Xsd3_Xcomp_tail vss sky130_fd_pr__nfet_01v8_lvt w=14 l=0.18
X935 t_Xrx_Xsd3_Xcomp_fp ctle_n t_Xrx_Xsd3_Xcomp_tail vss sky130_fd_pr__nfet_01v8_lvt w=14 l=0.18
X936 t_Xrx_Xsd3_Xcomp_fn t_Xrx_ckd3 vdd vdd sky130_fd_pr__pfet_01v8 w=3.6 l=0.15
X937 t_Xrx_Xsd3_Xcomp_fp t_Xrx_ckd3 vdd vdd sky130_fd_pr__pfet_01v8 w=3.6 l=0.15
X938 t_Xrx_Xsd3_Xcomp_fn t_Xrx_ckd3 t_Xrx_Xsd3_Xcomp_fp vdd sky130_fd_pr__pfet_01v8 w=1 l=0.18
X939 t_Xrx_Xsd3_Xcomp_tb0 t_Xrx_Xsd3_Xcomp_fn t_Xrx_Xsd3_Xcomp_tb0 vss sky130_fd_pr__nfet_01v8 w=0.45 l=0.18
X940 t_Xrx_Xsd3_Xcomp_tb1 t_Xrx_Xsd3_Xcomp_fn t_Xrx_Xsd3_Xcomp_tb1 vss sky130_fd_pr__nfet_01v8 w=0.9 l=0.18
X941 t_Xrx_Xsd3_Xcomp_tb2 t_Xrx_Xsd3_Xcomp_fn t_Xrx_Xsd3_Xcomp_tb2 vss sky130_fd_pr__nfet_01v8 w=1.8 l=0.18
X942 t_Xrx_Xsd3_Xcomp_tb3 t_Xrx_Xsd3_Xcomp_fn t_Xrx_Xsd3_Xcomp_tb3 vss sky130_fd_pr__nfet_01v8 w=3.6 l=0.18
X943 t_Xrx_Xsd3_Xcomp_tb4 t_Xrx_Xsd3_Xcomp_fn t_Xrx_Xsd3_Xcomp_tb4 vss sky130_fd_pr__nfet_01v8 w=7.2 l=0.18
X944 t_Xrx_Xsd3_Xcomp_tb5 t_Xrx_Xsd3_Xcomp_fn t_Xrx_Xsd3_Xcomp_tb5 vss sky130_fd_pr__nfet_01v8 w=14.4 l=0.18
X945 t_Xrx_Xsd3_Xcomp_r_off t_Xrx_Xsd3_Xcomp_fn t_Xrx_Xsd3_Xcomp_r_off vss sky130_fd_pr__nfet_01v8 w=0.45 l=0.18
X946 t_Xrx_Xsd3_Xcomp_r_on t_Xrx_Xsd3_Xcomp_fp t_Xrx_Xsd3_Xcomp_r_on vss sky130_fd_pr__nfet_01v8 w=14.4 l=0.18
X947 t_Xrx_Xsd3_Xcomp_r_off t_Xrx_Xsd3_Xcomp_fp t_Xrx_Xsd3_Xcomp_r_off vss sky130_fd_pr__nfet_01v8 w=14.4 l=0.18
X948 t_Xrx_Xsd3_Xcomp_vbot2 t_Xrx_ckd3 vss vss sky130_fd_pr__nfet_01v8 w=6 l=0.18
X949 t_Xrx_Xsd3_outp_b t_Xrx_Xsd3_Xcomp_fp t_Xrx_Xsd3_Xcomp_vbot2 vss sky130_fd_pr__nfet_01v8_lvt w=4.8 l=0.18
X950 t_Xrx_Xsd3_outn_b t_Xrx_Xsd3_Xcomp_fn t_Xrx_Xsd3_Xcomp_vbot2 vss sky130_fd_pr__nfet_01v8_lvt w=4.8 l=0.18
X951 t_Xrx_Xsd3_outp_b t_Xrx_Xsd3_outn_b t_Xrx_Xsd3_Xcomp_vbot2 vss sky130_fd_pr__nfet_01v8_lvt w=8 l=0.18
X952 t_Xrx_Xsd3_outn_b t_Xrx_Xsd3_outp_b t_Xrx_Xsd3_Xcomp_vbot2 vss sky130_fd_pr__nfet_01v8_lvt w=8 l=0.18
X953 t_Xrx_Xsd3_outp_b t_Xrx_Xsd3_outn_b vdd vdd sky130_fd_pr__pfet_01v8 w=9 l=0.18
X954 t_Xrx_Xsd3_outn_b t_Xrx_Xsd3_outp_b vdd vdd sky130_fd_pr__pfet_01v8 w=9 l=0.18
X955 t_Xrx_Xsd3_outp_b t_Xrx_ckd3 vdd vdd sky130_fd_pr__pfet_01v8 w=3.6 l=0.15
X956 t_Xrx_Xsd3_outn_b t_Xrx_ckd3 vdd vdd sky130_fd_pr__pfet_01v8 w=3.6 l=0.15
X957 t_Xrx_Xsd3_outp_b t_Xrx_ckd3 t_Xrx_Xsd3_outn_b vdd sky130_fd_pr__pfet_01v8 w=1 l=0.18
X958 t_Xrx_Xsd3_Xsr_sp t_Xrx_Xsd3_outp_b vss vss sky130_fd_pr__nfet_01v8_lvt w=1.5 l=0.15
X959 t_Xrx_Xsd3_Xsr_sp t_Xrx_Xsd3_outp_b vdd vdd sky130_fd_pr__pfet_01v8_lvt w=3.2 l=0.35
X960 t_Xrx_Xsd3_Xsr_sn t_Xrx_Xsd3_outn_b vss vss sky130_fd_pr__nfet_01v8_lvt w=1.5 l=0.15
X961 t_Xrx_Xsd3_Xsr_sn t_Xrx_Xsd3_outn_b vdd vdd sky130_fd_pr__pfet_01v8_lvt w=3.2 l=0.35
X962 t_Xrx_d3b t_Xrx_Xsd3_Xsr_sp vss vss sky130_fd_pr__nfet_01v8_lvt w=4.8 l=0.15
X963 t_Xrx_d3 t_Xrx_Xsd3_Xsr_sn vss vss sky130_fd_pr__nfet_01v8_lvt w=4.8 l=0.15
X964 t_Xrx_d3 t_Xrx_d3b vdd vdd sky130_fd_pr__pfet_01v8_lvt w=2.8 l=0.35
X965 t_Xrx_d3 t_Xrx_d3b vss vss sky130_fd_pr__nfet_01v8_lvt w=1 l=0.15
X966 t_Xrx_d3b t_Xrx_d3 vdd vdd sky130_fd_pr__pfet_01v8_lvt w=2.8 l=0.35
X967 t_Xrx_d3b t_Xrx_d3 vss vss sky130_fd_pr__nfet_01v8_lvt w=1 l=0.15
X968 t_Xrx_Xse0_Xcomp_tb0 vss vss vss sky130_fd_pr__nfet_01v8 w=1 l=0.18
X969 t_Xrx_Xse0_Xcomp_tb0 vss vdd vdd sky130_fd_pr__pfet_01v8 w=2 l=0.18
X970 t_Xrx_Xse0_Xcomp_tb1 vss vss vss sky130_fd_pr__nfet_01v8 w=1 l=0.18
X971 t_Xrx_Xse0_Xcomp_tb1 vss vdd vdd sky130_fd_pr__pfet_01v8 w=2 l=0.18
X972 t_Xrx_Xse0_Xcomp_tb2 vss vss vss sky130_fd_pr__nfet_01v8 w=2 l=0.18
X973 t_Xrx_Xse0_Xcomp_tb2 vss vdd vdd sky130_fd_pr__pfet_01v8 w=4 l=0.18
X974 t_Xrx_Xse0_Xcomp_tb3 vss vss vss sky130_fd_pr__nfet_01v8 w=4 l=0.18
X975 t_Xrx_Xse0_Xcomp_tb3 vss vdd vdd sky130_fd_pr__pfet_01v8 w=8 l=0.18
X976 t_Xrx_Xse0_Xcomp_tb4 vss vss vss sky130_fd_pr__nfet_01v8 w=8 l=0.18
X977 t_Xrx_Xse0_Xcomp_tb4 vss vdd vdd sky130_fd_pr__pfet_01v8 w=16 l=0.18
X978 t_Xrx_Xse0_Xcomp_tb5 vdd vss vss sky130_fd_pr__nfet_01v8 w=16 l=0.18
X979 t_Xrx_Xse0_Xcomp_tb5 vdd vdd vdd sky130_fd_pr__pfet_01v8 w=32 l=0.18
X980 t_Xrx_Xse0_Xcomp_r_on vdd vss vss sky130_fd_pr__nfet_01v8 w=16 l=0.18
X981 t_Xrx_Xse0_Xcomp_r_on vdd vdd vdd sky130_fd_pr__pfet_01v8 w=32 l=0.18
X982 t_Xrx_Xse0_Xcomp_r_off vss vss vss sky130_fd_pr__nfet_01v8 w=16 l=0.18
X983 t_Xrx_Xse0_Xcomp_r_off vss vdd vdd sky130_fd_pr__pfet_01v8 w=32 l=0.18
X984 t_Xrx_Xse0_Xcomp_tail t_Xrx_cke0 vss vss sky130_fd_pr__nfet_01v8_lvt w=7 l=0.15
X985 t_Xrx_Xse0_Xcomp_fn ctle_p t_Xrx_Xse0_Xcomp_tail vss sky130_fd_pr__nfet_01v8_lvt w=14 l=0.18
X986 t_Xrx_Xse0_Xcomp_fp ctle_n t_Xrx_Xse0_Xcomp_tail vss sky130_fd_pr__nfet_01v8_lvt w=14 l=0.18
X987 t_Xrx_Xse0_Xcomp_fn t_Xrx_cke0 vdd vdd sky130_fd_pr__pfet_01v8 w=3.6 l=0.15
X988 t_Xrx_Xse0_Xcomp_fp t_Xrx_cke0 vdd vdd sky130_fd_pr__pfet_01v8 w=3.6 l=0.15
X989 t_Xrx_Xse0_Xcomp_fn t_Xrx_cke0 t_Xrx_Xse0_Xcomp_fp vdd sky130_fd_pr__pfet_01v8 w=1 l=0.18
X990 t_Xrx_Xse0_Xcomp_tb0 t_Xrx_Xse0_Xcomp_fn t_Xrx_Xse0_Xcomp_tb0 vss sky130_fd_pr__nfet_01v8 w=0.45 l=0.18
X991 t_Xrx_Xse0_Xcomp_tb1 t_Xrx_Xse0_Xcomp_fn t_Xrx_Xse0_Xcomp_tb1 vss sky130_fd_pr__nfet_01v8 w=0.9 l=0.18
X992 t_Xrx_Xse0_Xcomp_tb2 t_Xrx_Xse0_Xcomp_fn t_Xrx_Xse0_Xcomp_tb2 vss sky130_fd_pr__nfet_01v8 w=1.8 l=0.18
X993 t_Xrx_Xse0_Xcomp_tb3 t_Xrx_Xse0_Xcomp_fn t_Xrx_Xse0_Xcomp_tb3 vss sky130_fd_pr__nfet_01v8 w=3.6 l=0.18
X994 t_Xrx_Xse0_Xcomp_tb4 t_Xrx_Xse0_Xcomp_fn t_Xrx_Xse0_Xcomp_tb4 vss sky130_fd_pr__nfet_01v8 w=7.2 l=0.18
X995 t_Xrx_Xse0_Xcomp_tb5 t_Xrx_Xse0_Xcomp_fn t_Xrx_Xse0_Xcomp_tb5 vss sky130_fd_pr__nfet_01v8 w=14.4 l=0.18
X996 t_Xrx_Xse0_Xcomp_r_off t_Xrx_Xse0_Xcomp_fn t_Xrx_Xse0_Xcomp_r_off vss sky130_fd_pr__nfet_01v8 w=0.45 l=0.18
X997 t_Xrx_Xse0_Xcomp_r_on t_Xrx_Xse0_Xcomp_fp t_Xrx_Xse0_Xcomp_r_on vss sky130_fd_pr__nfet_01v8 w=14.4 l=0.18
X998 t_Xrx_Xse0_Xcomp_r_off t_Xrx_Xse0_Xcomp_fp t_Xrx_Xse0_Xcomp_r_off vss sky130_fd_pr__nfet_01v8 w=14.4 l=0.18
X999 t_Xrx_Xse0_Xcomp_vbot2 t_Xrx_cke0 vss vss sky130_fd_pr__nfet_01v8 w=6 l=0.18
X1000 t_Xrx_Xse0_outp_b t_Xrx_Xse0_Xcomp_fp t_Xrx_Xse0_Xcomp_vbot2 vss sky130_fd_pr__nfet_01v8_lvt w=4.8 l=0.18
X1001 t_Xrx_Xse0_outn_b t_Xrx_Xse0_Xcomp_fn t_Xrx_Xse0_Xcomp_vbot2 vss sky130_fd_pr__nfet_01v8_lvt w=4.8 l=0.18
X1002 t_Xrx_Xse0_outp_b t_Xrx_Xse0_outn_b t_Xrx_Xse0_Xcomp_vbot2 vss sky130_fd_pr__nfet_01v8_lvt w=8 l=0.18
X1003 t_Xrx_Xse0_outn_b t_Xrx_Xse0_outp_b t_Xrx_Xse0_Xcomp_vbot2 vss sky130_fd_pr__nfet_01v8_lvt w=8 l=0.18
X1004 t_Xrx_Xse0_outp_b t_Xrx_Xse0_outn_b vdd vdd sky130_fd_pr__pfet_01v8 w=9 l=0.18
X1005 t_Xrx_Xse0_outn_b t_Xrx_Xse0_outp_b vdd vdd sky130_fd_pr__pfet_01v8 w=9 l=0.18
X1006 t_Xrx_Xse0_outp_b t_Xrx_cke0 vdd vdd sky130_fd_pr__pfet_01v8 w=3.6 l=0.15
X1007 t_Xrx_Xse0_outn_b t_Xrx_cke0 vdd vdd sky130_fd_pr__pfet_01v8 w=3.6 l=0.15
X1008 t_Xrx_Xse0_outp_b t_Xrx_cke0 t_Xrx_Xse0_outn_b vdd sky130_fd_pr__pfet_01v8 w=1 l=0.18
X1009 t_Xrx_Xse0_Xsr_sp t_Xrx_Xse0_outp_b vss vss sky130_fd_pr__nfet_01v8_lvt w=1.5 l=0.15
X1010 t_Xrx_Xse0_Xsr_sp t_Xrx_Xse0_outp_b vdd vdd sky130_fd_pr__pfet_01v8_lvt w=3.2 l=0.35
X1011 t_Xrx_Xse0_Xsr_sn t_Xrx_Xse0_outn_b vss vss sky130_fd_pr__nfet_01v8_lvt w=1.5 l=0.15
X1012 t_Xrx_Xse0_Xsr_sn t_Xrx_Xse0_outn_b vdd vdd sky130_fd_pr__pfet_01v8_lvt w=3.2 l=0.35
X1013 t_Xrx_e0b t_Xrx_Xse0_Xsr_sp vss vss sky130_fd_pr__nfet_01v8_lvt w=4.8 l=0.15
X1014 t_Xrx_e0 t_Xrx_Xse0_Xsr_sn vss vss sky130_fd_pr__nfet_01v8_lvt w=4.8 l=0.15
X1015 t_Xrx_e0 t_Xrx_e0b vdd vdd sky130_fd_pr__pfet_01v8_lvt w=2.8 l=0.35
X1016 t_Xrx_e0 t_Xrx_e0b vss vss sky130_fd_pr__nfet_01v8_lvt w=1 l=0.15
X1017 t_Xrx_e0b t_Xrx_e0 vdd vdd sky130_fd_pr__pfet_01v8_lvt w=2.8 l=0.35
X1018 t_Xrx_e0b t_Xrx_e0 vss vss sky130_fd_pr__nfet_01v8_lvt w=1 l=0.15
X1019 t_Xrx_Xse1_Xcomp_tb0 vss vss vss sky130_fd_pr__nfet_01v8 w=1 l=0.18
X1020 t_Xrx_Xse1_Xcomp_tb0 vss vdd vdd sky130_fd_pr__pfet_01v8 w=2 l=0.18
X1021 t_Xrx_Xse1_Xcomp_tb1 vss vss vss sky130_fd_pr__nfet_01v8 w=1 l=0.18
X1022 t_Xrx_Xse1_Xcomp_tb1 vss vdd vdd sky130_fd_pr__pfet_01v8 w=2 l=0.18
X1023 t_Xrx_Xse1_Xcomp_tb2 vss vss vss sky130_fd_pr__nfet_01v8 w=2 l=0.18
X1024 t_Xrx_Xse1_Xcomp_tb2 vss vdd vdd sky130_fd_pr__pfet_01v8 w=4 l=0.18
X1025 t_Xrx_Xse1_Xcomp_tb3 vss vss vss sky130_fd_pr__nfet_01v8 w=4 l=0.18
X1026 t_Xrx_Xse1_Xcomp_tb3 vss vdd vdd sky130_fd_pr__pfet_01v8 w=8 l=0.18
X1027 t_Xrx_Xse1_Xcomp_tb4 vss vss vss sky130_fd_pr__nfet_01v8 w=8 l=0.18
X1028 t_Xrx_Xse1_Xcomp_tb4 vss vdd vdd sky130_fd_pr__pfet_01v8 w=16 l=0.18
X1029 t_Xrx_Xse1_Xcomp_tb5 vdd vss vss sky130_fd_pr__nfet_01v8 w=16 l=0.18
X1030 t_Xrx_Xse1_Xcomp_tb5 vdd vdd vdd sky130_fd_pr__pfet_01v8 w=32 l=0.18
X1031 t_Xrx_Xse1_Xcomp_r_on vdd vss vss sky130_fd_pr__nfet_01v8 w=16 l=0.18
X1032 t_Xrx_Xse1_Xcomp_r_on vdd vdd vdd sky130_fd_pr__pfet_01v8 w=32 l=0.18
X1033 t_Xrx_Xse1_Xcomp_r_off vss vss vss sky130_fd_pr__nfet_01v8 w=16 l=0.18
X1034 t_Xrx_Xse1_Xcomp_r_off vss vdd vdd sky130_fd_pr__pfet_01v8 w=32 l=0.18
X1035 t_Xrx_Xse1_Xcomp_tail t_Xrx_cke1 vss vss sky130_fd_pr__nfet_01v8_lvt w=7 l=0.15
X1036 t_Xrx_Xse1_Xcomp_fn ctle_p t_Xrx_Xse1_Xcomp_tail vss sky130_fd_pr__nfet_01v8_lvt w=14 l=0.18
X1037 t_Xrx_Xse1_Xcomp_fp ctle_n t_Xrx_Xse1_Xcomp_tail vss sky130_fd_pr__nfet_01v8_lvt w=14 l=0.18
X1038 t_Xrx_Xse1_Xcomp_fn t_Xrx_cke1 vdd vdd sky130_fd_pr__pfet_01v8 w=3.6 l=0.15
X1039 t_Xrx_Xse1_Xcomp_fp t_Xrx_cke1 vdd vdd sky130_fd_pr__pfet_01v8 w=3.6 l=0.15
X1040 t_Xrx_Xse1_Xcomp_fn t_Xrx_cke1 t_Xrx_Xse1_Xcomp_fp vdd sky130_fd_pr__pfet_01v8 w=1 l=0.18
X1041 t_Xrx_Xse1_Xcomp_tb0 t_Xrx_Xse1_Xcomp_fn t_Xrx_Xse1_Xcomp_tb0 vss sky130_fd_pr__nfet_01v8 w=0.45 l=0.18
X1042 t_Xrx_Xse1_Xcomp_tb1 t_Xrx_Xse1_Xcomp_fn t_Xrx_Xse1_Xcomp_tb1 vss sky130_fd_pr__nfet_01v8 w=0.9 l=0.18
X1043 t_Xrx_Xse1_Xcomp_tb2 t_Xrx_Xse1_Xcomp_fn t_Xrx_Xse1_Xcomp_tb2 vss sky130_fd_pr__nfet_01v8 w=1.8 l=0.18
X1044 t_Xrx_Xse1_Xcomp_tb3 t_Xrx_Xse1_Xcomp_fn t_Xrx_Xse1_Xcomp_tb3 vss sky130_fd_pr__nfet_01v8 w=3.6 l=0.18
X1045 t_Xrx_Xse1_Xcomp_tb4 t_Xrx_Xse1_Xcomp_fn t_Xrx_Xse1_Xcomp_tb4 vss sky130_fd_pr__nfet_01v8 w=7.2 l=0.18
X1046 t_Xrx_Xse1_Xcomp_tb5 t_Xrx_Xse1_Xcomp_fn t_Xrx_Xse1_Xcomp_tb5 vss sky130_fd_pr__nfet_01v8 w=14.4 l=0.18
X1047 t_Xrx_Xse1_Xcomp_r_off t_Xrx_Xse1_Xcomp_fn t_Xrx_Xse1_Xcomp_r_off vss sky130_fd_pr__nfet_01v8 w=0.45 l=0.18
X1048 t_Xrx_Xse1_Xcomp_r_on t_Xrx_Xse1_Xcomp_fp t_Xrx_Xse1_Xcomp_r_on vss sky130_fd_pr__nfet_01v8 w=14.4 l=0.18
X1049 t_Xrx_Xse1_Xcomp_r_off t_Xrx_Xse1_Xcomp_fp t_Xrx_Xse1_Xcomp_r_off vss sky130_fd_pr__nfet_01v8 w=14.4 l=0.18
X1050 t_Xrx_Xse1_Xcomp_vbot2 t_Xrx_cke1 vss vss sky130_fd_pr__nfet_01v8 w=6 l=0.18
X1051 t_Xrx_Xse1_outp_b t_Xrx_Xse1_Xcomp_fp t_Xrx_Xse1_Xcomp_vbot2 vss sky130_fd_pr__nfet_01v8_lvt w=4.8 l=0.18
X1052 t_Xrx_Xse1_outn_b t_Xrx_Xse1_Xcomp_fn t_Xrx_Xse1_Xcomp_vbot2 vss sky130_fd_pr__nfet_01v8_lvt w=4.8 l=0.18
X1053 t_Xrx_Xse1_outp_b t_Xrx_Xse1_outn_b t_Xrx_Xse1_Xcomp_vbot2 vss sky130_fd_pr__nfet_01v8_lvt w=8 l=0.18
X1054 t_Xrx_Xse1_outn_b t_Xrx_Xse1_outp_b t_Xrx_Xse1_Xcomp_vbot2 vss sky130_fd_pr__nfet_01v8_lvt w=8 l=0.18
X1055 t_Xrx_Xse1_outp_b t_Xrx_Xse1_outn_b vdd vdd sky130_fd_pr__pfet_01v8 w=9 l=0.18
X1056 t_Xrx_Xse1_outn_b t_Xrx_Xse1_outp_b vdd vdd sky130_fd_pr__pfet_01v8 w=9 l=0.18
X1057 t_Xrx_Xse1_outp_b t_Xrx_cke1 vdd vdd sky130_fd_pr__pfet_01v8 w=3.6 l=0.15
X1058 t_Xrx_Xse1_outn_b t_Xrx_cke1 vdd vdd sky130_fd_pr__pfet_01v8 w=3.6 l=0.15
X1059 t_Xrx_Xse1_outp_b t_Xrx_cke1 t_Xrx_Xse1_outn_b vdd sky130_fd_pr__pfet_01v8 w=1 l=0.18
X1060 t_Xrx_Xse1_Xsr_sp t_Xrx_Xse1_outp_b vss vss sky130_fd_pr__nfet_01v8_lvt w=1.5 l=0.15
X1061 t_Xrx_Xse1_Xsr_sp t_Xrx_Xse1_outp_b vdd vdd sky130_fd_pr__pfet_01v8_lvt w=3.2 l=0.35
X1062 t_Xrx_Xse1_Xsr_sn t_Xrx_Xse1_outn_b vss vss sky130_fd_pr__nfet_01v8_lvt w=1.5 l=0.15
X1063 t_Xrx_Xse1_Xsr_sn t_Xrx_Xse1_outn_b vdd vdd sky130_fd_pr__pfet_01v8_lvt w=3.2 l=0.35
X1064 t_Xrx_e1b t_Xrx_Xse1_Xsr_sp vss vss sky130_fd_pr__nfet_01v8_lvt w=4.8 l=0.15
X1065 t_Xrx_e1 t_Xrx_Xse1_Xsr_sn vss vss sky130_fd_pr__nfet_01v8_lvt w=4.8 l=0.15
X1066 t_Xrx_e1 t_Xrx_e1b vdd vdd sky130_fd_pr__pfet_01v8_lvt w=2.8 l=0.35
X1067 t_Xrx_e1 t_Xrx_e1b vss vss sky130_fd_pr__nfet_01v8_lvt w=1 l=0.15
X1068 t_Xrx_e1b t_Xrx_e1 vdd vdd sky130_fd_pr__pfet_01v8_lvt w=2.8 l=0.35
X1069 t_Xrx_e1b t_Xrx_e1 vss vss sky130_fd_pr__nfet_01v8_lvt w=1 l=0.15
X1070 t_Xrx_Xse2_Xcomp_tb0 vss vss vss sky130_fd_pr__nfet_01v8 w=1 l=0.18
X1071 t_Xrx_Xse2_Xcomp_tb0 vss vdd vdd sky130_fd_pr__pfet_01v8 w=2 l=0.18
X1072 t_Xrx_Xse2_Xcomp_tb1 vss vss vss sky130_fd_pr__nfet_01v8 w=1 l=0.18
X1073 t_Xrx_Xse2_Xcomp_tb1 vss vdd vdd sky130_fd_pr__pfet_01v8 w=2 l=0.18
X1074 t_Xrx_Xse2_Xcomp_tb2 vss vss vss sky130_fd_pr__nfet_01v8 w=2 l=0.18
X1075 t_Xrx_Xse2_Xcomp_tb2 vss vdd vdd sky130_fd_pr__pfet_01v8 w=4 l=0.18
X1076 t_Xrx_Xse2_Xcomp_tb3 vss vss vss sky130_fd_pr__nfet_01v8 w=4 l=0.18
X1077 t_Xrx_Xse2_Xcomp_tb3 vss vdd vdd sky130_fd_pr__pfet_01v8 w=8 l=0.18
X1078 t_Xrx_Xse2_Xcomp_tb4 vss vss vss sky130_fd_pr__nfet_01v8 w=8 l=0.18
X1079 t_Xrx_Xse2_Xcomp_tb4 vss vdd vdd sky130_fd_pr__pfet_01v8 w=16 l=0.18
X1080 t_Xrx_Xse2_Xcomp_tb5 vdd vss vss sky130_fd_pr__nfet_01v8 w=16 l=0.18
X1081 t_Xrx_Xse2_Xcomp_tb5 vdd vdd vdd sky130_fd_pr__pfet_01v8 w=32 l=0.18
X1082 t_Xrx_Xse2_Xcomp_r_on vdd vss vss sky130_fd_pr__nfet_01v8 w=16 l=0.18
X1083 t_Xrx_Xse2_Xcomp_r_on vdd vdd vdd sky130_fd_pr__pfet_01v8 w=32 l=0.18
X1084 t_Xrx_Xse2_Xcomp_r_off vss vss vss sky130_fd_pr__nfet_01v8 w=16 l=0.18
X1085 t_Xrx_Xse2_Xcomp_r_off vss vdd vdd sky130_fd_pr__pfet_01v8 w=32 l=0.18
X1086 t_Xrx_Xse2_Xcomp_tail t_Xrx_cke2 vss vss sky130_fd_pr__nfet_01v8_lvt w=7 l=0.15
X1087 t_Xrx_Xse2_Xcomp_fn ctle_p t_Xrx_Xse2_Xcomp_tail vss sky130_fd_pr__nfet_01v8_lvt w=14 l=0.18
X1088 t_Xrx_Xse2_Xcomp_fp ctle_n t_Xrx_Xse2_Xcomp_tail vss sky130_fd_pr__nfet_01v8_lvt w=14 l=0.18
X1089 t_Xrx_Xse2_Xcomp_fn t_Xrx_cke2 vdd vdd sky130_fd_pr__pfet_01v8 w=3.6 l=0.15
X1090 t_Xrx_Xse2_Xcomp_fp t_Xrx_cke2 vdd vdd sky130_fd_pr__pfet_01v8 w=3.6 l=0.15
X1091 t_Xrx_Xse2_Xcomp_fn t_Xrx_cke2 t_Xrx_Xse2_Xcomp_fp vdd sky130_fd_pr__pfet_01v8 w=1 l=0.18
X1092 t_Xrx_Xse2_Xcomp_tb0 t_Xrx_Xse2_Xcomp_fn t_Xrx_Xse2_Xcomp_tb0 vss sky130_fd_pr__nfet_01v8 w=0.45 l=0.18
X1093 t_Xrx_Xse2_Xcomp_tb1 t_Xrx_Xse2_Xcomp_fn t_Xrx_Xse2_Xcomp_tb1 vss sky130_fd_pr__nfet_01v8 w=0.9 l=0.18
X1094 t_Xrx_Xse2_Xcomp_tb2 t_Xrx_Xse2_Xcomp_fn t_Xrx_Xse2_Xcomp_tb2 vss sky130_fd_pr__nfet_01v8 w=1.8 l=0.18
X1095 t_Xrx_Xse2_Xcomp_tb3 t_Xrx_Xse2_Xcomp_fn t_Xrx_Xse2_Xcomp_tb3 vss sky130_fd_pr__nfet_01v8 w=3.6 l=0.18
X1096 t_Xrx_Xse2_Xcomp_tb4 t_Xrx_Xse2_Xcomp_fn t_Xrx_Xse2_Xcomp_tb4 vss sky130_fd_pr__nfet_01v8 w=7.2 l=0.18
X1097 t_Xrx_Xse2_Xcomp_tb5 t_Xrx_Xse2_Xcomp_fn t_Xrx_Xse2_Xcomp_tb5 vss sky130_fd_pr__nfet_01v8 w=14.4 l=0.18
X1098 t_Xrx_Xse2_Xcomp_r_off t_Xrx_Xse2_Xcomp_fn t_Xrx_Xse2_Xcomp_r_off vss sky130_fd_pr__nfet_01v8 w=0.45 l=0.18
X1099 t_Xrx_Xse2_Xcomp_r_on t_Xrx_Xse2_Xcomp_fp t_Xrx_Xse2_Xcomp_r_on vss sky130_fd_pr__nfet_01v8 w=14.4 l=0.18
X1100 t_Xrx_Xse2_Xcomp_r_off t_Xrx_Xse2_Xcomp_fp t_Xrx_Xse2_Xcomp_r_off vss sky130_fd_pr__nfet_01v8 w=14.4 l=0.18
X1101 t_Xrx_Xse2_Xcomp_vbot2 t_Xrx_cke2 vss vss sky130_fd_pr__nfet_01v8 w=6 l=0.18
X1102 t_Xrx_Xse2_outp_b t_Xrx_Xse2_Xcomp_fp t_Xrx_Xse2_Xcomp_vbot2 vss sky130_fd_pr__nfet_01v8_lvt w=4.8 l=0.18
X1103 t_Xrx_Xse2_outn_b t_Xrx_Xse2_Xcomp_fn t_Xrx_Xse2_Xcomp_vbot2 vss sky130_fd_pr__nfet_01v8_lvt w=4.8 l=0.18
X1104 t_Xrx_Xse2_outp_b t_Xrx_Xse2_outn_b t_Xrx_Xse2_Xcomp_vbot2 vss sky130_fd_pr__nfet_01v8_lvt w=8 l=0.18
X1105 t_Xrx_Xse2_outn_b t_Xrx_Xse2_outp_b t_Xrx_Xse2_Xcomp_vbot2 vss sky130_fd_pr__nfet_01v8_lvt w=8 l=0.18
X1106 t_Xrx_Xse2_outp_b t_Xrx_Xse2_outn_b vdd vdd sky130_fd_pr__pfet_01v8 w=9 l=0.18
X1107 t_Xrx_Xse2_outn_b t_Xrx_Xse2_outp_b vdd vdd sky130_fd_pr__pfet_01v8 w=9 l=0.18
X1108 t_Xrx_Xse2_outp_b t_Xrx_cke2 vdd vdd sky130_fd_pr__pfet_01v8 w=3.6 l=0.15
X1109 t_Xrx_Xse2_outn_b t_Xrx_cke2 vdd vdd sky130_fd_pr__pfet_01v8 w=3.6 l=0.15
X1110 t_Xrx_Xse2_outp_b t_Xrx_cke2 t_Xrx_Xse2_outn_b vdd sky130_fd_pr__pfet_01v8 w=1 l=0.18
X1111 t_Xrx_Xse2_Xsr_sp t_Xrx_Xse2_outp_b vss vss sky130_fd_pr__nfet_01v8_lvt w=1.5 l=0.15
X1112 t_Xrx_Xse2_Xsr_sp t_Xrx_Xse2_outp_b vdd vdd sky130_fd_pr__pfet_01v8_lvt w=3.2 l=0.35
X1113 t_Xrx_Xse2_Xsr_sn t_Xrx_Xse2_outn_b vss vss sky130_fd_pr__nfet_01v8_lvt w=1.5 l=0.15
X1114 t_Xrx_Xse2_Xsr_sn t_Xrx_Xse2_outn_b vdd vdd sky130_fd_pr__pfet_01v8_lvt w=3.2 l=0.35
X1115 t_Xrx_e2b t_Xrx_Xse2_Xsr_sp vss vss sky130_fd_pr__nfet_01v8_lvt w=4.8 l=0.15
X1116 t_Xrx_e2 t_Xrx_Xse2_Xsr_sn vss vss sky130_fd_pr__nfet_01v8_lvt w=4.8 l=0.15
X1117 t_Xrx_e2 t_Xrx_e2b vdd vdd sky130_fd_pr__pfet_01v8_lvt w=2.8 l=0.35
X1118 t_Xrx_e2 t_Xrx_e2b vss vss sky130_fd_pr__nfet_01v8_lvt w=1 l=0.15
X1119 t_Xrx_e2b t_Xrx_e2 vdd vdd sky130_fd_pr__pfet_01v8_lvt w=2.8 l=0.35
X1120 t_Xrx_e2b t_Xrx_e2 vss vss sky130_fd_pr__nfet_01v8_lvt w=1 l=0.15
X1121 t_Xrx_Xse3_Xcomp_tb0 vss vss vss sky130_fd_pr__nfet_01v8 w=1 l=0.18
X1122 t_Xrx_Xse3_Xcomp_tb0 vss vdd vdd sky130_fd_pr__pfet_01v8 w=2 l=0.18
X1123 t_Xrx_Xse3_Xcomp_tb1 vss vss vss sky130_fd_pr__nfet_01v8 w=1 l=0.18
X1124 t_Xrx_Xse3_Xcomp_tb1 vss vdd vdd sky130_fd_pr__pfet_01v8 w=2 l=0.18
X1125 t_Xrx_Xse3_Xcomp_tb2 vss vss vss sky130_fd_pr__nfet_01v8 w=2 l=0.18
X1126 t_Xrx_Xse3_Xcomp_tb2 vss vdd vdd sky130_fd_pr__pfet_01v8 w=4 l=0.18
X1127 t_Xrx_Xse3_Xcomp_tb3 vss vss vss sky130_fd_pr__nfet_01v8 w=4 l=0.18
X1128 t_Xrx_Xse3_Xcomp_tb3 vss vdd vdd sky130_fd_pr__pfet_01v8 w=8 l=0.18
X1129 t_Xrx_Xse3_Xcomp_tb4 vss vss vss sky130_fd_pr__nfet_01v8 w=8 l=0.18
X1130 t_Xrx_Xse3_Xcomp_tb4 vss vdd vdd sky130_fd_pr__pfet_01v8 w=16 l=0.18
X1131 t_Xrx_Xse3_Xcomp_tb5 vdd vss vss sky130_fd_pr__nfet_01v8 w=16 l=0.18
X1132 t_Xrx_Xse3_Xcomp_tb5 vdd vdd vdd sky130_fd_pr__pfet_01v8 w=32 l=0.18
X1133 t_Xrx_Xse3_Xcomp_r_on vdd vss vss sky130_fd_pr__nfet_01v8 w=16 l=0.18
X1134 t_Xrx_Xse3_Xcomp_r_on vdd vdd vdd sky130_fd_pr__pfet_01v8 w=32 l=0.18
X1135 t_Xrx_Xse3_Xcomp_r_off vss vss vss sky130_fd_pr__nfet_01v8 w=16 l=0.18
X1136 t_Xrx_Xse3_Xcomp_r_off vss vdd vdd sky130_fd_pr__pfet_01v8 w=32 l=0.18
X1137 t_Xrx_Xse3_Xcomp_tail t_Xrx_cke3 vss vss sky130_fd_pr__nfet_01v8_lvt w=7 l=0.15
X1138 t_Xrx_Xse3_Xcomp_fn ctle_p t_Xrx_Xse3_Xcomp_tail vss sky130_fd_pr__nfet_01v8_lvt w=14 l=0.18
X1139 t_Xrx_Xse3_Xcomp_fp ctle_n t_Xrx_Xse3_Xcomp_tail vss sky130_fd_pr__nfet_01v8_lvt w=14 l=0.18
X1140 t_Xrx_Xse3_Xcomp_fn t_Xrx_cke3 vdd vdd sky130_fd_pr__pfet_01v8 w=3.6 l=0.15
X1141 t_Xrx_Xse3_Xcomp_fp t_Xrx_cke3 vdd vdd sky130_fd_pr__pfet_01v8 w=3.6 l=0.15
X1142 t_Xrx_Xse3_Xcomp_fn t_Xrx_cke3 t_Xrx_Xse3_Xcomp_fp vdd sky130_fd_pr__pfet_01v8 w=1 l=0.18
X1143 t_Xrx_Xse3_Xcomp_tb0 t_Xrx_Xse3_Xcomp_fn t_Xrx_Xse3_Xcomp_tb0 vss sky130_fd_pr__nfet_01v8 w=0.45 l=0.18
X1144 t_Xrx_Xse3_Xcomp_tb1 t_Xrx_Xse3_Xcomp_fn t_Xrx_Xse3_Xcomp_tb1 vss sky130_fd_pr__nfet_01v8 w=0.9 l=0.18
X1145 t_Xrx_Xse3_Xcomp_tb2 t_Xrx_Xse3_Xcomp_fn t_Xrx_Xse3_Xcomp_tb2 vss sky130_fd_pr__nfet_01v8 w=1.8 l=0.18
X1146 t_Xrx_Xse3_Xcomp_tb3 t_Xrx_Xse3_Xcomp_fn t_Xrx_Xse3_Xcomp_tb3 vss sky130_fd_pr__nfet_01v8 w=3.6 l=0.18
X1147 t_Xrx_Xse3_Xcomp_tb4 t_Xrx_Xse3_Xcomp_fn t_Xrx_Xse3_Xcomp_tb4 vss sky130_fd_pr__nfet_01v8 w=7.2 l=0.18
X1148 t_Xrx_Xse3_Xcomp_tb5 t_Xrx_Xse3_Xcomp_fn t_Xrx_Xse3_Xcomp_tb5 vss sky130_fd_pr__nfet_01v8 w=14.4 l=0.18
X1149 t_Xrx_Xse3_Xcomp_r_off t_Xrx_Xse3_Xcomp_fn t_Xrx_Xse3_Xcomp_r_off vss sky130_fd_pr__nfet_01v8 w=0.45 l=0.18
X1150 t_Xrx_Xse3_Xcomp_r_on t_Xrx_Xse3_Xcomp_fp t_Xrx_Xse3_Xcomp_r_on vss sky130_fd_pr__nfet_01v8 w=14.4 l=0.18
X1151 t_Xrx_Xse3_Xcomp_r_off t_Xrx_Xse3_Xcomp_fp t_Xrx_Xse3_Xcomp_r_off vss sky130_fd_pr__nfet_01v8 w=14.4 l=0.18
X1152 t_Xrx_Xse3_Xcomp_vbot2 t_Xrx_cke3 vss vss sky130_fd_pr__nfet_01v8 w=6 l=0.18
X1153 t_Xrx_Xse3_outp_b t_Xrx_Xse3_Xcomp_fp t_Xrx_Xse3_Xcomp_vbot2 vss sky130_fd_pr__nfet_01v8_lvt w=4.8 l=0.18
X1154 t_Xrx_Xse3_outn_b t_Xrx_Xse3_Xcomp_fn t_Xrx_Xse3_Xcomp_vbot2 vss sky130_fd_pr__nfet_01v8_lvt w=4.8 l=0.18
X1155 t_Xrx_Xse3_outp_b t_Xrx_Xse3_outn_b t_Xrx_Xse3_Xcomp_vbot2 vss sky130_fd_pr__nfet_01v8_lvt w=8 l=0.18
X1156 t_Xrx_Xse3_outn_b t_Xrx_Xse3_outp_b t_Xrx_Xse3_Xcomp_vbot2 vss sky130_fd_pr__nfet_01v8_lvt w=8 l=0.18
X1157 t_Xrx_Xse3_outp_b t_Xrx_Xse3_outn_b vdd vdd sky130_fd_pr__pfet_01v8 w=9 l=0.18
X1158 t_Xrx_Xse3_outn_b t_Xrx_Xse3_outp_b vdd vdd sky130_fd_pr__pfet_01v8 w=9 l=0.18
X1159 t_Xrx_Xse3_outp_b t_Xrx_cke3 vdd vdd sky130_fd_pr__pfet_01v8 w=3.6 l=0.15
X1160 t_Xrx_Xse3_outn_b t_Xrx_cke3 vdd vdd sky130_fd_pr__pfet_01v8 w=3.6 l=0.15
X1161 t_Xrx_Xse3_outp_b t_Xrx_cke3 t_Xrx_Xse3_outn_b vdd sky130_fd_pr__pfet_01v8 w=1 l=0.18
X1162 t_Xrx_Xse3_Xsr_sp t_Xrx_Xse3_outp_b vss vss sky130_fd_pr__nfet_01v8_lvt w=1.5 l=0.15
X1163 t_Xrx_Xse3_Xsr_sp t_Xrx_Xse3_outp_b vdd vdd sky130_fd_pr__pfet_01v8_lvt w=3.2 l=0.35
X1164 t_Xrx_Xse3_Xsr_sn t_Xrx_Xse3_outn_b vss vss sky130_fd_pr__nfet_01v8_lvt w=1.5 l=0.15
X1165 t_Xrx_Xse3_Xsr_sn t_Xrx_Xse3_outn_b vdd vdd sky130_fd_pr__pfet_01v8_lvt w=3.2 l=0.35
X1166 t_Xrx_e3b t_Xrx_Xse3_Xsr_sp vss vss sky130_fd_pr__nfet_01v8_lvt w=4.8 l=0.15
X1167 t_Xrx_e3 t_Xrx_Xse3_Xsr_sn vss vss sky130_fd_pr__nfet_01v8_lvt w=4.8 l=0.15
X1168 t_Xrx_e3 t_Xrx_e3b vdd vdd sky130_fd_pr__pfet_01v8_lvt w=2.8 l=0.35
X1169 t_Xrx_e3 t_Xrx_e3b vss vss sky130_fd_pr__nfet_01v8_lvt w=1 l=0.15
X1170 t_Xrx_e3b t_Xrx_e3 vdd vdd sky130_fd_pr__pfet_01v8_lvt w=2.8 l=0.35
X1171 t_Xrx_e3b t_Xrx_e3 vss vss sky130_fd_pr__nfet_01v8_lvt w=1 l=0.15
X1172 t_Xrx_Xdeser_ck0_1b t_Xrx_ckd0 vss vss sky130_fd_pr__nfet_01v8_lvt w=0.8 l=0.15
X1173 t_Xrx_Xdeser_ck0_1b t_Xrx_ckd0 vdd vdd sky130_fd_pr__pfet_01v8 w=2 l=0.15
X1174 t_Xrx_Xdeser_ck2_1b t_Xrx_ckd2 vss vss sky130_fd_pr__nfet_01v8_lvt w=0.8 l=0.15
X1175 t_Xrx_Xdeser_ck2_1b t_Xrx_ckd2 vdd vdd sky130_fd_pr__pfet_01v8 w=2 l=0.15
X1176 t_Xrx_Xdeser_ck2_1b t_Xrx_Xdeser_ck0_1b vss vss sky130_fd_pr__nfet_01v8_lvt w=0.42 l=0.15
X1177 t_Xrx_Xdeser_ck2_1b t_Xrx_Xdeser_ck0_1b vdd vdd sky130_fd_pr__pfet_01v8 w=1 l=0.15
X1178 t_Xrx_Xdeser_ck0_1b t_Xrx_Xdeser_ck2_1b vss vss sky130_fd_pr__nfet_01v8_lvt w=0.42 l=0.15
X1179 t_Xrx_Xdeser_ck0_1b t_Xrx_Xdeser_ck2_1b vdd vdd sky130_fd_pr__pfet_01v8 w=1 l=0.15
X1180 t_Xrx_Xdeser_ck0a t_Xrx_Xdeser_ck0_1b vss vss sky130_fd_pr__nfet_01v8_lvt w=2.6 l=0.15
X1181 t_Xrx_Xdeser_ck0a t_Xrx_Xdeser_ck0_1b vdd vdd sky130_fd_pr__pfet_01v8 w=6.6 l=0.15
X1182 t_Xrx_Xdeser_ck0ba t_Xrx_Xdeser_ck2_1b vss vss sky130_fd_pr__nfet_01v8_lvt w=2.6 l=0.15
X1183 t_Xrx_Xdeser_ck0ba t_Xrx_Xdeser_ck2_1b vdd vdd sky130_fd_pr__pfet_01v8 w=6.6 l=0.15
X1184 t_Xrx_Xdeser_ck0ba t_Xrx_Xdeser_ck0a vss vss sky130_fd_pr__nfet_01v8_lvt w=0.45 l=0.15
X1185 t_Xrx_Xdeser_ck0ba t_Xrx_Xdeser_ck0a vdd vdd sky130_fd_pr__pfet_01v8 w=1.1 l=0.15
X1186 t_Xrx_Xdeser_ck0a t_Xrx_Xdeser_ck0ba vss vss sky130_fd_pr__nfet_01v8_lvt w=0.45 l=0.15
X1187 t_Xrx_Xdeser_ck0a t_Xrx_Xdeser_ck0ba vdd vdd sky130_fd_pr__pfet_01v8 w=1.1 l=0.15
X1188 t_Xrx_Xdeser_ck0b t_Xrx_Xdeser_ck0_1b vss vss sky130_fd_pr__nfet_01v8_lvt w=2.6 l=0.15
X1189 t_Xrx_Xdeser_ck0b t_Xrx_Xdeser_ck0_1b vdd vdd sky130_fd_pr__pfet_01v8 w=6.6 l=0.15
X1190 t_Xrx_Xdeser_ck0bb t_Xrx_Xdeser_ck2_1b vss vss sky130_fd_pr__nfet_01v8_lvt w=2.6 l=0.15
X1191 t_Xrx_Xdeser_ck0bb t_Xrx_Xdeser_ck2_1b vdd vdd sky130_fd_pr__pfet_01v8 w=6.6 l=0.15
X1192 t_Xrx_Xdeser_ck0bb t_Xrx_Xdeser_ck0b vss vss sky130_fd_pr__nfet_01v8_lvt w=0.45 l=0.15
X1193 t_Xrx_Xdeser_ck0bb t_Xrx_Xdeser_ck0b vdd vdd sky130_fd_pr__pfet_01v8 w=1.1 l=0.15
X1194 t_Xrx_Xdeser_ck0b t_Xrx_Xdeser_ck0bb vss vss sky130_fd_pr__nfet_01v8_lvt w=0.45 l=0.15
X1195 t_Xrx_Xdeser_ck0b t_Xrx_Xdeser_ck0bb vdd vdd sky130_fd_pr__pfet_01v8 w=1.1 l=0.15
X1196 vss t_Xrx_ckd1 vss vss sky130_fd_pr__nfet_01v8_lvt w=0.8 l=0.15
X1197 vdd t_Xrx_ckd1 vdd vdd sky130_fd_pr__pfet_01v8 w=2 l=0.15
X1198 vss t_Xrx_ckd3 vss vss sky130_fd_pr__nfet_01v8_lvt w=0.8 l=0.15
X1199 vdd t_Xrx_ckd3 vdd vdd sky130_fd_pr__pfet_01v8 w=2 l=0.15
X1200 vss t_Xrx_cke0 vss vss sky130_fd_pr__nfet_01v8_lvt w=0.8 l=0.15
X1201 vdd t_Xrx_cke0 vdd vdd sky130_fd_pr__pfet_01v8 w=2 l=0.15
X1202 vss t_Xrx_cke1 vss vss sky130_fd_pr__nfet_01v8_lvt w=0.8 l=0.15
X1203 vdd t_Xrx_cke1 vdd vdd sky130_fd_pr__pfet_01v8 w=2 l=0.15
X1204 vss t_Xrx_cke2 vss vss sky130_fd_pr__nfet_01v8_lvt w=0.8 l=0.15
X1205 vdd t_Xrx_cke2 vdd vdd sky130_fd_pr__pfet_01v8 w=2 l=0.15
X1206 vss t_Xrx_cke3 vss vss sky130_fd_pr__nfet_01v8_lvt w=0.8 l=0.15
X1207 vdd t_Xrx_cke3 vdd vdd sky130_fd_pr__pfet_01v8 w=2 l=0.15
X1208 t_Xrx_d0 t_Xrx_Xdeser_ck0a t_Xrx_Xdeser_Xd0_a_m1 vss sky130_fd_pr__nfet_01v8_lvt w=0.65 l=0.15
X1209 t_Xrx_d0 t_Xrx_Xdeser_ck0ba t_Xrx_Xdeser_Xd0_a_m1 vdd sky130_fd_pr__pfet_01v8 w=1.8 l=0.15
X1210 t_Xrx_Xdeser_Xd0_a_m2 t_Xrx_Xdeser_Xd0_a_m1 t_Xrx_Xdeser_Xd0_a_Xm2_mid vss sky130_fd_pr__nfet_01v8_lvt w=0.9 l=0.15
X1211 t_Xrx_Xdeser_Xd0_a_Xm2_mid rst_n vss vss sky130_fd_pr__nfet_01v8_lvt w=0.9 l=0.15
X1212 t_Xrx_Xdeser_Xd0_a_m2 t_Xrx_Xdeser_Xd0_a_m1 vdd vdd sky130_fd_pr__pfet_01v8 w=1.6 l=0.15
X1213 t_Xrx_Xdeser_Xd0_a_m2 rst_n vdd vdd sky130_fd_pr__pfet_01v8 w=1.6 l=0.15
X1214 t_Xrx_Xdeser_Xd0_a_m3 t_Xrx_Xdeser_Xd0_a_m2 vss vss sky130_fd_pr__nfet_01v8_lvt w=0.45 l=0.15
X1215 t_Xrx_Xdeser_Xd0_a_m3 t_Xrx_Xdeser_Xd0_a_m2 vdd vdd sky130_fd_pr__pfet_01v8 w=1.15 l=0.15
X1216 t_Xrx_Xdeser_Xd0_a_m3 t_Xrx_Xdeser_ck0ba t_Xrx_Xdeser_Xd0_a_m1 vss sky130_fd_pr__nfet_01v8_lvt w=0.45 l=0.15
X1217 t_Xrx_Xdeser_Xd0_a_m3 t_Xrx_Xdeser_ck0a t_Xrx_Xdeser_Xd0_a_m1 vdd sky130_fd_pr__pfet_01v8 w=1.05 l=0.15
X1218 t_Xrx_Xdeser_Xd0_a_m2 t_Xrx_Xdeser_ck0ba t_Xrx_Xdeser_Xd0_a_s1 vss sky130_fd_pr__nfet_01v8_lvt w=0.65 l=0.15
X1219 t_Xrx_Xdeser_Xd0_a_m2 t_Xrx_Xdeser_ck0a t_Xrx_Xdeser_Xd0_a_s1 vdd sky130_fd_pr__pfet_01v8 w=1.8 l=0.15
X1220 t_Xrx_Xdeser_Xd0_a_qi t_Xrx_Xdeser_Xd0_a_s1 vss vss sky130_fd_pr__nfet_01v8_lvt w=0.65 l=0.15
X1221 t_Xrx_Xdeser_Xd0_a_qi t_Xrx_Xdeser_Xd0_a_s1 vdd vdd sky130_fd_pr__pfet_01v8 w=1.65 l=0.15
X1222 t_Xrx_Xdeser_Xd0_a_s2 t_Xrx_Xdeser_Xd0_a_qi t_Xrx_Xdeser_Xd0_a_Xsfb_mid vss sky130_fd_pr__nfet_01v8_lvt w=0.8 l=0.15
X1223 t_Xrx_Xdeser_Xd0_a_Xsfb_mid rst_n vss vss sky130_fd_pr__nfet_01v8_lvt w=0.8 l=0.15
X1224 t_Xrx_Xdeser_Xd0_a_s2 t_Xrx_Xdeser_Xd0_a_qi vdd vdd sky130_fd_pr__pfet_01v8 w=1.4 l=0.15
X1225 t_Xrx_Xdeser_Xd0_a_s2 rst_n vdd vdd sky130_fd_pr__pfet_01v8 w=1.4 l=0.15
X1226 t_Xrx_Xdeser_Xd0_a_s2 t_Xrx_Xdeser_ck0a t_Xrx_Xdeser_Xd0_a_s1 vss sky130_fd_pr__nfet_01v8_lvt w=0.45 l=0.15
X1227 t_Xrx_Xdeser_Xd0_a_s2 t_Xrx_Xdeser_ck0ba t_Xrx_Xdeser_Xd0_a_s1 vdd sky130_fd_pr__pfet_01v8 w=1.05 l=0.15
X1228 t_Xrx_Xdeser_d0_a t_Xrx_Xdeser_Xd0_a_s1 vss vss sky130_fd_pr__nfet_01v8_lvt w=0.7 l=0.15
X1229 t_Xrx_Xdeser_d0_a t_Xrx_Xdeser_Xd0_a_s1 vdd vdd sky130_fd_pr__pfet_01v8 w=1.8 l=0.15
X1230 t_Xrx_Xdeser_d0_ab t_Xrx_Xdeser_d0_a vss vss sky130_fd_pr__nfet_01v8_lvt w=0.55 l=0.15
X1231 t_Xrx_Xdeser_d0_ab t_Xrx_Xdeser_d0_a vdd vdd sky130_fd_pr__pfet_01v8 w=1.4 l=0.15
X1232 t_Xrx_Xdeser_d0_a t_Xrx_Xdeser_ck0ba t_Xrx_Xdeser_Xd0_p_m1 vss sky130_fd_pr__nfet_01v8_lvt w=0.65 l=0.15
X1233 t_Xrx_Xdeser_d0_a t_Xrx_Xdeser_ck0a t_Xrx_Xdeser_Xd0_p_m1 vdd sky130_fd_pr__pfet_01v8 w=1.8 l=0.15
X1234 t_Xrx_Xdeser_Xd0_p_m2 t_Xrx_Xdeser_Xd0_p_m1 t_Xrx_Xdeser_Xd0_p_Xm2_mid vss sky130_fd_pr__nfet_01v8_lvt w=0.9 l=0.15
X1235 t_Xrx_Xdeser_Xd0_p_Xm2_mid rst_n vss vss sky130_fd_pr__nfet_01v8_lvt w=0.9 l=0.15
X1236 t_Xrx_Xdeser_Xd0_p_m2 t_Xrx_Xdeser_Xd0_p_m1 vdd vdd sky130_fd_pr__pfet_01v8 w=1.6 l=0.15
X1237 t_Xrx_Xdeser_Xd0_p_m2 rst_n vdd vdd sky130_fd_pr__pfet_01v8 w=1.6 l=0.15
X1238 t_Xrx_Xdeser_Xd0_p_m3 t_Xrx_Xdeser_Xd0_p_m2 vss vss sky130_fd_pr__nfet_01v8_lvt w=0.45 l=0.15
X1239 t_Xrx_Xdeser_Xd0_p_m3 t_Xrx_Xdeser_Xd0_p_m2 vdd vdd sky130_fd_pr__pfet_01v8 w=1.15 l=0.15
X1240 t_Xrx_Xdeser_Xd0_p_m3 t_Xrx_Xdeser_ck0a t_Xrx_Xdeser_Xd0_p_m1 vss sky130_fd_pr__nfet_01v8_lvt w=0.45 l=0.15
X1241 t_Xrx_Xdeser_Xd0_p_m3 t_Xrx_Xdeser_ck0ba t_Xrx_Xdeser_Xd0_p_m1 vdd sky130_fd_pr__pfet_01v8 w=1.05 l=0.15
X1242 t_Xrx_Xdeser_Xd0_p_m2 t_Xrx_Xdeser_ck0a t_Xrx_Xdeser_Xd0_p_s1 vss sky130_fd_pr__nfet_01v8_lvt w=0.65 l=0.15
X1243 t_Xrx_Xdeser_Xd0_p_m2 t_Xrx_Xdeser_ck0ba t_Xrx_Xdeser_Xd0_p_s1 vdd sky130_fd_pr__pfet_01v8 w=1.8 l=0.15
X1244 t_Xrx_Xdeser_Xd0_p_qi t_Xrx_Xdeser_Xd0_p_s1 vss vss sky130_fd_pr__nfet_01v8_lvt w=0.65 l=0.15
X1245 t_Xrx_Xdeser_Xd0_p_qi t_Xrx_Xdeser_Xd0_p_s1 vdd vdd sky130_fd_pr__pfet_01v8 w=1.65 l=0.15
X1246 t_Xrx_Xdeser_Xd0_p_s2 t_Xrx_Xdeser_Xd0_p_qi t_Xrx_Xdeser_Xd0_p_Xsfb_mid vss sky130_fd_pr__nfet_01v8_lvt w=0.8 l=0.15
X1247 t_Xrx_Xdeser_Xd0_p_Xsfb_mid rst_n vss vss sky130_fd_pr__nfet_01v8_lvt w=0.8 l=0.15
X1248 t_Xrx_Xdeser_Xd0_p_s2 t_Xrx_Xdeser_Xd0_p_qi vdd vdd sky130_fd_pr__pfet_01v8 w=1.4 l=0.15
X1249 t_Xrx_Xdeser_Xd0_p_s2 rst_n vdd vdd sky130_fd_pr__pfet_01v8 w=1.4 l=0.15
X1250 t_Xrx_Xdeser_Xd0_p_s2 t_Xrx_Xdeser_ck0ba t_Xrx_Xdeser_Xd0_p_s1 vss sky130_fd_pr__nfet_01v8_lvt w=0.45 l=0.15
X1251 t_Xrx_Xdeser_Xd0_p_s2 t_Xrx_Xdeser_ck0a t_Xrx_Xdeser_Xd0_p_s1 vdd sky130_fd_pr__pfet_01v8 w=1.05 l=0.15
X1252 t_Xrx_Xdeser_d0_p t_Xrx_Xdeser_Xd0_p_s1 vss vss sky130_fd_pr__nfet_01v8_lvt w=0.7 l=0.15
X1253 t_Xrx_Xdeser_d0_p t_Xrx_Xdeser_Xd0_p_s1 vdd vdd sky130_fd_pr__pfet_01v8 w=1.8 l=0.15
X1254 t_Xrx_Xdeser_d0_pb t_Xrx_Xdeser_d0_p vss vss sky130_fd_pr__nfet_01v8_lvt w=0.55 l=0.15
X1255 t_Xrx_Xdeser_d0_pb t_Xrx_Xdeser_d0_p vdd vdd sky130_fd_pr__pfet_01v8 w=1.4 l=0.15
X1256 t_Xrx_d1 t_Xrx_Xdeser_ck0ba t_Xrx_Xdeser_Xd1_p_m1 vss sky130_fd_pr__nfet_01v8_lvt w=0.65 l=0.15
X1257 t_Xrx_d1 t_Xrx_Xdeser_ck0a t_Xrx_Xdeser_Xd1_p_m1 vdd sky130_fd_pr__pfet_01v8 w=1.8 l=0.15
X1258 t_Xrx_Xdeser_Xd1_p_m2 t_Xrx_Xdeser_Xd1_p_m1 t_Xrx_Xdeser_Xd1_p_Xm2_mid vss sky130_fd_pr__nfet_01v8_lvt w=0.9 l=0.15
X1259 t_Xrx_Xdeser_Xd1_p_Xm2_mid rst_n vss vss sky130_fd_pr__nfet_01v8_lvt w=0.9 l=0.15
X1260 t_Xrx_Xdeser_Xd1_p_m2 t_Xrx_Xdeser_Xd1_p_m1 vdd vdd sky130_fd_pr__pfet_01v8 w=1.6 l=0.15
X1261 t_Xrx_Xdeser_Xd1_p_m2 rst_n vdd vdd sky130_fd_pr__pfet_01v8 w=1.6 l=0.15
X1262 t_Xrx_Xdeser_Xd1_p_m3 t_Xrx_Xdeser_Xd1_p_m2 vss vss sky130_fd_pr__nfet_01v8_lvt w=0.45 l=0.15
X1263 t_Xrx_Xdeser_Xd1_p_m3 t_Xrx_Xdeser_Xd1_p_m2 vdd vdd sky130_fd_pr__pfet_01v8 w=1.15 l=0.15
X1264 t_Xrx_Xdeser_Xd1_p_m3 t_Xrx_Xdeser_ck0a t_Xrx_Xdeser_Xd1_p_m1 vss sky130_fd_pr__nfet_01v8_lvt w=0.45 l=0.15
X1265 t_Xrx_Xdeser_Xd1_p_m3 t_Xrx_Xdeser_ck0ba t_Xrx_Xdeser_Xd1_p_m1 vdd sky130_fd_pr__pfet_01v8 w=1.05 l=0.15
X1266 t_Xrx_Xdeser_Xd1_p_m2 t_Xrx_Xdeser_ck0a t_Xrx_Xdeser_Xd1_p_s1 vss sky130_fd_pr__nfet_01v8_lvt w=0.65 l=0.15
X1267 t_Xrx_Xdeser_Xd1_p_m2 t_Xrx_Xdeser_ck0ba t_Xrx_Xdeser_Xd1_p_s1 vdd sky130_fd_pr__pfet_01v8 w=1.8 l=0.15
X1268 t_Xrx_Xdeser_Xd1_p_qi t_Xrx_Xdeser_Xd1_p_s1 vss vss sky130_fd_pr__nfet_01v8_lvt w=0.65 l=0.15
X1269 t_Xrx_Xdeser_Xd1_p_qi t_Xrx_Xdeser_Xd1_p_s1 vdd vdd sky130_fd_pr__pfet_01v8 w=1.65 l=0.15
X1270 t_Xrx_Xdeser_Xd1_p_s2 t_Xrx_Xdeser_Xd1_p_qi t_Xrx_Xdeser_Xd1_p_Xsfb_mid vss sky130_fd_pr__nfet_01v8_lvt w=0.8 l=0.15
X1271 t_Xrx_Xdeser_Xd1_p_Xsfb_mid rst_n vss vss sky130_fd_pr__nfet_01v8_lvt w=0.8 l=0.15
X1272 t_Xrx_Xdeser_Xd1_p_s2 t_Xrx_Xdeser_Xd1_p_qi vdd vdd sky130_fd_pr__pfet_01v8 w=1.4 l=0.15
X1273 t_Xrx_Xdeser_Xd1_p_s2 rst_n vdd vdd sky130_fd_pr__pfet_01v8 w=1.4 l=0.15
X1274 t_Xrx_Xdeser_Xd1_p_s2 t_Xrx_Xdeser_ck0ba t_Xrx_Xdeser_Xd1_p_s1 vss sky130_fd_pr__nfet_01v8_lvt w=0.45 l=0.15
X1275 t_Xrx_Xdeser_Xd1_p_s2 t_Xrx_Xdeser_ck0a t_Xrx_Xdeser_Xd1_p_s1 vdd sky130_fd_pr__pfet_01v8 w=1.05 l=0.15
X1276 t_Xrx_Xdeser_d1_p t_Xrx_Xdeser_Xd1_p_s1 vss vss sky130_fd_pr__nfet_01v8_lvt w=0.7 l=0.15
X1277 t_Xrx_Xdeser_d1_p t_Xrx_Xdeser_Xd1_p_s1 vdd vdd sky130_fd_pr__pfet_01v8 w=1.8 l=0.15
X1278 t_Xrx_Xdeser_d1_pb t_Xrx_Xdeser_d1_p vss vss sky130_fd_pr__nfet_01v8_lvt w=0.55 l=0.15
X1279 t_Xrx_Xdeser_d1_pb t_Xrx_Xdeser_d1_p vdd vdd sky130_fd_pr__pfet_01v8 w=1.4 l=0.15
X1280 t_Xrx_d2 t_Xrx_Xdeser_ck0ba t_Xrx_Xdeser_Xd2_p_m1 vss sky130_fd_pr__nfet_01v8_lvt w=0.65 l=0.15
X1281 t_Xrx_d2 t_Xrx_Xdeser_ck0a t_Xrx_Xdeser_Xd2_p_m1 vdd sky130_fd_pr__pfet_01v8 w=1.8 l=0.15
X1282 t_Xrx_Xdeser_Xd2_p_m2 t_Xrx_Xdeser_Xd2_p_m1 t_Xrx_Xdeser_Xd2_p_Xm2_mid vss sky130_fd_pr__nfet_01v8_lvt w=0.9 l=0.15
X1283 t_Xrx_Xdeser_Xd2_p_Xm2_mid rst_n vss vss sky130_fd_pr__nfet_01v8_lvt w=0.9 l=0.15
X1284 t_Xrx_Xdeser_Xd2_p_m2 t_Xrx_Xdeser_Xd2_p_m1 vdd vdd sky130_fd_pr__pfet_01v8 w=1.6 l=0.15
X1285 t_Xrx_Xdeser_Xd2_p_m2 rst_n vdd vdd sky130_fd_pr__pfet_01v8 w=1.6 l=0.15
X1286 t_Xrx_Xdeser_Xd2_p_m3 t_Xrx_Xdeser_Xd2_p_m2 vss vss sky130_fd_pr__nfet_01v8_lvt w=0.45 l=0.15
X1287 t_Xrx_Xdeser_Xd2_p_m3 t_Xrx_Xdeser_Xd2_p_m2 vdd vdd sky130_fd_pr__pfet_01v8 w=1.15 l=0.15
X1288 t_Xrx_Xdeser_Xd2_p_m3 t_Xrx_Xdeser_ck0a t_Xrx_Xdeser_Xd2_p_m1 vss sky130_fd_pr__nfet_01v8_lvt w=0.45 l=0.15
X1289 t_Xrx_Xdeser_Xd2_p_m3 t_Xrx_Xdeser_ck0ba t_Xrx_Xdeser_Xd2_p_m1 vdd sky130_fd_pr__pfet_01v8 w=1.05 l=0.15
X1290 t_Xrx_Xdeser_Xd2_p_m2 t_Xrx_Xdeser_ck0a t_Xrx_Xdeser_Xd2_p_s1 vss sky130_fd_pr__nfet_01v8_lvt w=0.65 l=0.15
X1291 t_Xrx_Xdeser_Xd2_p_m2 t_Xrx_Xdeser_ck0ba t_Xrx_Xdeser_Xd2_p_s1 vdd sky130_fd_pr__pfet_01v8 w=1.8 l=0.15
X1292 t_Xrx_Xdeser_Xd2_p_qi t_Xrx_Xdeser_Xd2_p_s1 vss vss sky130_fd_pr__nfet_01v8_lvt w=0.65 l=0.15
X1293 t_Xrx_Xdeser_Xd2_p_qi t_Xrx_Xdeser_Xd2_p_s1 vdd vdd sky130_fd_pr__pfet_01v8 w=1.65 l=0.15
X1294 t_Xrx_Xdeser_Xd2_p_s2 t_Xrx_Xdeser_Xd2_p_qi t_Xrx_Xdeser_Xd2_p_Xsfb_mid vss sky130_fd_pr__nfet_01v8_lvt w=0.8 l=0.15
X1295 t_Xrx_Xdeser_Xd2_p_Xsfb_mid rst_n vss vss sky130_fd_pr__nfet_01v8_lvt w=0.8 l=0.15
X1296 t_Xrx_Xdeser_Xd2_p_s2 t_Xrx_Xdeser_Xd2_p_qi vdd vdd sky130_fd_pr__pfet_01v8 w=1.4 l=0.15
X1297 t_Xrx_Xdeser_Xd2_p_s2 rst_n vdd vdd sky130_fd_pr__pfet_01v8 w=1.4 l=0.15
X1298 t_Xrx_Xdeser_Xd2_p_s2 t_Xrx_Xdeser_ck0ba t_Xrx_Xdeser_Xd2_p_s1 vss sky130_fd_pr__nfet_01v8_lvt w=0.45 l=0.15
X1299 t_Xrx_Xdeser_Xd2_p_s2 t_Xrx_Xdeser_ck0a t_Xrx_Xdeser_Xd2_p_s1 vdd sky130_fd_pr__pfet_01v8 w=1.05 l=0.15
X1300 t_Xrx_Xdeser_d2_p t_Xrx_Xdeser_Xd2_p_s1 vss vss sky130_fd_pr__nfet_01v8_lvt w=0.7 l=0.15
X1301 t_Xrx_Xdeser_d2_p t_Xrx_Xdeser_Xd2_p_s1 vdd vdd sky130_fd_pr__pfet_01v8 w=1.8 l=0.15
X1302 t_Xrx_Xdeser_d2_pb t_Xrx_Xdeser_d2_p vss vss sky130_fd_pr__nfet_01v8_lvt w=0.55 l=0.15
X1303 t_Xrx_Xdeser_d2_pb t_Xrx_Xdeser_d2_p vdd vdd sky130_fd_pr__pfet_01v8 w=1.4 l=0.15
X1304 t_Xrx_e0 t_Xrx_Xdeser_ck0bb t_Xrx_Xdeser_Xe0_p_m1 vss sky130_fd_pr__nfet_01v8_lvt w=0.65 l=0.15
X1305 t_Xrx_e0 t_Xrx_Xdeser_ck0b t_Xrx_Xdeser_Xe0_p_m1 vdd sky130_fd_pr__pfet_01v8 w=1.8 l=0.15
X1306 t_Xrx_Xdeser_Xe0_p_m2 t_Xrx_Xdeser_Xe0_p_m1 t_Xrx_Xdeser_Xe0_p_Xm2_mid vss sky130_fd_pr__nfet_01v8_lvt w=0.9 l=0.15
X1307 t_Xrx_Xdeser_Xe0_p_Xm2_mid rst_n vss vss sky130_fd_pr__nfet_01v8_lvt w=0.9 l=0.15
X1308 t_Xrx_Xdeser_Xe0_p_m2 t_Xrx_Xdeser_Xe0_p_m1 vdd vdd sky130_fd_pr__pfet_01v8 w=1.6 l=0.15
X1309 t_Xrx_Xdeser_Xe0_p_m2 rst_n vdd vdd sky130_fd_pr__pfet_01v8 w=1.6 l=0.15
X1310 t_Xrx_Xdeser_Xe0_p_m3 t_Xrx_Xdeser_Xe0_p_m2 vss vss sky130_fd_pr__nfet_01v8_lvt w=0.45 l=0.15
X1311 t_Xrx_Xdeser_Xe0_p_m3 t_Xrx_Xdeser_Xe0_p_m2 vdd vdd sky130_fd_pr__pfet_01v8 w=1.15 l=0.15
X1312 t_Xrx_Xdeser_Xe0_p_m3 t_Xrx_Xdeser_ck0b t_Xrx_Xdeser_Xe0_p_m1 vss sky130_fd_pr__nfet_01v8_lvt w=0.45 l=0.15
X1313 t_Xrx_Xdeser_Xe0_p_m3 t_Xrx_Xdeser_ck0bb t_Xrx_Xdeser_Xe0_p_m1 vdd sky130_fd_pr__pfet_01v8 w=1.05 l=0.15
X1314 t_Xrx_Xdeser_Xe0_p_m2 t_Xrx_Xdeser_ck0b t_Xrx_Xdeser_Xe0_p_s1 vss sky130_fd_pr__nfet_01v8_lvt w=0.65 l=0.15
X1315 t_Xrx_Xdeser_Xe0_p_m2 t_Xrx_Xdeser_ck0bb t_Xrx_Xdeser_Xe0_p_s1 vdd sky130_fd_pr__pfet_01v8 w=1.8 l=0.15
X1316 t_Xrx_Xdeser_Xe0_p_qi t_Xrx_Xdeser_Xe0_p_s1 vss vss sky130_fd_pr__nfet_01v8_lvt w=0.65 l=0.15
X1317 t_Xrx_Xdeser_Xe0_p_qi t_Xrx_Xdeser_Xe0_p_s1 vdd vdd sky130_fd_pr__pfet_01v8 w=1.65 l=0.15
X1318 t_Xrx_Xdeser_Xe0_p_s2 t_Xrx_Xdeser_Xe0_p_qi t_Xrx_Xdeser_Xe0_p_Xsfb_mid vss sky130_fd_pr__nfet_01v8_lvt w=0.8 l=0.15
X1319 t_Xrx_Xdeser_Xe0_p_Xsfb_mid rst_n vss vss sky130_fd_pr__nfet_01v8_lvt w=0.8 l=0.15
X1320 t_Xrx_Xdeser_Xe0_p_s2 t_Xrx_Xdeser_Xe0_p_qi vdd vdd sky130_fd_pr__pfet_01v8 w=1.4 l=0.15
X1321 t_Xrx_Xdeser_Xe0_p_s2 rst_n vdd vdd sky130_fd_pr__pfet_01v8 w=1.4 l=0.15
X1322 t_Xrx_Xdeser_Xe0_p_s2 t_Xrx_Xdeser_ck0bb t_Xrx_Xdeser_Xe0_p_s1 vss sky130_fd_pr__nfet_01v8_lvt w=0.45 l=0.15
X1323 t_Xrx_Xdeser_Xe0_p_s2 t_Xrx_Xdeser_ck0b t_Xrx_Xdeser_Xe0_p_s1 vdd sky130_fd_pr__pfet_01v8 w=1.05 l=0.15
X1324 t_Xrx_Xdeser_e0_p t_Xrx_Xdeser_Xe0_p_s1 vss vss sky130_fd_pr__nfet_01v8_lvt w=0.7 l=0.15
X1325 t_Xrx_Xdeser_e0_p t_Xrx_Xdeser_Xe0_p_s1 vdd vdd sky130_fd_pr__pfet_01v8 w=1.8 l=0.15
X1326 t_Xrx_Xdeser_e0_pb t_Xrx_Xdeser_e0_p vss vss sky130_fd_pr__nfet_01v8_lvt w=0.55 l=0.15
X1327 t_Xrx_Xdeser_e0_pb t_Xrx_Xdeser_e0_p vdd vdd sky130_fd_pr__pfet_01v8 w=1.4 l=0.15
X1328 t_Xrx_e1 t_Xrx_Xdeser_ck0bb t_Xrx_Xdeser_Xe1_p_m1 vss sky130_fd_pr__nfet_01v8_lvt w=0.65 l=0.15
X1329 t_Xrx_e1 t_Xrx_Xdeser_ck0b t_Xrx_Xdeser_Xe1_p_m1 vdd sky130_fd_pr__pfet_01v8 w=1.8 l=0.15
X1330 t_Xrx_Xdeser_Xe1_p_m2 t_Xrx_Xdeser_Xe1_p_m1 t_Xrx_Xdeser_Xe1_p_Xm2_mid vss sky130_fd_pr__nfet_01v8_lvt w=0.9 l=0.15
X1331 t_Xrx_Xdeser_Xe1_p_Xm2_mid rst_n vss vss sky130_fd_pr__nfet_01v8_lvt w=0.9 l=0.15
X1332 t_Xrx_Xdeser_Xe1_p_m2 t_Xrx_Xdeser_Xe1_p_m1 vdd vdd sky130_fd_pr__pfet_01v8 w=1.6 l=0.15
X1333 t_Xrx_Xdeser_Xe1_p_m2 rst_n vdd vdd sky130_fd_pr__pfet_01v8 w=1.6 l=0.15
X1334 t_Xrx_Xdeser_Xe1_p_m3 t_Xrx_Xdeser_Xe1_p_m2 vss vss sky130_fd_pr__nfet_01v8_lvt w=0.45 l=0.15
X1335 t_Xrx_Xdeser_Xe1_p_m3 t_Xrx_Xdeser_Xe1_p_m2 vdd vdd sky130_fd_pr__pfet_01v8 w=1.15 l=0.15
X1336 t_Xrx_Xdeser_Xe1_p_m3 t_Xrx_Xdeser_ck0b t_Xrx_Xdeser_Xe1_p_m1 vss sky130_fd_pr__nfet_01v8_lvt w=0.45 l=0.15
X1337 t_Xrx_Xdeser_Xe1_p_m3 t_Xrx_Xdeser_ck0bb t_Xrx_Xdeser_Xe1_p_m1 vdd sky130_fd_pr__pfet_01v8 w=1.05 l=0.15
X1338 t_Xrx_Xdeser_Xe1_p_m2 t_Xrx_Xdeser_ck0b t_Xrx_Xdeser_Xe1_p_s1 vss sky130_fd_pr__nfet_01v8_lvt w=0.65 l=0.15
X1339 t_Xrx_Xdeser_Xe1_p_m2 t_Xrx_Xdeser_ck0bb t_Xrx_Xdeser_Xe1_p_s1 vdd sky130_fd_pr__pfet_01v8 w=1.8 l=0.15
X1340 t_Xrx_Xdeser_Xe1_p_qi t_Xrx_Xdeser_Xe1_p_s1 vss vss sky130_fd_pr__nfet_01v8_lvt w=0.65 l=0.15
X1341 t_Xrx_Xdeser_Xe1_p_qi t_Xrx_Xdeser_Xe1_p_s1 vdd vdd sky130_fd_pr__pfet_01v8 w=1.65 l=0.15
X1342 t_Xrx_Xdeser_Xe1_p_s2 t_Xrx_Xdeser_Xe1_p_qi t_Xrx_Xdeser_Xe1_p_Xsfb_mid vss sky130_fd_pr__nfet_01v8_lvt w=0.8 l=0.15
X1343 t_Xrx_Xdeser_Xe1_p_Xsfb_mid rst_n vss vss sky130_fd_pr__nfet_01v8_lvt w=0.8 l=0.15
X1344 t_Xrx_Xdeser_Xe1_p_s2 t_Xrx_Xdeser_Xe1_p_qi vdd vdd sky130_fd_pr__pfet_01v8 w=1.4 l=0.15
X1345 t_Xrx_Xdeser_Xe1_p_s2 rst_n vdd vdd sky130_fd_pr__pfet_01v8 w=1.4 l=0.15
X1346 t_Xrx_Xdeser_Xe1_p_s2 t_Xrx_Xdeser_ck0bb t_Xrx_Xdeser_Xe1_p_s1 vss sky130_fd_pr__nfet_01v8_lvt w=0.45 l=0.15
X1347 t_Xrx_Xdeser_Xe1_p_s2 t_Xrx_Xdeser_ck0b t_Xrx_Xdeser_Xe1_p_s1 vdd sky130_fd_pr__pfet_01v8 w=1.05 l=0.15
X1348 t_Xrx_Xdeser_e1_p t_Xrx_Xdeser_Xe1_p_s1 vss vss sky130_fd_pr__nfet_01v8_lvt w=0.7 l=0.15
X1349 t_Xrx_Xdeser_e1_p t_Xrx_Xdeser_Xe1_p_s1 vdd vdd sky130_fd_pr__pfet_01v8 w=1.8 l=0.15
X1350 t_Xrx_Xdeser_e1_pb t_Xrx_Xdeser_e1_p vss vss sky130_fd_pr__nfet_01v8_lvt w=0.55 l=0.15
X1351 t_Xrx_Xdeser_e1_pb t_Xrx_Xdeser_e1_p vdd vdd sky130_fd_pr__pfet_01v8 w=1.4 l=0.15
X1352 t_Xrx_d3 t_Xrx_Xdeser_ck0a t_Xrx_Xdeser_Xd3_a_m1 vss sky130_fd_pr__nfet_01v8_lvt w=0.65 l=0.15
X1353 t_Xrx_d3 t_Xrx_Xdeser_ck0ba t_Xrx_Xdeser_Xd3_a_m1 vdd sky130_fd_pr__pfet_01v8 w=1.8 l=0.15
X1354 t_Xrx_Xdeser_Xd3_a_m2 t_Xrx_Xdeser_Xd3_a_m1 t_Xrx_Xdeser_Xd3_a_Xm2_mid vss sky130_fd_pr__nfet_01v8_lvt w=0.9 l=0.15
X1355 t_Xrx_Xdeser_Xd3_a_Xm2_mid rst_n vss vss sky130_fd_pr__nfet_01v8_lvt w=0.9 l=0.15
X1356 t_Xrx_Xdeser_Xd3_a_m2 t_Xrx_Xdeser_Xd3_a_m1 vdd vdd sky130_fd_pr__pfet_01v8 w=1.6 l=0.15
X1357 t_Xrx_Xdeser_Xd3_a_m2 rst_n vdd vdd sky130_fd_pr__pfet_01v8 w=1.6 l=0.15
X1358 t_Xrx_Xdeser_Xd3_a_m3 t_Xrx_Xdeser_Xd3_a_m2 vss vss sky130_fd_pr__nfet_01v8_lvt w=0.45 l=0.15
X1359 t_Xrx_Xdeser_Xd3_a_m3 t_Xrx_Xdeser_Xd3_a_m2 vdd vdd sky130_fd_pr__pfet_01v8 w=1.15 l=0.15
X1360 t_Xrx_Xdeser_Xd3_a_m3 t_Xrx_Xdeser_ck0ba t_Xrx_Xdeser_Xd3_a_m1 vss sky130_fd_pr__nfet_01v8_lvt w=0.45 l=0.15
X1361 t_Xrx_Xdeser_Xd3_a_m3 t_Xrx_Xdeser_ck0a t_Xrx_Xdeser_Xd3_a_m1 vdd sky130_fd_pr__pfet_01v8 w=1.05 l=0.15
X1362 t_Xrx_Xdeser_Xd3_a_m2 t_Xrx_Xdeser_ck0ba t_Xrx_Xdeser_Xd3_a_s1 vss sky130_fd_pr__nfet_01v8_lvt w=0.65 l=0.15
X1363 t_Xrx_Xdeser_Xd3_a_m2 t_Xrx_Xdeser_ck0a t_Xrx_Xdeser_Xd3_a_s1 vdd sky130_fd_pr__pfet_01v8 w=1.8 l=0.15
X1364 t_Xrx_Xdeser_Xd3_a_qi t_Xrx_Xdeser_Xd3_a_s1 vss vss sky130_fd_pr__nfet_01v8_lvt w=0.65 l=0.15
X1365 t_Xrx_Xdeser_Xd3_a_qi t_Xrx_Xdeser_Xd3_a_s1 vdd vdd sky130_fd_pr__pfet_01v8 w=1.65 l=0.15
X1366 t_Xrx_Xdeser_Xd3_a_s2 t_Xrx_Xdeser_Xd3_a_qi t_Xrx_Xdeser_Xd3_a_Xsfb_mid vss sky130_fd_pr__nfet_01v8_lvt w=0.8 l=0.15
X1367 t_Xrx_Xdeser_Xd3_a_Xsfb_mid rst_n vss vss sky130_fd_pr__nfet_01v8_lvt w=0.8 l=0.15
X1368 t_Xrx_Xdeser_Xd3_a_s2 t_Xrx_Xdeser_Xd3_a_qi vdd vdd sky130_fd_pr__pfet_01v8 w=1.4 l=0.15
X1369 t_Xrx_Xdeser_Xd3_a_s2 rst_n vdd vdd sky130_fd_pr__pfet_01v8 w=1.4 l=0.15
X1370 t_Xrx_Xdeser_Xd3_a_s2 t_Xrx_Xdeser_ck0a t_Xrx_Xdeser_Xd3_a_s1 vss sky130_fd_pr__nfet_01v8_lvt w=0.45 l=0.15
X1371 t_Xrx_Xdeser_Xd3_a_s2 t_Xrx_Xdeser_ck0ba t_Xrx_Xdeser_Xd3_a_s1 vdd sky130_fd_pr__pfet_01v8 w=1.05 l=0.15
X1372 t_Xrx_Xdeser_d3_a t_Xrx_Xdeser_Xd3_a_s1 vss vss sky130_fd_pr__nfet_01v8_lvt w=0.7 l=0.15
X1373 t_Xrx_Xdeser_d3_a t_Xrx_Xdeser_Xd3_a_s1 vdd vdd sky130_fd_pr__pfet_01v8 w=1.8 l=0.15
X1374 t_Xrx_Xdeser_d3_ab t_Xrx_Xdeser_d3_a vss vss sky130_fd_pr__nfet_01v8_lvt w=0.55 l=0.15
X1375 t_Xrx_Xdeser_d3_ab t_Xrx_Xdeser_d3_a vdd vdd sky130_fd_pr__pfet_01v8 w=1.4 l=0.15
X1376 t_Xrx_e2 t_Xrx_Xdeser_ck0b t_Xrx_Xdeser_Xe2_a_m1 vss sky130_fd_pr__nfet_01v8_lvt w=0.65 l=0.15
X1377 t_Xrx_e2 t_Xrx_Xdeser_ck0bb t_Xrx_Xdeser_Xe2_a_m1 vdd sky130_fd_pr__pfet_01v8 w=1.8 l=0.15
X1378 t_Xrx_Xdeser_Xe2_a_m2 t_Xrx_Xdeser_Xe2_a_m1 t_Xrx_Xdeser_Xe2_a_Xm2_mid vss sky130_fd_pr__nfet_01v8_lvt w=0.9 l=0.15
X1379 t_Xrx_Xdeser_Xe2_a_Xm2_mid rst_n vss vss sky130_fd_pr__nfet_01v8_lvt w=0.9 l=0.15
X1380 t_Xrx_Xdeser_Xe2_a_m2 t_Xrx_Xdeser_Xe2_a_m1 vdd vdd sky130_fd_pr__pfet_01v8 w=1.6 l=0.15
X1381 t_Xrx_Xdeser_Xe2_a_m2 rst_n vdd vdd sky130_fd_pr__pfet_01v8 w=1.6 l=0.15
X1382 t_Xrx_Xdeser_Xe2_a_m3 t_Xrx_Xdeser_Xe2_a_m2 vss vss sky130_fd_pr__nfet_01v8_lvt w=0.45 l=0.15
X1383 t_Xrx_Xdeser_Xe2_a_m3 t_Xrx_Xdeser_Xe2_a_m2 vdd vdd sky130_fd_pr__pfet_01v8 w=1.15 l=0.15
X1384 t_Xrx_Xdeser_Xe2_a_m3 t_Xrx_Xdeser_ck0bb t_Xrx_Xdeser_Xe2_a_m1 vss sky130_fd_pr__nfet_01v8_lvt w=0.45 l=0.15
X1385 t_Xrx_Xdeser_Xe2_a_m3 t_Xrx_Xdeser_ck0b t_Xrx_Xdeser_Xe2_a_m1 vdd sky130_fd_pr__pfet_01v8 w=1.05 l=0.15
X1386 t_Xrx_Xdeser_Xe2_a_m2 t_Xrx_Xdeser_ck0bb t_Xrx_Xdeser_Xe2_a_s1 vss sky130_fd_pr__nfet_01v8_lvt w=0.65 l=0.15
X1387 t_Xrx_Xdeser_Xe2_a_m2 t_Xrx_Xdeser_ck0b t_Xrx_Xdeser_Xe2_a_s1 vdd sky130_fd_pr__pfet_01v8 w=1.8 l=0.15
X1388 t_Xrx_Xdeser_Xe2_a_qi t_Xrx_Xdeser_Xe2_a_s1 vss vss sky130_fd_pr__nfet_01v8_lvt w=0.65 l=0.15
X1389 t_Xrx_Xdeser_Xe2_a_qi t_Xrx_Xdeser_Xe2_a_s1 vdd vdd sky130_fd_pr__pfet_01v8 w=1.65 l=0.15
X1390 t_Xrx_Xdeser_Xe2_a_s2 t_Xrx_Xdeser_Xe2_a_qi t_Xrx_Xdeser_Xe2_a_Xsfb_mid vss sky130_fd_pr__nfet_01v8_lvt w=0.8 l=0.15
X1391 t_Xrx_Xdeser_Xe2_a_Xsfb_mid rst_n vss vss sky130_fd_pr__nfet_01v8_lvt w=0.8 l=0.15
X1392 t_Xrx_Xdeser_Xe2_a_s2 t_Xrx_Xdeser_Xe2_a_qi vdd vdd sky130_fd_pr__pfet_01v8 w=1.4 l=0.15
X1393 t_Xrx_Xdeser_Xe2_a_s2 rst_n vdd vdd sky130_fd_pr__pfet_01v8 w=1.4 l=0.15
X1394 t_Xrx_Xdeser_Xe2_a_s2 t_Xrx_Xdeser_ck0b t_Xrx_Xdeser_Xe2_a_s1 vss sky130_fd_pr__nfet_01v8_lvt w=0.45 l=0.15
X1395 t_Xrx_Xdeser_Xe2_a_s2 t_Xrx_Xdeser_ck0bb t_Xrx_Xdeser_Xe2_a_s1 vdd sky130_fd_pr__pfet_01v8 w=1.05 l=0.15
X1396 t_Xrx_Xdeser_e2_a t_Xrx_Xdeser_Xe2_a_s1 vss vss sky130_fd_pr__nfet_01v8_lvt w=0.7 l=0.15
X1397 t_Xrx_Xdeser_e2_a t_Xrx_Xdeser_Xe2_a_s1 vdd vdd sky130_fd_pr__pfet_01v8 w=1.8 l=0.15
X1398 t_Xrx_Xdeser_e2_ab t_Xrx_Xdeser_e2_a vss vss sky130_fd_pr__nfet_01v8_lvt w=0.55 l=0.15
X1399 t_Xrx_Xdeser_e2_ab t_Xrx_Xdeser_e2_a vdd vdd sky130_fd_pr__pfet_01v8 w=1.4 l=0.15
X1400 t_Xrx_e3 t_Xrx_Xdeser_ck0b t_Xrx_Xdeser_Xe3_a_m1 vss sky130_fd_pr__nfet_01v8_lvt w=0.65 l=0.15
X1401 t_Xrx_e3 t_Xrx_Xdeser_ck0bb t_Xrx_Xdeser_Xe3_a_m1 vdd sky130_fd_pr__pfet_01v8 w=1.8 l=0.15
X1402 t_Xrx_Xdeser_Xe3_a_m2 t_Xrx_Xdeser_Xe3_a_m1 t_Xrx_Xdeser_Xe3_a_Xm2_mid vss sky130_fd_pr__nfet_01v8_lvt w=0.9 l=0.15
X1403 t_Xrx_Xdeser_Xe3_a_Xm2_mid rst_n vss vss sky130_fd_pr__nfet_01v8_lvt w=0.9 l=0.15
X1404 t_Xrx_Xdeser_Xe3_a_m2 t_Xrx_Xdeser_Xe3_a_m1 vdd vdd sky130_fd_pr__pfet_01v8 w=1.6 l=0.15
X1405 t_Xrx_Xdeser_Xe3_a_m2 rst_n vdd vdd sky130_fd_pr__pfet_01v8 w=1.6 l=0.15
X1406 t_Xrx_Xdeser_Xe3_a_m3 t_Xrx_Xdeser_Xe3_a_m2 vss vss sky130_fd_pr__nfet_01v8_lvt w=0.45 l=0.15
X1407 t_Xrx_Xdeser_Xe3_a_m3 t_Xrx_Xdeser_Xe3_a_m2 vdd vdd sky130_fd_pr__pfet_01v8 w=1.15 l=0.15
X1408 t_Xrx_Xdeser_Xe3_a_m3 t_Xrx_Xdeser_ck0bb t_Xrx_Xdeser_Xe3_a_m1 vss sky130_fd_pr__nfet_01v8_lvt w=0.45 l=0.15
X1409 t_Xrx_Xdeser_Xe3_a_m3 t_Xrx_Xdeser_ck0b t_Xrx_Xdeser_Xe3_a_m1 vdd sky130_fd_pr__pfet_01v8 w=1.05 l=0.15
X1410 t_Xrx_Xdeser_Xe3_a_m2 t_Xrx_Xdeser_ck0bb t_Xrx_Xdeser_Xe3_a_s1 vss sky130_fd_pr__nfet_01v8_lvt w=0.65 l=0.15
X1411 t_Xrx_Xdeser_Xe3_a_m2 t_Xrx_Xdeser_ck0b t_Xrx_Xdeser_Xe3_a_s1 vdd sky130_fd_pr__pfet_01v8 w=1.8 l=0.15
X1412 t_Xrx_Xdeser_Xe3_a_qi t_Xrx_Xdeser_Xe3_a_s1 vss vss sky130_fd_pr__nfet_01v8_lvt w=0.65 l=0.15
X1413 t_Xrx_Xdeser_Xe3_a_qi t_Xrx_Xdeser_Xe3_a_s1 vdd vdd sky130_fd_pr__pfet_01v8 w=1.65 l=0.15
X1414 t_Xrx_Xdeser_Xe3_a_s2 t_Xrx_Xdeser_Xe3_a_qi t_Xrx_Xdeser_Xe3_a_Xsfb_mid vss sky130_fd_pr__nfet_01v8_lvt w=0.8 l=0.15
X1415 t_Xrx_Xdeser_Xe3_a_Xsfb_mid rst_n vss vss sky130_fd_pr__nfet_01v8_lvt w=0.8 l=0.15
X1416 t_Xrx_Xdeser_Xe3_a_s2 t_Xrx_Xdeser_Xe3_a_qi vdd vdd sky130_fd_pr__pfet_01v8 w=1.4 l=0.15
X1417 t_Xrx_Xdeser_Xe3_a_s2 rst_n vdd vdd sky130_fd_pr__pfet_01v8 w=1.4 l=0.15
X1418 t_Xrx_Xdeser_Xe3_a_s2 t_Xrx_Xdeser_ck0b t_Xrx_Xdeser_Xe3_a_s1 vss sky130_fd_pr__nfet_01v8_lvt w=0.45 l=0.15
X1419 t_Xrx_Xdeser_Xe3_a_s2 t_Xrx_Xdeser_ck0bb t_Xrx_Xdeser_Xe3_a_s1 vdd sky130_fd_pr__pfet_01v8 w=1.05 l=0.15
X1420 t_Xrx_Xdeser_e3_a t_Xrx_Xdeser_Xe3_a_s1 vss vss sky130_fd_pr__nfet_01v8_lvt w=0.7 l=0.15
X1421 t_Xrx_Xdeser_e3_a t_Xrx_Xdeser_Xe3_a_s1 vdd vdd sky130_fd_pr__pfet_01v8 w=1.8 l=0.15
X1422 t_Xrx_Xdeser_e3_ab t_Xrx_Xdeser_e3_a vss vss sky130_fd_pr__nfet_01v8_lvt w=0.55 l=0.15
X1423 t_Xrx_Xdeser_e3_ab t_Xrx_Xdeser_e3_a vdd vdd sky130_fd_pr__pfet_01v8 w=1.4 l=0.15
X1424 t_Xrx_Xdeser_d0_p t_Xrx_Xdeser_ck0ba t_Xrx_Xdeser_Xsh_d0_Xf0_m1 vss sky130_fd_pr__nfet_01v8_lvt w=0.65 l=0.15
X1425 t_Xrx_Xdeser_d0_p t_Xrx_Xdeser_ck0a t_Xrx_Xdeser_Xsh_d0_Xf0_m1 vdd sky130_fd_pr__pfet_01v8 w=1.8 l=0.15
X1426 t_Xrx_Xdeser_Xsh_d0_Xf0_m2 t_Xrx_Xdeser_Xsh_d0_Xf0_m1 t_Xrx_Xdeser_Xsh_d0_Xf0_Xm2_mid vss sky130_fd_pr__nfet_01v8_lvt w=0.9 l=0.15
X1427 t_Xrx_Xdeser_Xsh_d0_Xf0_Xm2_mid rst_n vss vss sky130_fd_pr__nfet_01v8_lvt w=0.9 l=0.15
X1428 t_Xrx_Xdeser_Xsh_d0_Xf0_m2 t_Xrx_Xdeser_Xsh_d0_Xf0_m1 vdd vdd sky130_fd_pr__pfet_01v8 w=1.6 l=0.15
X1429 t_Xrx_Xdeser_Xsh_d0_Xf0_m2 rst_n vdd vdd sky130_fd_pr__pfet_01v8 w=1.6 l=0.15
X1430 t_Xrx_Xdeser_Xsh_d0_Xf0_m3 t_Xrx_Xdeser_Xsh_d0_Xf0_m2 vss vss sky130_fd_pr__nfet_01v8_lvt w=0.45 l=0.15
X1431 t_Xrx_Xdeser_Xsh_d0_Xf0_m3 t_Xrx_Xdeser_Xsh_d0_Xf0_m2 vdd vdd sky130_fd_pr__pfet_01v8 w=1.15 l=0.15
X1432 t_Xrx_Xdeser_Xsh_d0_Xf0_m3 t_Xrx_Xdeser_ck0a t_Xrx_Xdeser_Xsh_d0_Xf0_m1 vss sky130_fd_pr__nfet_01v8_lvt w=0.45 l=0.15
X1433 t_Xrx_Xdeser_Xsh_d0_Xf0_m3 t_Xrx_Xdeser_ck0ba t_Xrx_Xdeser_Xsh_d0_Xf0_m1 vdd sky130_fd_pr__pfet_01v8 w=1.05 l=0.15
X1434 t_Xrx_Xdeser_Xsh_d0_Xf0_m2 t_Xrx_Xdeser_ck0a t_Xrx_Xdeser_Xsh_d0_Xf0_s1 vss sky130_fd_pr__nfet_01v8_lvt w=0.65 l=0.15
X1435 t_Xrx_Xdeser_Xsh_d0_Xf0_m2 t_Xrx_Xdeser_ck0ba t_Xrx_Xdeser_Xsh_d0_Xf0_s1 vdd sky130_fd_pr__pfet_01v8 w=1.8 l=0.15
X1436 t_Xrx_Xdeser_Xsh_d0_Xf0_qi t_Xrx_Xdeser_Xsh_d0_Xf0_s1 vss vss sky130_fd_pr__nfet_01v8_lvt w=0.65 l=0.15
X1437 t_Xrx_Xdeser_Xsh_d0_Xf0_qi t_Xrx_Xdeser_Xsh_d0_Xf0_s1 vdd vdd sky130_fd_pr__pfet_01v8 w=1.65 l=0.15
X1438 t_Xrx_Xdeser_Xsh_d0_Xf0_s2 t_Xrx_Xdeser_Xsh_d0_Xf0_qi t_Xrx_Xdeser_Xsh_d0_Xf0_Xsfb_mid vss sky130_fd_pr__nfet_01v8_lvt w=0.8 l=0.15
X1439 t_Xrx_Xdeser_Xsh_d0_Xf0_Xsfb_mid rst_n vss vss sky130_fd_pr__nfet_01v8_lvt w=0.8 l=0.15
X1440 t_Xrx_Xdeser_Xsh_d0_Xf0_s2 t_Xrx_Xdeser_Xsh_d0_Xf0_qi vdd vdd sky130_fd_pr__pfet_01v8 w=1.4 l=0.15
X1441 t_Xrx_Xdeser_Xsh_d0_Xf0_s2 rst_n vdd vdd sky130_fd_pr__pfet_01v8 w=1.4 l=0.15
X1442 t_Xrx_Xdeser_Xsh_d0_Xf0_s2 t_Xrx_Xdeser_ck0ba t_Xrx_Xdeser_Xsh_d0_Xf0_s1 vss sky130_fd_pr__nfet_01v8_lvt w=0.45 l=0.15
X1443 t_Xrx_Xdeser_Xsh_d0_Xf0_s2 t_Xrx_Xdeser_ck0a t_Xrx_Xdeser_Xsh_d0_Xf0_s1 vdd sky130_fd_pr__pfet_01v8 w=1.05 l=0.15
X1444 t_Xrx_Xdeser_d0_0 t_Xrx_Xdeser_Xsh_d0_Xf0_s1 vss vss sky130_fd_pr__nfet_01v8_lvt w=0.7 l=0.15
X1445 t_Xrx_Xdeser_d0_0 t_Xrx_Xdeser_Xsh_d0_Xf0_s1 vdd vdd sky130_fd_pr__pfet_01v8 w=1.8 l=0.15
X1446 t_Xrx_Xdeser_Xsh_d0_s0b t_Xrx_Xdeser_d0_0 vss vss sky130_fd_pr__nfet_01v8_lvt w=0.55 l=0.15
X1447 t_Xrx_Xdeser_Xsh_d0_s0b t_Xrx_Xdeser_d0_0 vdd vdd sky130_fd_pr__pfet_01v8 w=1.4 l=0.15
X1448 t_Xrx_Xdeser_d0_0 t_Xrx_Xdeser_ck0ba t_Xrx_Xdeser_Xsh_d0_Xf1_m1 vss sky130_fd_pr__nfet_01v8_lvt w=0.65 l=0.15
X1449 t_Xrx_Xdeser_d0_0 t_Xrx_Xdeser_ck0a t_Xrx_Xdeser_Xsh_d0_Xf1_m1 vdd sky130_fd_pr__pfet_01v8 w=1.8 l=0.15
X1450 t_Xrx_Xdeser_Xsh_d0_Xf1_m2 t_Xrx_Xdeser_Xsh_d0_Xf1_m1 t_Xrx_Xdeser_Xsh_d0_Xf1_Xm2_mid vss sky130_fd_pr__nfet_01v8_lvt w=0.9 l=0.15
X1451 t_Xrx_Xdeser_Xsh_d0_Xf1_Xm2_mid rst_n vss vss sky130_fd_pr__nfet_01v8_lvt w=0.9 l=0.15
X1452 t_Xrx_Xdeser_Xsh_d0_Xf1_m2 t_Xrx_Xdeser_Xsh_d0_Xf1_m1 vdd vdd sky130_fd_pr__pfet_01v8 w=1.6 l=0.15
X1453 t_Xrx_Xdeser_Xsh_d0_Xf1_m2 rst_n vdd vdd sky130_fd_pr__pfet_01v8 w=1.6 l=0.15
X1454 t_Xrx_Xdeser_Xsh_d0_Xf1_m3 t_Xrx_Xdeser_Xsh_d0_Xf1_m2 vss vss sky130_fd_pr__nfet_01v8_lvt w=0.45 l=0.15
X1455 t_Xrx_Xdeser_Xsh_d0_Xf1_m3 t_Xrx_Xdeser_Xsh_d0_Xf1_m2 vdd vdd sky130_fd_pr__pfet_01v8 w=1.15 l=0.15
X1456 t_Xrx_Xdeser_Xsh_d0_Xf1_m3 t_Xrx_Xdeser_ck0a t_Xrx_Xdeser_Xsh_d0_Xf1_m1 vss sky130_fd_pr__nfet_01v8_lvt w=0.45 l=0.15
X1457 t_Xrx_Xdeser_Xsh_d0_Xf1_m3 t_Xrx_Xdeser_ck0ba t_Xrx_Xdeser_Xsh_d0_Xf1_m1 vdd sky130_fd_pr__pfet_01v8 w=1.05 l=0.15
X1458 t_Xrx_Xdeser_Xsh_d0_Xf1_m2 t_Xrx_Xdeser_ck0a t_Xrx_Xdeser_Xsh_d0_Xf1_s1 vss sky130_fd_pr__nfet_01v8_lvt w=0.65 l=0.15
X1459 t_Xrx_Xdeser_Xsh_d0_Xf1_m2 t_Xrx_Xdeser_ck0ba t_Xrx_Xdeser_Xsh_d0_Xf1_s1 vdd sky130_fd_pr__pfet_01v8 w=1.8 l=0.15
X1460 t_Xrx_Xdeser_Xsh_d0_Xf1_qi t_Xrx_Xdeser_Xsh_d0_Xf1_s1 vss vss sky130_fd_pr__nfet_01v8_lvt w=0.65 l=0.15
X1461 t_Xrx_Xdeser_Xsh_d0_Xf1_qi t_Xrx_Xdeser_Xsh_d0_Xf1_s1 vdd vdd sky130_fd_pr__pfet_01v8 w=1.65 l=0.15
X1462 t_Xrx_Xdeser_Xsh_d0_Xf1_s2 t_Xrx_Xdeser_Xsh_d0_Xf1_qi t_Xrx_Xdeser_Xsh_d0_Xf1_Xsfb_mid vss sky130_fd_pr__nfet_01v8_lvt w=0.8 l=0.15
X1463 t_Xrx_Xdeser_Xsh_d0_Xf1_Xsfb_mid rst_n vss vss sky130_fd_pr__nfet_01v8_lvt w=0.8 l=0.15
X1464 t_Xrx_Xdeser_Xsh_d0_Xf1_s2 t_Xrx_Xdeser_Xsh_d0_Xf1_qi vdd vdd sky130_fd_pr__pfet_01v8 w=1.4 l=0.15
X1465 t_Xrx_Xdeser_Xsh_d0_Xf1_s2 rst_n vdd vdd sky130_fd_pr__pfet_01v8 w=1.4 l=0.15
X1466 t_Xrx_Xdeser_Xsh_d0_Xf1_s2 t_Xrx_Xdeser_ck0ba t_Xrx_Xdeser_Xsh_d0_Xf1_s1 vss sky130_fd_pr__nfet_01v8_lvt w=0.45 l=0.15
X1467 t_Xrx_Xdeser_Xsh_d0_Xf1_s2 t_Xrx_Xdeser_ck0a t_Xrx_Xdeser_Xsh_d0_Xf1_s1 vdd sky130_fd_pr__pfet_01v8 w=1.05 l=0.15
X1468 t_Xrx_Xdeser_d0_1 t_Xrx_Xdeser_Xsh_d0_Xf1_s1 vss vss sky130_fd_pr__nfet_01v8_lvt w=0.7 l=0.15
X1469 t_Xrx_Xdeser_d0_1 t_Xrx_Xdeser_Xsh_d0_Xf1_s1 vdd vdd sky130_fd_pr__pfet_01v8 w=1.8 l=0.15
X1470 t_Xrx_Xdeser_Xsh_d0_s1b t_Xrx_Xdeser_d0_1 vss vss sky130_fd_pr__nfet_01v8_lvt w=0.55 l=0.15
X1471 t_Xrx_Xdeser_Xsh_d0_s1b t_Xrx_Xdeser_d0_1 vdd vdd sky130_fd_pr__pfet_01v8 w=1.4 l=0.15
X1472 t_Xrx_Xdeser_d0_1 t_Xrx_Xdeser_ck0ba t_Xrx_Xdeser_Xsh_d0_Xf2_m1 vss sky130_fd_pr__nfet_01v8_lvt w=0.65 l=0.15
X1473 t_Xrx_Xdeser_d0_1 t_Xrx_Xdeser_ck0a t_Xrx_Xdeser_Xsh_d0_Xf2_m1 vdd sky130_fd_pr__pfet_01v8 w=1.8 l=0.15
X1474 t_Xrx_Xdeser_Xsh_d0_Xf2_m2 t_Xrx_Xdeser_Xsh_d0_Xf2_m1 t_Xrx_Xdeser_Xsh_d0_Xf2_Xm2_mid vss sky130_fd_pr__nfet_01v8_lvt w=0.9 l=0.15
X1475 t_Xrx_Xdeser_Xsh_d0_Xf2_Xm2_mid rst_n vss vss sky130_fd_pr__nfet_01v8_lvt w=0.9 l=0.15
X1476 t_Xrx_Xdeser_Xsh_d0_Xf2_m2 t_Xrx_Xdeser_Xsh_d0_Xf2_m1 vdd vdd sky130_fd_pr__pfet_01v8 w=1.6 l=0.15
X1477 t_Xrx_Xdeser_Xsh_d0_Xf2_m2 rst_n vdd vdd sky130_fd_pr__pfet_01v8 w=1.6 l=0.15
X1478 t_Xrx_Xdeser_Xsh_d0_Xf2_m3 t_Xrx_Xdeser_Xsh_d0_Xf2_m2 vss vss sky130_fd_pr__nfet_01v8_lvt w=0.45 l=0.15
X1479 t_Xrx_Xdeser_Xsh_d0_Xf2_m3 t_Xrx_Xdeser_Xsh_d0_Xf2_m2 vdd vdd sky130_fd_pr__pfet_01v8 w=1.15 l=0.15
X1480 t_Xrx_Xdeser_Xsh_d0_Xf2_m3 t_Xrx_Xdeser_ck0a t_Xrx_Xdeser_Xsh_d0_Xf2_m1 vss sky130_fd_pr__nfet_01v8_lvt w=0.45 l=0.15
X1481 t_Xrx_Xdeser_Xsh_d0_Xf2_m3 t_Xrx_Xdeser_ck0ba t_Xrx_Xdeser_Xsh_d0_Xf2_m1 vdd sky130_fd_pr__pfet_01v8 w=1.05 l=0.15
X1482 t_Xrx_Xdeser_Xsh_d0_Xf2_m2 t_Xrx_Xdeser_ck0a t_Xrx_Xdeser_Xsh_d0_Xf2_s1 vss sky130_fd_pr__nfet_01v8_lvt w=0.65 l=0.15
X1483 t_Xrx_Xdeser_Xsh_d0_Xf2_m2 t_Xrx_Xdeser_ck0ba t_Xrx_Xdeser_Xsh_d0_Xf2_s1 vdd sky130_fd_pr__pfet_01v8 w=1.8 l=0.15
X1484 t_Xrx_Xdeser_Xsh_d0_Xf2_qi t_Xrx_Xdeser_Xsh_d0_Xf2_s1 vss vss sky130_fd_pr__nfet_01v8_lvt w=0.65 l=0.15
X1485 t_Xrx_Xdeser_Xsh_d0_Xf2_qi t_Xrx_Xdeser_Xsh_d0_Xf2_s1 vdd vdd sky130_fd_pr__pfet_01v8 w=1.65 l=0.15
X1486 t_Xrx_Xdeser_Xsh_d0_Xf2_s2 t_Xrx_Xdeser_Xsh_d0_Xf2_qi t_Xrx_Xdeser_Xsh_d0_Xf2_Xsfb_mid vss sky130_fd_pr__nfet_01v8_lvt w=0.8 l=0.15
X1487 t_Xrx_Xdeser_Xsh_d0_Xf2_Xsfb_mid rst_n vss vss sky130_fd_pr__nfet_01v8_lvt w=0.8 l=0.15
X1488 t_Xrx_Xdeser_Xsh_d0_Xf2_s2 t_Xrx_Xdeser_Xsh_d0_Xf2_qi vdd vdd sky130_fd_pr__pfet_01v8 w=1.4 l=0.15
X1489 t_Xrx_Xdeser_Xsh_d0_Xf2_s2 rst_n vdd vdd sky130_fd_pr__pfet_01v8 w=1.4 l=0.15
X1490 t_Xrx_Xdeser_Xsh_d0_Xf2_s2 t_Xrx_Xdeser_ck0ba t_Xrx_Xdeser_Xsh_d0_Xf2_s1 vss sky130_fd_pr__nfet_01v8_lvt w=0.45 l=0.15
X1491 t_Xrx_Xdeser_Xsh_d0_Xf2_s2 t_Xrx_Xdeser_ck0a t_Xrx_Xdeser_Xsh_d0_Xf2_s1 vdd sky130_fd_pr__pfet_01v8 w=1.05 l=0.15
X1492 t_Xrx_Xdeser_d0_2 t_Xrx_Xdeser_Xsh_d0_Xf2_s1 vss vss sky130_fd_pr__nfet_01v8_lvt w=0.7 l=0.15
X1493 t_Xrx_Xdeser_d0_2 t_Xrx_Xdeser_Xsh_d0_Xf2_s1 vdd vdd sky130_fd_pr__pfet_01v8 w=1.8 l=0.15
X1494 t_Xrx_Xdeser_Xsh_d0_s2b t_Xrx_Xdeser_d0_2 vss vss sky130_fd_pr__nfet_01v8_lvt w=0.55 l=0.15
X1495 t_Xrx_Xdeser_Xsh_d0_s2b t_Xrx_Xdeser_d0_2 vdd vdd sky130_fd_pr__pfet_01v8 w=1.4 l=0.15
X1496 t_Xrx_Xdeser_d0_2 t_Xrx_Xdeser_ck0ba t_Xrx_Xdeser_Xsh_d0_Xf3_m1 vss sky130_fd_pr__nfet_01v8_lvt w=0.65 l=0.15
X1497 t_Xrx_Xdeser_d0_2 t_Xrx_Xdeser_ck0a t_Xrx_Xdeser_Xsh_d0_Xf3_m1 vdd sky130_fd_pr__pfet_01v8 w=1.8 l=0.15
X1498 t_Xrx_Xdeser_Xsh_d0_Xf3_m2 t_Xrx_Xdeser_Xsh_d0_Xf3_m1 t_Xrx_Xdeser_Xsh_d0_Xf3_Xm2_mid vss sky130_fd_pr__nfet_01v8_lvt w=0.9 l=0.15
X1499 t_Xrx_Xdeser_Xsh_d0_Xf3_Xm2_mid rst_n vss vss sky130_fd_pr__nfet_01v8_lvt w=0.9 l=0.15
X1500 t_Xrx_Xdeser_Xsh_d0_Xf3_m2 t_Xrx_Xdeser_Xsh_d0_Xf3_m1 vdd vdd sky130_fd_pr__pfet_01v8 w=1.6 l=0.15
X1501 t_Xrx_Xdeser_Xsh_d0_Xf3_m2 rst_n vdd vdd sky130_fd_pr__pfet_01v8 w=1.6 l=0.15
X1502 t_Xrx_Xdeser_Xsh_d0_Xf3_m3 t_Xrx_Xdeser_Xsh_d0_Xf3_m2 vss vss sky130_fd_pr__nfet_01v8_lvt w=0.45 l=0.15
X1503 t_Xrx_Xdeser_Xsh_d0_Xf3_m3 t_Xrx_Xdeser_Xsh_d0_Xf3_m2 vdd vdd sky130_fd_pr__pfet_01v8 w=1.15 l=0.15
X1504 t_Xrx_Xdeser_Xsh_d0_Xf3_m3 t_Xrx_Xdeser_ck0a t_Xrx_Xdeser_Xsh_d0_Xf3_m1 vss sky130_fd_pr__nfet_01v8_lvt w=0.45 l=0.15
X1505 t_Xrx_Xdeser_Xsh_d0_Xf3_m3 t_Xrx_Xdeser_ck0ba t_Xrx_Xdeser_Xsh_d0_Xf3_m1 vdd sky130_fd_pr__pfet_01v8 w=1.05 l=0.15
X1506 t_Xrx_Xdeser_Xsh_d0_Xf3_m2 t_Xrx_Xdeser_ck0a t_Xrx_Xdeser_Xsh_d0_Xf3_s1 vss sky130_fd_pr__nfet_01v8_lvt w=0.65 l=0.15
X1507 t_Xrx_Xdeser_Xsh_d0_Xf3_m2 t_Xrx_Xdeser_ck0ba t_Xrx_Xdeser_Xsh_d0_Xf3_s1 vdd sky130_fd_pr__pfet_01v8 w=1.8 l=0.15
X1508 t_Xrx_Xdeser_Xsh_d0_Xf3_qi t_Xrx_Xdeser_Xsh_d0_Xf3_s1 vss vss sky130_fd_pr__nfet_01v8_lvt w=0.65 l=0.15
X1509 t_Xrx_Xdeser_Xsh_d0_Xf3_qi t_Xrx_Xdeser_Xsh_d0_Xf3_s1 vdd vdd sky130_fd_pr__pfet_01v8 w=1.65 l=0.15
X1510 t_Xrx_Xdeser_Xsh_d0_Xf3_s2 t_Xrx_Xdeser_Xsh_d0_Xf3_qi t_Xrx_Xdeser_Xsh_d0_Xf3_Xsfb_mid vss sky130_fd_pr__nfet_01v8_lvt w=0.8 l=0.15
X1511 t_Xrx_Xdeser_Xsh_d0_Xf3_Xsfb_mid rst_n vss vss sky130_fd_pr__nfet_01v8_lvt w=0.8 l=0.15
X1512 t_Xrx_Xdeser_Xsh_d0_Xf3_s2 t_Xrx_Xdeser_Xsh_d0_Xf3_qi vdd vdd sky130_fd_pr__pfet_01v8 w=1.4 l=0.15
X1513 t_Xrx_Xdeser_Xsh_d0_Xf3_s2 rst_n vdd vdd sky130_fd_pr__pfet_01v8 w=1.4 l=0.15
X1514 t_Xrx_Xdeser_Xsh_d0_Xf3_s2 t_Xrx_Xdeser_ck0ba t_Xrx_Xdeser_Xsh_d0_Xf3_s1 vss sky130_fd_pr__nfet_01v8_lvt w=0.45 l=0.15
X1515 t_Xrx_Xdeser_Xsh_d0_Xf3_s2 t_Xrx_Xdeser_ck0a t_Xrx_Xdeser_Xsh_d0_Xf3_s1 vdd sky130_fd_pr__pfet_01v8 w=1.05 l=0.15
X1516 t_Xrx_Xdeser_d0_3 t_Xrx_Xdeser_Xsh_d0_Xf3_s1 vss vss sky130_fd_pr__nfet_01v8_lvt w=0.7 l=0.15
X1517 t_Xrx_Xdeser_d0_3 t_Xrx_Xdeser_Xsh_d0_Xf3_s1 vdd vdd sky130_fd_pr__pfet_01v8 w=1.8 l=0.15
X1518 t_Xrx_Xdeser_Xsh_d0_s3b t_Xrx_Xdeser_d0_3 vss vss sky130_fd_pr__nfet_01v8_lvt w=0.55 l=0.15
X1519 t_Xrx_Xdeser_Xsh_d0_s3b t_Xrx_Xdeser_d0_3 vdd vdd sky130_fd_pr__pfet_01v8 w=1.4 l=0.15
X1520 t_Xrx_Xdeser_d1_p t_Xrx_Xdeser_ck0ba t_Xrx_Xdeser_Xsh_d1_Xf0_m1 vss sky130_fd_pr__nfet_01v8_lvt w=0.65 l=0.15
X1521 t_Xrx_Xdeser_d1_p t_Xrx_Xdeser_ck0a t_Xrx_Xdeser_Xsh_d1_Xf0_m1 vdd sky130_fd_pr__pfet_01v8 w=1.8 l=0.15
X1522 t_Xrx_Xdeser_Xsh_d1_Xf0_m2 t_Xrx_Xdeser_Xsh_d1_Xf0_m1 t_Xrx_Xdeser_Xsh_d1_Xf0_Xm2_mid vss sky130_fd_pr__nfet_01v8_lvt w=0.9 l=0.15
X1523 t_Xrx_Xdeser_Xsh_d1_Xf0_Xm2_mid rst_n vss vss sky130_fd_pr__nfet_01v8_lvt w=0.9 l=0.15
X1524 t_Xrx_Xdeser_Xsh_d1_Xf0_m2 t_Xrx_Xdeser_Xsh_d1_Xf0_m1 vdd vdd sky130_fd_pr__pfet_01v8 w=1.6 l=0.15
X1525 t_Xrx_Xdeser_Xsh_d1_Xf0_m2 rst_n vdd vdd sky130_fd_pr__pfet_01v8 w=1.6 l=0.15
X1526 t_Xrx_Xdeser_Xsh_d1_Xf0_m3 t_Xrx_Xdeser_Xsh_d1_Xf0_m2 vss vss sky130_fd_pr__nfet_01v8_lvt w=0.45 l=0.15
X1527 t_Xrx_Xdeser_Xsh_d1_Xf0_m3 t_Xrx_Xdeser_Xsh_d1_Xf0_m2 vdd vdd sky130_fd_pr__pfet_01v8 w=1.15 l=0.15
X1528 t_Xrx_Xdeser_Xsh_d1_Xf0_m3 t_Xrx_Xdeser_ck0a t_Xrx_Xdeser_Xsh_d1_Xf0_m1 vss sky130_fd_pr__nfet_01v8_lvt w=0.45 l=0.15
X1529 t_Xrx_Xdeser_Xsh_d1_Xf0_m3 t_Xrx_Xdeser_ck0ba t_Xrx_Xdeser_Xsh_d1_Xf0_m1 vdd sky130_fd_pr__pfet_01v8 w=1.05 l=0.15
X1530 t_Xrx_Xdeser_Xsh_d1_Xf0_m2 t_Xrx_Xdeser_ck0a t_Xrx_Xdeser_Xsh_d1_Xf0_s1 vss sky130_fd_pr__nfet_01v8_lvt w=0.65 l=0.15
X1531 t_Xrx_Xdeser_Xsh_d1_Xf0_m2 t_Xrx_Xdeser_ck0ba t_Xrx_Xdeser_Xsh_d1_Xf0_s1 vdd sky130_fd_pr__pfet_01v8 w=1.8 l=0.15
X1532 t_Xrx_Xdeser_Xsh_d1_Xf0_qi t_Xrx_Xdeser_Xsh_d1_Xf0_s1 vss vss sky130_fd_pr__nfet_01v8_lvt w=0.65 l=0.15
X1533 t_Xrx_Xdeser_Xsh_d1_Xf0_qi t_Xrx_Xdeser_Xsh_d1_Xf0_s1 vdd vdd sky130_fd_pr__pfet_01v8 w=1.65 l=0.15
X1534 t_Xrx_Xdeser_Xsh_d1_Xf0_s2 t_Xrx_Xdeser_Xsh_d1_Xf0_qi t_Xrx_Xdeser_Xsh_d1_Xf0_Xsfb_mid vss sky130_fd_pr__nfet_01v8_lvt w=0.8 l=0.15
X1535 t_Xrx_Xdeser_Xsh_d1_Xf0_Xsfb_mid rst_n vss vss sky130_fd_pr__nfet_01v8_lvt w=0.8 l=0.15
X1536 t_Xrx_Xdeser_Xsh_d1_Xf0_s2 t_Xrx_Xdeser_Xsh_d1_Xf0_qi vdd vdd sky130_fd_pr__pfet_01v8 w=1.4 l=0.15
X1537 t_Xrx_Xdeser_Xsh_d1_Xf0_s2 rst_n vdd vdd sky130_fd_pr__pfet_01v8 w=1.4 l=0.15
X1538 t_Xrx_Xdeser_Xsh_d1_Xf0_s2 t_Xrx_Xdeser_ck0ba t_Xrx_Xdeser_Xsh_d1_Xf0_s1 vss sky130_fd_pr__nfet_01v8_lvt w=0.45 l=0.15
X1539 t_Xrx_Xdeser_Xsh_d1_Xf0_s2 t_Xrx_Xdeser_ck0a t_Xrx_Xdeser_Xsh_d1_Xf0_s1 vdd sky130_fd_pr__pfet_01v8 w=1.05 l=0.15
X1540 t_Xrx_Xdeser_d1_0 t_Xrx_Xdeser_Xsh_d1_Xf0_s1 vss vss sky130_fd_pr__nfet_01v8_lvt w=0.7 l=0.15
X1541 t_Xrx_Xdeser_d1_0 t_Xrx_Xdeser_Xsh_d1_Xf0_s1 vdd vdd sky130_fd_pr__pfet_01v8 w=1.8 l=0.15
X1542 t_Xrx_Xdeser_Xsh_d1_s0b t_Xrx_Xdeser_d1_0 vss vss sky130_fd_pr__nfet_01v8_lvt w=0.55 l=0.15
X1543 t_Xrx_Xdeser_Xsh_d1_s0b t_Xrx_Xdeser_d1_0 vdd vdd sky130_fd_pr__pfet_01v8 w=1.4 l=0.15
X1544 t_Xrx_Xdeser_d1_0 t_Xrx_Xdeser_ck0ba t_Xrx_Xdeser_Xsh_d1_Xf1_m1 vss sky130_fd_pr__nfet_01v8_lvt w=0.65 l=0.15
X1545 t_Xrx_Xdeser_d1_0 t_Xrx_Xdeser_ck0a t_Xrx_Xdeser_Xsh_d1_Xf1_m1 vdd sky130_fd_pr__pfet_01v8 w=1.8 l=0.15
X1546 t_Xrx_Xdeser_Xsh_d1_Xf1_m2 t_Xrx_Xdeser_Xsh_d1_Xf1_m1 t_Xrx_Xdeser_Xsh_d1_Xf1_Xm2_mid vss sky130_fd_pr__nfet_01v8_lvt w=0.9 l=0.15
X1547 t_Xrx_Xdeser_Xsh_d1_Xf1_Xm2_mid rst_n vss vss sky130_fd_pr__nfet_01v8_lvt w=0.9 l=0.15
X1548 t_Xrx_Xdeser_Xsh_d1_Xf1_m2 t_Xrx_Xdeser_Xsh_d1_Xf1_m1 vdd vdd sky130_fd_pr__pfet_01v8 w=1.6 l=0.15
X1549 t_Xrx_Xdeser_Xsh_d1_Xf1_m2 rst_n vdd vdd sky130_fd_pr__pfet_01v8 w=1.6 l=0.15
X1550 t_Xrx_Xdeser_Xsh_d1_Xf1_m3 t_Xrx_Xdeser_Xsh_d1_Xf1_m2 vss vss sky130_fd_pr__nfet_01v8_lvt w=0.45 l=0.15
X1551 t_Xrx_Xdeser_Xsh_d1_Xf1_m3 t_Xrx_Xdeser_Xsh_d1_Xf1_m2 vdd vdd sky130_fd_pr__pfet_01v8 w=1.15 l=0.15
X1552 t_Xrx_Xdeser_Xsh_d1_Xf1_m3 t_Xrx_Xdeser_ck0a t_Xrx_Xdeser_Xsh_d1_Xf1_m1 vss sky130_fd_pr__nfet_01v8_lvt w=0.45 l=0.15
X1553 t_Xrx_Xdeser_Xsh_d1_Xf1_m3 t_Xrx_Xdeser_ck0ba t_Xrx_Xdeser_Xsh_d1_Xf1_m1 vdd sky130_fd_pr__pfet_01v8 w=1.05 l=0.15
X1554 t_Xrx_Xdeser_Xsh_d1_Xf1_m2 t_Xrx_Xdeser_ck0a t_Xrx_Xdeser_Xsh_d1_Xf1_s1 vss sky130_fd_pr__nfet_01v8_lvt w=0.65 l=0.15
X1555 t_Xrx_Xdeser_Xsh_d1_Xf1_m2 t_Xrx_Xdeser_ck0ba t_Xrx_Xdeser_Xsh_d1_Xf1_s1 vdd sky130_fd_pr__pfet_01v8 w=1.8 l=0.15
X1556 t_Xrx_Xdeser_Xsh_d1_Xf1_qi t_Xrx_Xdeser_Xsh_d1_Xf1_s1 vss vss sky130_fd_pr__nfet_01v8_lvt w=0.65 l=0.15
X1557 t_Xrx_Xdeser_Xsh_d1_Xf1_qi t_Xrx_Xdeser_Xsh_d1_Xf1_s1 vdd vdd sky130_fd_pr__pfet_01v8 w=1.65 l=0.15
X1558 t_Xrx_Xdeser_Xsh_d1_Xf1_s2 t_Xrx_Xdeser_Xsh_d1_Xf1_qi t_Xrx_Xdeser_Xsh_d1_Xf1_Xsfb_mid vss sky130_fd_pr__nfet_01v8_lvt w=0.8 l=0.15
X1559 t_Xrx_Xdeser_Xsh_d1_Xf1_Xsfb_mid rst_n vss vss sky130_fd_pr__nfet_01v8_lvt w=0.8 l=0.15
X1560 t_Xrx_Xdeser_Xsh_d1_Xf1_s2 t_Xrx_Xdeser_Xsh_d1_Xf1_qi vdd vdd sky130_fd_pr__pfet_01v8 w=1.4 l=0.15
X1561 t_Xrx_Xdeser_Xsh_d1_Xf1_s2 rst_n vdd vdd sky130_fd_pr__pfet_01v8 w=1.4 l=0.15
X1562 t_Xrx_Xdeser_Xsh_d1_Xf1_s2 t_Xrx_Xdeser_ck0ba t_Xrx_Xdeser_Xsh_d1_Xf1_s1 vss sky130_fd_pr__nfet_01v8_lvt w=0.45 l=0.15
X1563 t_Xrx_Xdeser_Xsh_d1_Xf1_s2 t_Xrx_Xdeser_ck0a t_Xrx_Xdeser_Xsh_d1_Xf1_s1 vdd sky130_fd_pr__pfet_01v8 w=1.05 l=0.15
X1564 t_Xrx_Xdeser_d1_1 t_Xrx_Xdeser_Xsh_d1_Xf1_s1 vss vss sky130_fd_pr__nfet_01v8_lvt w=0.7 l=0.15
X1565 t_Xrx_Xdeser_d1_1 t_Xrx_Xdeser_Xsh_d1_Xf1_s1 vdd vdd sky130_fd_pr__pfet_01v8 w=1.8 l=0.15
X1566 t_Xrx_Xdeser_Xsh_d1_s1b t_Xrx_Xdeser_d1_1 vss vss sky130_fd_pr__nfet_01v8_lvt w=0.55 l=0.15
X1567 t_Xrx_Xdeser_Xsh_d1_s1b t_Xrx_Xdeser_d1_1 vdd vdd sky130_fd_pr__pfet_01v8 w=1.4 l=0.15
X1568 t_Xrx_Xdeser_d1_1 t_Xrx_Xdeser_ck0ba t_Xrx_Xdeser_Xsh_d1_Xf2_m1 vss sky130_fd_pr__nfet_01v8_lvt w=0.65 l=0.15
X1569 t_Xrx_Xdeser_d1_1 t_Xrx_Xdeser_ck0a t_Xrx_Xdeser_Xsh_d1_Xf2_m1 vdd sky130_fd_pr__pfet_01v8 w=1.8 l=0.15
X1570 t_Xrx_Xdeser_Xsh_d1_Xf2_m2 t_Xrx_Xdeser_Xsh_d1_Xf2_m1 t_Xrx_Xdeser_Xsh_d1_Xf2_Xm2_mid vss sky130_fd_pr__nfet_01v8_lvt w=0.9 l=0.15
X1571 t_Xrx_Xdeser_Xsh_d1_Xf2_Xm2_mid rst_n vss vss sky130_fd_pr__nfet_01v8_lvt w=0.9 l=0.15
X1572 t_Xrx_Xdeser_Xsh_d1_Xf2_m2 t_Xrx_Xdeser_Xsh_d1_Xf2_m1 vdd vdd sky130_fd_pr__pfet_01v8 w=1.6 l=0.15
X1573 t_Xrx_Xdeser_Xsh_d1_Xf2_m2 rst_n vdd vdd sky130_fd_pr__pfet_01v8 w=1.6 l=0.15
X1574 t_Xrx_Xdeser_Xsh_d1_Xf2_m3 t_Xrx_Xdeser_Xsh_d1_Xf2_m2 vss vss sky130_fd_pr__nfet_01v8_lvt w=0.45 l=0.15
X1575 t_Xrx_Xdeser_Xsh_d1_Xf2_m3 t_Xrx_Xdeser_Xsh_d1_Xf2_m2 vdd vdd sky130_fd_pr__pfet_01v8 w=1.15 l=0.15
X1576 t_Xrx_Xdeser_Xsh_d1_Xf2_m3 t_Xrx_Xdeser_ck0a t_Xrx_Xdeser_Xsh_d1_Xf2_m1 vss sky130_fd_pr__nfet_01v8_lvt w=0.45 l=0.15
X1577 t_Xrx_Xdeser_Xsh_d1_Xf2_m3 t_Xrx_Xdeser_ck0ba t_Xrx_Xdeser_Xsh_d1_Xf2_m1 vdd sky130_fd_pr__pfet_01v8 w=1.05 l=0.15
X1578 t_Xrx_Xdeser_Xsh_d1_Xf2_m2 t_Xrx_Xdeser_ck0a t_Xrx_Xdeser_Xsh_d1_Xf2_s1 vss sky130_fd_pr__nfet_01v8_lvt w=0.65 l=0.15
X1579 t_Xrx_Xdeser_Xsh_d1_Xf2_m2 t_Xrx_Xdeser_ck0ba t_Xrx_Xdeser_Xsh_d1_Xf2_s1 vdd sky130_fd_pr__pfet_01v8 w=1.8 l=0.15
X1580 t_Xrx_Xdeser_Xsh_d1_Xf2_qi t_Xrx_Xdeser_Xsh_d1_Xf2_s1 vss vss sky130_fd_pr__nfet_01v8_lvt w=0.65 l=0.15
X1581 t_Xrx_Xdeser_Xsh_d1_Xf2_qi t_Xrx_Xdeser_Xsh_d1_Xf2_s1 vdd vdd sky130_fd_pr__pfet_01v8 w=1.65 l=0.15
X1582 t_Xrx_Xdeser_Xsh_d1_Xf2_s2 t_Xrx_Xdeser_Xsh_d1_Xf2_qi t_Xrx_Xdeser_Xsh_d1_Xf2_Xsfb_mid vss sky130_fd_pr__nfet_01v8_lvt w=0.8 l=0.15
X1583 t_Xrx_Xdeser_Xsh_d1_Xf2_Xsfb_mid rst_n vss vss sky130_fd_pr__nfet_01v8_lvt w=0.8 l=0.15
X1584 t_Xrx_Xdeser_Xsh_d1_Xf2_s2 t_Xrx_Xdeser_Xsh_d1_Xf2_qi vdd vdd sky130_fd_pr__pfet_01v8 w=1.4 l=0.15
X1585 t_Xrx_Xdeser_Xsh_d1_Xf2_s2 rst_n vdd vdd sky130_fd_pr__pfet_01v8 w=1.4 l=0.15
X1586 t_Xrx_Xdeser_Xsh_d1_Xf2_s2 t_Xrx_Xdeser_ck0ba t_Xrx_Xdeser_Xsh_d1_Xf2_s1 vss sky130_fd_pr__nfet_01v8_lvt w=0.45 l=0.15
X1587 t_Xrx_Xdeser_Xsh_d1_Xf2_s2 t_Xrx_Xdeser_ck0a t_Xrx_Xdeser_Xsh_d1_Xf2_s1 vdd sky130_fd_pr__pfet_01v8 w=1.05 l=0.15
X1588 t_Xrx_Xdeser_d1_2 t_Xrx_Xdeser_Xsh_d1_Xf2_s1 vss vss sky130_fd_pr__nfet_01v8_lvt w=0.7 l=0.15
X1589 t_Xrx_Xdeser_d1_2 t_Xrx_Xdeser_Xsh_d1_Xf2_s1 vdd vdd sky130_fd_pr__pfet_01v8 w=1.8 l=0.15
X1590 t_Xrx_Xdeser_Xsh_d1_s2b t_Xrx_Xdeser_d1_2 vss vss sky130_fd_pr__nfet_01v8_lvt w=0.55 l=0.15
X1591 t_Xrx_Xdeser_Xsh_d1_s2b t_Xrx_Xdeser_d1_2 vdd vdd sky130_fd_pr__pfet_01v8 w=1.4 l=0.15
X1592 t_Xrx_Xdeser_d1_2 t_Xrx_Xdeser_ck0ba t_Xrx_Xdeser_Xsh_d1_Xf3_m1 vss sky130_fd_pr__nfet_01v8_lvt w=0.65 l=0.15
X1593 t_Xrx_Xdeser_d1_2 t_Xrx_Xdeser_ck0a t_Xrx_Xdeser_Xsh_d1_Xf3_m1 vdd sky130_fd_pr__pfet_01v8 w=1.8 l=0.15
X1594 t_Xrx_Xdeser_Xsh_d1_Xf3_m2 t_Xrx_Xdeser_Xsh_d1_Xf3_m1 t_Xrx_Xdeser_Xsh_d1_Xf3_Xm2_mid vss sky130_fd_pr__nfet_01v8_lvt w=0.9 l=0.15
X1595 t_Xrx_Xdeser_Xsh_d1_Xf3_Xm2_mid rst_n vss vss sky130_fd_pr__nfet_01v8_lvt w=0.9 l=0.15
X1596 t_Xrx_Xdeser_Xsh_d1_Xf3_m2 t_Xrx_Xdeser_Xsh_d1_Xf3_m1 vdd vdd sky130_fd_pr__pfet_01v8 w=1.6 l=0.15
X1597 t_Xrx_Xdeser_Xsh_d1_Xf3_m2 rst_n vdd vdd sky130_fd_pr__pfet_01v8 w=1.6 l=0.15
X1598 t_Xrx_Xdeser_Xsh_d1_Xf3_m3 t_Xrx_Xdeser_Xsh_d1_Xf3_m2 vss vss sky130_fd_pr__nfet_01v8_lvt w=0.45 l=0.15
X1599 t_Xrx_Xdeser_Xsh_d1_Xf3_m3 t_Xrx_Xdeser_Xsh_d1_Xf3_m2 vdd vdd sky130_fd_pr__pfet_01v8 w=1.15 l=0.15
X1600 t_Xrx_Xdeser_Xsh_d1_Xf3_m3 t_Xrx_Xdeser_ck0a t_Xrx_Xdeser_Xsh_d1_Xf3_m1 vss sky130_fd_pr__nfet_01v8_lvt w=0.45 l=0.15
X1601 t_Xrx_Xdeser_Xsh_d1_Xf3_m3 t_Xrx_Xdeser_ck0ba t_Xrx_Xdeser_Xsh_d1_Xf3_m1 vdd sky130_fd_pr__pfet_01v8 w=1.05 l=0.15
X1602 t_Xrx_Xdeser_Xsh_d1_Xf3_m2 t_Xrx_Xdeser_ck0a t_Xrx_Xdeser_Xsh_d1_Xf3_s1 vss sky130_fd_pr__nfet_01v8_lvt w=0.65 l=0.15
X1603 t_Xrx_Xdeser_Xsh_d1_Xf3_m2 t_Xrx_Xdeser_ck0ba t_Xrx_Xdeser_Xsh_d1_Xf3_s1 vdd sky130_fd_pr__pfet_01v8 w=1.8 l=0.15
X1604 t_Xrx_Xdeser_Xsh_d1_Xf3_qi t_Xrx_Xdeser_Xsh_d1_Xf3_s1 vss vss sky130_fd_pr__nfet_01v8_lvt w=0.65 l=0.15
X1605 t_Xrx_Xdeser_Xsh_d1_Xf3_qi t_Xrx_Xdeser_Xsh_d1_Xf3_s1 vdd vdd sky130_fd_pr__pfet_01v8 w=1.65 l=0.15
X1606 t_Xrx_Xdeser_Xsh_d1_Xf3_s2 t_Xrx_Xdeser_Xsh_d1_Xf3_qi t_Xrx_Xdeser_Xsh_d1_Xf3_Xsfb_mid vss sky130_fd_pr__nfet_01v8_lvt w=0.8 l=0.15
X1607 t_Xrx_Xdeser_Xsh_d1_Xf3_Xsfb_mid rst_n vss vss sky130_fd_pr__nfet_01v8_lvt w=0.8 l=0.15
X1608 t_Xrx_Xdeser_Xsh_d1_Xf3_s2 t_Xrx_Xdeser_Xsh_d1_Xf3_qi vdd vdd sky130_fd_pr__pfet_01v8 w=1.4 l=0.15
X1609 t_Xrx_Xdeser_Xsh_d1_Xf3_s2 rst_n vdd vdd sky130_fd_pr__pfet_01v8 w=1.4 l=0.15
X1610 t_Xrx_Xdeser_Xsh_d1_Xf3_s2 t_Xrx_Xdeser_ck0ba t_Xrx_Xdeser_Xsh_d1_Xf3_s1 vss sky130_fd_pr__nfet_01v8_lvt w=0.45 l=0.15
X1611 t_Xrx_Xdeser_Xsh_d1_Xf3_s2 t_Xrx_Xdeser_ck0a t_Xrx_Xdeser_Xsh_d1_Xf3_s1 vdd sky130_fd_pr__pfet_01v8 w=1.05 l=0.15
X1612 t_Xrx_Xdeser_d1_3 t_Xrx_Xdeser_Xsh_d1_Xf3_s1 vss vss sky130_fd_pr__nfet_01v8_lvt w=0.7 l=0.15
X1613 t_Xrx_Xdeser_d1_3 t_Xrx_Xdeser_Xsh_d1_Xf3_s1 vdd vdd sky130_fd_pr__pfet_01v8 w=1.8 l=0.15
X1614 t_Xrx_Xdeser_Xsh_d1_s3b t_Xrx_Xdeser_d1_3 vss vss sky130_fd_pr__nfet_01v8_lvt w=0.55 l=0.15
X1615 t_Xrx_Xdeser_Xsh_d1_s3b t_Xrx_Xdeser_d1_3 vdd vdd sky130_fd_pr__pfet_01v8 w=1.4 l=0.15
X1616 t_Xrx_Xdeser_d2_p t_Xrx_Xdeser_ck0ba t_Xrx_Xdeser_Xsh_d2_Xf0_m1 vss sky130_fd_pr__nfet_01v8_lvt w=0.65 l=0.15
X1617 t_Xrx_Xdeser_d2_p t_Xrx_Xdeser_ck0a t_Xrx_Xdeser_Xsh_d2_Xf0_m1 vdd sky130_fd_pr__pfet_01v8 w=1.8 l=0.15
X1618 t_Xrx_Xdeser_Xsh_d2_Xf0_m2 t_Xrx_Xdeser_Xsh_d2_Xf0_m1 t_Xrx_Xdeser_Xsh_d2_Xf0_Xm2_mid vss sky130_fd_pr__nfet_01v8_lvt w=0.9 l=0.15
X1619 t_Xrx_Xdeser_Xsh_d2_Xf0_Xm2_mid rst_n vss vss sky130_fd_pr__nfet_01v8_lvt w=0.9 l=0.15
X1620 t_Xrx_Xdeser_Xsh_d2_Xf0_m2 t_Xrx_Xdeser_Xsh_d2_Xf0_m1 vdd vdd sky130_fd_pr__pfet_01v8 w=1.6 l=0.15
X1621 t_Xrx_Xdeser_Xsh_d2_Xf0_m2 rst_n vdd vdd sky130_fd_pr__pfet_01v8 w=1.6 l=0.15
X1622 t_Xrx_Xdeser_Xsh_d2_Xf0_m3 t_Xrx_Xdeser_Xsh_d2_Xf0_m2 vss vss sky130_fd_pr__nfet_01v8_lvt w=0.45 l=0.15
X1623 t_Xrx_Xdeser_Xsh_d2_Xf0_m3 t_Xrx_Xdeser_Xsh_d2_Xf0_m2 vdd vdd sky130_fd_pr__pfet_01v8 w=1.15 l=0.15
X1624 t_Xrx_Xdeser_Xsh_d2_Xf0_m3 t_Xrx_Xdeser_ck0a t_Xrx_Xdeser_Xsh_d2_Xf0_m1 vss sky130_fd_pr__nfet_01v8_lvt w=0.45 l=0.15
X1625 t_Xrx_Xdeser_Xsh_d2_Xf0_m3 t_Xrx_Xdeser_ck0ba t_Xrx_Xdeser_Xsh_d2_Xf0_m1 vdd sky130_fd_pr__pfet_01v8 w=1.05 l=0.15
X1626 t_Xrx_Xdeser_Xsh_d2_Xf0_m2 t_Xrx_Xdeser_ck0a t_Xrx_Xdeser_Xsh_d2_Xf0_s1 vss sky130_fd_pr__nfet_01v8_lvt w=0.65 l=0.15
X1627 t_Xrx_Xdeser_Xsh_d2_Xf0_m2 t_Xrx_Xdeser_ck0ba t_Xrx_Xdeser_Xsh_d2_Xf0_s1 vdd sky130_fd_pr__pfet_01v8 w=1.8 l=0.15
X1628 t_Xrx_Xdeser_Xsh_d2_Xf0_qi t_Xrx_Xdeser_Xsh_d2_Xf0_s1 vss vss sky130_fd_pr__nfet_01v8_lvt w=0.65 l=0.15
X1629 t_Xrx_Xdeser_Xsh_d2_Xf0_qi t_Xrx_Xdeser_Xsh_d2_Xf0_s1 vdd vdd sky130_fd_pr__pfet_01v8 w=1.65 l=0.15
X1630 t_Xrx_Xdeser_Xsh_d2_Xf0_s2 t_Xrx_Xdeser_Xsh_d2_Xf0_qi t_Xrx_Xdeser_Xsh_d2_Xf0_Xsfb_mid vss sky130_fd_pr__nfet_01v8_lvt w=0.8 l=0.15
X1631 t_Xrx_Xdeser_Xsh_d2_Xf0_Xsfb_mid rst_n vss vss sky130_fd_pr__nfet_01v8_lvt w=0.8 l=0.15
X1632 t_Xrx_Xdeser_Xsh_d2_Xf0_s2 t_Xrx_Xdeser_Xsh_d2_Xf0_qi vdd vdd sky130_fd_pr__pfet_01v8 w=1.4 l=0.15
X1633 t_Xrx_Xdeser_Xsh_d2_Xf0_s2 rst_n vdd vdd sky130_fd_pr__pfet_01v8 w=1.4 l=0.15
X1634 t_Xrx_Xdeser_Xsh_d2_Xf0_s2 t_Xrx_Xdeser_ck0ba t_Xrx_Xdeser_Xsh_d2_Xf0_s1 vss sky130_fd_pr__nfet_01v8_lvt w=0.45 l=0.15
X1635 t_Xrx_Xdeser_Xsh_d2_Xf0_s2 t_Xrx_Xdeser_ck0a t_Xrx_Xdeser_Xsh_d2_Xf0_s1 vdd sky130_fd_pr__pfet_01v8 w=1.05 l=0.15
X1636 t_Xrx_Xdeser_d2_0 t_Xrx_Xdeser_Xsh_d2_Xf0_s1 vss vss sky130_fd_pr__nfet_01v8_lvt w=0.7 l=0.15
X1637 t_Xrx_Xdeser_d2_0 t_Xrx_Xdeser_Xsh_d2_Xf0_s1 vdd vdd sky130_fd_pr__pfet_01v8 w=1.8 l=0.15
X1638 t_Xrx_Xdeser_Xsh_d2_s0b t_Xrx_Xdeser_d2_0 vss vss sky130_fd_pr__nfet_01v8_lvt w=0.55 l=0.15
X1639 t_Xrx_Xdeser_Xsh_d2_s0b t_Xrx_Xdeser_d2_0 vdd vdd sky130_fd_pr__pfet_01v8 w=1.4 l=0.15
X1640 t_Xrx_Xdeser_d2_0 t_Xrx_Xdeser_ck0ba t_Xrx_Xdeser_Xsh_d2_Xf1_m1 vss sky130_fd_pr__nfet_01v8_lvt w=0.65 l=0.15
X1641 t_Xrx_Xdeser_d2_0 t_Xrx_Xdeser_ck0a t_Xrx_Xdeser_Xsh_d2_Xf1_m1 vdd sky130_fd_pr__pfet_01v8 w=1.8 l=0.15
X1642 t_Xrx_Xdeser_Xsh_d2_Xf1_m2 t_Xrx_Xdeser_Xsh_d2_Xf1_m1 t_Xrx_Xdeser_Xsh_d2_Xf1_Xm2_mid vss sky130_fd_pr__nfet_01v8_lvt w=0.9 l=0.15
X1643 t_Xrx_Xdeser_Xsh_d2_Xf1_Xm2_mid rst_n vss vss sky130_fd_pr__nfet_01v8_lvt w=0.9 l=0.15
X1644 t_Xrx_Xdeser_Xsh_d2_Xf1_m2 t_Xrx_Xdeser_Xsh_d2_Xf1_m1 vdd vdd sky130_fd_pr__pfet_01v8 w=1.6 l=0.15
X1645 t_Xrx_Xdeser_Xsh_d2_Xf1_m2 rst_n vdd vdd sky130_fd_pr__pfet_01v8 w=1.6 l=0.15
X1646 t_Xrx_Xdeser_Xsh_d2_Xf1_m3 t_Xrx_Xdeser_Xsh_d2_Xf1_m2 vss vss sky130_fd_pr__nfet_01v8_lvt w=0.45 l=0.15
X1647 t_Xrx_Xdeser_Xsh_d2_Xf1_m3 t_Xrx_Xdeser_Xsh_d2_Xf1_m2 vdd vdd sky130_fd_pr__pfet_01v8 w=1.15 l=0.15
X1648 t_Xrx_Xdeser_Xsh_d2_Xf1_m3 t_Xrx_Xdeser_ck0a t_Xrx_Xdeser_Xsh_d2_Xf1_m1 vss sky130_fd_pr__nfet_01v8_lvt w=0.45 l=0.15
X1649 t_Xrx_Xdeser_Xsh_d2_Xf1_m3 t_Xrx_Xdeser_ck0ba t_Xrx_Xdeser_Xsh_d2_Xf1_m1 vdd sky130_fd_pr__pfet_01v8 w=1.05 l=0.15
X1650 t_Xrx_Xdeser_Xsh_d2_Xf1_m2 t_Xrx_Xdeser_ck0a t_Xrx_Xdeser_Xsh_d2_Xf1_s1 vss sky130_fd_pr__nfet_01v8_lvt w=0.65 l=0.15
X1651 t_Xrx_Xdeser_Xsh_d2_Xf1_m2 t_Xrx_Xdeser_ck0ba t_Xrx_Xdeser_Xsh_d2_Xf1_s1 vdd sky130_fd_pr__pfet_01v8 w=1.8 l=0.15
X1652 t_Xrx_Xdeser_Xsh_d2_Xf1_qi t_Xrx_Xdeser_Xsh_d2_Xf1_s1 vss vss sky130_fd_pr__nfet_01v8_lvt w=0.65 l=0.15
X1653 t_Xrx_Xdeser_Xsh_d2_Xf1_qi t_Xrx_Xdeser_Xsh_d2_Xf1_s1 vdd vdd sky130_fd_pr__pfet_01v8 w=1.65 l=0.15
X1654 t_Xrx_Xdeser_Xsh_d2_Xf1_s2 t_Xrx_Xdeser_Xsh_d2_Xf1_qi t_Xrx_Xdeser_Xsh_d2_Xf1_Xsfb_mid vss sky130_fd_pr__nfet_01v8_lvt w=0.8 l=0.15
X1655 t_Xrx_Xdeser_Xsh_d2_Xf1_Xsfb_mid rst_n vss vss sky130_fd_pr__nfet_01v8_lvt w=0.8 l=0.15
X1656 t_Xrx_Xdeser_Xsh_d2_Xf1_s2 t_Xrx_Xdeser_Xsh_d2_Xf1_qi vdd vdd sky130_fd_pr__pfet_01v8 w=1.4 l=0.15
X1657 t_Xrx_Xdeser_Xsh_d2_Xf1_s2 rst_n vdd vdd sky130_fd_pr__pfet_01v8 w=1.4 l=0.15
X1658 t_Xrx_Xdeser_Xsh_d2_Xf1_s2 t_Xrx_Xdeser_ck0ba t_Xrx_Xdeser_Xsh_d2_Xf1_s1 vss sky130_fd_pr__nfet_01v8_lvt w=0.45 l=0.15
X1659 t_Xrx_Xdeser_Xsh_d2_Xf1_s2 t_Xrx_Xdeser_ck0a t_Xrx_Xdeser_Xsh_d2_Xf1_s1 vdd sky130_fd_pr__pfet_01v8 w=1.05 l=0.15
X1660 t_Xrx_Xdeser_d2_1 t_Xrx_Xdeser_Xsh_d2_Xf1_s1 vss vss sky130_fd_pr__nfet_01v8_lvt w=0.7 l=0.15
X1661 t_Xrx_Xdeser_d2_1 t_Xrx_Xdeser_Xsh_d2_Xf1_s1 vdd vdd sky130_fd_pr__pfet_01v8 w=1.8 l=0.15
X1662 t_Xrx_Xdeser_Xsh_d2_s1b t_Xrx_Xdeser_d2_1 vss vss sky130_fd_pr__nfet_01v8_lvt w=0.55 l=0.15
X1663 t_Xrx_Xdeser_Xsh_d2_s1b t_Xrx_Xdeser_d2_1 vdd vdd sky130_fd_pr__pfet_01v8 w=1.4 l=0.15
X1664 t_Xrx_Xdeser_d2_1 t_Xrx_Xdeser_ck0ba t_Xrx_Xdeser_Xsh_d2_Xf2_m1 vss sky130_fd_pr__nfet_01v8_lvt w=0.65 l=0.15
X1665 t_Xrx_Xdeser_d2_1 t_Xrx_Xdeser_ck0a t_Xrx_Xdeser_Xsh_d2_Xf2_m1 vdd sky130_fd_pr__pfet_01v8 w=1.8 l=0.15
X1666 t_Xrx_Xdeser_Xsh_d2_Xf2_m2 t_Xrx_Xdeser_Xsh_d2_Xf2_m1 t_Xrx_Xdeser_Xsh_d2_Xf2_Xm2_mid vss sky130_fd_pr__nfet_01v8_lvt w=0.9 l=0.15
X1667 t_Xrx_Xdeser_Xsh_d2_Xf2_Xm2_mid rst_n vss vss sky130_fd_pr__nfet_01v8_lvt w=0.9 l=0.15
X1668 t_Xrx_Xdeser_Xsh_d2_Xf2_m2 t_Xrx_Xdeser_Xsh_d2_Xf2_m1 vdd vdd sky130_fd_pr__pfet_01v8 w=1.6 l=0.15
X1669 t_Xrx_Xdeser_Xsh_d2_Xf2_m2 rst_n vdd vdd sky130_fd_pr__pfet_01v8 w=1.6 l=0.15
X1670 t_Xrx_Xdeser_Xsh_d2_Xf2_m3 t_Xrx_Xdeser_Xsh_d2_Xf2_m2 vss vss sky130_fd_pr__nfet_01v8_lvt w=0.45 l=0.15
X1671 t_Xrx_Xdeser_Xsh_d2_Xf2_m3 t_Xrx_Xdeser_Xsh_d2_Xf2_m2 vdd vdd sky130_fd_pr__pfet_01v8 w=1.15 l=0.15
X1672 t_Xrx_Xdeser_Xsh_d2_Xf2_m3 t_Xrx_Xdeser_ck0a t_Xrx_Xdeser_Xsh_d2_Xf2_m1 vss sky130_fd_pr__nfet_01v8_lvt w=0.45 l=0.15
X1673 t_Xrx_Xdeser_Xsh_d2_Xf2_m3 t_Xrx_Xdeser_ck0ba t_Xrx_Xdeser_Xsh_d2_Xf2_m1 vdd sky130_fd_pr__pfet_01v8 w=1.05 l=0.15
X1674 t_Xrx_Xdeser_Xsh_d2_Xf2_m2 t_Xrx_Xdeser_ck0a t_Xrx_Xdeser_Xsh_d2_Xf2_s1 vss sky130_fd_pr__nfet_01v8_lvt w=0.65 l=0.15
X1675 t_Xrx_Xdeser_Xsh_d2_Xf2_m2 t_Xrx_Xdeser_ck0ba t_Xrx_Xdeser_Xsh_d2_Xf2_s1 vdd sky130_fd_pr__pfet_01v8 w=1.8 l=0.15
X1676 t_Xrx_Xdeser_Xsh_d2_Xf2_qi t_Xrx_Xdeser_Xsh_d2_Xf2_s1 vss vss sky130_fd_pr__nfet_01v8_lvt w=0.65 l=0.15
X1677 t_Xrx_Xdeser_Xsh_d2_Xf2_qi t_Xrx_Xdeser_Xsh_d2_Xf2_s1 vdd vdd sky130_fd_pr__pfet_01v8 w=1.65 l=0.15
X1678 t_Xrx_Xdeser_Xsh_d2_Xf2_s2 t_Xrx_Xdeser_Xsh_d2_Xf2_qi t_Xrx_Xdeser_Xsh_d2_Xf2_Xsfb_mid vss sky130_fd_pr__nfet_01v8_lvt w=0.8 l=0.15
X1679 t_Xrx_Xdeser_Xsh_d2_Xf2_Xsfb_mid rst_n vss vss sky130_fd_pr__nfet_01v8_lvt w=0.8 l=0.15
X1680 t_Xrx_Xdeser_Xsh_d2_Xf2_s2 t_Xrx_Xdeser_Xsh_d2_Xf2_qi vdd vdd sky130_fd_pr__pfet_01v8 w=1.4 l=0.15
X1681 t_Xrx_Xdeser_Xsh_d2_Xf2_s2 rst_n vdd vdd sky130_fd_pr__pfet_01v8 w=1.4 l=0.15
X1682 t_Xrx_Xdeser_Xsh_d2_Xf2_s2 t_Xrx_Xdeser_ck0ba t_Xrx_Xdeser_Xsh_d2_Xf2_s1 vss sky130_fd_pr__nfet_01v8_lvt w=0.45 l=0.15
X1683 t_Xrx_Xdeser_Xsh_d2_Xf2_s2 t_Xrx_Xdeser_ck0a t_Xrx_Xdeser_Xsh_d2_Xf2_s1 vdd sky130_fd_pr__pfet_01v8 w=1.05 l=0.15
X1684 t_Xrx_Xdeser_d2_2 t_Xrx_Xdeser_Xsh_d2_Xf2_s1 vss vss sky130_fd_pr__nfet_01v8_lvt w=0.7 l=0.15
X1685 t_Xrx_Xdeser_d2_2 t_Xrx_Xdeser_Xsh_d2_Xf2_s1 vdd vdd sky130_fd_pr__pfet_01v8 w=1.8 l=0.15
X1686 t_Xrx_Xdeser_Xsh_d2_s2b t_Xrx_Xdeser_d2_2 vss vss sky130_fd_pr__nfet_01v8_lvt w=0.55 l=0.15
X1687 t_Xrx_Xdeser_Xsh_d2_s2b t_Xrx_Xdeser_d2_2 vdd vdd sky130_fd_pr__pfet_01v8 w=1.4 l=0.15
X1688 t_Xrx_Xdeser_d2_2 t_Xrx_Xdeser_ck0ba t_Xrx_Xdeser_Xsh_d2_Xf3_m1 vss sky130_fd_pr__nfet_01v8_lvt w=0.65 l=0.15
X1689 t_Xrx_Xdeser_d2_2 t_Xrx_Xdeser_ck0a t_Xrx_Xdeser_Xsh_d2_Xf3_m1 vdd sky130_fd_pr__pfet_01v8 w=1.8 l=0.15
X1690 t_Xrx_Xdeser_Xsh_d2_Xf3_m2 t_Xrx_Xdeser_Xsh_d2_Xf3_m1 t_Xrx_Xdeser_Xsh_d2_Xf3_Xm2_mid vss sky130_fd_pr__nfet_01v8_lvt w=0.9 l=0.15
X1691 t_Xrx_Xdeser_Xsh_d2_Xf3_Xm2_mid rst_n vss vss sky130_fd_pr__nfet_01v8_lvt w=0.9 l=0.15
X1692 t_Xrx_Xdeser_Xsh_d2_Xf3_m2 t_Xrx_Xdeser_Xsh_d2_Xf3_m1 vdd vdd sky130_fd_pr__pfet_01v8 w=1.6 l=0.15
X1693 t_Xrx_Xdeser_Xsh_d2_Xf3_m2 rst_n vdd vdd sky130_fd_pr__pfet_01v8 w=1.6 l=0.15
X1694 t_Xrx_Xdeser_Xsh_d2_Xf3_m3 t_Xrx_Xdeser_Xsh_d2_Xf3_m2 vss vss sky130_fd_pr__nfet_01v8_lvt w=0.45 l=0.15
X1695 t_Xrx_Xdeser_Xsh_d2_Xf3_m3 t_Xrx_Xdeser_Xsh_d2_Xf3_m2 vdd vdd sky130_fd_pr__pfet_01v8 w=1.15 l=0.15
X1696 t_Xrx_Xdeser_Xsh_d2_Xf3_m3 t_Xrx_Xdeser_ck0a t_Xrx_Xdeser_Xsh_d2_Xf3_m1 vss sky130_fd_pr__nfet_01v8_lvt w=0.45 l=0.15
X1697 t_Xrx_Xdeser_Xsh_d2_Xf3_m3 t_Xrx_Xdeser_ck0ba t_Xrx_Xdeser_Xsh_d2_Xf3_m1 vdd sky130_fd_pr__pfet_01v8 w=1.05 l=0.15
X1698 t_Xrx_Xdeser_Xsh_d2_Xf3_m2 t_Xrx_Xdeser_ck0a t_Xrx_Xdeser_Xsh_d2_Xf3_s1 vss sky130_fd_pr__nfet_01v8_lvt w=0.65 l=0.15
X1699 t_Xrx_Xdeser_Xsh_d2_Xf3_m2 t_Xrx_Xdeser_ck0ba t_Xrx_Xdeser_Xsh_d2_Xf3_s1 vdd sky130_fd_pr__pfet_01v8 w=1.8 l=0.15
X1700 t_Xrx_Xdeser_Xsh_d2_Xf3_qi t_Xrx_Xdeser_Xsh_d2_Xf3_s1 vss vss sky130_fd_pr__nfet_01v8_lvt w=0.65 l=0.15
X1701 t_Xrx_Xdeser_Xsh_d2_Xf3_qi t_Xrx_Xdeser_Xsh_d2_Xf3_s1 vdd vdd sky130_fd_pr__pfet_01v8 w=1.65 l=0.15
X1702 t_Xrx_Xdeser_Xsh_d2_Xf3_s2 t_Xrx_Xdeser_Xsh_d2_Xf3_qi t_Xrx_Xdeser_Xsh_d2_Xf3_Xsfb_mid vss sky130_fd_pr__nfet_01v8_lvt w=0.8 l=0.15
X1703 t_Xrx_Xdeser_Xsh_d2_Xf3_Xsfb_mid rst_n vss vss sky130_fd_pr__nfet_01v8_lvt w=0.8 l=0.15
X1704 t_Xrx_Xdeser_Xsh_d2_Xf3_s2 t_Xrx_Xdeser_Xsh_d2_Xf3_qi vdd vdd sky130_fd_pr__pfet_01v8 w=1.4 l=0.15
X1705 t_Xrx_Xdeser_Xsh_d2_Xf3_s2 rst_n vdd vdd sky130_fd_pr__pfet_01v8 w=1.4 l=0.15
X1706 t_Xrx_Xdeser_Xsh_d2_Xf3_s2 t_Xrx_Xdeser_ck0ba t_Xrx_Xdeser_Xsh_d2_Xf3_s1 vss sky130_fd_pr__nfet_01v8_lvt w=0.45 l=0.15
X1707 t_Xrx_Xdeser_Xsh_d2_Xf3_s2 t_Xrx_Xdeser_ck0a t_Xrx_Xdeser_Xsh_d2_Xf3_s1 vdd sky130_fd_pr__pfet_01v8 w=1.05 l=0.15
X1708 t_Xrx_Xdeser_d2_3 t_Xrx_Xdeser_Xsh_d2_Xf3_s1 vss vss sky130_fd_pr__nfet_01v8_lvt w=0.7 l=0.15
X1709 t_Xrx_Xdeser_d2_3 t_Xrx_Xdeser_Xsh_d2_Xf3_s1 vdd vdd sky130_fd_pr__pfet_01v8 w=1.8 l=0.15
X1710 t_Xrx_Xdeser_Xsh_d2_s3b t_Xrx_Xdeser_d2_3 vss vss sky130_fd_pr__nfet_01v8_lvt w=0.55 l=0.15
X1711 t_Xrx_Xdeser_Xsh_d2_s3b t_Xrx_Xdeser_d2_3 vdd vdd sky130_fd_pr__pfet_01v8 w=1.4 l=0.15
X1712 t_Xrx_Xdeser_d3_a t_Xrx_Xdeser_ck0ba t_Xrx_Xdeser_Xsh_d3_Xf0_m1 vss sky130_fd_pr__nfet_01v8_lvt w=0.65 l=0.15
X1713 t_Xrx_Xdeser_d3_a t_Xrx_Xdeser_ck0a t_Xrx_Xdeser_Xsh_d3_Xf0_m1 vdd sky130_fd_pr__pfet_01v8 w=1.8 l=0.15
X1714 t_Xrx_Xdeser_Xsh_d3_Xf0_m2 t_Xrx_Xdeser_Xsh_d3_Xf0_m1 t_Xrx_Xdeser_Xsh_d3_Xf0_Xm2_mid vss sky130_fd_pr__nfet_01v8_lvt w=0.9 l=0.15
X1715 t_Xrx_Xdeser_Xsh_d3_Xf0_Xm2_mid rst_n vss vss sky130_fd_pr__nfet_01v8_lvt w=0.9 l=0.15
X1716 t_Xrx_Xdeser_Xsh_d3_Xf0_m2 t_Xrx_Xdeser_Xsh_d3_Xf0_m1 vdd vdd sky130_fd_pr__pfet_01v8 w=1.6 l=0.15
X1717 t_Xrx_Xdeser_Xsh_d3_Xf0_m2 rst_n vdd vdd sky130_fd_pr__pfet_01v8 w=1.6 l=0.15
X1718 t_Xrx_Xdeser_Xsh_d3_Xf0_m3 t_Xrx_Xdeser_Xsh_d3_Xf0_m2 vss vss sky130_fd_pr__nfet_01v8_lvt w=0.45 l=0.15
X1719 t_Xrx_Xdeser_Xsh_d3_Xf0_m3 t_Xrx_Xdeser_Xsh_d3_Xf0_m2 vdd vdd sky130_fd_pr__pfet_01v8 w=1.15 l=0.15
X1720 t_Xrx_Xdeser_Xsh_d3_Xf0_m3 t_Xrx_Xdeser_ck0a t_Xrx_Xdeser_Xsh_d3_Xf0_m1 vss sky130_fd_pr__nfet_01v8_lvt w=0.45 l=0.15
X1721 t_Xrx_Xdeser_Xsh_d3_Xf0_m3 t_Xrx_Xdeser_ck0ba t_Xrx_Xdeser_Xsh_d3_Xf0_m1 vdd sky130_fd_pr__pfet_01v8 w=1.05 l=0.15
X1722 t_Xrx_Xdeser_Xsh_d3_Xf0_m2 t_Xrx_Xdeser_ck0a t_Xrx_Xdeser_Xsh_d3_Xf0_s1 vss sky130_fd_pr__nfet_01v8_lvt w=0.65 l=0.15
X1723 t_Xrx_Xdeser_Xsh_d3_Xf0_m2 t_Xrx_Xdeser_ck0ba t_Xrx_Xdeser_Xsh_d3_Xf0_s1 vdd sky130_fd_pr__pfet_01v8 w=1.8 l=0.15
X1724 t_Xrx_Xdeser_Xsh_d3_Xf0_qi t_Xrx_Xdeser_Xsh_d3_Xf0_s1 vss vss sky130_fd_pr__nfet_01v8_lvt w=0.65 l=0.15
X1725 t_Xrx_Xdeser_Xsh_d3_Xf0_qi t_Xrx_Xdeser_Xsh_d3_Xf0_s1 vdd vdd sky130_fd_pr__pfet_01v8 w=1.65 l=0.15
X1726 t_Xrx_Xdeser_Xsh_d3_Xf0_s2 t_Xrx_Xdeser_Xsh_d3_Xf0_qi t_Xrx_Xdeser_Xsh_d3_Xf0_Xsfb_mid vss sky130_fd_pr__nfet_01v8_lvt w=0.8 l=0.15
X1727 t_Xrx_Xdeser_Xsh_d3_Xf0_Xsfb_mid rst_n vss vss sky130_fd_pr__nfet_01v8_lvt w=0.8 l=0.15
X1728 t_Xrx_Xdeser_Xsh_d3_Xf0_s2 t_Xrx_Xdeser_Xsh_d3_Xf0_qi vdd vdd sky130_fd_pr__pfet_01v8 w=1.4 l=0.15
X1729 t_Xrx_Xdeser_Xsh_d3_Xf0_s2 rst_n vdd vdd sky130_fd_pr__pfet_01v8 w=1.4 l=0.15
X1730 t_Xrx_Xdeser_Xsh_d3_Xf0_s2 t_Xrx_Xdeser_ck0ba t_Xrx_Xdeser_Xsh_d3_Xf0_s1 vss sky130_fd_pr__nfet_01v8_lvt w=0.45 l=0.15
X1731 t_Xrx_Xdeser_Xsh_d3_Xf0_s2 t_Xrx_Xdeser_ck0a t_Xrx_Xdeser_Xsh_d3_Xf0_s1 vdd sky130_fd_pr__pfet_01v8 w=1.05 l=0.15
X1732 t_Xrx_Xdeser_d3_0 t_Xrx_Xdeser_Xsh_d3_Xf0_s1 vss vss sky130_fd_pr__nfet_01v8_lvt w=0.7 l=0.15
X1733 t_Xrx_Xdeser_d3_0 t_Xrx_Xdeser_Xsh_d3_Xf0_s1 vdd vdd sky130_fd_pr__pfet_01v8 w=1.8 l=0.15
X1734 t_Xrx_Xdeser_Xsh_d3_s0b t_Xrx_Xdeser_d3_0 vss vss sky130_fd_pr__nfet_01v8_lvt w=0.55 l=0.15
X1735 t_Xrx_Xdeser_Xsh_d3_s0b t_Xrx_Xdeser_d3_0 vdd vdd sky130_fd_pr__pfet_01v8 w=1.4 l=0.15
X1736 t_Xrx_Xdeser_d3_0 t_Xrx_Xdeser_ck0ba t_Xrx_Xdeser_Xsh_d3_Xf1_m1 vss sky130_fd_pr__nfet_01v8_lvt w=0.65 l=0.15
X1737 t_Xrx_Xdeser_d3_0 t_Xrx_Xdeser_ck0a t_Xrx_Xdeser_Xsh_d3_Xf1_m1 vdd sky130_fd_pr__pfet_01v8 w=1.8 l=0.15
X1738 t_Xrx_Xdeser_Xsh_d3_Xf1_m2 t_Xrx_Xdeser_Xsh_d3_Xf1_m1 t_Xrx_Xdeser_Xsh_d3_Xf1_Xm2_mid vss sky130_fd_pr__nfet_01v8_lvt w=0.9 l=0.15
X1739 t_Xrx_Xdeser_Xsh_d3_Xf1_Xm2_mid rst_n vss vss sky130_fd_pr__nfet_01v8_lvt w=0.9 l=0.15
X1740 t_Xrx_Xdeser_Xsh_d3_Xf1_m2 t_Xrx_Xdeser_Xsh_d3_Xf1_m1 vdd vdd sky130_fd_pr__pfet_01v8 w=1.6 l=0.15
X1741 t_Xrx_Xdeser_Xsh_d3_Xf1_m2 rst_n vdd vdd sky130_fd_pr__pfet_01v8 w=1.6 l=0.15
X1742 t_Xrx_Xdeser_Xsh_d3_Xf1_m3 t_Xrx_Xdeser_Xsh_d3_Xf1_m2 vss vss sky130_fd_pr__nfet_01v8_lvt w=0.45 l=0.15
X1743 t_Xrx_Xdeser_Xsh_d3_Xf1_m3 t_Xrx_Xdeser_Xsh_d3_Xf1_m2 vdd vdd sky130_fd_pr__pfet_01v8 w=1.15 l=0.15
X1744 t_Xrx_Xdeser_Xsh_d3_Xf1_m3 t_Xrx_Xdeser_ck0a t_Xrx_Xdeser_Xsh_d3_Xf1_m1 vss sky130_fd_pr__nfet_01v8_lvt w=0.45 l=0.15
X1745 t_Xrx_Xdeser_Xsh_d3_Xf1_m3 t_Xrx_Xdeser_ck0ba t_Xrx_Xdeser_Xsh_d3_Xf1_m1 vdd sky130_fd_pr__pfet_01v8 w=1.05 l=0.15
X1746 t_Xrx_Xdeser_Xsh_d3_Xf1_m2 t_Xrx_Xdeser_ck0a t_Xrx_Xdeser_Xsh_d3_Xf1_s1 vss sky130_fd_pr__nfet_01v8_lvt w=0.65 l=0.15
X1747 t_Xrx_Xdeser_Xsh_d3_Xf1_m2 t_Xrx_Xdeser_ck0ba t_Xrx_Xdeser_Xsh_d3_Xf1_s1 vdd sky130_fd_pr__pfet_01v8 w=1.8 l=0.15
X1748 t_Xrx_Xdeser_Xsh_d3_Xf1_qi t_Xrx_Xdeser_Xsh_d3_Xf1_s1 vss vss sky130_fd_pr__nfet_01v8_lvt w=0.65 l=0.15
X1749 t_Xrx_Xdeser_Xsh_d3_Xf1_qi t_Xrx_Xdeser_Xsh_d3_Xf1_s1 vdd vdd sky130_fd_pr__pfet_01v8 w=1.65 l=0.15
X1750 t_Xrx_Xdeser_Xsh_d3_Xf1_s2 t_Xrx_Xdeser_Xsh_d3_Xf1_qi t_Xrx_Xdeser_Xsh_d3_Xf1_Xsfb_mid vss sky130_fd_pr__nfet_01v8_lvt w=0.8 l=0.15
X1751 t_Xrx_Xdeser_Xsh_d3_Xf1_Xsfb_mid rst_n vss vss sky130_fd_pr__nfet_01v8_lvt w=0.8 l=0.15
X1752 t_Xrx_Xdeser_Xsh_d3_Xf1_s2 t_Xrx_Xdeser_Xsh_d3_Xf1_qi vdd vdd sky130_fd_pr__pfet_01v8 w=1.4 l=0.15
X1753 t_Xrx_Xdeser_Xsh_d3_Xf1_s2 rst_n vdd vdd sky130_fd_pr__pfet_01v8 w=1.4 l=0.15
X1754 t_Xrx_Xdeser_Xsh_d3_Xf1_s2 t_Xrx_Xdeser_ck0ba t_Xrx_Xdeser_Xsh_d3_Xf1_s1 vss sky130_fd_pr__nfet_01v8_lvt w=0.45 l=0.15
X1755 t_Xrx_Xdeser_Xsh_d3_Xf1_s2 t_Xrx_Xdeser_ck0a t_Xrx_Xdeser_Xsh_d3_Xf1_s1 vdd sky130_fd_pr__pfet_01v8 w=1.05 l=0.15
X1756 t_Xrx_Xdeser_d3_1 t_Xrx_Xdeser_Xsh_d3_Xf1_s1 vss vss sky130_fd_pr__nfet_01v8_lvt w=0.7 l=0.15
X1757 t_Xrx_Xdeser_d3_1 t_Xrx_Xdeser_Xsh_d3_Xf1_s1 vdd vdd sky130_fd_pr__pfet_01v8 w=1.8 l=0.15
X1758 t_Xrx_Xdeser_Xsh_d3_s1b t_Xrx_Xdeser_d3_1 vss vss sky130_fd_pr__nfet_01v8_lvt w=0.55 l=0.15
X1759 t_Xrx_Xdeser_Xsh_d3_s1b t_Xrx_Xdeser_d3_1 vdd vdd sky130_fd_pr__pfet_01v8 w=1.4 l=0.15
X1760 t_Xrx_Xdeser_d3_1 t_Xrx_Xdeser_ck0ba t_Xrx_Xdeser_Xsh_d3_Xf2_m1 vss sky130_fd_pr__nfet_01v8_lvt w=0.65 l=0.15
X1761 t_Xrx_Xdeser_d3_1 t_Xrx_Xdeser_ck0a t_Xrx_Xdeser_Xsh_d3_Xf2_m1 vdd sky130_fd_pr__pfet_01v8 w=1.8 l=0.15
X1762 t_Xrx_Xdeser_Xsh_d3_Xf2_m2 t_Xrx_Xdeser_Xsh_d3_Xf2_m1 t_Xrx_Xdeser_Xsh_d3_Xf2_Xm2_mid vss sky130_fd_pr__nfet_01v8_lvt w=0.9 l=0.15
X1763 t_Xrx_Xdeser_Xsh_d3_Xf2_Xm2_mid rst_n vss vss sky130_fd_pr__nfet_01v8_lvt w=0.9 l=0.15
X1764 t_Xrx_Xdeser_Xsh_d3_Xf2_m2 t_Xrx_Xdeser_Xsh_d3_Xf2_m1 vdd vdd sky130_fd_pr__pfet_01v8 w=1.6 l=0.15
X1765 t_Xrx_Xdeser_Xsh_d3_Xf2_m2 rst_n vdd vdd sky130_fd_pr__pfet_01v8 w=1.6 l=0.15
X1766 t_Xrx_Xdeser_Xsh_d3_Xf2_m3 t_Xrx_Xdeser_Xsh_d3_Xf2_m2 vss vss sky130_fd_pr__nfet_01v8_lvt w=0.45 l=0.15
X1767 t_Xrx_Xdeser_Xsh_d3_Xf2_m3 t_Xrx_Xdeser_Xsh_d3_Xf2_m2 vdd vdd sky130_fd_pr__pfet_01v8 w=1.15 l=0.15
X1768 t_Xrx_Xdeser_Xsh_d3_Xf2_m3 t_Xrx_Xdeser_ck0a t_Xrx_Xdeser_Xsh_d3_Xf2_m1 vss sky130_fd_pr__nfet_01v8_lvt w=0.45 l=0.15
X1769 t_Xrx_Xdeser_Xsh_d3_Xf2_m3 t_Xrx_Xdeser_ck0ba t_Xrx_Xdeser_Xsh_d3_Xf2_m1 vdd sky130_fd_pr__pfet_01v8 w=1.05 l=0.15
X1770 t_Xrx_Xdeser_Xsh_d3_Xf2_m2 t_Xrx_Xdeser_ck0a t_Xrx_Xdeser_Xsh_d3_Xf2_s1 vss sky130_fd_pr__nfet_01v8_lvt w=0.65 l=0.15
X1771 t_Xrx_Xdeser_Xsh_d3_Xf2_m2 t_Xrx_Xdeser_ck0ba t_Xrx_Xdeser_Xsh_d3_Xf2_s1 vdd sky130_fd_pr__pfet_01v8 w=1.8 l=0.15
X1772 t_Xrx_Xdeser_Xsh_d3_Xf2_qi t_Xrx_Xdeser_Xsh_d3_Xf2_s1 vss vss sky130_fd_pr__nfet_01v8_lvt w=0.65 l=0.15
X1773 t_Xrx_Xdeser_Xsh_d3_Xf2_qi t_Xrx_Xdeser_Xsh_d3_Xf2_s1 vdd vdd sky130_fd_pr__pfet_01v8 w=1.65 l=0.15
X1774 t_Xrx_Xdeser_Xsh_d3_Xf2_s2 t_Xrx_Xdeser_Xsh_d3_Xf2_qi t_Xrx_Xdeser_Xsh_d3_Xf2_Xsfb_mid vss sky130_fd_pr__nfet_01v8_lvt w=0.8 l=0.15
X1775 t_Xrx_Xdeser_Xsh_d3_Xf2_Xsfb_mid rst_n vss vss sky130_fd_pr__nfet_01v8_lvt w=0.8 l=0.15
X1776 t_Xrx_Xdeser_Xsh_d3_Xf2_s2 t_Xrx_Xdeser_Xsh_d3_Xf2_qi vdd vdd sky130_fd_pr__pfet_01v8 w=1.4 l=0.15
X1777 t_Xrx_Xdeser_Xsh_d3_Xf2_s2 rst_n vdd vdd sky130_fd_pr__pfet_01v8 w=1.4 l=0.15
X1778 t_Xrx_Xdeser_Xsh_d3_Xf2_s2 t_Xrx_Xdeser_ck0ba t_Xrx_Xdeser_Xsh_d3_Xf2_s1 vss sky130_fd_pr__nfet_01v8_lvt w=0.45 l=0.15
X1779 t_Xrx_Xdeser_Xsh_d3_Xf2_s2 t_Xrx_Xdeser_ck0a t_Xrx_Xdeser_Xsh_d3_Xf2_s1 vdd sky130_fd_pr__pfet_01v8 w=1.05 l=0.15
X1780 t_Xrx_Xdeser_d3_2 t_Xrx_Xdeser_Xsh_d3_Xf2_s1 vss vss sky130_fd_pr__nfet_01v8_lvt w=0.7 l=0.15
X1781 t_Xrx_Xdeser_d3_2 t_Xrx_Xdeser_Xsh_d3_Xf2_s1 vdd vdd sky130_fd_pr__pfet_01v8 w=1.8 l=0.15
X1782 t_Xrx_Xdeser_Xsh_d3_s2b t_Xrx_Xdeser_d3_2 vss vss sky130_fd_pr__nfet_01v8_lvt w=0.55 l=0.15
X1783 t_Xrx_Xdeser_Xsh_d3_s2b t_Xrx_Xdeser_d3_2 vdd vdd sky130_fd_pr__pfet_01v8 w=1.4 l=0.15
X1784 t_Xrx_Xdeser_d3_2 t_Xrx_Xdeser_ck0ba t_Xrx_Xdeser_Xsh_d3_Xf3_m1 vss sky130_fd_pr__nfet_01v8_lvt w=0.65 l=0.15
X1785 t_Xrx_Xdeser_d3_2 t_Xrx_Xdeser_ck0a t_Xrx_Xdeser_Xsh_d3_Xf3_m1 vdd sky130_fd_pr__pfet_01v8 w=1.8 l=0.15
X1786 t_Xrx_Xdeser_Xsh_d3_Xf3_m2 t_Xrx_Xdeser_Xsh_d3_Xf3_m1 t_Xrx_Xdeser_Xsh_d3_Xf3_Xm2_mid vss sky130_fd_pr__nfet_01v8_lvt w=0.9 l=0.15
X1787 t_Xrx_Xdeser_Xsh_d3_Xf3_Xm2_mid rst_n vss vss sky130_fd_pr__nfet_01v8_lvt w=0.9 l=0.15
X1788 t_Xrx_Xdeser_Xsh_d3_Xf3_m2 t_Xrx_Xdeser_Xsh_d3_Xf3_m1 vdd vdd sky130_fd_pr__pfet_01v8 w=1.6 l=0.15
X1789 t_Xrx_Xdeser_Xsh_d3_Xf3_m2 rst_n vdd vdd sky130_fd_pr__pfet_01v8 w=1.6 l=0.15
X1790 t_Xrx_Xdeser_Xsh_d3_Xf3_m3 t_Xrx_Xdeser_Xsh_d3_Xf3_m2 vss vss sky130_fd_pr__nfet_01v8_lvt w=0.45 l=0.15
X1791 t_Xrx_Xdeser_Xsh_d3_Xf3_m3 t_Xrx_Xdeser_Xsh_d3_Xf3_m2 vdd vdd sky130_fd_pr__pfet_01v8 w=1.15 l=0.15
X1792 t_Xrx_Xdeser_Xsh_d3_Xf3_m3 t_Xrx_Xdeser_ck0a t_Xrx_Xdeser_Xsh_d3_Xf3_m1 vss sky130_fd_pr__nfet_01v8_lvt w=0.45 l=0.15
X1793 t_Xrx_Xdeser_Xsh_d3_Xf3_m3 t_Xrx_Xdeser_ck0ba t_Xrx_Xdeser_Xsh_d3_Xf3_m1 vdd sky130_fd_pr__pfet_01v8 w=1.05 l=0.15
X1794 t_Xrx_Xdeser_Xsh_d3_Xf3_m2 t_Xrx_Xdeser_ck0a t_Xrx_Xdeser_Xsh_d3_Xf3_s1 vss sky130_fd_pr__nfet_01v8_lvt w=0.65 l=0.15
X1795 t_Xrx_Xdeser_Xsh_d3_Xf3_m2 t_Xrx_Xdeser_ck0ba t_Xrx_Xdeser_Xsh_d3_Xf3_s1 vdd sky130_fd_pr__pfet_01v8 w=1.8 l=0.15
X1796 t_Xrx_Xdeser_Xsh_d3_Xf3_qi t_Xrx_Xdeser_Xsh_d3_Xf3_s1 vss vss sky130_fd_pr__nfet_01v8_lvt w=0.65 l=0.15
X1797 t_Xrx_Xdeser_Xsh_d3_Xf3_qi t_Xrx_Xdeser_Xsh_d3_Xf3_s1 vdd vdd sky130_fd_pr__pfet_01v8 w=1.65 l=0.15
X1798 t_Xrx_Xdeser_Xsh_d3_Xf3_s2 t_Xrx_Xdeser_Xsh_d3_Xf3_qi t_Xrx_Xdeser_Xsh_d3_Xf3_Xsfb_mid vss sky130_fd_pr__nfet_01v8_lvt w=0.8 l=0.15
X1799 t_Xrx_Xdeser_Xsh_d3_Xf3_Xsfb_mid rst_n vss vss sky130_fd_pr__nfet_01v8_lvt w=0.8 l=0.15
X1800 t_Xrx_Xdeser_Xsh_d3_Xf3_s2 t_Xrx_Xdeser_Xsh_d3_Xf3_qi vdd vdd sky130_fd_pr__pfet_01v8 w=1.4 l=0.15
X1801 t_Xrx_Xdeser_Xsh_d3_Xf3_s2 rst_n vdd vdd sky130_fd_pr__pfet_01v8 w=1.4 l=0.15
X1802 t_Xrx_Xdeser_Xsh_d3_Xf3_s2 t_Xrx_Xdeser_ck0ba t_Xrx_Xdeser_Xsh_d3_Xf3_s1 vss sky130_fd_pr__nfet_01v8_lvt w=0.45 l=0.15
X1803 t_Xrx_Xdeser_Xsh_d3_Xf3_s2 t_Xrx_Xdeser_ck0a t_Xrx_Xdeser_Xsh_d3_Xf3_s1 vdd sky130_fd_pr__pfet_01v8 w=1.05 l=0.15
X1804 t_Xrx_Xdeser_d3_3 t_Xrx_Xdeser_Xsh_d3_Xf3_s1 vss vss sky130_fd_pr__nfet_01v8_lvt w=0.7 l=0.15
X1805 t_Xrx_Xdeser_d3_3 t_Xrx_Xdeser_Xsh_d3_Xf3_s1 vdd vdd sky130_fd_pr__pfet_01v8 w=1.8 l=0.15
X1806 t_Xrx_Xdeser_Xsh_d3_s3b t_Xrx_Xdeser_d3_3 vss vss sky130_fd_pr__nfet_01v8_lvt w=0.55 l=0.15
X1807 t_Xrx_Xdeser_Xsh_d3_s3b t_Xrx_Xdeser_d3_3 vdd vdd sky130_fd_pr__pfet_01v8 w=1.4 l=0.15
X1808 t_Xrx_Xdeser_e0_p t_Xrx_Xdeser_ck0bb t_Xrx_Xdeser_Xsh_e0_Xf0_m1 vss sky130_fd_pr__nfet_01v8_lvt w=0.65 l=0.15
X1809 t_Xrx_Xdeser_e0_p t_Xrx_Xdeser_ck0b t_Xrx_Xdeser_Xsh_e0_Xf0_m1 vdd sky130_fd_pr__pfet_01v8 w=1.8 l=0.15
X1810 t_Xrx_Xdeser_Xsh_e0_Xf0_m2 t_Xrx_Xdeser_Xsh_e0_Xf0_m1 t_Xrx_Xdeser_Xsh_e0_Xf0_Xm2_mid vss sky130_fd_pr__nfet_01v8_lvt w=0.9 l=0.15
X1811 t_Xrx_Xdeser_Xsh_e0_Xf0_Xm2_mid rst_n vss vss sky130_fd_pr__nfet_01v8_lvt w=0.9 l=0.15
X1812 t_Xrx_Xdeser_Xsh_e0_Xf0_m2 t_Xrx_Xdeser_Xsh_e0_Xf0_m1 vdd vdd sky130_fd_pr__pfet_01v8 w=1.6 l=0.15
X1813 t_Xrx_Xdeser_Xsh_e0_Xf0_m2 rst_n vdd vdd sky130_fd_pr__pfet_01v8 w=1.6 l=0.15
X1814 t_Xrx_Xdeser_Xsh_e0_Xf0_m3 t_Xrx_Xdeser_Xsh_e0_Xf0_m2 vss vss sky130_fd_pr__nfet_01v8_lvt w=0.45 l=0.15
X1815 t_Xrx_Xdeser_Xsh_e0_Xf0_m3 t_Xrx_Xdeser_Xsh_e0_Xf0_m2 vdd vdd sky130_fd_pr__pfet_01v8 w=1.15 l=0.15
X1816 t_Xrx_Xdeser_Xsh_e0_Xf0_m3 t_Xrx_Xdeser_ck0b t_Xrx_Xdeser_Xsh_e0_Xf0_m1 vss sky130_fd_pr__nfet_01v8_lvt w=0.45 l=0.15
X1817 t_Xrx_Xdeser_Xsh_e0_Xf0_m3 t_Xrx_Xdeser_ck0bb t_Xrx_Xdeser_Xsh_e0_Xf0_m1 vdd sky130_fd_pr__pfet_01v8 w=1.05 l=0.15
X1818 t_Xrx_Xdeser_Xsh_e0_Xf0_m2 t_Xrx_Xdeser_ck0b t_Xrx_Xdeser_Xsh_e0_Xf0_s1 vss sky130_fd_pr__nfet_01v8_lvt w=0.65 l=0.15
X1819 t_Xrx_Xdeser_Xsh_e0_Xf0_m2 t_Xrx_Xdeser_ck0bb t_Xrx_Xdeser_Xsh_e0_Xf0_s1 vdd sky130_fd_pr__pfet_01v8 w=1.8 l=0.15
X1820 t_Xrx_Xdeser_Xsh_e0_Xf0_qi t_Xrx_Xdeser_Xsh_e0_Xf0_s1 vss vss sky130_fd_pr__nfet_01v8_lvt w=0.65 l=0.15
X1821 t_Xrx_Xdeser_Xsh_e0_Xf0_qi t_Xrx_Xdeser_Xsh_e0_Xf0_s1 vdd vdd sky130_fd_pr__pfet_01v8 w=1.65 l=0.15
X1822 t_Xrx_Xdeser_Xsh_e0_Xf0_s2 t_Xrx_Xdeser_Xsh_e0_Xf0_qi t_Xrx_Xdeser_Xsh_e0_Xf0_Xsfb_mid vss sky130_fd_pr__nfet_01v8_lvt w=0.8 l=0.15
X1823 t_Xrx_Xdeser_Xsh_e0_Xf0_Xsfb_mid rst_n vss vss sky130_fd_pr__nfet_01v8_lvt w=0.8 l=0.15
X1824 t_Xrx_Xdeser_Xsh_e0_Xf0_s2 t_Xrx_Xdeser_Xsh_e0_Xf0_qi vdd vdd sky130_fd_pr__pfet_01v8 w=1.4 l=0.15
X1825 t_Xrx_Xdeser_Xsh_e0_Xf0_s2 rst_n vdd vdd sky130_fd_pr__pfet_01v8 w=1.4 l=0.15
X1826 t_Xrx_Xdeser_Xsh_e0_Xf0_s2 t_Xrx_Xdeser_ck0bb t_Xrx_Xdeser_Xsh_e0_Xf0_s1 vss sky130_fd_pr__nfet_01v8_lvt w=0.45 l=0.15
X1827 t_Xrx_Xdeser_Xsh_e0_Xf0_s2 t_Xrx_Xdeser_ck0b t_Xrx_Xdeser_Xsh_e0_Xf0_s1 vdd sky130_fd_pr__pfet_01v8 w=1.05 l=0.15
X1828 t_Xrx_Xdeser_e0_0 t_Xrx_Xdeser_Xsh_e0_Xf0_s1 vss vss sky130_fd_pr__nfet_01v8_lvt w=0.7 l=0.15
X1829 t_Xrx_Xdeser_e0_0 t_Xrx_Xdeser_Xsh_e0_Xf0_s1 vdd vdd sky130_fd_pr__pfet_01v8 w=1.8 l=0.15
X1830 t_Xrx_Xdeser_Xsh_e0_s0b t_Xrx_Xdeser_e0_0 vss vss sky130_fd_pr__nfet_01v8_lvt w=0.55 l=0.15
X1831 t_Xrx_Xdeser_Xsh_e0_s0b t_Xrx_Xdeser_e0_0 vdd vdd sky130_fd_pr__pfet_01v8 w=1.4 l=0.15
X1832 t_Xrx_Xdeser_e0_0 t_Xrx_Xdeser_ck0bb t_Xrx_Xdeser_Xsh_e0_Xf1_m1 vss sky130_fd_pr__nfet_01v8_lvt w=0.65 l=0.15
X1833 t_Xrx_Xdeser_e0_0 t_Xrx_Xdeser_ck0b t_Xrx_Xdeser_Xsh_e0_Xf1_m1 vdd sky130_fd_pr__pfet_01v8 w=1.8 l=0.15
X1834 t_Xrx_Xdeser_Xsh_e0_Xf1_m2 t_Xrx_Xdeser_Xsh_e0_Xf1_m1 t_Xrx_Xdeser_Xsh_e0_Xf1_Xm2_mid vss sky130_fd_pr__nfet_01v8_lvt w=0.9 l=0.15
X1835 t_Xrx_Xdeser_Xsh_e0_Xf1_Xm2_mid rst_n vss vss sky130_fd_pr__nfet_01v8_lvt w=0.9 l=0.15
X1836 t_Xrx_Xdeser_Xsh_e0_Xf1_m2 t_Xrx_Xdeser_Xsh_e0_Xf1_m1 vdd vdd sky130_fd_pr__pfet_01v8 w=1.6 l=0.15
X1837 t_Xrx_Xdeser_Xsh_e0_Xf1_m2 rst_n vdd vdd sky130_fd_pr__pfet_01v8 w=1.6 l=0.15
X1838 t_Xrx_Xdeser_Xsh_e0_Xf1_m3 t_Xrx_Xdeser_Xsh_e0_Xf1_m2 vss vss sky130_fd_pr__nfet_01v8_lvt w=0.45 l=0.15
X1839 t_Xrx_Xdeser_Xsh_e0_Xf1_m3 t_Xrx_Xdeser_Xsh_e0_Xf1_m2 vdd vdd sky130_fd_pr__pfet_01v8 w=1.15 l=0.15
X1840 t_Xrx_Xdeser_Xsh_e0_Xf1_m3 t_Xrx_Xdeser_ck0b t_Xrx_Xdeser_Xsh_e0_Xf1_m1 vss sky130_fd_pr__nfet_01v8_lvt w=0.45 l=0.15
X1841 t_Xrx_Xdeser_Xsh_e0_Xf1_m3 t_Xrx_Xdeser_ck0bb t_Xrx_Xdeser_Xsh_e0_Xf1_m1 vdd sky130_fd_pr__pfet_01v8 w=1.05 l=0.15
X1842 t_Xrx_Xdeser_Xsh_e0_Xf1_m2 t_Xrx_Xdeser_ck0b t_Xrx_Xdeser_Xsh_e0_Xf1_s1 vss sky130_fd_pr__nfet_01v8_lvt w=0.65 l=0.15
X1843 t_Xrx_Xdeser_Xsh_e0_Xf1_m2 t_Xrx_Xdeser_ck0bb t_Xrx_Xdeser_Xsh_e0_Xf1_s1 vdd sky130_fd_pr__pfet_01v8 w=1.8 l=0.15
X1844 t_Xrx_Xdeser_Xsh_e0_Xf1_qi t_Xrx_Xdeser_Xsh_e0_Xf1_s1 vss vss sky130_fd_pr__nfet_01v8_lvt w=0.65 l=0.15
X1845 t_Xrx_Xdeser_Xsh_e0_Xf1_qi t_Xrx_Xdeser_Xsh_e0_Xf1_s1 vdd vdd sky130_fd_pr__pfet_01v8 w=1.65 l=0.15
X1846 t_Xrx_Xdeser_Xsh_e0_Xf1_s2 t_Xrx_Xdeser_Xsh_e0_Xf1_qi t_Xrx_Xdeser_Xsh_e0_Xf1_Xsfb_mid vss sky130_fd_pr__nfet_01v8_lvt w=0.8 l=0.15
X1847 t_Xrx_Xdeser_Xsh_e0_Xf1_Xsfb_mid rst_n vss vss sky130_fd_pr__nfet_01v8_lvt w=0.8 l=0.15
X1848 t_Xrx_Xdeser_Xsh_e0_Xf1_s2 t_Xrx_Xdeser_Xsh_e0_Xf1_qi vdd vdd sky130_fd_pr__pfet_01v8 w=1.4 l=0.15
X1849 t_Xrx_Xdeser_Xsh_e0_Xf1_s2 rst_n vdd vdd sky130_fd_pr__pfet_01v8 w=1.4 l=0.15
X1850 t_Xrx_Xdeser_Xsh_e0_Xf1_s2 t_Xrx_Xdeser_ck0bb t_Xrx_Xdeser_Xsh_e0_Xf1_s1 vss sky130_fd_pr__nfet_01v8_lvt w=0.45 l=0.15
X1851 t_Xrx_Xdeser_Xsh_e0_Xf1_s2 t_Xrx_Xdeser_ck0b t_Xrx_Xdeser_Xsh_e0_Xf1_s1 vdd sky130_fd_pr__pfet_01v8 w=1.05 l=0.15
X1852 t_Xrx_Xdeser_e0_1 t_Xrx_Xdeser_Xsh_e0_Xf1_s1 vss vss sky130_fd_pr__nfet_01v8_lvt w=0.7 l=0.15
X1853 t_Xrx_Xdeser_e0_1 t_Xrx_Xdeser_Xsh_e0_Xf1_s1 vdd vdd sky130_fd_pr__pfet_01v8 w=1.8 l=0.15
X1854 t_Xrx_Xdeser_Xsh_e0_s1b t_Xrx_Xdeser_e0_1 vss vss sky130_fd_pr__nfet_01v8_lvt w=0.55 l=0.15
X1855 t_Xrx_Xdeser_Xsh_e0_s1b t_Xrx_Xdeser_e0_1 vdd vdd sky130_fd_pr__pfet_01v8 w=1.4 l=0.15
X1856 t_Xrx_Xdeser_e0_1 t_Xrx_Xdeser_ck0bb t_Xrx_Xdeser_Xsh_e0_Xf2_m1 vss sky130_fd_pr__nfet_01v8_lvt w=0.65 l=0.15
X1857 t_Xrx_Xdeser_e0_1 t_Xrx_Xdeser_ck0b t_Xrx_Xdeser_Xsh_e0_Xf2_m1 vdd sky130_fd_pr__pfet_01v8 w=1.8 l=0.15
X1858 t_Xrx_Xdeser_Xsh_e0_Xf2_m2 t_Xrx_Xdeser_Xsh_e0_Xf2_m1 t_Xrx_Xdeser_Xsh_e0_Xf2_Xm2_mid vss sky130_fd_pr__nfet_01v8_lvt w=0.9 l=0.15
X1859 t_Xrx_Xdeser_Xsh_e0_Xf2_Xm2_mid rst_n vss vss sky130_fd_pr__nfet_01v8_lvt w=0.9 l=0.15
X1860 t_Xrx_Xdeser_Xsh_e0_Xf2_m2 t_Xrx_Xdeser_Xsh_e0_Xf2_m1 vdd vdd sky130_fd_pr__pfet_01v8 w=1.6 l=0.15
X1861 t_Xrx_Xdeser_Xsh_e0_Xf2_m2 rst_n vdd vdd sky130_fd_pr__pfet_01v8 w=1.6 l=0.15
X1862 t_Xrx_Xdeser_Xsh_e0_Xf2_m3 t_Xrx_Xdeser_Xsh_e0_Xf2_m2 vss vss sky130_fd_pr__nfet_01v8_lvt w=0.45 l=0.15
X1863 t_Xrx_Xdeser_Xsh_e0_Xf2_m3 t_Xrx_Xdeser_Xsh_e0_Xf2_m2 vdd vdd sky130_fd_pr__pfet_01v8 w=1.15 l=0.15
X1864 t_Xrx_Xdeser_Xsh_e0_Xf2_m3 t_Xrx_Xdeser_ck0b t_Xrx_Xdeser_Xsh_e0_Xf2_m1 vss sky130_fd_pr__nfet_01v8_lvt w=0.45 l=0.15
X1865 t_Xrx_Xdeser_Xsh_e0_Xf2_m3 t_Xrx_Xdeser_ck0bb t_Xrx_Xdeser_Xsh_e0_Xf2_m1 vdd sky130_fd_pr__pfet_01v8 w=1.05 l=0.15
X1866 t_Xrx_Xdeser_Xsh_e0_Xf2_m2 t_Xrx_Xdeser_ck0b t_Xrx_Xdeser_Xsh_e0_Xf2_s1 vss sky130_fd_pr__nfet_01v8_lvt w=0.65 l=0.15
X1867 t_Xrx_Xdeser_Xsh_e0_Xf2_m2 t_Xrx_Xdeser_ck0bb t_Xrx_Xdeser_Xsh_e0_Xf2_s1 vdd sky130_fd_pr__pfet_01v8 w=1.8 l=0.15
X1868 t_Xrx_Xdeser_Xsh_e0_Xf2_qi t_Xrx_Xdeser_Xsh_e0_Xf2_s1 vss vss sky130_fd_pr__nfet_01v8_lvt w=0.65 l=0.15
X1869 t_Xrx_Xdeser_Xsh_e0_Xf2_qi t_Xrx_Xdeser_Xsh_e0_Xf2_s1 vdd vdd sky130_fd_pr__pfet_01v8 w=1.65 l=0.15
X1870 t_Xrx_Xdeser_Xsh_e0_Xf2_s2 t_Xrx_Xdeser_Xsh_e0_Xf2_qi t_Xrx_Xdeser_Xsh_e0_Xf2_Xsfb_mid vss sky130_fd_pr__nfet_01v8_lvt w=0.8 l=0.15
X1871 t_Xrx_Xdeser_Xsh_e0_Xf2_Xsfb_mid rst_n vss vss sky130_fd_pr__nfet_01v8_lvt w=0.8 l=0.15
X1872 t_Xrx_Xdeser_Xsh_e0_Xf2_s2 t_Xrx_Xdeser_Xsh_e0_Xf2_qi vdd vdd sky130_fd_pr__pfet_01v8 w=1.4 l=0.15
X1873 t_Xrx_Xdeser_Xsh_e0_Xf2_s2 rst_n vdd vdd sky130_fd_pr__pfet_01v8 w=1.4 l=0.15
X1874 t_Xrx_Xdeser_Xsh_e0_Xf2_s2 t_Xrx_Xdeser_ck0bb t_Xrx_Xdeser_Xsh_e0_Xf2_s1 vss sky130_fd_pr__nfet_01v8_lvt w=0.45 l=0.15
X1875 t_Xrx_Xdeser_Xsh_e0_Xf2_s2 t_Xrx_Xdeser_ck0b t_Xrx_Xdeser_Xsh_e0_Xf2_s1 vdd sky130_fd_pr__pfet_01v8 w=1.05 l=0.15
X1876 t_Xrx_Xdeser_e0_2 t_Xrx_Xdeser_Xsh_e0_Xf2_s1 vss vss sky130_fd_pr__nfet_01v8_lvt w=0.7 l=0.15
X1877 t_Xrx_Xdeser_e0_2 t_Xrx_Xdeser_Xsh_e0_Xf2_s1 vdd vdd sky130_fd_pr__pfet_01v8 w=1.8 l=0.15
X1878 t_Xrx_Xdeser_Xsh_e0_s2b t_Xrx_Xdeser_e0_2 vss vss sky130_fd_pr__nfet_01v8_lvt w=0.55 l=0.15
X1879 t_Xrx_Xdeser_Xsh_e0_s2b t_Xrx_Xdeser_e0_2 vdd vdd sky130_fd_pr__pfet_01v8 w=1.4 l=0.15
X1880 t_Xrx_Xdeser_e0_2 t_Xrx_Xdeser_ck0bb t_Xrx_Xdeser_Xsh_e0_Xf3_m1 vss sky130_fd_pr__nfet_01v8_lvt w=0.65 l=0.15
X1881 t_Xrx_Xdeser_e0_2 t_Xrx_Xdeser_ck0b t_Xrx_Xdeser_Xsh_e0_Xf3_m1 vdd sky130_fd_pr__pfet_01v8 w=1.8 l=0.15
X1882 t_Xrx_Xdeser_Xsh_e0_Xf3_m2 t_Xrx_Xdeser_Xsh_e0_Xf3_m1 t_Xrx_Xdeser_Xsh_e0_Xf3_Xm2_mid vss sky130_fd_pr__nfet_01v8_lvt w=0.9 l=0.15
X1883 t_Xrx_Xdeser_Xsh_e0_Xf3_Xm2_mid rst_n vss vss sky130_fd_pr__nfet_01v8_lvt w=0.9 l=0.15
X1884 t_Xrx_Xdeser_Xsh_e0_Xf3_m2 t_Xrx_Xdeser_Xsh_e0_Xf3_m1 vdd vdd sky130_fd_pr__pfet_01v8 w=1.6 l=0.15
X1885 t_Xrx_Xdeser_Xsh_e0_Xf3_m2 rst_n vdd vdd sky130_fd_pr__pfet_01v8 w=1.6 l=0.15
X1886 t_Xrx_Xdeser_Xsh_e0_Xf3_m3 t_Xrx_Xdeser_Xsh_e0_Xf3_m2 vss vss sky130_fd_pr__nfet_01v8_lvt w=0.45 l=0.15
X1887 t_Xrx_Xdeser_Xsh_e0_Xf3_m3 t_Xrx_Xdeser_Xsh_e0_Xf3_m2 vdd vdd sky130_fd_pr__pfet_01v8 w=1.15 l=0.15
X1888 t_Xrx_Xdeser_Xsh_e0_Xf3_m3 t_Xrx_Xdeser_ck0b t_Xrx_Xdeser_Xsh_e0_Xf3_m1 vss sky130_fd_pr__nfet_01v8_lvt w=0.45 l=0.15
X1889 t_Xrx_Xdeser_Xsh_e0_Xf3_m3 t_Xrx_Xdeser_ck0bb t_Xrx_Xdeser_Xsh_e0_Xf3_m1 vdd sky130_fd_pr__pfet_01v8 w=1.05 l=0.15
X1890 t_Xrx_Xdeser_Xsh_e0_Xf3_m2 t_Xrx_Xdeser_ck0b t_Xrx_Xdeser_Xsh_e0_Xf3_s1 vss sky130_fd_pr__nfet_01v8_lvt w=0.65 l=0.15
X1891 t_Xrx_Xdeser_Xsh_e0_Xf3_m2 t_Xrx_Xdeser_ck0bb t_Xrx_Xdeser_Xsh_e0_Xf3_s1 vdd sky130_fd_pr__pfet_01v8 w=1.8 l=0.15
X1892 t_Xrx_Xdeser_Xsh_e0_Xf3_qi t_Xrx_Xdeser_Xsh_e0_Xf3_s1 vss vss sky130_fd_pr__nfet_01v8_lvt w=0.65 l=0.15
X1893 t_Xrx_Xdeser_Xsh_e0_Xf3_qi t_Xrx_Xdeser_Xsh_e0_Xf3_s1 vdd vdd sky130_fd_pr__pfet_01v8 w=1.65 l=0.15
X1894 t_Xrx_Xdeser_Xsh_e0_Xf3_s2 t_Xrx_Xdeser_Xsh_e0_Xf3_qi t_Xrx_Xdeser_Xsh_e0_Xf3_Xsfb_mid vss sky130_fd_pr__nfet_01v8_lvt w=0.8 l=0.15
X1895 t_Xrx_Xdeser_Xsh_e0_Xf3_Xsfb_mid rst_n vss vss sky130_fd_pr__nfet_01v8_lvt w=0.8 l=0.15
X1896 t_Xrx_Xdeser_Xsh_e0_Xf3_s2 t_Xrx_Xdeser_Xsh_e0_Xf3_qi vdd vdd sky130_fd_pr__pfet_01v8 w=1.4 l=0.15
X1897 t_Xrx_Xdeser_Xsh_e0_Xf3_s2 rst_n vdd vdd sky130_fd_pr__pfet_01v8 w=1.4 l=0.15
X1898 t_Xrx_Xdeser_Xsh_e0_Xf3_s2 t_Xrx_Xdeser_ck0bb t_Xrx_Xdeser_Xsh_e0_Xf3_s1 vss sky130_fd_pr__nfet_01v8_lvt w=0.45 l=0.15
X1899 t_Xrx_Xdeser_Xsh_e0_Xf3_s2 t_Xrx_Xdeser_ck0b t_Xrx_Xdeser_Xsh_e0_Xf3_s1 vdd sky130_fd_pr__pfet_01v8 w=1.05 l=0.15
X1900 t_Xrx_Xdeser_e0_3 t_Xrx_Xdeser_Xsh_e0_Xf3_s1 vss vss sky130_fd_pr__nfet_01v8_lvt w=0.7 l=0.15
X1901 t_Xrx_Xdeser_e0_3 t_Xrx_Xdeser_Xsh_e0_Xf3_s1 vdd vdd sky130_fd_pr__pfet_01v8 w=1.8 l=0.15
X1902 t_Xrx_Xdeser_Xsh_e0_s3b t_Xrx_Xdeser_e0_3 vss vss sky130_fd_pr__nfet_01v8_lvt w=0.55 l=0.15
X1903 t_Xrx_Xdeser_Xsh_e0_s3b t_Xrx_Xdeser_e0_3 vdd vdd sky130_fd_pr__pfet_01v8 w=1.4 l=0.15
X1904 t_Xrx_Xdeser_e1_p t_Xrx_Xdeser_ck0bb t_Xrx_Xdeser_Xsh_e1_Xf0_m1 vss sky130_fd_pr__nfet_01v8_lvt w=0.65 l=0.15
X1905 t_Xrx_Xdeser_e1_p t_Xrx_Xdeser_ck0b t_Xrx_Xdeser_Xsh_e1_Xf0_m1 vdd sky130_fd_pr__pfet_01v8 w=1.8 l=0.15
X1906 t_Xrx_Xdeser_Xsh_e1_Xf0_m2 t_Xrx_Xdeser_Xsh_e1_Xf0_m1 t_Xrx_Xdeser_Xsh_e1_Xf0_Xm2_mid vss sky130_fd_pr__nfet_01v8_lvt w=0.9 l=0.15
X1907 t_Xrx_Xdeser_Xsh_e1_Xf0_Xm2_mid rst_n vss vss sky130_fd_pr__nfet_01v8_lvt w=0.9 l=0.15
X1908 t_Xrx_Xdeser_Xsh_e1_Xf0_m2 t_Xrx_Xdeser_Xsh_e1_Xf0_m1 vdd vdd sky130_fd_pr__pfet_01v8 w=1.6 l=0.15
X1909 t_Xrx_Xdeser_Xsh_e1_Xf0_m2 rst_n vdd vdd sky130_fd_pr__pfet_01v8 w=1.6 l=0.15
X1910 t_Xrx_Xdeser_Xsh_e1_Xf0_m3 t_Xrx_Xdeser_Xsh_e1_Xf0_m2 vss vss sky130_fd_pr__nfet_01v8_lvt w=0.45 l=0.15
X1911 t_Xrx_Xdeser_Xsh_e1_Xf0_m3 t_Xrx_Xdeser_Xsh_e1_Xf0_m2 vdd vdd sky130_fd_pr__pfet_01v8 w=1.15 l=0.15
X1912 t_Xrx_Xdeser_Xsh_e1_Xf0_m3 t_Xrx_Xdeser_ck0b t_Xrx_Xdeser_Xsh_e1_Xf0_m1 vss sky130_fd_pr__nfet_01v8_lvt w=0.45 l=0.15
X1913 t_Xrx_Xdeser_Xsh_e1_Xf0_m3 t_Xrx_Xdeser_ck0bb t_Xrx_Xdeser_Xsh_e1_Xf0_m1 vdd sky130_fd_pr__pfet_01v8 w=1.05 l=0.15
X1914 t_Xrx_Xdeser_Xsh_e1_Xf0_m2 t_Xrx_Xdeser_ck0b t_Xrx_Xdeser_Xsh_e1_Xf0_s1 vss sky130_fd_pr__nfet_01v8_lvt w=0.65 l=0.15
X1915 t_Xrx_Xdeser_Xsh_e1_Xf0_m2 t_Xrx_Xdeser_ck0bb t_Xrx_Xdeser_Xsh_e1_Xf0_s1 vdd sky130_fd_pr__pfet_01v8 w=1.8 l=0.15
X1916 t_Xrx_Xdeser_Xsh_e1_Xf0_qi t_Xrx_Xdeser_Xsh_e1_Xf0_s1 vss vss sky130_fd_pr__nfet_01v8_lvt w=0.65 l=0.15
X1917 t_Xrx_Xdeser_Xsh_e1_Xf0_qi t_Xrx_Xdeser_Xsh_e1_Xf0_s1 vdd vdd sky130_fd_pr__pfet_01v8 w=1.65 l=0.15
X1918 t_Xrx_Xdeser_Xsh_e1_Xf0_s2 t_Xrx_Xdeser_Xsh_e1_Xf0_qi t_Xrx_Xdeser_Xsh_e1_Xf0_Xsfb_mid vss sky130_fd_pr__nfet_01v8_lvt w=0.8 l=0.15
X1919 t_Xrx_Xdeser_Xsh_e1_Xf0_Xsfb_mid rst_n vss vss sky130_fd_pr__nfet_01v8_lvt w=0.8 l=0.15
X1920 t_Xrx_Xdeser_Xsh_e1_Xf0_s2 t_Xrx_Xdeser_Xsh_e1_Xf0_qi vdd vdd sky130_fd_pr__pfet_01v8 w=1.4 l=0.15
X1921 t_Xrx_Xdeser_Xsh_e1_Xf0_s2 rst_n vdd vdd sky130_fd_pr__pfet_01v8 w=1.4 l=0.15
X1922 t_Xrx_Xdeser_Xsh_e1_Xf0_s2 t_Xrx_Xdeser_ck0bb t_Xrx_Xdeser_Xsh_e1_Xf0_s1 vss sky130_fd_pr__nfet_01v8_lvt w=0.45 l=0.15
X1923 t_Xrx_Xdeser_Xsh_e1_Xf0_s2 t_Xrx_Xdeser_ck0b t_Xrx_Xdeser_Xsh_e1_Xf0_s1 vdd sky130_fd_pr__pfet_01v8 w=1.05 l=0.15
X1924 t_Xrx_Xdeser_e1_0 t_Xrx_Xdeser_Xsh_e1_Xf0_s1 vss vss sky130_fd_pr__nfet_01v8_lvt w=0.7 l=0.15
X1925 t_Xrx_Xdeser_e1_0 t_Xrx_Xdeser_Xsh_e1_Xf0_s1 vdd vdd sky130_fd_pr__pfet_01v8 w=1.8 l=0.15
X1926 t_Xrx_Xdeser_Xsh_e1_s0b t_Xrx_Xdeser_e1_0 vss vss sky130_fd_pr__nfet_01v8_lvt w=0.55 l=0.15
X1927 t_Xrx_Xdeser_Xsh_e1_s0b t_Xrx_Xdeser_e1_0 vdd vdd sky130_fd_pr__pfet_01v8 w=1.4 l=0.15
X1928 t_Xrx_Xdeser_e1_0 t_Xrx_Xdeser_ck0bb t_Xrx_Xdeser_Xsh_e1_Xf1_m1 vss sky130_fd_pr__nfet_01v8_lvt w=0.65 l=0.15
X1929 t_Xrx_Xdeser_e1_0 t_Xrx_Xdeser_ck0b t_Xrx_Xdeser_Xsh_e1_Xf1_m1 vdd sky130_fd_pr__pfet_01v8 w=1.8 l=0.15
X1930 t_Xrx_Xdeser_Xsh_e1_Xf1_m2 t_Xrx_Xdeser_Xsh_e1_Xf1_m1 t_Xrx_Xdeser_Xsh_e1_Xf1_Xm2_mid vss sky130_fd_pr__nfet_01v8_lvt w=0.9 l=0.15
X1931 t_Xrx_Xdeser_Xsh_e1_Xf1_Xm2_mid rst_n vss vss sky130_fd_pr__nfet_01v8_lvt w=0.9 l=0.15
X1932 t_Xrx_Xdeser_Xsh_e1_Xf1_m2 t_Xrx_Xdeser_Xsh_e1_Xf1_m1 vdd vdd sky130_fd_pr__pfet_01v8 w=1.6 l=0.15
X1933 t_Xrx_Xdeser_Xsh_e1_Xf1_m2 rst_n vdd vdd sky130_fd_pr__pfet_01v8 w=1.6 l=0.15
X1934 t_Xrx_Xdeser_Xsh_e1_Xf1_m3 t_Xrx_Xdeser_Xsh_e1_Xf1_m2 vss vss sky130_fd_pr__nfet_01v8_lvt w=0.45 l=0.15
X1935 t_Xrx_Xdeser_Xsh_e1_Xf1_m3 t_Xrx_Xdeser_Xsh_e1_Xf1_m2 vdd vdd sky130_fd_pr__pfet_01v8 w=1.15 l=0.15
X1936 t_Xrx_Xdeser_Xsh_e1_Xf1_m3 t_Xrx_Xdeser_ck0b t_Xrx_Xdeser_Xsh_e1_Xf1_m1 vss sky130_fd_pr__nfet_01v8_lvt w=0.45 l=0.15
X1937 t_Xrx_Xdeser_Xsh_e1_Xf1_m3 t_Xrx_Xdeser_ck0bb t_Xrx_Xdeser_Xsh_e1_Xf1_m1 vdd sky130_fd_pr__pfet_01v8 w=1.05 l=0.15
X1938 t_Xrx_Xdeser_Xsh_e1_Xf1_m2 t_Xrx_Xdeser_ck0b t_Xrx_Xdeser_Xsh_e1_Xf1_s1 vss sky130_fd_pr__nfet_01v8_lvt w=0.65 l=0.15
X1939 t_Xrx_Xdeser_Xsh_e1_Xf1_m2 t_Xrx_Xdeser_ck0bb t_Xrx_Xdeser_Xsh_e1_Xf1_s1 vdd sky130_fd_pr__pfet_01v8 w=1.8 l=0.15
X1940 t_Xrx_Xdeser_Xsh_e1_Xf1_qi t_Xrx_Xdeser_Xsh_e1_Xf1_s1 vss vss sky130_fd_pr__nfet_01v8_lvt w=0.65 l=0.15
X1941 t_Xrx_Xdeser_Xsh_e1_Xf1_qi t_Xrx_Xdeser_Xsh_e1_Xf1_s1 vdd vdd sky130_fd_pr__pfet_01v8 w=1.65 l=0.15
X1942 t_Xrx_Xdeser_Xsh_e1_Xf1_s2 t_Xrx_Xdeser_Xsh_e1_Xf1_qi t_Xrx_Xdeser_Xsh_e1_Xf1_Xsfb_mid vss sky130_fd_pr__nfet_01v8_lvt w=0.8 l=0.15
X1943 t_Xrx_Xdeser_Xsh_e1_Xf1_Xsfb_mid rst_n vss vss sky130_fd_pr__nfet_01v8_lvt w=0.8 l=0.15
X1944 t_Xrx_Xdeser_Xsh_e1_Xf1_s2 t_Xrx_Xdeser_Xsh_e1_Xf1_qi vdd vdd sky130_fd_pr__pfet_01v8 w=1.4 l=0.15
X1945 t_Xrx_Xdeser_Xsh_e1_Xf1_s2 rst_n vdd vdd sky130_fd_pr__pfet_01v8 w=1.4 l=0.15
X1946 t_Xrx_Xdeser_Xsh_e1_Xf1_s2 t_Xrx_Xdeser_ck0bb t_Xrx_Xdeser_Xsh_e1_Xf1_s1 vss sky130_fd_pr__nfet_01v8_lvt w=0.45 l=0.15
X1947 t_Xrx_Xdeser_Xsh_e1_Xf1_s2 t_Xrx_Xdeser_ck0b t_Xrx_Xdeser_Xsh_e1_Xf1_s1 vdd sky130_fd_pr__pfet_01v8 w=1.05 l=0.15
X1948 t_Xrx_Xdeser_e1_1 t_Xrx_Xdeser_Xsh_e1_Xf1_s1 vss vss sky130_fd_pr__nfet_01v8_lvt w=0.7 l=0.15
X1949 t_Xrx_Xdeser_e1_1 t_Xrx_Xdeser_Xsh_e1_Xf1_s1 vdd vdd sky130_fd_pr__pfet_01v8 w=1.8 l=0.15
X1950 t_Xrx_Xdeser_Xsh_e1_s1b t_Xrx_Xdeser_e1_1 vss vss sky130_fd_pr__nfet_01v8_lvt w=0.55 l=0.15
X1951 t_Xrx_Xdeser_Xsh_e1_s1b t_Xrx_Xdeser_e1_1 vdd vdd sky130_fd_pr__pfet_01v8 w=1.4 l=0.15
X1952 t_Xrx_Xdeser_e1_1 t_Xrx_Xdeser_ck0bb t_Xrx_Xdeser_Xsh_e1_Xf2_m1 vss sky130_fd_pr__nfet_01v8_lvt w=0.65 l=0.15
X1953 t_Xrx_Xdeser_e1_1 t_Xrx_Xdeser_ck0b t_Xrx_Xdeser_Xsh_e1_Xf2_m1 vdd sky130_fd_pr__pfet_01v8 w=1.8 l=0.15
X1954 t_Xrx_Xdeser_Xsh_e1_Xf2_m2 t_Xrx_Xdeser_Xsh_e1_Xf2_m1 t_Xrx_Xdeser_Xsh_e1_Xf2_Xm2_mid vss sky130_fd_pr__nfet_01v8_lvt w=0.9 l=0.15
X1955 t_Xrx_Xdeser_Xsh_e1_Xf2_Xm2_mid rst_n vss vss sky130_fd_pr__nfet_01v8_lvt w=0.9 l=0.15
X1956 t_Xrx_Xdeser_Xsh_e1_Xf2_m2 t_Xrx_Xdeser_Xsh_e1_Xf2_m1 vdd vdd sky130_fd_pr__pfet_01v8 w=1.6 l=0.15
X1957 t_Xrx_Xdeser_Xsh_e1_Xf2_m2 rst_n vdd vdd sky130_fd_pr__pfet_01v8 w=1.6 l=0.15
X1958 t_Xrx_Xdeser_Xsh_e1_Xf2_m3 t_Xrx_Xdeser_Xsh_e1_Xf2_m2 vss vss sky130_fd_pr__nfet_01v8_lvt w=0.45 l=0.15
X1959 t_Xrx_Xdeser_Xsh_e1_Xf2_m3 t_Xrx_Xdeser_Xsh_e1_Xf2_m2 vdd vdd sky130_fd_pr__pfet_01v8 w=1.15 l=0.15
X1960 t_Xrx_Xdeser_Xsh_e1_Xf2_m3 t_Xrx_Xdeser_ck0b t_Xrx_Xdeser_Xsh_e1_Xf2_m1 vss sky130_fd_pr__nfet_01v8_lvt w=0.45 l=0.15
X1961 t_Xrx_Xdeser_Xsh_e1_Xf2_m3 t_Xrx_Xdeser_ck0bb t_Xrx_Xdeser_Xsh_e1_Xf2_m1 vdd sky130_fd_pr__pfet_01v8 w=1.05 l=0.15
X1962 t_Xrx_Xdeser_Xsh_e1_Xf2_m2 t_Xrx_Xdeser_ck0b t_Xrx_Xdeser_Xsh_e1_Xf2_s1 vss sky130_fd_pr__nfet_01v8_lvt w=0.65 l=0.15
X1963 t_Xrx_Xdeser_Xsh_e1_Xf2_m2 t_Xrx_Xdeser_ck0bb t_Xrx_Xdeser_Xsh_e1_Xf2_s1 vdd sky130_fd_pr__pfet_01v8 w=1.8 l=0.15
X1964 t_Xrx_Xdeser_Xsh_e1_Xf2_qi t_Xrx_Xdeser_Xsh_e1_Xf2_s1 vss vss sky130_fd_pr__nfet_01v8_lvt w=0.65 l=0.15
X1965 t_Xrx_Xdeser_Xsh_e1_Xf2_qi t_Xrx_Xdeser_Xsh_e1_Xf2_s1 vdd vdd sky130_fd_pr__pfet_01v8 w=1.65 l=0.15
X1966 t_Xrx_Xdeser_Xsh_e1_Xf2_s2 t_Xrx_Xdeser_Xsh_e1_Xf2_qi t_Xrx_Xdeser_Xsh_e1_Xf2_Xsfb_mid vss sky130_fd_pr__nfet_01v8_lvt w=0.8 l=0.15
X1967 t_Xrx_Xdeser_Xsh_e1_Xf2_Xsfb_mid rst_n vss vss sky130_fd_pr__nfet_01v8_lvt w=0.8 l=0.15
X1968 t_Xrx_Xdeser_Xsh_e1_Xf2_s2 t_Xrx_Xdeser_Xsh_e1_Xf2_qi vdd vdd sky130_fd_pr__pfet_01v8 w=1.4 l=0.15
X1969 t_Xrx_Xdeser_Xsh_e1_Xf2_s2 rst_n vdd vdd sky130_fd_pr__pfet_01v8 w=1.4 l=0.15
X1970 t_Xrx_Xdeser_Xsh_e1_Xf2_s2 t_Xrx_Xdeser_ck0bb t_Xrx_Xdeser_Xsh_e1_Xf2_s1 vss sky130_fd_pr__nfet_01v8_lvt w=0.45 l=0.15
X1971 t_Xrx_Xdeser_Xsh_e1_Xf2_s2 t_Xrx_Xdeser_ck0b t_Xrx_Xdeser_Xsh_e1_Xf2_s1 vdd sky130_fd_pr__pfet_01v8 w=1.05 l=0.15
X1972 t_Xrx_Xdeser_e1_2 t_Xrx_Xdeser_Xsh_e1_Xf2_s1 vss vss sky130_fd_pr__nfet_01v8_lvt w=0.7 l=0.15
X1973 t_Xrx_Xdeser_e1_2 t_Xrx_Xdeser_Xsh_e1_Xf2_s1 vdd vdd sky130_fd_pr__pfet_01v8 w=1.8 l=0.15
X1974 t_Xrx_Xdeser_Xsh_e1_s2b t_Xrx_Xdeser_e1_2 vss vss sky130_fd_pr__nfet_01v8_lvt w=0.55 l=0.15
X1975 t_Xrx_Xdeser_Xsh_e1_s2b t_Xrx_Xdeser_e1_2 vdd vdd sky130_fd_pr__pfet_01v8 w=1.4 l=0.15
X1976 t_Xrx_Xdeser_e1_2 t_Xrx_Xdeser_ck0bb t_Xrx_Xdeser_Xsh_e1_Xf3_m1 vss sky130_fd_pr__nfet_01v8_lvt w=0.65 l=0.15
X1977 t_Xrx_Xdeser_e1_2 t_Xrx_Xdeser_ck0b t_Xrx_Xdeser_Xsh_e1_Xf3_m1 vdd sky130_fd_pr__pfet_01v8 w=1.8 l=0.15
X1978 t_Xrx_Xdeser_Xsh_e1_Xf3_m2 t_Xrx_Xdeser_Xsh_e1_Xf3_m1 t_Xrx_Xdeser_Xsh_e1_Xf3_Xm2_mid vss sky130_fd_pr__nfet_01v8_lvt w=0.9 l=0.15
X1979 t_Xrx_Xdeser_Xsh_e1_Xf3_Xm2_mid rst_n vss vss sky130_fd_pr__nfet_01v8_lvt w=0.9 l=0.15
X1980 t_Xrx_Xdeser_Xsh_e1_Xf3_m2 t_Xrx_Xdeser_Xsh_e1_Xf3_m1 vdd vdd sky130_fd_pr__pfet_01v8 w=1.6 l=0.15
X1981 t_Xrx_Xdeser_Xsh_e1_Xf3_m2 rst_n vdd vdd sky130_fd_pr__pfet_01v8 w=1.6 l=0.15
X1982 t_Xrx_Xdeser_Xsh_e1_Xf3_m3 t_Xrx_Xdeser_Xsh_e1_Xf3_m2 vss vss sky130_fd_pr__nfet_01v8_lvt w=0.45 l=0.15
X1983 t_Xrx_Xdeser_Xsh_e1_Xf3_m3 t_Xrx_Xdeser_Xsh_e1_Xf3_m2 vdd vdd sky130_fd_pr__pfet_01v8 w=1.15 l=0.15
X1984 t_Xrx_Xdeser_Xsh_e1_Xf3_m3 t_Xrx_Xdeser_ck0b t_Xrx_Xdeser_Xsh_e1_Xf3_m1 vss sky130_fd_pr__nfet_01v8_lvt w=0.45 l=0.15
X1985 t_Xrx_Xdeser_Xsh_e1_Xf3_m3 t_Xrx_Xdeser_ck0bb t_Xrx_Xdeser_Xsh_e1_Xf3_m1 vdd sky130_fd_pr__pfet_01v8 w=1.05 l=0.15
X1986 t_Xrx_Xdeser_Xsh_e1_Xf3_m2 t_Xrx_Xdeser_ck0b t_Xrx_Xdeser_Xsh_e1_Xf3_s1 vss sky130_fd_pr__nfet_01v8_lvt w=0.65 l=0.15
X1987 t_Xrx_Xdeser_Xsh_e1_Xf3_m2 t_Xrx_Xdeser_ck0bb t_Xrx_Xdeser_Xsh_e1_Xf3_s1 vdd sky130_fd_pr__pfet_01v8 w=1.8 l=0.15
X1988 t_Xrx_Xdeser_Xsh_e1_Xf3_qi t_Xrx_Xdeser_Xsh_e1_Xf3_s1 vss vss sky130_fd_pr__nfet_01v8_lvt w=0.65 l=0.15
X1989 t_Xrx_Xdeser_Xsh_e1_Xf3_qi t_Xrx_Xdeser_Xsh_e1_Xf3_s1 vdd vdd sky130_fd_pr__pfet_01v8 w=1.65 l=0.15
X1990 t_Xrx_Xdeser_Xsh_e1_Xf3_s2 t_Xrx_Xdeser_Xsh_e1_Xf3_qi t_Xrx_Xdeser_Xsh_e1_Xf3_Xsfb_mid vss sky130_fd_pr__nfet_01v8_lvt w=0.8 l=0.15
X1991 t_Xrx_Xdeser_Xsh_e1_Xf3_Xsfb_mid rst_n vss vss sky130_fd_pr__nfet_01v8_lvt w=0.8 l=0.15
X1992 t_Xrx_Xdeser_Xsh_e1_Xf3_s2 t_Xrx_Xdeser_Xsh_e1_Xf3_qi vdd vdd sky130_fd_pr__pfet_01v8 w=1.4 l=0.15
X1993 t_Xrx_Xdeser_Xsh_e1_Xf3_s2 rst_n vdd vdd sky130_fd_pr__pfet_01v8 w=1.4 l=0.15
X1994 t_Xrx_Xdeser_Xsh_e1_Xf3_s2 t_Xrx_Xdeser_ck0bb t_Xrx_Xdeser_Xsh_e1_Xf3_s1 vss sky130_fd_pr__nfet_01v8_lvt w=0.45 l=0.15
X1995 t_Xrx_Xdeser_Xsh_e1_Xf3_s2 t_Xrx_Xdeser_ck0b t_Xrx_Xdeser_Xsh_e1_Xf3_s1 vdd sky130_fd_pr__pfet_01v8 w=1.05 l=0.15
X1996 t_Xrx_Xdeser_e1_3 t_Xrx_Xdeser_Xsh_e1_Xf3_s1 vss vss sky130_fd_pr__nfet_01v8_lvt w=0.7 l=0.15
X1997 t_Xrx_Xdeser_e1_3 t_Xrx_Xdeser_Xsh_e1_Xf3_s1 vdd vdd sky130_fd_pr__pfet_01v8 w=1.8 l=0.15
X1998 t_Xrx_Xdeser_Xsh_e1_s3b t_Xrx_Xdeser_e1_3 vss vss sky130_fd_pr__nfet_01v8_lvt w=0.55 l=0.15
X1999 t_Xrx_Xdeser_Xsh_e1_s3b t_Xrx_Xdeser_e1_3 vdd vdd sky130_fd_pr__pfet_01v8 w=1.4 l=0.15
X2000 t_Xrx_Xdeser_e2_a t_Xrx_Xdeser_ck0bb t_Xrx_Xdeser_Xsh_e2_Xf0_m1 vss sky130_fd_pr__nfet_01v8_lvt w=0.65 l=0.15
X2001 t_Xrx_Xdeser_e2_a t_Xrx_Xdeser_ck0b t_Xrx_Xdeser_Xsh_e2_Xf0_m1 vdd sky130_fd_pr__pfet_01v8 w=1.8 l=0.15
X2002 t_Xrx_Xdeser_Xsh_e2_Xf0_m2 t_Xrx_Xdeser_Xsh_e2_Xf0_m1 t_Xrx_Xdeser_Xsh_e2_Xf0_Xm2_mid vss sky130_fd_pr__nfet_01v8_lvt w=0.9 l=0.15
X2003 t_Xrx_Xdeser_Xsh_e2_Xf0_Xm2_mid rst_n vss vss sky130_fd_pr__nfet_01v8_lvt w=0.9 l=0.15
X2004 t_Xrx_Xdeser_Xsh_e2_Xf0_m2 t_Xrx_Xdeser_Xsh_e2_Xf0_m1 vdd vdd sky130_fd_pr__pfet_01v8 w=1.6 l=0.15
X2005 t_Xrx_Xdeser_Xsh_e2_Xf0_m2 rst_n vdd vdd sky130_fd_pr__pfet_01v8 w=1.6 l=0.15
X2006 t_Xrx_Xdeser_Xsh_e2_Xf0_m3 t_Xrx_Xdeser_Xsh_e2_Xf0_m2 vss vss sky130_fd_pr__nfet_01v8_lvt w=0.45 l=0.15
X2007 t_Xrx_Xdeser_Xsh_e2_Xf0_m3 t_Xrx_Xdeser_Xsh_e2_Xf0_m2 vdd vdd sky130_fd_pr__pfet_01v8 w=1.15 l=0.15
X2008 t_Xrx_Xdeser_Xsh_e2_Xf0_m3 t_Xrx_Xdeser_ck0b t_Xrx_Xdeser_Xsh_e2_Xf0_m1 vss sky130_fd_pr__nfet_01v8_lvt w=0.45 l=0.15
X2009 t_Xrx_Xdeser_Xsh_e2_Xf0_m3 t_Xrx_Xdeser_ck0bb t_Xrx_Xdeser_Xsh_e2_Xf0_m1 vdd sky130_fd_pr__pfet_01v8 w=1.05 l=0.15
X2010 t_Xrx_Xdeser_Xsh_e2_Xf0_m2 t_Xrx_Xdeser_ck0b t_Xrx_Xdeser_Xsh_e2_Xf0_s1 vss sky130_fd_pr__nfet_01v8_lvt w=0.65 l=0.15
X2011 t_Xrx_Xdeser_Xsh_e2_Xf0_m2 t_Xrx_Xdeser_ck0bb t_Xrx_Xdeser_Xsh_e2_Xf0_s1 vdd sky130_fd_pr__pfet_01v8 w=1.8 l=0.15
X2012 t_Xrx_Xdeser_Xsh_e2_Xf0_qi t_Xrx_Xdeser_Xsh_e2_Xf0_s1 vss vss sky130_fd_pr__nfet_01v8_lvt w=0.65 l=0.15
X2013 t_Xrx_Xdeser_Xsh_e2_Xf0_qi t_Xrx_Xdeser_Xsh_e2_Xf0_s1 vdd vdd sky130_fd_pr__pfet_01v8 w=1.65 l=0.15
X2014 t_Xrx_Xdeser_Xsh_e2_Xf0_s2 t_Xrx_Xdeser_Xsh_e2_Xf0_qi t_Xrx_Xdeser_Xsh_e2_Xf0_Xsfb_mid vss sky130_fd_pr__nfet_01v8_lvt w=0.8 l=0.15
X2015 t_Xrx_Xdeser_Xsh_e2_Xf0_Xsfb_mid rst_n vss vss sky130_fd_pr__nfet_01v8_lvt w=0.8 l=0.15
X2016 t_Xrx_Xdeser_Xsh_e2_Xf0_s2 t_Xrx_Xdeser_Xsh_e2_Xf0_qi vdd vdd sky130_fd_pr__pfet_01v8 w=1.4 l=0.15
X2017 t_Xrx_Xdeser_Xsh_e2_Xf0_s2 rst_n vdd vdd sky130_fd_pr__pfet_01v8 w=1.4 l=0.15
X2018 t_Xrx_Xdeser_Xsh_e2_Xf0_s2 t_Xrx_Xdeser_ck0bb t_Xrx_Xdeser_Xsh_e2_Xf0_s1 vss sky130_fd_pr__nfet_01v8_lvt w=0.45 l=0.15
X2019 t_Xrx_Xdeser_Xsh_e2_Xf0_s2 t_Xrx_Xdeser_ck0b t_Xrx_Xdeser_Xsh_e2_Xf0_s1 vdd sky130_fd_pr__pfet_01v8 w=1.05 l=0.15
X2020 t_Xrx_Xdeser_e2_0 t_Xrx_Xdeser_Xsh_e2_Xf0_s1 vss vss sky130_fd_pr__nfet_01v8_lvt w=0.7 l=0.15
X2021 t_Xrx_Xdeser_e2_0 t_Xrx_Xdeser_Xsh_e2_Xf0_s1 vdd vdd sky130_fd_pr__pfet_01v8 w=1.8 l=0.15
X2022 t_Xrx_Xdeser_Xsh_e2_s0b t_Xrx_Xdeser_e2_0 vss vss sky130_fd_pr__nfet_01v8_lvt w=0.55 l=0.15
X2023 t_Xrx_Xdeser_Xsh_e2_s0b t_Xrx_Xdeser_e2_0 vdd vdd sky130_fd_pr__pfet_01v8 w=1.4 l=0.15
X2024 t_Xrx_Xdeser_e2_0 t_Xrx_Xdeser_ck0bb t_Xrx_Xdeser_Xsh_e2_Xf1_m1 vss sky130_fd_pr__nfet_01v8_lvt w=0.65 l=0.15
X2025 t_Xrx_Xdeser_e2_0 t_Xrx_Xdeser_ck0b t_Xrx_Xdeser_Xsh_e2_Xf1_m1 vdd sky130_fd_pr__pfet_01v8 w=1.8 l=0.15
X2026 t_Xrx_Xdeser_Xsh_e2_Xf1_m2 t_Xrx_Xdeser_Xsh_e2_Xf1_m1 t_Xrx_Xdeser_Xsh_e2_Xf1_Xm2_mid vss sky130_fd_pr__nfet_01v8_lvt w=0.9 l=0.15
X2027 t_Xrx_Xdeser_Xsh_e2_Xf1_Xm2_mid rst_n vss vss sky130_fd_pr__nfet_01v8_lvt w=0.9 l=0.15
X2028 t_Xrx_Xdeser_Xsh_e2_Xf1_m2 t_Xrx_Xdeser_Xsh_e2_Xf1_m1 vdd vdd sky130_fd_pr__pfet_01v8 w=1.6 l=0.15
X2029 t_Xrx_Xdeser_Xsh_e2_Xf1_m2 rst_n vdd vdd sky130_fd_pr__pfet_01v8 w=1.6 l=0.15
X2030 t_Xrx_Xdeser_Xsh_e2_Xf1_m3 t_Xrx_Xdeser_Xsh_e2_Xf1_m2 vss vss sky130_fd_pr__nfet_01v8_lvt w=0.45 l=0.15
X2031 t_Xrx_Xdeser_Xsh_e2_Xf1_m3 t_Xrx_Xdeser_Xsh_e2_Xf1_m2 vdd vdd sky130_fd_pr__pfet_01v8 w=1.15 l=0.15
X2032 t_Xrx_Xdeser_Xsh_e2_Xf1_m3 t_Xrx_Xdeser_ck0b t_Xrx_Xdeser_Xsh_e2_Xf1_m1 vss sky130_fd_pr__nfet_01v8_lvt w=0.45 l=0.15
X2033 t_Xrx_Xdeser_Xsh_e2_Xf1_m3 t_Xrx_Xdeser_ck0bb t_Xrx_Xdeser_Xsh_e2_Xf1_m1 vdd sky130_fd_pr__pfet_01v8 w=1.05 l=0.15
X2034 t_Xrx_Xdeser_Xsh_e2_Xf1_m2 t_Xrx_Xdeser_ck0b t_Xrx_Xdeser_Xsh_e2_Xf1_s1 vss sky130_fd_pr__nfet_01v8_lvt w=0.65 l=0.15
X2035 t_Xrx_Xdeser_Xsh_e2_Xf1_m2 t_Xrx_Xdeser_ck0bb t_Xrx_Xdeser_Xsh_e2_Xf1_s1 vdd sky130_fd_pr__pfet_01v8 w=1.8 l=0.15
X2036 t_Xrx_Xdeser_Xsh_e2_Xf1_qi t_Xrx_Xdeser_Xsh_e2_Xf1_s1 vss vss sky130_fd_pr__nfet_01v8_lvt w=0.65 l=0.15
X2037 t_Xrx_Xdeser_Xsh_e2_Xf1_qi t_Xrx_Xdeser_Xsh_e2_Xf1_s1 vdd vdd sky130_fd_pr__pfet_01v8 w=1.65 l=0.15
X2038 t_Xrx_Xdeser_Xsh_e2_Xf1_s2 t_Xrx_Xdeser_Xsh_e2_Xf1_qi t_Xrx_Xdeser_Xsh_e2_Xf1_Xsfb_mid vss sky130_fd_pr__nfet_01v8_lvt w=0.8 l=0.15
X2039 t_Xrx_Xdeser_Xsh_e2_Xf1_Xsfb_mid rst_n vss vss sky130_fd_pr__nfet_01v8_lvt w=0.8 l=0.15
X2040 t_Xrx_Xdeser_Xsh_e2_Xf1_s2 t_Xrx_Xdeser_Xsh_e2_Xf1_qi vdd vdd sky130_fd_pr__pfet_01v8 w=1.4 l=0.15
X2041 t_Xrx_Xdeser_Xsh_e2_Xf1_s2 rst_n vdd vdd sky130_fd_pr__pfet_01v8 w=1.4 l=0.15
X2042 t_Xrx_Xdeser_Xsh_e2_Xf1_s2 t_Xrx_Xdeser_ck0bb t_Xrx_Xdeser_Xsh_e2_Xf1_s1 vss sky130_fd_pr__nfet_01v8_lvt w=0.45 l=0.15
X2043 t_Xrx_Xdeser_Xsh_e2_Xf1_s2 t_Xrx_Xdeser_ck0b t_Xrx_Xdeser_Xsh_e2_Xf1_s1 vdd sky130_fd_pr__pfet_01v8 w=1.05 l=0.15
X2044 t_Xrx_Xdeser_e2_1 t_Xrx_Xdeser_Xsh_e2_Xf1_s1 vss vss sky130_fd_pr__nfet_01v8_lvt w=0.7 l=0.15
X2045 t_Xrx_Xdeser_e2_1 t_Xrx_Xdeser_Xsh_e2_Xf1_s1 vdd vdd sky130_fd_pr__pfet_01v8 w=1.8 l=0.15
X2046 t_Xrx_Xdeser_Xsh_e2_s1b t_Xrx_Xdeser_e2_1 vss vss sky130_fd_pr__nfet_01v8_lvt w=0.55 l=0.15
X2047 t_Xrx_Xdeser_Xsh_e2_s1b t_Xrx_Xdeser_e2_1 vdd vdd sky130_fd_pr__pfet_01v8 w=1.4 l=0.15
X2048 t_Xrx_Xdeser_e2_1 t_Xrx_Xdeser_ck0bb t_Xrx_Xdeser_Xsh_e2_Xf2_m1 vss sky130_fd_pr__nfet_01v8_lvt w=0.65 l=0.15
X2049 t_Xrx_Xdeser_e2_1 t_Xrx_Xdeser_ck0b t_Xrx_Xdeser_Xsh_e2_Xf2_m1 vdd sky130_fd_pr__pfet_01v8 w=1.8 l=0.15
X2050 t_Xrx_Xdeser_Xsh_e2_Xf2_m2 t_Xrx_Xdeser_Xsh_e2_Xf2_m1 t_Xrx_Xdeser_Xsh_e2_Xf2_Xm2_mid vss sky130_fd_pr__nfet_01v8_lvt w=0.9 l=0.15
X2051 t_Xrx_Xdeser_Xsh_e2_Xf2_Xm2_mid rst_n vss vss sky130_fd_pr__nfet_01v8_lvt w=0.9 l=0.15
X2052 t_Xrx_Xdeser_Xsh_e2_Xf2_m2 t_Xrx_Xdeser_Xsh_e2_Xf2_m1 vdd vdd sky130_fd_pr__pfet_01v8 w=1.6 l=0.15
X2053 t_Xrx_Xdeser_Xsh_e2_Xf2_m2 rst_n vdd vdd sky130_fd_pr__pfet_01v8 w=1.6 l=0.15
X2054 t_Xrx_Xdeser_Xsh_e2_Xf2_m3 t_Xrx_Xdeser_Xsh_e2_Xf2_m2 vss vss sky130_fd_pr__nfet_01v8_lvt w=0.45 l=0.15
X2055 t_Xrx_Xdeser_Xsh_e2_Xf2_m3 t_Xrx_Xdeser_Xsh_e2_Xf2_m2 vdd vdd sky130_fd_pr__pfet_01v8 w=1.15 l=0.15
X2056 t_Xrx_Xdeser_Xsh_e2_Xf2_m3 t_Xrx_Xdeser_ck0b t_Xrx_Xdeser_Xsh_e2_Xf2_m1 vss sky130_fd_pr__nfet_01v8_lvt w=0.45 l=0.15
X2057 t_Xrx_Xdeser_Xsh_e2_Xf2_m3 t_Xrx_Xdeser_ck0bb t_Xrx_Xdeser_Xsh_e2_Xf2_m1 vdd sky130_fd_pr__pfet_01v8 w=1.05 l=0.15
X2058 t_Xrx_Xdeser_Xsh_e2_Xf2_m2 t_Xrx_Xdeser_ck0b t_Xrx_Xdeser_Xsh_e2_Xf2_s1 vss sky130_fd_pr__nfet_01v8_lvt w=0.65 l=0.15
X2059 t_Xrx_Xdeser_Xsh_e2_Xf2_m2 t_Xrx_Xdeser_ck0bb t_Xrx_Xdeser_Xsh_e2_Xf2_s1 vdd sky130_fd_pr__pfet_01v8 w=1.8 l=0.15
X2060 t_Xrx_Xdeser_Xsh_e2_Xf2_qi t_Xrx_Xdeser_Xsh_e2_Xf2_s1 vss vss sky130_fd_pr__nfet_01v8_lvt w=0.65 l=0.15
X2061 t_Xrx_Xdeser_Xsh_e2_Xf2_qi t_Xrx_Xdeser_Xsh_e2_Xf2_s1 vdd vdd sky130_fd_pr__pfet_01v8 w=1.65 l=0.15
X2062 t_Xrx_Xdeser_Xsh_e2_Xf2_s2 t_Xrx_Xdeser_Xsh_e2_Xf2_qi t_Xrx_Xdeser_Xsh_e2_Xf2_Xsfb_mid vss sky130_fd_pr__nfet_01v8_lvt w=0.8 l=0.15
X2063 t_Xrx_Xdeser_Xsh_e2_Xf2_Xsfb_mid rst_n vss vss sky130_fd_pr__nfet_01v8_lvt w=0.8 l=0.15
X2064 t_Xrx_Xdeser_Xsh_e2_Xf2_s2 t_Xrx_Xdeser_Xsh_e2_Xf2_qi vdd vdd sky130_fd_pr__pfet_01v8 w=1.4 l=0.15
X2065 t_Xrx_Xdeser_Xsh_e2_Xf2_s2 rst_n vdd vdd sky130_fd_pr__pfet_01v8 w=1.4 l=0.15
X2066 t_Xrx_Xdeser_Xsh_e2_Xf2_s2 t_Xrx_Xdeser_ck0bb t_Xrx_Xdeser_Xsh_e2_Xf2_s1 vss sky130_fd_pr__nfet_01v8_lvt w=0.45 l=0.15
X2067 t_Xrx_Xdeser_Xsh_e2_Xf2_s2 t_Xrx_Xdeser_ck0b t_Xrx_Xdeser_Xsh_e2_Xf2_s1 vdd sky130_fd_pr__pfet_01v8 w=1.05 l=0.15
X2068 t_Xrx_Xdeser_e2_2 t_Xrx_Xdeser_Xsh_e2_Xf2_s1 vss vss sky130_fd_pr__nfet_01v8_lvt w=0.7 l=0.15
X2069 t_Xrx_Xdeser_e2_2 t_Xrx_Xdeser_Xsh_e2_Xf2_s1 vdd vdd sky130_fd_pr__pfet_01v8 w=1.8 l=0.15
X2070 t_Xrx_Xdeser_Xsh_e2_s2b t_Xrx_Xdeser_e2_2 vss vss sky130_fd_pr__nfet_01v8_lvt w=0.55 l=0.15
X2071 t_Xrx_Xdeser_Xsh_e2_s2b t_Xrx_Xdeser_e2_2 vdd vdd sky130_fd_pr__pfet_01v8 w=1.4 l=0.15
X2072 t_Xrx_Xdeser_e2_2 t_Xrx_Xdeser_ck0bb t_Xrx_Xdeser_Xsh_e2_Xf3_m1 vss sky130_fd_pr__nfet_01v8_lvt w=0.65 l=0.15
X2073 t_Xrx_Xdeser_e2_2 t_Xrx_Xdeser_ck0b t_Xrx_Xdeser_Xsh_e2_Xf3_m1 vdd sky130_fd_pr__pfet_01v8 w=1.8 l=0.15
X2074 t_Xrx_Xdeser_Xsh_e2_Xf3_m2 t_Xrx_Xdeser_Xsh_e2_Xf3_m1 t_Xrx_Xdeser_Xsh_e2_Xf3_Xm2_mid vss sky130_fd_pr__nfet_01v8_lvt w=0.9 l=0.15
X2075 t_Xrx_Xdeser_Xsh_e2_Xf3_Xm2_mid rst_n vss vss sky130_fd_pr__nfet_01v8_lvt w=0.9 l=0.15
X2076 t_Xrx_Xdeser_Xsh_e2_Xf3_m2 t_Xrx_Xdeser_Xsh_e2_Xf3_m1 vdd vdd sky130_fd_pr__pfet_01v8 w=1.6 l=0.15
X2077 t_Xrx_Xdeser_Xsh_e2_Xf3_m2 rst_n vdd vdd sky130_fd_pr__pfet_01v8 w=1.6 l=0.15
X2078 t_Xrx_Xdeser_Xsh_e2_Xf3_m3 t_Xrx_Xdeser_Xsh_e2_Xf3_m2 vss vss sky130_fd_pr__nfet_01v8_lvt w=0.45 l=0.15
X2079 t_Xrx_Xdeser_Xsh_e2_Xf3_m3 t_Xrx_Xdeser_Xsh_e2_Xf3_m2 vdd vdd sky130_fd_pr__pfet_01v8 w=1.15 l=0.15
X2080 t_Xrx_Xdeser_Xsh_e2_Xf3_m3 t_Xrx_Xdeser_ck0b t_Xrx_Xdeser_Xsh_e2_Xf3_m1 vss sky130_fd_pr__nfet_01v8_lvt w=0.45 l=0.15
X2081 t_Xrx_Xdeser_Xsh_e2_Xf3_m3 t_Xrx_Xdeser_ck0bb t_Xrx_Xdeser_Xsh_e2_Xf3_m1 vdd sky130_fd_pr__pfet_01v8 w=1.05 l=0.15
X2082 t_Xrx_Xdeser_Xsh_e2_Xf3_m2 t_Xrx_Xdeser_ck0b t_Xrx_Xdeser_Xsh_e2_Xf3_s1 vss sky130_fd_pr__nfet_01v8_lvt w=0.65 l=0.15
X2083 t_Xrx_Xdeser_Xsh_e2_Xf3_m2 t_Xrx_Xdeser_ck0bb t_Xrx_Xdeser_Xsh_e2_Xf3_s1 vdd sky130_fd_pr__pfet_01v8 w=1.8 l=0.15
X2084 t_Xrx_Xdeser_Xsh_e2_Xf3_qi t_Xrx_Xdeser_Xsh_e2_Xf3_s1 vss vss sky130_fd_pr__nfet_01v8_lvt w=0.65 l=0.15
X2085 t_Xrx_Xdeser_Xsh_e2_Xf3_qi t_Xrx_Xdeser_Xsh_e2_Xf3_s1 vdd vdd sky130_fd_pr__pfet_01v8 w=1.65 l=0.15
X2086 t_Xrx_Xdeser_Xsh_e2_Xf3_s2 t_Xrx_Xdeser_Xsh_e2_Xf3_qi t_Xrx_Xdeser_Xsh_e2_Xf3_Xsfb_mid vss sky130_fd_pr__nfet_01v8_lvt w=0.8 l=0.15
X2087 t_Xrx_Xdeser_Xsh_e2_Xf3_Xsfb_mid rst_n vss vss sky130_fd_pr__nfet_01v8_lvt w=0.8 l=0.15
X2088 t_Xrx_Xdeser_Xsh_e2_Xf3_s2 t_Xrx_Xdeser_Xsh_e2_Xf3_qi vdd vdd sky130_fd_pr__pfet_01v8 w=1.4 l=0.15
X2089 t_Xrx_Xdeser_Xsh_e2_Xf3_s2 rst_n vdd vdd sky130_fd_pr__pfet_01v8 w=1.4 l=0.15
X2090 t_Xrx_Xdeser_Xsh_e2_Xf3_s2 t_Xrx_Xdeser_ck0bb t_Xrx_Xdeser_Xsh_e2_Xf3_s1 vss sky130_fd_pr__nfet_01v8_lvt w=0.45 l=0.15
X2091 t_Xrx_Xdeser_Xsh_e2_Xf3_s2 t_Xrx_Xdeser_ck0b t_Xrx_Xdeser_Xsh_e2_Xf3_s1 vdd sky130_fd_pr__pfet_01v8 w=1.05 l=0.15
X2092 t_Xrx_Xdeser_e2_3 t_Xrx_Xdeser_Xsh_e2_Xf3_s1 vss vss sky130_fd_pr__nfet_01v8_lvt w=0.7 l=0.15
X2093 t_Xrx_Xdeser_e2_3 t_Xrx_Xdeser_Xsh_e2_Xf3_s1 vdd vdd sky130_fd_pr__pfet_01v8 w=1.8 l=0.15
X2094 t_Xrx_Xdeser_Xsh_e2_s3b t_Xrx_Xdeser_e2_3 vss vss sky130_fd_pr__nfet_01v8_lvt w=0.55 l=0.15
X2095 t_Xrx_Xdeser_Xsh_e2_s3b t_Xrx_Xdeser_e2_3 vdd vdd sky130_fd_pr__pfet_01v8 w=1.4 l=0.15
X2096 t_Xrx_Xdeser_e3_a t_Xrx_Xdeser_ck0bb t_Xrx_Xdeser_Xsh_e3_Xf0_m1 vss sky130_fd_pr__nfet_01v8_lvt w=0.65 l=0.15
X2097 t_Xrx_Xdeser_e3_a t_Xrx_Xdeser_ck0b t_Xrx_Xdeser_Xsh_e3_Xf0_m1 vdd sky130_fd_pr__pfet_01v8 w=1.8 l=0.15
X2098 t_Xrx_Xdeser_Xsh_e3_Xf0_m2 t_Xrx_Xdeser_Xsh_e3_Xf0_m1 t_Xrx_Xdeser_Xsh_e3_Xf0_Xm2_mid vss sky130_fd_pr__nfet_01v8_lvt w=0.9 l=0.15
X2099 t_Xrx_Xdeser_Xsh_e3_Xf0_Xm2_mid rst_n vss vss sky130_fd_pr__nfet_01v8_lvt w=0.9 l=0.15
X2100 t_Xrx_Xdeser_Xsh_e3_Xf0_m2 t_Xrx_Xdeser_Xsh_e3_Xf0_m1 vdd vdd sky130_fd_pr__pfet_01v8 w=1.6 l=0.15
X2101 t_Xrx_Xdeser_Xsh_e3_Xf0_m2 rst_n vdd vdd sky130_fd_pr__pfet_01v8 w=1.6 l=0.15
X2102 t_Xrx_Xdeser_Xsh_e3_Xf0_m3 t_Xrx_Xdeser_Xsh_e3_Xf0_m2 vss vss sky130_fd_pr__nfet_01v8_lvt w=0.45 l=0.15
X2103 t_Xrx_Xdeser_Xsh_e3_Xf0_m3 t_Xrx_Xdeser_Xsh_e3_Xf0_m2 vdd vdd sky130_fd_pr__pfet_01v8 w=1.15 l=0.15
X2104 t_Xrx_Xdeser_Xsh_e3_Xf0_m3 t_Xrx_Xdeser_ck0b t_Xrx_Xdeser_Xsh_e3_Xf0_m1 vss sky130_fd_pr__nfet_01v8_lvt w=0.45 l=0.15
X2105 t_Xrx_Xdeser_Xsh_e3_Xf0_m3 t_Xrx_Xdeser_ck0bb t_Xrx_Xdeser_Xsh_e3_Xf0_m1 vdd sky130_fd_pr__pfet_01v8 w=1.05 l=0.15
X2106 t_Xrx_Xdeser_Xsh_e3_Xf0_m2 t_Xrx_Xdeser_ck0b t_Xrx_Xdeser_Xsh_e3_Xf0_s1 vss sky130_fd_pr__nfet_01v8_lvt w=0.65 l=0.15
X2107 t_Xrx_Xdeser_Xsh_e3_Xf0_m2 t_Xrx_Xdeser_ck0bb t_Xrx_Xdeser_Xsh_e3_Xf0_s1 vdd sky130_fd_pr__pfet_01v8 w=1.8 l=0.15
X2108 t_Xrx_Xdeser_Xsh_e3_Xf0_qi t_Xrx_Xdeser_Xsh_e3_Xf0_s1 vss vss sky130_fd_pr__nfet_01v8_lvt w=0.65 l=0.15
X2109 t_Xrx_Xdeser_Xsh_e3_Xf0_qi t_Xrx_Xdeser_Xsh_e3_Xf0_s1 vdd vdd sky130_fd_pr__pfet_01v8 w=1.65 l=0.15
X2110 t_Xrx_Xdeser_Xsh_e3_Xf0_s2 t_Xrx_Xdeser_Xsh_e3_Xf0_qi t_Xrx_Xdeser_Xsh_e3_Xf0_Xsfb_mid vss sky130_fd_pr__nfet_01v8_lvt w=0.8 l=0.15
X2111 t_Xrx_Xdeser_Xsh_e3_Xf0_Xsfb_mid rst_n vss vss sky130_fd_pr__nfet_01v8_lvt w=0.8 l=0.15
X2112 t_Xrx_Xdeser_Xsh_e3_Xf0_s2 t_Xrx_Xdeser_Xsh_e3_Xf0_qi vdd vdd sky130_fd_pr__pfet_01v8 w=1.4 l=0.15
X2113 t_Xrx_Xdeser_Xsh_e3_Xf0_s2 rst_n vdd vdd sky130_fd_pr__pfet_01v8 w=1.4 l=0.15
X2114 t_Xrx_Xdeser_Xsh_e3_Xf0_s2 t_Xrx_Xdeser_ck0bb t_Xrx_Xdeser_Xsh_e3_Xf0_s1 vss sky130_fd_pr__nfet_01v8_lvt w=0.45 l=0.15
X2115 t_Xrx_Xdeser_Xsh_e3_Xf0_s2 t_Xrx_Xdeser_ck0b t_Xrx_Xdeser_Xsh_e3_Xf0_s1 vdd sky130_fd_pr__pfet_01v8 w=1.05 l=0.15
X2116 t_Xrx_Xdeser_e3_0 t_Xrx_Xdeser_Xsh_e3_Xf0_s1 vss vss sky130_fd_pr__nfet_01v8_lvt w=0.7 l=0.15
X2117 t_Xrx_Xdeser_e3_0 t_Xrx_Xdeser_Xsh_e3_Xf0_s1 vdd vdd sky130_fd_pr__pfet_01v8 w=1.8 l=0.15
X2118 t_Xrx_Xdeser_Xsh_e3_s0b t_Xrx_Xdeser_e3_0 vss vss sky130_fd_pr__nfet_01v8_lvt w=0.55 l=0.15
X2119 t_Xrx_Xdeser_Xsh_e3_s0b t_Xrx_Xdeser_e3_0 vdd vdd sky130_fd_pr__pfet_01v8 w=1.4 l=0.15
X2120 t_Xrx_Xdeser_e3_0 t_Xrx_Xdeser_ck0bb t_Xrx_Xdeser_Xsh_e3_Xf1_m1 vss sky130_fd_pr__nfet_01v8_lvt w=0.65 l=0.15
X2121 t_Xrx_Xdeser_e3_0 t_Xrx_Xdeser_ck0b t_Xrx_Xdeser_Xsh_e3_Xf1_m1 vdd sky130_fd_pr__pfet_01v8 w=1.8 l=0.15
X2122 t_Xrx_Xdeser_Xsh_e3_Xf1_m2 t_Xrx_Xdeser_Xsh_e3_Xf1_m1 t_Xrx_Xdeser_Xsh_e3_Xf1_Xm2_mid vss sky130_fd_pr__nfet_01v8_lvt w=0.9 l=0.15
X2123 t_Xrx_Xdeser_Xsh_e3_Xf1_Xm2_mid rst_n vss vss sky130_fd_pr__nfet_01v8_lvt w=0.9 l=0.15
X2124 t_Xrx_Xdeser_Xsh_e3_Xf1_m2 t_Xrx_Xdeser_Xsh_e3_Xf1_m1 vdd vdd sky130_fd_pr__pfet_01v8 w=1.6 l=0.15
X2125 t_Xrx_Xdeser_Xsh_e3_Xf1_m2 rst_n vdd vdd sky130_fd_pr__pfet_01v8 w=1.6 l=0.15
X2126 t_Xrx_Xdeser_Xsh_e3_Xf1_m3 t_Xrx_Xdeser_Xsh_e3_Xf1_m2 vss vss sky130_fd_pr__nfet_01v8_lvt w=0.45 l=0.15
X2127 t_Xrx_Xdeser_Xsh_e3_Xf1_m3 t_Xrx_Xdeser_Xsh_e3_Xf1_m2 vdd vdd sky130_fd_pr__pfet_01v8 w=1.15 l=0.15
X2128 t_Xrx_Xdeser_Xsh_e3_Xf1_m3 t_Xrx_Xdeser_ck0b t_Xrx_Xdeser_Xsh_e3_Xf1_m1 vss sky130_fd_pr__nfet_01v8_lvt w=0.45 l=0.15
X2129 t_Xrx_Xdeser_Xsh_e3_Xf1_m3 t_Xrx_Xdeser_ck0bb t_Xrx_Xdeser_Xsh_e3_Xf1_m1 vdd sky130_fd_pr__pfet_01v8 w=1.05 l=0.15
X2130 t_Xrx_Xdeser_Xsh_e3_Xf1_m2 t_Xrx_Xdeser_ck0b t_Xrx_Xdeser_Xsh_e3_Xf1_s1 vss sky130_fd_pr__nfet_01v8_lvt w=0.65 l=0.15
X2131 t_Xrx_Xdeser_Xsh_e3_Xf1_m2 t_Xrx_Xdeser_ck0bb t_Xrx_Xdeser_Xsh_e3_Xf1_s1 vdd sky130_fd_pr__pfet_01v8 w=1.8 l=0.15
X2132 t_Xrx_Xdeser_Xsh_e3_Xf1_qi t_Xrx_Xdeser_Xsh_e3_Xf1_s1 vss vss sky130_fd_pr__nfet_01v8_lvt w=0.65 l=0.15
X2133 t_Xrx_Xdeser_Xsh_e3_Xf1_qi t_Xrx_Xdeser_Xsh_e3_Xf1_s1 vdd vdd sky130_fd_pr__pfet_01v8 w=1.65 l=0.15
X2134 t_Xrx_Xdeser_Xsh_e3_Xf1_s2 t_Xrx_Xdeser_Xsh_e3_Xf1_qi t_Xrx_Xdeser_Xsh_e3_Xf1_Xsfb_mid vss sky130_fd_pr__nfet_01v8_lvt w=0.8 l=0.15
X2135 t_Xrx_Xdeser_Xsh_e3_Xf1_Xsfb_mid rst_n vss vss sky130_fd_pr__nfet_01v8_lvt w=0.8 l=0.15
X2136 t_Xrx_Xdeser_Xsh_e3_Xf1_s2 t_Xrx_Xdeser_Xsh_e3_Xf1_qi vdd vdd sky130_fd_pr__pfet_01v8 w=1.4 l=0.15
X2137 t_Xrx_Xdeser_Xsh_e3_Xf1_s2 rst_n vdd vdd sky130_fd_pr__pfet_01v8 w=1.4 l=0.15
X2138 t_Xrx_Xdeser_Xsh_e3_Xf1_s2 t_Xrx_Xdeser_ck0bb t_Xrx_Xdeser_Xsh_e3_Xf1_s1 vss sky130_fd_pr__nfet_01v8_lvt w=0.45 l=0.15
X2139 t_Xrx_Xdeser_Xsh_e3_Xf1_s2 t_Xrx_Xdeser_ck0b t_Xrx_Xdeser_Xsh_e3_Xf1_s1 vdd sky130_fd_pr__pfet_01v8 w=1.05 l=0.15
X2140 t_Xrx_Xdeser_e3_1 t_Xrx_Xdeser_Xsh_e3_Xf1_s1 vss vss sky130_fd_pr__nfet_01v8_lvt w=0.7 l=0.15
X2141 t_Xrx_Xdeser_e3_1 t_Xrx_Xdeser_Xsh_e3_Xf1_s1 vdd vdd sky130_fd_pr__pfet_01v8 w=1.8 l=0.15
X2142 t_Xrx_Xdeser_Xsh_e3_s1b t_Xrx_Xdeser_e3_1 vss vss sky130_fd_pr__nfet_01v8_lvt w=0.55 l=0.15
X2143 t_Xrx_Xdeser_Xsh_e3_s1b t_Xrx_Xdeser_e3_1 vdd vdd sky130_fd_pr__pfet_01v8 w=1.4 l=0.15
X2144 t_Xrx_Xdeser_e3_1 t_Xrx_Xdeser_ck0bb t_Xrx_Xdeser_Xsh_e3_Xf2_m1 vss sky130_fd_pr__nfet_01v8_lvt w=0.65 l=0.15
X2145 t_Xrx_Xdeser_e3_1 t_Xrx_Xdeser_ck0b t_Xrx_Xdeser_Xsh_e3_Xf2_m1 vdd sky130_fd_pr__pfet_01v8 w=1.8 l=0.15
X2146 t_Xrx_Xdeser_Xsh_e3_Xf2_m2 t_Xrx_Xdeser_Xsh_e3_Xf2_m1 t_Xrx_Xdeser_Xsh_e3_Xf2_Xm2_mid vss sky130_fd_pr__nfet_01v8_lvt w=0.9 l=0.15
X2147 t_Xrx_Xdeser_Xsh_e3_Xf2_Xm2_mid rst_n vss vss sky130_fd_pr__nfet_01v8_lvt w=0.9 l=0.15
X2148 t_Xrx_Xdeser_Xsh_e3_Xf2_m2 t_Xrx_Xdeser_Xsh_e3_Xf2_m1 vdd vdd sky130_fd_pr__pfet_01v8 w=1.6 l=0.15
X2149 t_Xrx_Xdeser_Xsh_e3_Xf2_m2 rst_n vdd vdd sky130_fd_pr__pfet_01v8 w=1.6 l=0.15
X2150 t_Xrx_Xdeser_Xsh_e3_Xf2_m3 t_Xrx_Xdeser_Xsh_e3_Xf2_m2 vss vss sky130_fd_pr__nfet_01v8_lvt w=0.45 l=0.15
X2151 t_Xrx_Xdeser_Xsh_e3_Xf2_m3 t_Xrx_Xdeser_Xsh_e3_Xf2_m2 vdd vdd sky130_fd_pr__pfet_01v8 w=1.15 l=0.15
X2152 t_Xrx_Xdeser_Xsh_e3_Xf2_m3 t_Xrx_Xdeser_ck0b t_Xrx_Xdeser_Xsh_e3_Xf2_m1 vss sky130_fd_pr__nfet_01v8_lvt w=0.45 l=0.15
X2153 t_Xrx_Xdeser_Xsh_e3_Xf2_m3 t_Xrx_Xdeser_ck0bb t_Xrx_Xdeser_Xsh_e3_Xf2_m1 vdd sky130_fd_pr__pfet_01v8 w=1.05 l=0.15
X2154 t_Xrx_Xdeser_Xsh_e3_Xf2_m2 t_Xrx_Xdeser_ck0b t_Xrx_Xdeser_Xsh_e3_Xf2_s1 vss sky130_fd_pr__nfet_01v8_lvt w=0.65 l=0.15
X2155 t_Xrx_Xdeser_Xsh_e3_Xf2_m2 t_Xrx_Xdeser_ck0bb t_Xrx_Xdeser_Xsh_e3_Xf2_s1 vdd sky130_fd_pr__pfet_01v8 w=1.8 l=0.15
X2156 t_Xrx_Xdeser_Xsh_e3_Xf2_qi t_Xrx_Xdeser_Xsh_e3_Xf2_s1 vss vss sky130_fd_pr__nfet_01v8_lvt w=0.65 l=0.15
X2157 t_Xrx_Xdeser_Xsh_e3_Xf2_qi t_Xrx_Xdeser_Xsh_e3_Xf2_s1 vdd vdd sky130_fd_pr__pfet_01v8 w=1.65 l=0.15
X2158 t_Xrx_Xdeser_Xsh_e3_Xf2_s2 t_Xrx_Xdeser_Xsh_e3_Xf2_qi t_Xrx_Xdeser_Xsh_e3_Xf2_Xsfb_mid vss sky130_fd_pr__nfet_01v8_lvt w=0.8 l=0.15
X2159 t_Xrx_Xdeser_Xsh_e3_Xf2_Xsfb_mid rst_n vss vss sky130_fd_pr__nfet_01v8_lvt w=0.8 l=0.15
X2160 t_Xrx_Xdeser_Xsh_e3_Xf2_s2 t_Xrx_Xdeser_Xsh_e3_Xf2_qi vdd vdd sky130_fd_pr__pfet_01v8 w=1.4 l=0.15
X2161 t_Xrx_Xdeser_Xsh_e3_Xf2_s2 rst_n vdd vdd sky130_fd_pr__pfet_01v8 w=1.4 l=0.15
X2162 t_Xrx_Xdeser_Xsh_e3_Xf2_s2 t_Xrx_Xdeser_ck0bb t_Xrx_Xdeser_Xsh_e3_Xf2_s1 vss sky130_fd_pr__nfet_01v8_lvt w=0.45 l=0.15
X2163 t_Xrx_Xdeser_Xsh_e3_Xf2_s2 t_Xrx_Xdeser_ck0b t_Xrx_Xdeser_Xsh_e3_Xf2_s1 vdd sky130_fd_pr__pfet_01v8 w=1.05 l=0.15
X2164 t_Xrx_Xdeser_e3_2 t_Xrx_Xdeser_Xsh_e3_Xf2_s1 vss vss sky130_fd_pr__nfet_01v8_lvt w=0.7 l=0.15
X2165 t_Xrx_Xdeser_e3_2 t_Xrx_Xdeser_Xsh_e3_Xf2_s1 vdd vdd sky130_fd_pr__pfet_01v8 w=1.8 l=0.15
X2166 t_Xrx_Xdeser_Xsh_e3_s2b t_Xrx_Xdeser_e3_2 vss vss sky130_fd_pr__nfet_01v8_lvt w=0.55 l=0.15
X2167 t_Xrx_Xdeser_Xsh_e3_s2b t_Xrx_Xdeser_e3_2 vdd vdd sky130_fd_pr__pfet_01v8 w=1.4 l=0.15
X2168 t_Xrx_Xdeser_e3_2 t_Xrx_Xdeser_ck0bb t_Xrx_Xdeser_Xsh_e3_Xf3_m1 vss sky130_fd_pr__nfet_01v8_lvt w=0.65 l=0.15
X2169 t_Xrx_Xdeser_e3_2 t_Xrx_Xdeser_ck0b t_Xrx_Xdeser_Xsh_e3_Xf3_m1 vdd sky130_fd_pr__pfet_01v8 w=1.8 l=0.15
X2170 t_Xrx_Xdeser_Xsh_e3_Xf3_m2 t_Xrx_Xdeser_Xsh_e3_Xf3_m1 t_Xrx_Xdeser_Xsh_e3_Xf3_Xm2_mid vss sky130_fd_pr__nfet_01v8_lvt w=0.9 l=0.15
X2171 t_Xrx_Xdeser_Xsh_e3_Xf3_Xm2_mid rst_n vss vss sky130_fd_pr__nfet_01v8_lvt w=0.9 l=0.15
X2172 t_Xrx_Xdeser_Xsh_e3_Xf3_m2 t_Xrx_Xdeser_Xsh_e3_Xf3_m1 vdd vdd sky130_fd_pr__pfet_01v8 w=1.6 l=0.15
X2173 t_Xrx_Xdeser_Xsh_e3_Xf3_m2 rst_n vdd vdd sky130_fd_pr__pfet_01v8 w=1.6 l=0.15
X2174 t_Xrx_Xdeser_Xsh_e3_Xf3_m3 t_Xrx_Xdeser_Xsh_e3_Xf3_m2 vss vss sky130_fd_pr__nfet_01v8_lvt w=0.45 l=0.15
X2175 t_Xrx_Xdeser_Xsh_e3_Xf3_m3 t_Xrx_Xdeser_Xsh_e3_Xf3_m2 vdd vdd sky130_fd_pr__pfet_01v8 w=1.15 l=0.15
X2176 t_Xrx_Xdeser_Xsh_e3_Xf3_m3 t_Xrx_Xdeser_ck0b t_Xrx_Xdeser_Xsh_e3_Xf3_m1 vss sky130_fd_pr__nfet_01v8_lvt w=0.45 l=0.15
X2177 t_Xrx_Xdeser_Xsh_e3_Xf3_m3 t_Xrx_Xdeser_ck0bb t_Xrx_Xdeser_Xsh_e3_Xf3_m1 vdd sky130_fd_pr__pfet_01v8 w=1.05 l=0.15
X2178 t_Xrx_Xdeser_Xsh_e3_Xf3_m2 t_Xrx_Xdeser_ck0b t_Xrx_Xdeser_Xsh_e3_Xf3_s1 vss sky130_fd_pr__nfet_01v8_lvt w=0.65 l=0.15
X2179 t_Xrx_Xdeser_Xsh_e3_Xf3_m2 t_Xrx_Xdeser_ck0bb t_Xrx_Xdeser_Xsh_e3_Xf3_s1 vdd sky130_fd_pr__pfet_01v8 w=1.8 l=0.15
X2180 t_Xrx_Xdeser_Xsh_e3_Xf3_qi t_Xrx_Xdeser_Xsh_e3_Xf3_s1 vss vss sky130_fd_pr__nfet_01v8_lvt w=0.65 l=0.15
X2181 t_Xrx_Xdeser_Xsh_e3_Xf3_qi t_Xrx_Xdeser_Xsh_e3_Xf3_s1 vdd vdd sky130_fd_pr__pfet_01v8 w=1.65 l=0.15
X2182 t_Xrx_Xdeser_Xsh_e3_Xf3_s2 t_Xrx_Xdeser_Xsh_e3_Xf3_qi t_Xrx_Xdeser_Xsh_e3_Xf3_Xsfb_mid vss sky130_fd_pr__nfet_01v8_lvt w=0.8 l=0.15
X2183 t_Xrx_Xdeser_Xsh_e3_Xf3_Xsfb_mid rst_n vss vss sky130_fd_pr__nfet_01v8_lvt w=0.8 l=0.15
X2184 t_Xrx_Xdeser_Xsh_e3_Xf3_s2 t_Xrx_Xdeser_Xsh_e3_Xf3_qi vdd vdd sky130_fd_pr__pfet_01v8 w=1.4 l=0.15
X2185 t_Xrx_Xdeser_Xsh_e3_Xf3_s2 rst_n vdd vdd sky130_fd_pr__pfet_01v8 w=1.4 l=0.15
X2186 t_Xrx_Xdeser_Xsh_e3_Xf3_s2 t_Xrx_Xdeser_ck0bb t_Xrx_Xdeser_Xsh_e3_Xf3_s1 vss sky130_fd_pr__nfet_01v8_lvt w=0.45 l=0.15
X2187 t_Xrx_Xdeser_Xsh_e3_Xf3_s2 t_Xrx_Xdeser_ck0b t_Xrx_Xdeser_Xsh_e3_Xf3_s1 vdd sky130_fd_pr__pfet_01v8 w=1.05 l=0.15
X2188 t_Xrx_Xdeser_e3_3 t_Xrx_Xdeser_Xsh_e3_Xf3_s1 vss vss sky130_fd_pr__nfet_01v8_lvt w=0.7 l=0.15
X2189 t_Xrx_Xdeser_e3_3 t_Xrx_Xdeser_Xsh_e3_Xf3_s1 vdd vdd sky130_fd_pr__pfet_01v8 w=1.8 l=0.15
X2190 t_Xrx_Xdeser_Xsh_e3_s3b t_Xrx_Xdeser_e3_3 vss vss sky130_fd_pr__nfet_01v8_lvt w=0.55 l=0.15
X2191 t_Xrx_Xdeser_Xsh_e3_s3b t_Xrx_Xdeser_e3_3 vdd vdd sky130_fd_pr__pfet_01v8 w=1.4 l=0.15
X2192 t_Xrx_Xdeser_e3_3 t_Xrx_Xdeser_ck0bb t_Xrx_Xdeser_Xe3_4_m1 vss sky130_fd_pr__nfet_01v8_lvt w=0.65 l=0.15
X2193 t_Xrx_Xdeser_e3_3 t_Xrx_Xdeser_ck0b t_Xrx_Xdeser_Xe3_4_m1 vdd sky130_fd_pr__pfet_01v8 w=1.8 l=0.15
X2194 t_Xrx_Xdeser_Xe3_4_m2 t_Xrx_Xdeser_Xe3_4_m1 t_Xrx_Xdeser_Xe3_4_Xm2_mid vss sky130_fd_pr__nfet_01v8_lvt w=0.9 l=0.15
X2195 t_Xrx_Xdeser_Xe3_4_Xm2_mid rst_n vss vss sky130_fd_pr__nfet_01v8_lvt w=0.9 l=0.15
X2196 t_Xrx_Xdeser_Xe3_4_m2 t_Xrx_Xdeser_Xe3_4_m1 vdd vdd sky130_fd_pr__pfet_01v8 w=1.6 l=0.15
X2197 t_Xrx_Xdeser_Xe3_4_m2 rst_n vdd vdd sky130_fd_pr__pfet_01v8 w=1.6 l=0.15
X2198 t_Xrx_Xdeser_Xe3_4_m3 t_Xrx_Xdeser_Xe3_4_m2 vss vss sky130_fd_pr__nfet_01v8_lvt w=0.45 l=0.15
X2199 t_Xrx_Xdeser_Xe3_4_m3 t_Xrx_Xdeser_Xe3_4_m2 vdd vdd sky130_fd_pr__pfet_01v8 w=1.15 l=0.15
X2200 t_Xrx_Xdeser_Xe3_4_m3 t_Xrx_Xdeser_ck0b t_Xrx_Xdeser_Xe3_4_m1 vss sky130_fd_pr__nfet_01v8_lvt w=0.45 l=0.15
X2201 t_Xrx_Xdeser_Xe3_4_m3 t_Xrx_Xdeser_ck0bb t_Xrx_Xdeser_Xe3_4_m1 vdd sky130_fd_pr__pfet_01v8 w=1.05 l=0.15
X2202 t_Xrx_Xdeser_Xe3_4_m2 t_Xrx_Xdeser_ck0b t_Xrx_Xdeser_Xe3_4_s1 vss sky130_fd_pr__nfet_01v8_lvt w=0.65 l=0.15
X2203 t_Xrx_Xdeser_Xe3_4_m2 t_Xrx_Xdeser_ck0bb t_Xrx_Xdeser_Xe3_4_s1 vdd sky130_fd_pr__pfet_01v8 w=1.8 l=0.15
X2204 t_Xrx_Xdeser_Xe3_4_qi t_Xrx_Xdeser_Xe3_4_s1 vss vss sky130_fd_pr__nfet_01v8_lvt w=0.65 l=0.15
X2205 t_Xrx_Xdeser_Xe3_4_qi t_Xrx_Xdeser_Xe3_4_s1 vdd vdd sky130_fd_pr__pfet_01v8 w=1.65 l=0.15
X2206 t_Xrx_Xdeser_Xe3_4_s2 t_Xrx_Xdeser_Xe3_4_qi t_Xrx_Xdeser_Xe3_4_Xsfb_mid vss sky130_fd_pr__nfet_01v8_lvt w=0.8 l=0.15
X2207 t_Xrx_Xdeser_Xe3_4_Xsfb_mid rst_n vss vss sky130_fd_pr__nfet_01v8_lvt w=0.8 l=0.15
X2208 t_Xrx_Xdeser_Xe3_4_s2 t_Xrx_Xdeser_Xe3_4_qi vdd vdd sky130_fd_pr__pfet_01v8 w=1.4 l=0.15
X2209 t_Xrx_Xdeser_Xe3_4_s2 rst_n vdd vdd sky130_fd_pr__pfet_01v8 w=1.4 l=0.15
X2210 t_Xrx_Xdeser_Xe3_4_s2 t_Xrx_Xdeser_ck0bb t_Xrx_Xdeser_Xe3_4_s1 vss sky130_fd_pr__nfet_01v8_lvt w=0.45 l=0.15
X2211 t_Xrx_Xdeser_Xe3_4_s2 t_Xrx_Xdeser_ck0b t_Xrx_Xdeser_Xe3_4_s1 vdd sky130_fd_pr__pfet_01v8 w=1.05 l=0.15
X2212 t_Xrx_Xdeser_e3_4 t_Xrx_Xdeser_Xe3_4_s1 vss vss sky130_fd_pr__nfet_01v8_lvt w=0.7 l=0.15
X2213 t_Xrx_Xdeser_e3_4 t_Xrx_Xdeser_Xe3_4_s1 vdd vdd sky130_fd_pr__pfet_01v8 w=1.8 l=0.15
X2214 t_Xrx_Xdeser_e3_4b t_Xrx_Xdeser_e3_4 vss vss sky130_fd_pr__nfet_01v8_lvt w=0.55 l=0.15
X2215 t_Xrx_Xdeser_e3_4b t_Xrx_Xdeser_e3_4 vdd vdd sky130_fd_pr__pfet_01v8 w=1.4 l=0.15
X2216 t_Xrx_Xdeser_j1b t_Xrx_Xdeser_ck0b t_Xrx_Xdeser_Xj0_m1 vss sky130_fd_pr__nfet_01v8_lvt w=0.65 l=0.15
X2217 t_Xrx_Xdeser_j1b t_Xrx_Xdeser_ck0bb t_Xrx_Xdeser_Xj0_m1 vdd sky130_fd_pr__pfet_01v8 w=1.8 l=0.15
X2218 t_Xrx_Xdeser_Xj0_m2 t_Xrx_Xdeser_Xj0_m1 t_Xrx_Xdeser_Xj0_Xm2_mid vss sky130_fd_pr__nfet_01v8_lvt w=0.9 l=0.15
X2219 t_Xrx_Xdeser_Xj0_Xm2_mid rst_n vss vss sky130_fd_pr__nfet_01v8_lvt w=0.9 l=0.15
X2220 t_Xrx_Xdeser_Xj0_m2 t_Xrx_Xdeser_Xj0_m1 vdd vdd sky130_fd_pr__pfet_01v8 w=1.6 l=0.15
X2221 t_Xrx_Xdeser_Xj0_m2 rst_n vdd vdd sky130_fd_pr__pfet_01v8 w=1.6 l=0.15
X2222 t_Xrx_Xdeser_Xj0_m3 t_Xrx_Xdeser_Xj0_m2 vss vss sky130_fd_pr__nfet_01v8_lvt w=0.45 l=0.15
X2223 t_Xrx_Xdeser_Xj0_m3 t_Xrx_Xdeser_Xj0_m2 vdd vdd sky130_fd_pr__pfet_01v8 w=1.15 l=0.15
X2224 t_Xrx_Xdeser_Xj0_m3 t_Xrx_Xdeser_ck0bb t_Xrx_Xdeser_Xj0_m1 vss sky130_fd_pr__nfet_01v8_lvt w=0.45 l=0.15
X2225 t_Xrx_Xdeser_Xj0_m3 t_Xrx_Xdeser_ck0b t_Xrx_Xdeser_Xj0_m1 vdd sky130_fd_pr__pfet_01v8 w=1.05 l=0.15
X2226 t_Xrx_Xdeser_Xj0_m2 t_Xrx_Xdeser_ck0bb t_Xrx_Xdeser_Xj0_s1 vss sky130_fd_pr__nfet_01v8_lvt w=0.65 l=0.15
X2227 t_Xrx_Xdeser_Xj0_m2 t_Xrx_Xdeser_ck0b t_Xrx_Xdeser_Xj0_s1 vdd sky130_fd_pr__pfet_01v8 w=1.8 l=0.15
X2228 t_Xrx_Xdeser_Xj0_qi t_Xrx_Xdeser_Xj0_s1 vss vss sky130_fd_pr__nfet_01v8_lvt w=0.65 l=0.15
X2229 t_Xrx_Xdeser_Xj0_qi t_Xrx_Xdeser_Xj0_s1 vdd vdd sky130_fd_pr__pfet_01v8 w=1.65 l=0.15
X2230 t_Xrx_Xdeser_Xj0_s2 t_Xrx_Xdeser_Xj0_qi t_Xrx_Xdeser_Xj0_Xsfb_mid vss sky130_fd_pr__nfet_01v8_lvt w=0.8 l=0.15
X2231 t_Xrx_Xdeser_Xj0_Xsfb_mid rst_n vss vss sky130_fd_pr__nfet_01v8_lvt w=0.8 l=0.15
X2232 t_Xrx_Xdeser_Xj0_s2 t_Xrx_Xdeser_Xj0_qi vdd vdd sky130_fd_pr__pfet_01v8 w=1.4 l=0.15
X2233 t_Xrx_Xdeser_Xj0_s2 rst_n vdd vdd sky130_fd_pr__pfet_01v8 w=1.4 l=0.15
X2234 t_Xrx_Xdeser_Xj0_s2 t_Xrx_Xdeser_ck0b t_Xrx_Xdeser_Xj0_s1 vss sky130_fd_pr__nfet_01v8_lvt w=0.45 l=0.15
X2235 t_Xrx_Xdeser_Xj0_s2 t_Xrx_Xdeser_ck0bb t_Xrx_Xdeser_Xj0_s1 vdd sky130_fd_pr__pfet_01v8 w=1.05 l=0.15
X2236 t_Xrx_Xdeser_j0 t_Xrx_Xdeser_Xj0_s1 vss vss sky130_fd_pr__nfet_01v8_lvt w=0.7 l=0.15
X2237 t_Xrx_Xdeser_j0 t_Xrx_Xdeser_Xj0_s1 vdd vdd sky130_fd_pr__pfet_01v8 w=1.8 l=0.15
X2238 t_Xrx_Xdeser_j0b t_Xrx_Xdeser_j0 vss vss sky130_fd_pr__nfet_01v8_lvt w=0.55 l=0.15
X2239 t_Xrx_Xdeser_j0b t_Xrx_Xdeser_j0 vdd vdd sky130_fd_pr__pfet_01v8 w=1.4 l=0.15
X2240 t_Xrx_Xdeser_j0 t_Xrx_Xdeser_ck0b t_Xrx_Xdeser_Xj1_m1 vss sky130_fd_pr__nfet_01v8_lvt w=0.65 l=0.15
X2241 t_Xrx_Xdeser_j0 t_Xrx_Xdeser_ck0bb t_Xrx_Xdeser_Xj1_m1 vdd sky130_fd_pr__pfet_01v8 w=1.8 l=0.15
X2242 t_Xrx_Xdeser_Xj1_m2 t_Xrx_Xdeser_Xj1_m1 t_Xrx_Xdeser_Xj1_Xm2_mid vss sky130_fd_pr__nfet_01v8_lvt w=0.9 l=0.15
X2243 t_Xrx_Xdeser_Xj1_Xm2_mid rst_n vss vss sky130_fd_pr__nfet_01v8_lvt w=0.9 l=0.15
X2244 t_Xrx_Xdeser_Xj1_m2 t_Xrx_Xdeser_Xj1_m1 vdd vdd sky130_fd_pr__pfet_01v8 w=1.6 l=0.15
X2245 t_Xrx_Xdeser_Xj1_m2 rst_n vdd vdd sky130_fd_pr__pfet_01v8 w=1.6 l=0.15
X2246 t_Xrx_Xdeser_Xj1_m3 t_Xrx_Xdeser_Xj1_m2 vss vss sky130_fd_pr__nfet_01v8_lvt w=0.45 l=0.15
X2247 t_Xrx_Xdeser_Xj1_m3 t_Xrx_Xdeser_Xj1_m2 vdd vdd sky130_fd_pr__pfet_01v8 w=1.15 l=0.15
X2248 t_Xrx_Xdeser_Xj1_m3 t_Xrx_Xdeser_ck0bb t_Xrx_Xdeser_Xj1_m1 vss sky130_fd_pr__nfet_01v8_lvt w=0.45 l=0.15
X2249 t_Xrx_Xdeser_Xj1_m3 t_Xrx_Xdeser_ck0b t_Xrx_Xdeser_Xj1_m1 vdd sky130_fd_pr__pfet_01v8 w=1.05 l=0.15
X2250 t_Xrx_Xdeser_Xj1_m2 t_Xrx_Xdeser_ck0bb t_Xrx_Xdeser_Xj1_s1 vss sky130_fd_pr__nfet_01v8_lvt w=0.65 l=0.15
X2251 t_Xrx_Xdeser_Xj1_m2 t_Xrx_Xdeser_ck0b t_Xrx_Xdeser_Xj1_s1 vdd sky130_fd_pr__pfet_01v8 w=1.8 l=0.15
X2252 t_Xrx_Xdeser_Xj1_qi t_Xrx_Xdeser_Xj1_s1 vss vss sky130_fd_pr__nfet_01v8_lvt w=0.65 l=0.15
X2253 t_Xrx_Xdeser_Xj1_qi t_Xrx_Xdeser_Xj1_s1 vdd vdd sky130_fd_pr__pfet_01v8 w=1.65 l=0.15
X2254 t_Xrx_Xdeser_Xj1_s2 t_Xrx_Xdeser_Xj1_qi t_Xrx_Xdeser_Xj1_Xsfb_mid vss sky130_fd_pr__nfet_01v8_lvt w=0.8 l=0.15
X2255 t_Xrx_Xdeser_Xj1_Xsfb_mid rst_n vss vss sky130_fd_pr__nfet_01v8_lvt w=0.8 l=0.15
X2256 t_Xrx_Xdeser_Xj1_s2 t_Xrx_Xdeser_Xj1_qi vdd vdd sky130_fd_pr__pfet_01v8 w=1.4 l=0.15
X2257 t_Xrx_Xdeser_Xj1_s2 rst_n vdd vdd sky130_fd_pr__pfet_01v8 w=1.4 l=0.15
X2258 t_Xrx_Xdeser_Xj1_s2 t_Xrx_Xdeser_ck0b t_Xrx_Xdeser_Xj1_s1 vss sky130_fd_pr__nfet_01v8_lvt w=0.45 l=0.15
X2259 t_Xrx_Xdeser_Xj1_s2 t_Xrx_Xdeser_ck0bb t_Xrx_Xdeser_Xj1_s1 vdd sky130_fd_pr__pfet_01v8 w=1.05 l=0.15
X2260 t_Xrx_Xdeser_j1 t_Xrx_Xdeser_Xj1_s1 vss vss sky130_fd_pr__nfet_01v8_lvt w=0.7 l=0.15
X2261 t_Xrx_Xdeser_j1 t_Xrx_Xdeser_Xj1_s1 vdd vdd sky130_fd_pr__pfet_01v8 w=1.8 l=0.15
X2262 t_Xrx_Xdeser_j1b t_Xrx_Xdeser_j1 vss vss sky130_fd_pr__nfet_01v8_lvt w=0.55 l=0.15
X2263 t_Xrx_Xdeser_j1b t_Xrx_Xdeser_j1 vdd vdd sky130_fd_pr__pfet_01v8 w=1.4 l=0.15
X2264 t_Xrx_Xdeser_wcapb_i t_Xrx_Xdeser_j0 vss vss sky130_fd_pr__nfet_01v8_lvt w=1.4 l=0.15
X2265 t_Xrx_Xdeser_wcapb_i t_Xrx_Xdeser_j0 vdd vdd sky130_fd_pr__pfet_01v8 w=3.4 l=0.15
X2266 t_Xrx_Xdeser_wcap t_Xrx_Xdeser_wcapb_i vss vss sky130_fd_pr__nfet_01v8_lvt w=2.4 l=0.15
X2267 t_Xrx_Xdeser_wcap t_Xrx_Xdeser_wcapb_i vdd vdd sky130_fd_pr__pfet_01v8 w=5.8 l=0.15
X2268 t_Xrx_Xdeser_wcap_i t_Xrx_Xdeser_j0b vss vss sky130_fd_pr__nfet_01v8_lvt w=1.4 l=0.15
X2269 t_Xrx_Xdeser_wcap_i t_Xrx_Xdeser_j0b vdd vdd sky130_fd_pr__pfet_01v8 w=3.4 l=0.15
X2270 t_Xrx_Xdeser_wcapb t_Xrx_Xdeser_wcap_i vss vss sky130_fd_pr__nfet_01v8_lvt w=2.4 l=0.15
X2271 t_Xrx_Xdeser_wcapb t_Xrx_Xdeser_wcap_i vdd vdd sky130_fd_pr__pfet_01v8 w=5.8 l=0.15
X2272 t_Xrx_Xdeser_wcapb t_Xrx_Xdeser_wcap vss vss sky130_fd_pr__nfet_01v8_lvt w=0.45 l=0.15
X2273 t_Xrx_Xdeser_wcapb t_Xrx_Xdeser_wcap vdd vdd sky130_fd_pr__pfet_01v8 w=1.1 l=0.15
X2274 t_Xrx_Xdeser_wcap t_Xrx_Xdeser_wcapb vss vss sky130_fd_pr__nfet_01v8_lvt w=0.45 l=0.15
X2275 t_Xrx_Xdeser_wcap t_Xrx_Xdeser_wcapb vdd vdd sky130_fd_pr__pfet_01v8 w=1.1 l=0.15
X2276 t_Xrx_Xdeser_wclk_b t_Xrx_Xdeser_j0b vss vss sky130_fd_pr__nfet_01v8_lvt w=1 l=0.15
X2277 t_Xrx_Xdeser_wclk_b t_Xrx_Xdeser_j0b vdd vdd sky130_fd_pr__pfet_01v8 w=2.4 l=0.15
X2278 wclk t_Xrx_Xdeser_wclk_b vss vss sky130_fd_pr__nfet_01v8_lvt w=1.6 l=0.15
X2279 wclk t_Xrx_Xdeser_wclk_b vdd vdd sky130_fd_pr__pfet_01v8 w=3.8 l=0.15
X2280 t_Xrx_Xdeser_d0_3 t_Xrx_Xdeser_wcapb t_Xrx_Xdeser_Xwd0_m1 vss sky130_fd_pr__nfet_01v8 w=0.5 l=0.18
X2281 t_Xrx_Xdeser_d0_3 t_Xrx_Xdeser_wcap t_Xrx_Xdeser_Xwd0_m1 vdd sky130_fd_pr__pfet_01v8 w=1 l=0.18
X2282 t_Xrx_Xdeser_Xwd0_m2 t_Xrx_Xdeser_Xwd0_m1 t_Xrx_Xdeser_Xwd0_Xm2_mid vss sky130_fd_pr__nfet_01v8 w=0.75 l=0.18
X2283 t_Xrx_Xdeser_Xwd0_Xm2_mid rst_n vss vss sky130_fd_pr__nfet_01v8 w=0.75 l=0.18
X2284 t_Xrx_Xdeser_Xwd0_m2 t_Xrx_Xdeser_Xwd0_m1 vdd vdd sky130_fd_pr__pfet_01v8 w=1 l=0.18
X2285 t_Xrx_Xdeser_Xwd0_m2 rst_n vdd vdd sky130_fd_pr__pfet_01v8 w=1 l=0.18
X2286 t_Xrx_Xdeser_Xwd0_m3 t_Xrx_Xdeser_Xwd0_m2 vss vss sky130_fd_pr__nfet_01v8 w=0.45 l=0.18
X2287 t_Xrx_Xdeser_Xwd0_m3 t_Xrx_Xdeser_Xwd0_m2 vdd vdd sky130_fd_pr__pfet_01v8 w=0.9 l=0.18
X2288 t_Xrx_Xdeser_Xwd0_m3 t_Xrx_Xdeser_wcap t_Xrx_Xdeser_Xwd0_m1 vss sky130_fd_pr__nfet_01v8 w=0.45 l=0.18
X2289 t_Xrx_Xdeser_Xwd0_m3 t_Xrx_Xdeser_wcapb t_Xrx_Xdeser_Xwd0_m1 vdd sky130_fd_pr__pfet_01v8 w=0.9 l=0.18
X2290 t_Xrx_Xdeser_Xwd0_m2 t_Xrx_Xdeser_wcap t_Xrx_Xdeser_Xwd0_s1 vss sky130_fd_pr__nfet_01v8 w=0.5 l=0.18
X2291 t_Xrx_Xdeser_Xwd0_m2 t_Xrx_Xdeser_wcapb t_Xrx_Xdeser_Xwd0_s1 vdd sky130_fd_pr__pfet_01v8 w=1 l=0.18
X2292 t_Xrx_Xdeser_Xwd0_qi t_Xrx_Xdeser_Xwd0_s1 vss vss sky130_fd_pr__nfet_01v8 w=0.55 l=0.18
X2293 t_Xrx_Xdeser_Xwd0_qi t_Xrx_Xdeser_Xwd0_s1 vdd vdd sky130_fd_pr__pfet_01v8 w=1.2 l=0.18
X2294 t_Xrx_Xdeser_Xwd0_s2 t_Xrx_Xdeser_Xwd0_qi t_Xrx_Xdeser_Xwd0_Xsfb_mid vss sky130_fd_pr__nfet_01v8 w=0.7 l=0.18
X2295 t_Xrx_Xdeser_Xwd0_Xsfb_mid rst_n vss vss sky130_fd_pr__nfet_01v8 w=0.7 l=0.18
X2296 t_Xrx_Xdeser_Xwd0_s2 t_Xrx_Xdeser_Xwd0_qi vdd vdd sky130_fd_pr__pfet_01v8 w=0.95 l=0.18
X2297 t_Xrx_Xdeser_Xwd0_s2 rst_n vdd vdd sky130_fd_pr__pfet_01v8 w=0.95 l=0.18
X2298 t_Xrx_Xdeser_Xwd0_s2 t_Xrx_Xdeser_wcapb t_Xrx_Xdeser_Xwd0_s1 vss sky130_fd_pr__nfet_01v8 w=0.45 l=0.18
X2299 t_Xrx_Xdeser_Xwd0_s2 t_Xrx_Xdeser_wcap t_Xrx_Xdeser_Xwd0_s1 vdd sky130_fd_pr__pfet_01v8 w=0.9 l=0.18
X2300 wd0 t_Xrx_Xdeser_Xwd0_s1 vss vss sky130_fd_pr__nfet_01v8 w=0.75 l=0.18
X2301 wd0 t_Xrx_Xdeser_Xwd0_s1 vdd vdd sky130_fd_pr__pfet_01v8 w=1.6 l=0.18
X2302 t_Xrx_Xdeser_d1_3 t_Xrx_Xdeser_wcapb t_Xrx_Xdeser_Xwd1_m1 vss sky130_fd_pr__nfet_01v8 w=0.5 l=0.18
X2303 t_Xrx_Xdeser_d1_3 t_Xrx_Xdeser_wcap t_Xrx_Xdeser_Xwd1_m1 vdd sky130_fd_pr__pfet_01v8 w=1 l=0.18
X2304 t_Xrx_Xdeser_Xwd1_m2 t_Xrx_Xdeser_Xwd1_m1 t_Xrx_Xdeser_Xwd1_Xm2_mid vss sky130_fd_pr__nfet_01v8 w=0.75 l=0.18
X2305 t_Xrx_Xdeser_Xwd1_Xm2_mid rst_n vss vss sky130_fd_pr__nfet_01v8 w=0.75 l=0.18
X2306 t_Xrx_Xdeser_Xwd1_m2 t_Xrx_Xdeser_Xwd1_m1 vdd vdd sky130_fd_pr__pfet_01v8 w=1 l=0.18
X2307 t_Xrx_Xdeser_Xwd1_m2 rst_n vdd vdd sky130_fd_pr__pfet_01v8 w=1 l=0.18
X2308 t_Xrx_Xdeser_Xwd1_m3 t_Xrx_Xdeser_Xwd1_m2 vss vss sky130_fd_pr__nfet_01v8 w=0.45 l=0.18
X2309 t_Xrx_Xdeser_Xwd1_m3 t_Xrx_Xdeser_Xwd1_m2 vdd vdd sky130_fd_pr__pfet_01v8 w=0.9 l=0.18
X2310 t_Xrx_Xdeser_Xwd1_m3 t_Xrx_Xdeser_wcap t_Xrx_Xdeser_Xwd1_m1 vss sky130_fd_pr__nfet_01v8 w=0.45 l=0.18
X2311 t_Xrx_Xdeser_Xwd1_m3 t_Xrx_Xdeser_wcapb t_Xrx_Xdeser_Xwd1_m1 vdd sky130_fd_pr__pfet_01v8 w=0.9 l=0.18
X2312 t_Xrx_Xdeser_Xwd1_m2 t_Xrx_Xdeser_wcap t_Xrx_Xdeser_Xwd1_s1 vss sky130_fd_pr__nfet_01v8 w=0.5 l=0.18
X2313 t_Xrx_Xdeser_Xwd1_m2 t_Xrx_Xdeser_wcapb t_Xrx_Xdeser_Xwd1_s1 vdd sky130_fd_pr__pfet_01v8 w=1 l=0.18
X2314 t_Xrx_Xdeser_Xwd1_qi t_Xrx_Xdeser_Xwd1_s1 vss vss sky130_fd_pr__nfet_01v8 w=0.55 l=0.18
X2315 t_Xrx_Xdeser_Xwd1_qi t_Xrx_Xdeser_Xwd1_s1 vdd vdd sky130_fd_pr__pfet_01v8 w=1.2 l=0.18
X2316 t_Xrx_Xdeser_Xwd1_s2 t_Xrx_Xdeser_Xwd1_qi t_Xrx_Xdeser_Xwd1_Xsfb_mid vss sky130_fd_pr__nfet_01v8 w=0.7 l=0.18
X2317 t_Xrx_Xdeser_Xwd1_Xsfb_mid rst_n vss vss sky130_fd_pr__nfet_01v8 w=0.7 l=0.18
X2318 t_Xrx_Xdeser_Xwd1_s2 t_Xrx_Xdeser_Xwd1_qi vdd vdd sky130_fd_pr__pfet_01v8 w=0.95 l=0.18
X2319 t_Xrx_Xdeser_Xwd1_s2 rst_n vdd vdd sky130_fd_pr__pfet_01v8 w=0.95 l=0.18
X2320 t_Xrx_Xdeser_Xwd1_s2 t_Xrx_Xdeser_wcapb t_Xrx_Xdeser_Xwd1_s1 vss sky130_fd_pr__nfet_01v8 w=0.45 l=0.18
X2321 t_Xrx_Xdeser_Xwd1_s2 t_Xrx_Xdeser_wcap t_Xrx_Xdeser_Xwd1_s1 vdd sky130_fd_pr__pfet_01v8 w=0.9 l=0.18
X2322 wd1 t_Xrx_Xdeser_Xwd1_s1 vss vss sky130_fd_pr__nfet_01v8 w=0.75 l=0.18
X2323 wd1 t_Xrx_Xdeser_Xwd1_s1 vdd vdd sky130_fd_pr__pfet_01v8 w=1.6 l=0.18
X2324 t_Xrx_Xdeser_d2_3 t_Xrx_Xdeser_wcapb t_Xrx_Xdeser_Xwd2_m1 vss sky130_fd_pr__nfet_01v8 w=0.5 l=0.18
X2325 t_Xrx_Xdeser_d2_3 t_Xrx_Xdeser_wcap t_Xrx_Xdeser_Xwd2_m1 vdd sky130_fd_pr__pfet_01v8 w=1 l=0.18
X2326 t_Xrx_Xdeser_Xwd2_m2 t_Xrx_Xdeser_Xwd2_m1 t_Xrx_Xdeser_Xwd2_Xm2_mid vss sky130_fd_pr__nfet_01v8 w=0.75 l=0.18
X2327 t_Xrx_Xdeser_Xwd2_Xm2_mid rst_n vss vss sky130_fd_pr__nfet_01v8 w=0.75 l=0.18
X2328 t_Xrx_Xdeser_Xwd2_m2 t_Xrx_Xdeser_Xwd2_m1 vdd vdd sky130_fd_pr__pfet_01v8 w=1 l=0.18
X2329 t_Xrx_Xdeser_Xwd2_m2 rst_n vdd vdd sky130_fd_pr__pfet_01v8 w=1 l=0.18
X2330 t_Xrx_Xdeser_Xwd2_m3 t_Xrx_Xdeser_Xwd2_m2 vss vss sky130_fd_pr__nfet_01v8 w=0.45 l=0.18
X2331 t_Xrx_Xdeser_Xwd2_m3 t_Xrx_Xdeser_Xwd2_m2 vdd vdd sky130_fd_pr__pfet_01v8 w=0.9 l=0.18
X2332 t_Xrx_Xdeser_Xwd2_m3 t_Xrx_Xdeser_wcap t_Xrx_Xdeser_Xwd2_m1 vss sky130_fd_pr__nfet_01v8 w=0.45 l=0.18
X2333 t_Xrx_Xdeser_Xwd2_m3 t_Xrx_Xdeser_wcapb t_Xrx_Xdeser_Xwd2_m1 vdd sky130_fd_pr__pfet_01v8 w=0.9 l=0.18
X2334 t_Xrx_Xdeser_Xwd2_m2 t_Xrx_Xdeser_wcap t_Xrx_Xdeser_Xwd2_s1 vss sky130_fd_pr__nfet_01v8 w=0.5 l=0.18
X2335 t_Xrx_Xdeser_Xwd2_m2 t_Xrx_Xdeser_wcapb t_Xrx_Xdeser_Xwd2_s1 vdd sky130_fd_pr__pfet_01v8 w=1 l=0.18
X2336 t_Xrx_Xdeser_Xwd2_qi t_Xrx_Xdeser_Xwd2_s1 vss vss sky130_fd_pr__nfet_01v8 w=0.55 l=0.18
X2337 t_Xrx_Xdeser_Xwd2_qi t_Xrx_Xdeser_Xwd2_s1 vdd vdd sky130_fd_pr__pfet_01v8 w=1.2 l=0.18
X2338 t_Xrx_Xdeser_Xwd2_s2 t_Xrx_Xdeser_Xwd2_qi t_Xrx_Xdeser_Xwd2_Xsfb_mid vss sky130_fd_pr__nfet_01v8 w=0.7 l=0.18
X2339 t_Xrx_Xdeser_Xwd2_Xsfb_mid rst_n vss vss sky130_fd_pr__nfet_01v8 w=0.7 l=0.18
X2340 t_Xrx_Xdeser_Xwd2_s2 t_Xrx_Xdeser_Xwd2_qi vdd vdd sky130_fd_pr__pfet_01v8 w=0.95 l=0.18
X2341 t_Xrx_Xdeser_Xwd2_s2 rst_n vdd vdd sky130_fd_pr__pfet_01v8 w=0.95 l=0.18
X2342 t_Xrx_Xdeser_Xwd2_s2 t_Xrx_Xdeser_wcapb t_Xrx_Xdeser_Xwd2_s1 vss sky130_fd_pr__nfet_01v8 w=0.45 l=0.18
X2343 t_Xrx_Xdeser_Xwd2_s2 t_Xrx_Xdeser_wcap t_Xrx_Xdeser_Xwd2_s1 vdd sky130_fd_pr__pfet_01v8 w=0.9 l=0.18
X2344 wd2 t_Xrx_Xdeser_Xwd2_s1 vss vss sky130_fd_pr__nfet_01v8 w=0.75 l=0.18
X2345 wd2 t_Xrx_Xdeser_Xwd2_s1 vdd vdd sky130_fd_pr__pfet_01v8 w=1.6 l=0.18
X2346 t_Xrx_Xdeser_d3_3 t_Xrx_Xdeser_wcapb t_Xrx_Xdeser_Xwd3_m1 vss sky130_fd_pr__nfet_01v8 w=0.5 l=0.18
X2347 t_Xrx_Xdeser_d3_3 t_Xrx_Xdeser_wcap t_Xrx_Xdeser_Xwd3_m1 vdd sky130_fd_pr__pfet_01v8 w=1 l=0.18
X2348 t_Xrx_Xdeser_Xwd3_m2 t_Xrx_Xdeser_Xwd3_m1 t_Xrx_Xdeser_Xwd3_Xm2_mid vss sky130_fd_pr__nfet_01v8 w=0.75 l=0.18
X2349 t_Xrx_Xdeser_Xwd3_Xm2_mid rst_n vss vss sky130_fd_pr__nfet_01v8 w=0.75 l=0.18
X2350 t_Xrx_Xdeser_Xwd3_m2 t_Xrx_Xdeser_Xwd3_m1 vdd vdd sky130_fd_pr__pfet_01v8 w=1 l=0.18
X2351 t_Xrx_Xdeser_Xwd3_m2 rst_n vdd vdd sky130_fd_pr__pfet_01v8 w=1 l=0.18
X2352 t_Xrx_Xdeser_Xwd3_m3 t_Xrx_Xdeser_Xwd3_m2 vss vss sky130_fd_pr__nfet_01v8 w=0.45 l=0.18
X2353 t_Xrx_Xdeser_Xwd3_m3 t_Xrx_Xdeser_Xwd3_m2 vdd vdd sky130_fd_pr__pfet_01v8 w=0.9 l=0.18
X2354 t_Xrx_Xdeser_Xwd3_m3 t_Xrx_Xdeser_wcap t_Xrx_Xdeser_Xwd3_m1 vss sky130_fd_pr__nfet_01v8 w=0.45 l=0.18
X2355 t_Xrx_Xdeser_Xwd3_m3 t_Xrx_Xdeser_wcapb t_Xrx_Xdeser_Xwd3_m1 vdd sky130_fd_pr__pfet_01v8 w=0.9 l=0.18
X2356 t_Xrx_Xdeser_Xwd3_m2 t_Xrx_Xdeser_wcap t_Xrx_Xdeser_Xwd3_s1 vss sky130_fd_pr__nfet_01v8 w=0.5 l=0.18
X2357 t_Xrx_Xdeser_Xwd3_m2 t_Xrx_Xdeser_wcapb t_Xrx_Xdeser_Xwd3_s1 vdd sky130_fd_pr__pfet_01v8 w=1 l=0.18
X2358 t_Xrx_Xdeser_Xwd3_qi t_Xrx_Xdeser_Xwd3_s1 vss vss sky130_fd_pr__nfet_01v8 w=0.55 l=0.18
X2359 t_Xrx_Xdeser_Xwd3_qi t_Xrx_Xdeser_Xwd3_s1 vdd vdd sky130_fd_pr__pfet_01v8 w=1.2 l=0.18
X2360 t_Xrx_Xdeser_Xwd3_s2 t_Xrx_Xdeser_Xwd3_qi t_Xrx_Xdeser_Xwd3_Xsfb_mid vss sky130_fd_pr__nfet_01v8 w=0.7 l=0.18
X2361 t_Xrx_Xdeser_Xwd3_Xsfb_mid rst_n vss vss sky130_fd_pr__nfet_01v8 w=0.7 l=0.18
X2362 t_Xrx_Xdeser_Xwd3_s2 t_Xrx_Xdeser_Xwd3_qi vdd vdd sky130_fd_pr__pfet_01v8 w=0.95 l=0.18
X2363 t_Xrx_Xdeser_Xwd3_s2 rst_n vdd vdd sky130_fd_pr__pfet_01v8 w=0.95 l=0.18
X2364 t_Xrx_Xdeser_Xwd3_s2 t_Xrx_Xdeser_wcapb t_Xrx_Xdeser_Xwd3_s1 vss sky130_fd_pr__nfet_01v8 w=0.45 l=0.18
X2365 t_Xrx_Xdeser_Xwd3_s2 t_Xrx_Xdeser_wcap t_Xrx_Xdeser_Xwd3_s1 vdd sky130_fd_pr__pfet_01v8 w=0.9 l=0.18
X2366 wd3 t_Xrx_Xdeser_Xwd3_s1 vss vss sky130_fd_pr__nfet_01v8 w=0.75 l=0.18
X2367 wd3 t_Xrx_Xdeser_Xwd3_s1 vdd vdd sky130_fd_pr__pfet_01v8 w=1.6 l=0.18
X2368 t_Xrx_Xdeser_d0_2 t_Xrx_Xdeser_wcapb t_Xrx_Xdeser_Xwd4_m1 vss sky130_fd_pr__nfet_01v8 w=0.5 l=0.18
X2369 t_Xrx_Xdeser_d0_2 t_Xrx_Xdeser_wcap t_Xrx_Xdeser_Xwd4_m1 vdd sky130_fd_pr__pfet_01v8 w=1 l=0.18
X2370 t_Xrx_Xdeser_Xwd4_m2 t_Xrx_Xdeser_Xwd4_m1 t_Xrx_Xdeser_Xwd4_Xm2_mid vss sky130_fd_pr__nfet_01v8 w=0.75 l=0.18
X2371 t_Xrx_Xdeser_Xwd4_Xm2_mid rst_n vss vss sky130_fd_pr__nfet_01v8 w=0.75 l=0.18
X2372 t_Xrx_Xdeser_Xwd4_m2 t_Xrx_Xdeser_Xwd4_m1 vdd vdd sky130_fd_pr__pfet_01v8 w=1 l=0.18
X2373 t_Xrx_Xdeser_Xwd4_m2 rst_n vdd vdd sky130_fd_pr__pfet_01v8 w=1 l=0.18
X2374 t_Xrx_Xdeser_Xwd4_m3 t_Xrx_Xdeser_Xwd4_m2 vss vss sky130_fd_pr__nfet_01v8 w=0.45 l=0.18
X2375 t_Xrx_Xdeser_Xwd4_m3 t_Xrx_Xdeser_Xwd4_m2 vdd vdd sky130_fd_pr__pfet_01v8 w=0.9 l=0.18
X2376 t_Xrx_Xdeser_Xwd4_m3 t_Xrx_Xdeser_wcap t_Xrx_Xdeser_Xwd4_m1 vss sky130_fd_pr__nfet_01v8 w=0.45 l=0.18
X2377 t_Xrx_Xdeser_Xwd4_m3 t_Xrx_Xdeser_wcapb t_Xrx_Xdeser_Xwd4_m1 vdd sky130_fd_pr__pfet_01v8 w=0.9 l=0.18
X2378 t_Xrx_Xdeser_Xwd4_m2 t_Xrx_Xdeser_wcap t_Xrx_Xdeser_Xwd4_s1 vss sky130_fd_pr__nfet_01v8 w=0.5 l=0.18
X2379 t_Xrx_Xdeser_Xwd4_m2 t_Xrx_Xdeser_wcapb t_Xrx_Xdeser_Xwd4_s1 vdd sky130_fd_pr__pfet_01v8 w=1 l=0.18
X2380 t_Xrx_Xdeser_Xwd4_qi t_Xrx_Xdeser_Xwd4_s1 vss vss sky130_fd_pr__nfet_01v8 w=0.55 l=0.18
X2381 t_Xrx_Xdeser_Xwd4_qi t_Xrx_Xdeser_Xwd4_s1 vdd vdd sky130_fd_pr__pfet_01v8 w=1.2 l=0.18
X2382 t_Xrx_Xdeser_Xwd4_s2 t_Xrx_Xdeser_Xwd4_qi t_Xrx_Xdeser_Xwd4_Xsfb_mid vss sky130_fd_pr__nfet_01v8 w=0.7 l=0.18
X2383 t_Xrx_Xdeser_Xwd4_Xsfb_mid rst_n vss vss sky130_fd_pr__nfet_01v8 w=0.7 l=0.18
X2384 t_Xrx_Xdeser_Xwd4_s2 t_Xrx_Xdeser_Xwd4_qi vdd vdd sky130_fd_pr__pfet_01v8 w=0.95 l=0.18
X2385 t_Xrx_Xdeser_Xwd4_s2 rst_n vdd vdd sky130_fd_pr__pfet_01v8 w=0.95 l=0.18
X2386 t_Xrx_Xdeser_Xwd4_s2 t_Xrx_Xdeser_wcapb t_Xrx_Xdeser_Xwd4_s1 vss sky130_fd_pr__nfet_01v8 w=0.45 l=0.18
X2387 t_Xrx_Xdeser_Xwd4_s2 t_Xrx_Xdeser_wcap t_Xrx_Xdeser_Xwd4_s1 vdd sky130_fd_pr__pfet_01v8 w=0.9 l=0.18
X2388 wd4 t_Xrx_Xdeser_Xwd4_s1 vss vss sky130_fd_pr__nfet_01v8 w=0.75 l=0.18
X2389 wd4 t_Xrx_Xdeser_Xwd4_s1 vdd vdd sky130_fd_pr__pfet_01v8 w=1.6 l=0.18
X2390 t_Xrx_Xdeser_d1_2 t_Xrx_Xdeser_wcapb t_Xrx_Xdeser_Xwd5_m1 vss sky130_fd_pr__nfet_01v8 w=0.5 l=0.18
X2391 t_Xrx_Xdeser_d1_2 t_Xrx_Xdeser_wcap t_Xrx_Xdeser_Xwd5_m1 vdd sky130_fd_pr__pfet_01v8 w=1 l=0.18
X2392 t_Xrx_Xdeser_Xwd5_m2 t_Xrx_Xdeser_Xwd5_m1 t_Xrx_Xdeser_Xwd5_Xm2_mid vss sky130_fd_pr__nfet_01v8 w=0.75 l=0.18
X2393 t_Xrx_Xdeser_Xwd5_Xm2_mid rst_n vss vss sky130_fd_pr__nfet_01v8 w=0.75 l=0.18
X2394 t_Xrx_Xdeser_Xwd5_m2 t_Xrx_Xdeser_Xwd5_m1 vdd vdd sky130_fd_pr__pfet_01v8 w=1 l=0.18
X2395 t_Xrx_Xdeser_Xwd5_m2 rst_n vdd vdd sky130_fd_pr__pfet_01v8 w=1 l=0.18
X2396 t_Xrx_Xdeser_Xwd5_m3 t_Xrx_Xdeser_Xwd5_m2 vss vss sky130_fd_pr__nfet_01v8 w=0.45 l=0.18
X2397 t_Xrx_Xdeser_Xwd5_m3 t_Xrx_Xdeser_Xwd5_m2 vdd vdd sky130_fd_pr__pfet_01v8 w=0.9 l=0.18
X2398 t_Xrx_Xdeser_Xwd5_m3 t_Xrx_Xdeser_wcap t_Xrx_Xdeser_Xwd5_m1 vss sky130_fd_pr__nfet_01v8 w=0.45 l=0.18
X2399 t_Xrx_Xdeser_Xwd5_m3 t_Xrx_Xdeser_wcapb t_Xrx_Xdeser_Xwd5_m1 vdd sky130_fd_pr__pfet_01v8 w=0.9 l=0.18
X2400 t_Xrx_Xdeser_Xwd5_m2 t_Xrx_Xdeser_wcap t_Xrx_Xdeser_Xwd5_s1 vss sky130_fd_pr__nfet_01v8 w=0.5 l=0.18
X2401 t_Xrx_Xdeser_Xwd5_m2 t_Xrx_Xdeser_wcapb t_Xrx_Xdeser_Xwd5_s1 vdd sky130_fd_pr__pfet_01v8 w=1 l=0.18
X2402 t_Xrx_Xdeser_Xwd5_qi t_Xrx_Xdeser_Xwd5_s1 vss vss sky130_fd_pr__nfet_01v8 w=0.55 l=0.18
X2403 t_Xrx_Xdeser_Xwd5_qi t_Xrx_Xdeser_Xwd5_s1 vdd vdd sky130_fd_pr__pfet_01v8 w=1.2 l=0.18
X2404 t_Xrx_Xdeser_Xwd5_s2 t_Xrx_Xdeser_Xwd5_qi t_Xrx_Xdeser_Xwd5_Xsfb_mid vss sky130_fd_pr__nfet_01v8 w=0.7 l=0.18
X2405 t_Xrx_Xdeser_Xwd5_Xsfb_mid rst_n vss vss sky130_fd_pr__nfet_01v8 w=0.7 l=0.18
X2406 t_Xrx_Xdeser_Xwd5_s2 t_Xrx_Xdeser_Xwd5_qi vdd vdd sky130_fd_pr__pfet_01v8 w=0.95 l=0.18
X2407 t_Xrx_Xdeser_Xwd5_s2 rst_n vdd vdd sky130_fd_pr__pfet_01v8 w=0.95 l=0.18
X2408 t_Xrx_Xdeser_Xwd5_s2 t_Xrx_Xdeser_wcapb t_Xrx_Xdeser_Xwd5_s1 vss sky130_fd_pr__nfet_01v8 w=0.45 l=0.18
X2409 t_Xrx_Xdeser_Xwd5_s2 t_Xrx_Xdeser_wcap t_Xrx_Xdeser_Xwd5_s1 vdd sky130_fd_pr__pfet_01v8 w=0.9 l=0.18
X2410 wd5 t_Xrx_Xdeser_Xwd5_s1 vss vss sky130_fd_pr__nfet_01v8 w=0.75 l=0.18
X2411 wd5 t_Xrx_Xdeser_Xwd5_s1 vdd vdd sky130_fd_pr__pfet_01v8 w=1.6 l=0.18
X2412 t_Xrx_Xdeser_d2_2 t_Xrx_Xdeser_wcapb t_Xrx_Xdeser_Xwd6_m1 vss sky130_fd_pr__nfet_01v8 w=0.5 l=0.18
X2413 t_Xrx_Xdeser_d2_2 t_Xrx_Xdeser_wcap t_Xrx_Xdeser_Xwd6_m1 vdd sky130_fd_pr__pfet_01v8 w=1 l=0.18
X2414 t_Xrx_Xdeser_Xwd6_m2 t_Xrx_Xdeser_Xwd6_m1 t_Xrx_Xdeser_Xwd6_Xm2_mid vss sky130_fd_pr__nfet_01v8 w=0.75 l=0.18
X2415 t_Xrx_Xdeser_Xwd6_Xm2_mid rst_n vss vss sky130_fd_pr__nfet_01v8 w=0.75 l=0.18
X2416 t_Xrx_Xdeser_Xwd6_m2 t_Xrx_Xdeser_Xwd6_m1 vdd vdd sky130_fd_pr__pfet_01v8 w=1 l=0.18
X2417 t_Xrx_Xdeser_Xwd6_m2 rst_n vdd vdd sky130_fd_pr__pfet_01v8 w=1 l=0.18
X2418 t_Xrx_Xdeser_Xwd6_m3 t_Xrx_Xdeser_Xwd6_m2 vss vss sky130_fd_pr__nfet_01v8 w=0.45 l=0.18
X2419 t_Xrx_Xdeser_Xwd6_m3 t_Xrx_Xdeser_Xwd6_m2 vdd vdd sky130_fd_pr__pfet_01v8 w=0.9 l=0.18
X2420 t_Xrx_Xdeser_Xwd6_m3 t_Xrx_Xdeser_wcap t_Xrx_Xdeser_Xwd6_m1 vss sky130_fd_pr__nfet_01v8 w=0.45 l=0.18
X2421 t_Xrx_Xdeser_Xwd6_m3 t_Xrx_Xdeser_wcapb t_Xrx_Xdeser_Xwd6_m1 vdd sky130_fd_pr__pfet_01v8 w=0.9 l=0.18
X2422 t_Xrx_Xdeser_Xwd6_m2 t_Xrx_Xdeser_wcap t_Xrx_Xdeser_Xwd6_s1 vss sky130_fd_pr__nfet_01v8 w=0.5 l=0.18
X2423 t_Xrx_Xdeser_Xwd6_m2 t_Xrx_Xdeser_wcapb t_Xrx_Xdeser_Xwd6_s1 vdd sky130_fd_pr__pfet_01v8 w=1 l=0.18
X2424 t_Xrx_Xdeser_Xwd6_qi t_Xrx_Xdeser_Xwd6_s1 vss vss sky130_fd_pr__nfet_01v8 w=0.55 l=0.18
X2425 t_Xrx_Xdeser_Xwd6_qi t_Xrx_Xdeser_Xwd6_s1 vdd vdd sky130_fd_pr__pfet_01v8 w=1.2 l=0.18
X2426 t_Xrx_Xdeser_Xwd6_s2 t_Xrx_Xdeser_Xwd6_qi t_Xrx_Xdeser_Xwd6_Xsfb_mid vss sky130_fd_pr__nfet_01v8 w=0.7 l=0.18
X2427 t_Xrx_Xdeser_Xwd6_Xsfb_mid rst_n vss vss sky130_fd_pr__nfet_01v8 w=0.7 l=0.18
X2428 t_Xrx_Xdeser_Xwd6_s2 t_Xrx_Xdeser_Xwd6_qi vdd vdd sky130_fd_pr__pfet_01v8 w=0.95 l=0.18
X2429 t_Xrx_Xdeser_Xwd6_s2 rst_n vdd vdd sky130_fd_pr__pfet_01v8 w=0.95 l=0.18
X2430 t_Xrx_Xdeser_Xwd6_s2 t_Xrx_Xdeser_wcapb t_Xrx_Xdeser_Xwd6_s1 vss sky130_fd_pr__nfet_01v8 w=0.45 l=0.18
X2431 t_Xrx_Xdeser_Xwd6_s2 t_Xrx_Xdeser_wcap t_Xrx_Xdeser_Xwd6_s1 vdd sky130_fd_pr__pfet_01v8 w=0.9 l=0.18
X2432 wd6 t_Xrx_Xdeser_Xwd6_s1 vss vss sky130_fd_pr__nfet_01v8 w=0.75 l=0.18
X2433 wd6 t_Xrx_Xdeser_Xwd6_s1 vdd vdd sky130_fd_pr__pfet_01v8 w=1.6 l=0.18
X2434 t_Xrx_Xdeser_d3_2 t_Xrx_Xdeser_wcapb t_Xrx_Xdeser_Xwd7_m1 vss sky130_fd_pr__nfet_01v8 w=0.5 l=0.18
X2435 t_Xrx_Xdeser_d3_2 t_Xrx_Xdeser_wcap t_Xrx_Xdeser_Xwd7_m1 vdd sky130_fd_pr__pfet_01v8 w=1 l=0.18
X2436 t_Xrx_Xdeser_Xwd7_m2 t_Xrx_Xdeser_Xwd7_m1 t_Xrx_Xdeser_Xwd7_Xm2_mid vss sky130_fd_pr__nfet_01v8 w=0.75 l=0.18
X2437 t_Xrx_Xdeser_Xwd7_Xm2_mid rst_n vss vss sky130_fd_pr__nfet_01v8 w=0.75 l=0.18
X2438 t_Xrx_Xdeser_Xwd7_m2 t_Xrx_Xdeser_Xwd7_m1 vdd vdd sky130_fd_pr__pfet_01v8 w=1 l=0.18
X2439 t_Xrx_Xdeser_Xwd7_m2 rst_n vdd vdd sky130_fd_pr__pfet_01v8 w=1 l=0.18
X2440 t_Xrx_Xdeser_Xwd7_m3 t_Xrx_Xdeser_Xwd7_m2 vss vss sky130_fd_pr__nfet_01v8 w=0.45 l=0.18
X2441 t_Xrx_Xdeser_Xwd7_m3 t_Xrx_Xdeser_Xwd7_m2 vdd vdd sky130_fd_pr__pfet_01v8 w=0.9 l=0.18
X2442 t_Xrx_Xdeser_Xwd7_m3 t_Xrx_Xdeser_wcap t_Xrx_Xdeser_Xwd7_m1 vss sky130_fd_pr__nfet_01v8 w=0.45 l=0.18
X2443 t_Xrx_Xdeser_Xwd7_m3 t_Xrx_Xdeser_wcapb t_Xrx_Xdeser_Xwd7_m1 vdd sky130_fd_pr__pfet_01v8 w=0.9 l=0.18
X2444 t_Xrx_Xdeser_Xwd7_m2 t_Xrx_Xdeser_wcap t_Xrx_Xdeser_Xwd7_s1 vss sky130_fd_pr__nfet_01v8 w=0.5 l=0.18
X2445 t_Xrx_Xdeser_Xwd7_m2 t_Xrx_Xdeser_wcapb t_Xrx_Xdeser_Xwd7_s1 vdd sky130_fd_pr__pfet_01v8 w=1 l=0.18
X2446 t_Xrx_Xdeser_Xwd7_qi t_Xrx_Xdeser_Xwd7_s1 vss vss sky130_fd_pr__nfet_01v8 w=0.55 l=0.18
X2447 t_Xrx_Xdeser_Xwd7_qi t_Xrx_Xdeser_Xwd7_s1 vdd vdd sky130_fd_pr__pfet_01v8 w=1.2 l=0.18
X2448 t_Xrx_Xdeser_Xwd7_s2 t_Xrx_Xdeser_Xwd7_qi t_Xrx_Xdeser_Xwd7_Xsfb_mid vss sky130_fd_pr__nfet_01v8 w=0.7 l=0.18
X2449 t_Xrx_Xdeser_Xwd7_Xsfb_mid rst_n vss vss sky130_fd_pr__nfet_01v8 w=0.7 l=0.18
X2450 t_Xrx_Xdeser_Xwd7_s2 t_Xrx_Xdeser_Xwd7_qi vdd vdd sky130_fd_pr__pfet_01v8 w=0.95 l=0.18
X2451 t_Xrx_Xdeser_Xwd7_s2 rst_n vdd vdd sky130_fd_pr__pfet_01v8 w=0.95 l=0.18
X2452 t_Xrx_Xdeser_Xwd7_s2 t_Xrx_Xdeser_wcapb t_Xrx_Xdeser_Xwd7_s1 vss sky130_fd_pr__nfet_01v8 w=0.45 l=0.18
X2453 t_Xrx_Xdeser_Xwd7_s2 t_Xrx_Xdeser_wcap t_Xrx_Xdeser_Xwd7_s1 vdd sky130_fd_pr__pfet_01v8 w=0.9 l=0.18
X2454 wd7 t_Xrx_Xdeser_Xwd7_s1 vss vss sky130_fd_pr__nfet_01v8 w=0.75 l=0.18
X2455 wd7 t_Xrx_Xdeser_Xwd7_s1 vdd vdd sky130_fd_pr__pfet_01v8 w=1.6 l=0.18
X2456 t_Xrx_Xdeser_d0_1 t_Xrx_Xdeser_wcapb t_Xrx_Xdeser_Xwd8_m1 vss sky130_fd_pr__nfet_01v8 w=0.5 l=0.18
X2457 t_Xrx_Xdeser_d0_1 t_Xrx_Xdeser_wcap t_Xrx_Xdeser_Xwd8_m1 vdd sky130_fd_pr__pfet_01v8 w=1 l=0.18
X2458 t_Xrx_Xdeser_Xwd8_m2 t_Xrx_Xdeser_Xwd8_m1 t_Xrx_Xdeser_Xwd8_Xm2_mid vss sky130_fd_pr__nfet_01v8 w=0.75 l=0.18
X2459 t_Xrx_Xdeser_Xwd8_Xm2_mid rst_n vss vss sky130_fd_pr__nfet_01v8 w=0.75 l=0.18
X2460 t_Xrx_Xdeser_Xwd8_m2 t_Xrx_Xdeser_Xwd8_m1 vdd vdd sky130_fd_pr__pfet_01v8 w=1 l=0.18
X2461 t_Xrx_Xdeser_Xwd8_m2 rst_n vdd vdd sky130_fd_pr__pfet_01v8 w=1 l=0.18
X2462 t_Xrx_Xdeser_Xwd8_m3 t_Xrx_Xdeser_Xwd8_m2 vss vss sky130_fd_pr__nfet_01v8 w=0.45 l=0.18
X2463 t_Xrx_Xdeser_Xwd8_m3 t_Xrx_Xdeser_Xwd8_m2 vdd vdd sky130_fd_pr__pfet_01v8 w=0.9 l=0.18
X2464 t_Xrx_Xdeser_Xwd8_m3 t_Xrx_Xdeser_wcap t_Xrx_Xdeser_Xwd8_m1 vss sky130_fd_pr__nfet_01v8 w=0.45 l=0.18
X2465 t_Xrx_Xdeser_Xwd8_m3 t_Xrx_Xdeser_wcapb t_Xrx_Xdeser_Xwd8_m1 vdd sky130_fd_pr__pfet_01v8 w=0.9 l=0.18
X2466 t_Xrx_Xdeser_Xwd8_m2 t_Xrx_Xdeser_wcap t_Xrx_Xdeser_Xwd8_s1 vss sky130_fd_pr__nfet_01v8 w=0.5 l=0.18
X2467 t_Xrx_Xdeser_Xwd8_m2 t_Xrx_Xdeser_wcapb t_Xrx_Xdeser_Xwd8_s1 vdd sky130_fd_pr__pfet_01v8 w=1 l=0.18
X2468 t_Xrx_Xdeser_Xwd8_qi t_Xrx_Xdeser_Xwd8_s1 vss vss sky130_fd_pr__nfet_01v8 w=0.55 l=0.18
X2469 t_Xrx_Xdeser_Xwd8_qi t_Xrx_Xdeser_Xwd8_s1 vdd vdd sky130_fd_pr__pfet_01v8 w=1.2 l=0.18
X2470 t_Xrx_Xdeser_Xwd8_s2 t_Xrx_Xdeser_Xwd8_qi t_Xrx_Xdeser_Xwd8_Xsfb_mid vss sky130_fd_pr__nfet_01v8 w=0.7 l=0.18
X2471 t_Xrx_Xdeser_Xwd8_Xsfb_mid rst_n vss vss sky130_fd_pr__nfet_01v8 w=0.7 l=0.18
X2472 t_Xrx_Xdeser_Xwd8_s2 t_Xrx_Xdeser_Xwd8_qi vdd vdd sky130_fd_pr__pfet_01v8 w=0.95 l=0.18
X2473 t_Xrx_Xdeser_Xwd8_s2 rst_n vdd vdd sky130_fd_pr__pfet_01v8 w=0.95 l=0.18
X2474 t_Xrx_Xdeser_Xwd8_s2 t_Xrx_Xdeser_wcapb t_Xrx_Xdeser_Xwd8_s1 vss sky130_fd_pr__nfet_01v8 w=0.45 l=0.18
X2475 t_Xrx_Xdeser_Xwd8_s2 t_Xrx_Xdeser_wcap t_Xrx_Xdeser_Xwd8_s1 vdd sky130_fd_pr__pfet_01v8 w=0.9 l=0.18
X2476 wd8 t_Xrx_Xdeser_Xwd8_s1 vss vss sky130_fd_pr__nfet_01v8 w=0.75 l=0.18
X2477 wd8 t_Xrx_Xdeser_Xwd8_s1 vdd vdd sky130_fd_pr__pfet_01v8 w=1.6 l=0.18
X2478 t_Xrx_Xdeser_d1_1 t_Xrx_Xdeser_wcapb t_Xrx_Xdeser_Xwd9_m1 vss sky130_fd_pr__nfet_01v8 w=0.5 l=0.18
X2479 t_Xrx_Xdeser_d1_1 t_Xrx_Xdeser_wcap t_Xrx_Xdeser_Xwd9_m1 vdd sky130_fd_pr__pfet_01v8 w=1 l=0.18
X2480 t_Xrx_Xdeser_Xwd9_m2 t_Xrx_Xdeser_Xwd9_m1 t_Xrx_Xdeser_Xwd9_Xm2_mid vss sky130_fd_pr__nfet_01v8 w=0.75 l=0.18
X2481 t_Xrx_Xdeser_Xwd9_Xm2_mid rst_n vss vss sky130_fd_pr__nfet_01v8 w=0.75 l=0.18
X2482 t_Xrx_Xdeser_Xwd9_m2 t_Xrx_Xdeser_Xwd9_m1 vdd vdd sky130_fd_pr__pfet_01v8 w=1 l=0.18
X2483 t_Xrx_Xdeser_Xwd9_m2 rst_n vdd vdd sky130_fd_pr__pfet_01v8 w=1 l=0.18
X2484 t_Xrx_Xdeser_Xwd9_m3 t_Xrx_Xdeser_Xwd9_m2 vss vss sky130_fd_pr__nfet_01v8 w=0.45 l=0.18
X2485 t_Xrx_Xdeser_Xwd9_m3 t_Xrx_Xdeser_Xwd9_m2 vdd vdd sky130_fd_pr__pfet_01v8 w=0.9 l=0.18
X2486 t_Xrx_Xdeser_Xwd9_m3 t_Xrx_Xdeser_wcap t_Xrx_Xdeser_Xwd9_m1 vss sky130_fd_pr__nfet_01v8 w=0.45 l=0.18
X2487 t_Xrx_Xdeser_Xwd9_m3 t_Xrx_Xdeser_wcapb t_Xrx_Xdeser_Xwd9_m1 vdd sky130_fd_pr__pfet_01v8 w=0.9 l=0.18
X2488 t_Xrx_Xdeser_Xwd9_m2 t_Xrx_Xdeser_wcap t_Xrx_Xdeser_Xwd9_s1 vss sky130_fd_pr__nfet_01v8 w=0.5 l=0.18
X2489 t_Xrx_Xdeser_Xwd9_m2 t_Xrx_Xdeser_wcapb t_Xrx_Xdeser_Xwd9_s1 vdd sky130_fd_pr__pfet_01v8 w=1 l=0.18
X2490 t_Xrx_Xdeser_Xwd9_qi t_Xrx_Xdeser_Xwd9_s1 vss vss sky130_fd_pr__nfet_01v8 w=0.55 l=0.18
X2491 t_Xrx_Xdeser_Xwd9_qi t_Xrx_Xdeser_Xwd9_s1 vdd vdd sky130_fd_pr__pfet_01v8 w=1.2 l=0.18
X2492 t_Xrx_Xdeser_Xwd9_s2 t_Xrx_Xdeser_Xwd9_qi t_Xrx_Xdeser_Xwd9_Xsfb_mid vss sky130_fd_pr__nfet_01v8 w=0.7 l=0.18
X2493 t_Xrx_Xdeser_Xwd9_Xsfb_mid rst_n vss vss sky130_fd_pr__nfet_01v8 w=0.7 l=0.18
X2494 t_Xrx_Xdeser_Xwd9_s2 t_Xrx_Xdeser_Xwd9_qi vdd vdd sky130_fd_pr__pfet_01v8 w=0.95 l=0.18
X2495 t_Xrx_Xdeser_Xwd9_s2 rst_n vdd vdd sky130_fd_pr__pfet_01v8 w=0.95 l=0.18
X2496 t_Xrx_Xdeser_Xwd9_s2 t_Xrx_Xdeser_wcapb t_Xrx_Xdeser_Xwd9_s1 vss sky130_fd_pr__nfet_01v8 w=0.45 l=0.18
X2497 t_Xrx_Xdeser_Xwd9_s2 t_Xrx_Xdeser_wcap t_Xrx_Xdeser_Xwd9_s1 vdd sky130_fd_pr__pfet_01v8 w=0.9 l=0.18
X2498 wd9 t_Xrx_Xdeser_Xwd9_s1 vss vss sky130_fd_pr__nfet_01v8 w=0.75 l=0.18
X2499 wd9 t_Xrx_Xdeser_Xwd9_s1 vdd vdd sky130_fd_pr__pfet_01v8 w=1.6 l=0.18
X2500 t_Xrx_Xdeser_d2_1 t_Xrx_Xdeser_wcapb t_Xrx_Xdeser_Xwd10_m1 vss sky130_fd_pr__nfet_01v8 w=0.5 l=0.18
X2501 t_Xrx_Xdeser_d2_1 t_Xrx_Xdeser_wcap t_Xrx_Xdeser_Xwd10_m1 vdd sky130_fd_pr__pfet_01v8 w=1 l=0.18
X2502 t_Xrx_Xdeser_Xwd10_m2 t_Xrx_Xdeser_Xwd10_m1 t_Xrx_Xdeser_Xwd10_Xm2_mid vss sky130_fd_pr__nfet_01v8 w=0.75 l=0.18
X2503 t_Xrx_Xdeser_Xwd10_Xm2_mid rst_n vss vss sky130_fd_pr__nfet_01v8 w=0.75 l=0.18
X2504 t_Xrx_Xdeser_Xwd10_m2 t_Xrx_Xdeser_Xwd10_m1 vdd vdd sky130_fd_pr__pfet_01v8 w=1 l=0.18
X2505 t_Xrx_Xdeser_Xwd10_m2 rst_n vdd vdd sky130_fd_pr__pfet_01v8 w=1 l=0.18
X2506 t_Xrx_Xdeser_Xwd10_m3 t_Xrx_Xdeser_Xwd10_m2 vss vss sky130_fd_pr__nfet_01v8 w=0.45 l=0.18
X2507 t_Xrx_Xdeser_Xwd10_m3 t_Xrx_Xdeser_Xwd10_m2 vdd vdd sky130_fd_pr__pfet_01v8 w=0.9 l=0.18
X2508 t_Xrx_Xdeser_Xwd10_m3 t_Xrx_Xdeser_wcap t_Xrx_Xdeser_Xwd10_m1 vss sky130_fd_pr__nfet_01v8 w=0.45 l=0.18
X2509 t_Xrx_Xdeser_Xwd10_m3 t_Xrx_Xdeser_wcapb t_Xrx_Xdeser_Xwd10_m1 vdd sky130_fd_pr__pfet_01v8 w=0.9 l=0.18
X2510 t_Xrx_Xdeser_Xwd10_m2 t_Xrx_Xdeser_wcap t_Xrx_Xdeser_Xwd10_s1 vss sky130_fd_pr__nfet_01v8 w=0.5 l=0.18
X2511 t_Xrx_Xdeser_Xwd10_m2 t_Xrx_Xdeser_wcapb t_Xrx_Xdeser_Xwd10_s1 vdd sky130_fd_pr__pfet_01v8 w=1 l=0.18
X2512 t_Xrx_Xdeser_Xwd10_qi t_Xrx_Xdeser_Xwd10_s1 vss vss sky130_fd_pr__nfet_01v8 w=0.55 l=0.18
X2513 t_Xrx_Xdeser_Xwd10_qi t_Xrx_Xdeser_Xwd10_s1 vdd vdd sky130_fd_pr__pfet_01v8 w=1.2 l=0.18
X2514 t_Xrx_Xdeser_Xwd10_s2 t_Xrx_Xdeser_Xwd10_qi t_Xrx_Xdeser_Xwd10_Xsfb_mid vss sky130_fd_pr__nfet_01v8 w=0.7 l=0.18
X2515 t_Xrx_Xdeser_Xwd10_Xsfb_mid rst_n vss vss sky130_fd_pr__nfet_01v8 w=0.7 l=0.18
X2516 t_Xrx_Xdeser_Xwd10_s2 t_Xrx_Xdeser_Xwd10_qi vdd vdd sky130_fd_pr__pfet_01v8 w=0.95 l=0.18
X2517 t_Xrx_Xdeser_Xwd10_s2 rst_n vdd vdd sky130_fd_pr__pfet_01v8 w=0.95 l=0.18
X2518 t_Xrx_Xdeser_Xwd10_s2 t_Xrx_Xdeser_wcapb t_Xrx_Xdeser_Xwd10_s1 vss sky130_fd_pr__nfet_01v8 w=0.45 l=0.18
X2519 t_Xrx_Xdeser_Xwd10_s2 t_Xrx_Xdeser_wcap t_Xrx_Xdeser_Xwd10_s1 vdd sky130_fd_pr__pfet_01v8 w=0.9 l=0.18
X2520 wd10 t_Xrx_Xdeser_Xwd10_s1 vss vss sky130_fd_pr__nfet_01v8 w=0.75 l=0.18
X2521 wd10 t_Xrx_Xdeser_Xwd10_s1 vdd vdd sky130_fd_pr__pfet_01v8 w=1.6 l=0.18
X2522 t_Xrx_Xdeser_d3_1 t_Xrx_Xdeser_wcapb t_Xrx_Xdeser_Xwd11_m1 vss sky130_fd_pr__nfet_01v8 w=0.5 l=0.18
X2523 t_Xrx_Xdeser_d3_1 t_Xrx_Xdeser_wcap t_Xrx_Xdeser_Xwd11_m1 vdd sky130_fd_pr__pfet_01v8 w=1 l=0.18
X2524 t_Xrx_Xdeser_Xwd11_m2 t_Xrx_Xdeser_Xwd11_m1 t_Xrx_Xdeser_Xwd11_Xm2_mid vss sky130_fd_pr__nfet_01v8 w=0.75 l=0.18
X2525 t_Xrx_Xdeser_Xwd11_Xm2_mid rst_n vss vss sky130_fd_pr__nfet_01v8 w=0.75 l=0.18
X2526 t_Xrx_Xdeser_Xwd11_m2 t_Xrx_Xdeser_Xwd11_m1 vdd vdd sky130_fd_pr__pfet_01v8 w=1 l=0.18
X2527 t_Xrx_Xdeser_Xwd11_m2 rst_n vdd vdd sky130_fd_pr__pfet_01v8 w=1 l=0.18
X2528 t_Xrx_Xdeser_Xwd11_m3 t_Xrx_Xdeser_Xwd11_m2 vss vss sky130_fd_pr__nfet_01v8 w=0.45 l=0.18
X2529 t_Xrx_Xdeser_Xwd11_m3 t_Xrx_Xdeser_Xwd11_m2 vdd vdd sky130_fd_pr__pfet_01v8 w=0.9 l=0.18
X2530 t_Xrx_Xdeser_Xwd11_m3 t_Xrx_Xdeser_wcap t_Xrx_Xdeser_Xwd11_m1 vss sky130_fd_pr__nfet_01v8 w=0.45 l=0.18
X2531 t_Xrx_Xdeser_Xwd11_m3 t_Xrx_Xdeser_wcapb t_Xrx_Xdeser_Xwd11_m1 vdd sky130_fd_pr__pfet_01v8 w=0.9 l=0.18
X2532 t_Xrx_Xdeser_Xwd11_m2 t_Xrx_Xdeser_wcap t_Xrx_Xdeser_Xwd11_s1 vss sky130_fd_pr__nfet_01v8 w=0.5 l=0.18
X2533 t_Xrx_Xdeser_Xwd11_m2 t_Xrx_Xdeser_wcapb t_Xrx_Xdeser_Xwd11_s1 vdd sky130_fd_pr__pfet_01v8 w=1 l=0.18
X2534 t_Xrx_Xdeser_Xwd11_qi t_Xrx_Xdeser_Xwd11_s1 vss vss sky130_fd_pr__nfet_01v8 w=0.55 l=0.18
X2535 t_Xrx_Xdeser_Xwd11_qi t_Xrx_Xdeser_Xwd11_s1 vdd vdd sky130_fd_pr__pfet_01v8 w=1.2 l=0.18
X2536 t_Xrx_Xdeser_Xwd11_s2 t_Xrx_Xdeser_Xwd11_qi t_Xrx_Xdeser_Xwd11_Xsfb_mid vss sky130_fd_pr__nfet_01v8 w=0.7 l=0.18
X2537 t_Xrx_Xdeser_Xwd11_Xsfb_mid rst_n vss vss sky130_fd_pr__nfet_01v8 w=0.7 l=0.18
X2538 t_Xrx_Xdeser_Xwd11_s2 t_Xrx_Xdeser_Xwd11_qi vdd vdd sky130_fd_pr__pfet_01v8 w=0.95 l=0.18
X2539 t_Xrx_Xdeser_Xwd11_s2 rst_n vdd vdd sky130_fd_pr__pfet_01v8 w=0.95 l=0.18
X2540 t_Xrx_Xdeser_Xwd11_s2 t_Xrx_Xdeser_wcapb t_Xrx_Xdeser_Xwd11_s1 vss sky130_fd_pr__nfet_01v8 w=0.45 l=0.18
X2541 t_Xrx_Xdeser_Xwd11_s2 t_Xrx_Xdeser_wcap t_Xrx_Xdeser_Xwd11_s1 vdd sky130_fd_pr__pfet_01v8 w=0.9 l=0.18
X2542 wd11 t_Xrx_Xdeser_Xwd11_s1 vss vss sky130_fd_pr__nfet_01v8 w=0.75 l=0.18
X2543 wd11 t_Xrx_Xdeser_Xwd11_s1 vdd vdd sky130_fd_pr__pfet_01v8 w=1.6 l=0.18
X2544 t_Xrx_Xdeser_d0_0 t_Xrx_Xdeser_wcapb t_Xrx_Xdeser_Xwd12_m1 vss sky130_fd_pr__nfet_01v8 w=0.5 l=0.18
X2545 t_Xrx_Xdeser_d0_0 t_Xrx_Xdeser_wcap t_Xrx_Xdeser_Xwd12_m1 vdd sky130_fd_pr__pfet_01v8 w=1 l=0.18
X2546 t_Xrx_Xdeser_Xwd12_m2 t_Xrx_Xdeser_Xwd12_m1 t_Xrx_Xdeser_Xwd12_Xm2_mid vss sky130_fd_pr__nfet_01v8 w=0.75 l=0.18
X2547 t_Xrx_Xdeser_Xwd12_Xm2_mid rst_n vss vss sky130_fd_pr__nfet_01v8 w=0.75 l=0.18
X2548 t_Xrx_Xdeser_Xwd12_m2 t_Xrx_Xdeser_Xwd12_m1 vdd vdd sky130_fd_pr__pfet_01v8 w=1 l=0.18
X2549 t_Xrx_Xdeser_Xwd12_m2 rst_n vdd vdd sky130_fd_pr__pfet_01v8 w=1 l=0.18
X2550 t_Xrx_Xdeser_Xwd12_m3 t_Xrx_Xdeser_Xwd12_m2 vss vss sky130_fd_pr__nfet_01v8 w=0.45 l=0.18
X2551 t_Xrx_Xdeser_Xwd12_m3 t_Xrx_Xdeser_Xwd12_m2 vdd vdd sky130_fd_pr__pfet_01v8 w=0.9 l=0.18
X2552 t_Xrx_Xdeser_Xwd12_m3 t_Xrx_Xdeser_wcap t_Xrx_Xdeser_Xwd12_m1 vss sky130_fd_pr__nfet_01v8 w=0.45 l=0.18
X2553 t_Xrx_Xdeser_Xwd12_m3 t_Xrx_Xdeser_wcapb t_Xrx_Xdeser_Xwd12_m1 vdd sky130_fd_pr__pfet_01v8 w=0.9 l=0.18
X2554 t_Xrx_Xdeser_Xwd12_m2 t_Xrx_Xdeser_wcap t_Xrx_Xdeser_Xwd12_s1 vss sky130_fd_pr__nfet_01v8 w=0.5 l=0.18
X2555 t_Xrx_Xdeser_Xwd12_m2 t_Xrx_Xdeser_wcapb t_Xrx_Xdeser_Xwd12_s1 vdd sky130_fd_pr__pfet_01v8 w=1 l=0.18
X2556 t_Xrx_Xdeser_Xwd12_qi t_Xrx_Xdeser_Xwd12_s1 vss vss sky130_fd_pr__nfet_01v8 w=0.55 l=0.18
X2557 t_Xrx_Xdeser_Xwd12_qi t_Xrx_Xdeser_Xwd12_s1 vdd vdd sky130_fd_pr__pfet_01v8 w=1.2 l=0.18
X2558 t_Xrx_Xdeser_Xwd12_s2 t_Xrx_Xdeser_Xwd12_qi t_Xrx_Xdeser_Xwd12_Xsfb_mid vss sky130_fd_pr__nfet_01v8 w=0.7 l=0.18
X2559 t_Xrx_Xdeser_Xwd12_Xsfb_mid rst_n vss vss sky130_fd_pr__nfet_01v8 w=0.7 l=0.18
X2560 t_Xrx_Xdeser_Xwd12_s2 t_Xrx_Xdeser_Xwd12_qi vdd vdd sky130_fd_pr__pfet_01v8 w=0.95 l=0.18
X2561 t_Xrx_Xdeser_Xwd12_s2 rst_n vdd vdd sky130_fd_pr__pfet_01v8 w=0.95 l=0.18
X2562 t_Xrx_Xdeser_Xwd12_s2 t_Xrx_Xdeser_wcapb t_Xrx_Xdeser_Xwd12_s1 vss sky130_fd_pr__nfet_01v8 w=0.45 l=0.18
X2563 t_Xrx_Xdeser_Xwd12_s2 t_Xrx_Xdeser_wcap t_Xrx_Xdeser_Xwd12_s1 vdd sky130_fd_pr__pfet_01v8 w=0.9 l=0.18
X2564 wd12 t_Xrx_Xdeser_Xwd12_s1 vss vss sky130_fd_pr__nfet_01v8 w=0.75 l=0.18
X2565 wd12 t_Xrx_Xdeser_Xwd12_s1 vdd vdd sky130_fd_pr__pfet_01v8 w=1.6 l=0.18
X2566 t_Xrx_Xdeser_d1_0 t_Xrx_Xdeser_wcapb t_Xrx_Xdeser_Xwd13_m1 vss sky130_fd_pr__nfet_01v8 w=0.5 l=0.18
X2567 t_Xrx_Xdeser_d1_0 t_Xrx_Xdeser_wcap t_Xrx_Xdeser_Xwd13_m1 vdd sky130_fd_pr__pfet_01v8 w=1 l=0.18
X2568 t_Xrx_Xdeser_Xwd13_m2 t_Xrx_Xdeser_Xwd13_m1 t_Xrx_Xdeser_Xwd13_Xm2_mid vss sky130_fd_pr__nfet_01v8 w=0.75 l=0.18
X2569 t_Xrx_Xdeser_Xwd13_Xm2_mid rst_n vss vss sky130_fd_pr__nfet_01v8 w=0.75 l=0.18
X2570 t_Xrx_Xdeser_Xwd13_m2 t_Xrx_Xdeser_Xwd13_m1 vdd vdd sky130_fd_pr__pfet_01v8 w=1 l=0.18
X2571 t_Xrx_Xdeser_Xwd13_m2 rst_n vdd vdd sky130_fd_pr__pfet_01v8 w=1 l=0.18
X2572 t_Xrx_Xdeser_Xwd13_m3 t_Xrx_Xdeser_Xwd13_m2 vss vss sky130_fd_pr__nfet_01v8 w=0.45 l=0.18
X2573 t_Xrx_Xdeser_Xwd13_m3 t_Xrx_Xdeser_Xwd13_m2 vdd vdd sky130_fd_pr__pfet_01v8 w=0.9 l=0.18
X2574 t_Xrx_Xdeser_Xwd13_m3 t_Xrx_Xdeser_wcap t_Xrx_Xdeser_Xwd13_m1 vss sky130_fd_pr__nfet_01v8 w=0.45 l=0.18
X2575 t_Xrx_Xdeser_Xwd13_m3 t_Xrx_Xdeser_wcapb t_Xrx_Xdeser_Xwd13_m1 vdd sky130_fd_pr__pfet_01v8 w=0.9 l=0.18
X2576 t_Xrx_Xdeser_Xwd13_m2 t_Xrx_Xdeser_wcap t_Xrx_Xdeser_Xwd13_s1 vss sky130_fd_pr__nfet_01v8 w=0.5 l=0.18
X2577 t_Xrx_Xdeser_Xwd13_m2 t_Xrx_Xdeser_wcapb t_Xrx_Xdeser_Xwd13_s1 vdd sky130_fd_pr__pfet_01v8 w=1 l=0.18
X2578 t_Xrx_Xdeser_Xwd13_qi t_Xrx_Xdeser_Xwd13_s1 vss vss sky130_fd_pr__nfet_01v8 w=0.55 l=0.18
X2579 t_Xrx_Xdeser_Xwd13_qi t_Xrx_Xdeser_Xwd13_s1 vdd vdd sky130_fd_pr__pfet_01v8 w=1.2 l=0.18
X2580 t_Xrx_Xdeser_Xwd13_s2 t_Xrx_Xdeser_Xwd13_qi t_Xrx_Xdeser_Xwd13_Xsfb_mid vss sky130_fd_pr__nfet_01v8 w=0.7 l=0.18
X2581 t_Xrx_Xdeser_Xwd13_Xsfb_mid rst_n vss vss sky130_fd_pr__nfet_01v8 w=0.7 l=0.18
X2582 t_Xrx_Xdeser_Xwd13_s2 t_Xrx_Xdeser_Xwd13_qi vdd vdd sky130_fd_pr__pfet_01v8 w=0.95 l=0.18
X2583 t_Xrx_Xdeser_Xwd13_s2 rst_n vdd vdd sky130_fd_pr__pfet_01v8 w=0.95 l=0.18
X2584 t_Xrx_Xdeser_Xwd13_s2 t_Xrx_Xdeser_wcapb t_Xrx_Xdeser_Xwd13_s1 vss sky130_fd_pr__nfet_01v8 w=0.45 l=0.18
X2585 t_Xrx_Xdeser_Xwd13_s2 t_Xrx_Xdeser_wcap t_Xrx_Xdeser_Xwd13_s1 vdd sky130_fd_pr__pfet_01v8 w=0.9 l=0.18
X2586 wd13 t_Xrx_Xdeser_Xwd13_s1 vss vss sky130_fd_pr__nfet_01v8 w=0.75 l=0.18
X2587 wd13 t_Xrx_Xdeser_Xwd13_s1 vdd vdd sky130_fd_pr__pfet_01v8 w=1.6 l=0.18
X2588 t_Xrx_Xdeser_d2_0 t_Xrx_Xdeser_wcapb t_Xrx_Xdeser_Xwd14_m1 vss sky130_fd_pr__nfet_01v8 w=0.5 l=0.18
X2589 t_Xrx_Xdeser_d2_0 t_Xrx_Xdeser_wcap t_Xrx_Xdeser_Xwd14_m1 vdd sky130_fd_pr__pfet_01v8 w=1 l=0.18
X2590 t_Xrx_Xdeser_Xwd14_m2 t_Xrx_Xdeser_Xwd14_m1 t_Xrx_Xdeser_Xwd14_Xm2_mid vss sky130_fd_pr__nfet_01v8 w=0.75 l=0.18
X2591 t_Xrx_Xdeser_Xwd14_Xm2_mid rst_n vss vss sky130_fd_pr__nfet_01v8 w=0.75 l=0.18
X2592 t_Xrx_Xdeser_Xwd14_m2 t_Xrx_Xdeser_Xwd14_m1 vdd vdd sky130_fd_pr__pfet_01v8 w=1 l=0.18
X2593 t_Xrx_Xdeser_Xwd14_m2 rst_n vdd vdd sky130_fd_pr__pfet_01v8 w=1 l=0.18
X2594 t_Xrx_Xdeser_Xwd14_m3 t_Xrx_Xdeser_Xwd14_m2 vss vss sky130_fd_pr__nfet_01v8 w=0.45 l=0.18
X2595 t_Xrx_Xdeser_Xwd14_m3 t_Xrx_Xdeser_Xwd14_m2 vdd vdd sky130_fd_pr__pfet_01v8 w=0.9 l=0.18
X2596 t_Xrx_Xdeser_Xwd14_m3 t_Xrx_Xdeser_wcap t_Xrx_Xdeser_Xwd14_m1 vss sky130_fd_pr__nfet_01v8 w=0.45 l=0.18
X2597 t_Xrx_Xdeser_Xwd14_m3 t_Xrx_Xdeser_wcapb t_Xrx_Xdeser_Xwd14_m1 vdd sky130_fd_pr__pfet_01v8 w=0.9 l=0.18
X2598 t_Xrx_Xdeser_Xwd14_m2 t_Xrx_Xdeser_wcap t_Xrx_Xdeser_Xwd14_s1 vss sky130_fd_pr__nfet_01v8 w=0.5 l=0.18
X2599 t_Xrx_Xdeser_Xwd14_m2 t_Xrx_Xdeser_wcapb t_Xrx_Xdeser_Xwd14_s1 vdd sky130_fd_pr__pfet_01v8 w=1 l=0.18
X2600 t_Xrx_Xdeser_Xwd14_qi t_Xrx_Xdeser_Xwd14_s1 vss vss sky130_fd_pr__nfet_01v8 w=0.55 l=0.18
X2601 t_Xrx_Xdeser_Xwd14_qi t_Xrx_Xdeser_Xwd14_s1 vdd vdd sky130_fd_pr__pfet_01v8 w=1.2 l=0.18
X2602 t_Xrx_Xdeser_Xwd14_s2 t_Xrx_Xdeser_Xwd14_qi t_Xrx_Xdeser_Xwd14_Xsfb_mid vss sky130_fd_pr__nfet_01v8 w=0.7 l=0.18
X2603 t_Xrx_Xdeser_Xwd14_Xsfb_mid rst_n vss vss sky130_fd_pr__nfet_01v8 w=0.7 l=0.18
X2604 t_Xrx_Xdeser_Xwd14_s2 t_Xrx_Xdeser_Xwd14_qi vdd vdd sky130_fd_pr__pfet_01v8 w=0.95 l=0.18
X2605 t_Xrx_Xdeser_Xwd14_s2 rst_n vdd vdd sky130_fd_pr__pfet_01v8 w=0.95 l=0.18
X2606 t_Xrx_Xdeser_Xwd14_s2 t_Xrx_Xdeser_wcapb t_Xrx_Xdeser_Xwd14_s1 vss sky130_fd_pr__nfet_01v8 w=0.45 l=0.18
X2607 t_Xrx_Xdeser_Xwd14_s2 t_Xrx_Xdeser_wcap t_Xrx_Xdeser_Xwd14_s1 vdd sky130_fd_pr__pfet_01v8 w=0.9 l=0.18
X2608 wd14 t_Xrx_Xdeser_Xwd14_s1 vss vss sky130_fd_pr__nfet_01v8 w=0.75 l=0.18
X2609 wd14 t_Xrx_Xdeser_Xwd14_s1 vdd vdd sky130_fd_pr__pfet_01v8 w=1.6 l=0.18
X2610 t_Xrx_Xdeser_d3_0 t_Xrx_Xdeser_wcapb t_Xrx_Xdeser_Xwd15_m1 vss sky130_fd_pr__nfet_01v8 w=0.5 l=0.18
X2611 t_Xrx_Xdeser_d3_0 t_Xrx_Xdeser_wcap t_Xrx_Xdeser_Xwd15_m1 vdd sky130_fd_pr__pfet_01v8 w=1 l=0.18
X2612 t_Xrx_Xdeser_Xwd15_m2 t_Xrx_Xdeser_Xwd15_m1 t_Xrx_Xdeser_Xwd15_Xm2_mid vss sky130_fd_pr__nfet_01v8 w=0.75 l=0.18
X2613 t_Xrx_Xdeser_Xwd15_Xm2_mid rst_n vss vss sky130_fd_pr__nfet_01v8 w=0.75 l=0.18
X2614 t_Xrx_Xdeser_Xwd15_m2 t_Xrx_Xdeser_Xwd15_m1 vdd vdd sky130_fd_pr__pfet_01v8 w=1 l=0.18
X2615 t_Xrx_Xdeser_Xwd15_m2 rst_n vdd vdd sky130_fd_pr__pfet_01v8 w=1 l=0.18
X2616 t_Xrx_Xdeser_Xwd15_m3 t_Xrx_Xdeser_Xwd15_m2 vss vss sky130_fd_pr__nfet_01v8 w=0.45 l=0.18
X2617 t_Xrx_Xdeser_Xwd15_m3 t_Xrx_Xdeser_Xwd15_m2 vdd vdd sky130_fd_pr__pfet_01v8 w=0.9 l=0.18
X2618 t_Xrx_Xdeser_Xwd15_m3 t_Xrx_Xdeser_wcap t_Xrx_Xdeser_Xwd15_m1 vss sky130_fd_pr__nfet_01v8 w=0.45 l=0.18
X2619 t_Xrx_Xdeser_Xwd15_m3 t_Xrx_Xdeser_wcapb t_Xrx_Xdeser_Xwd15_m1 vdd sky130_fd_pr__pfet_01v8 w=0.9 l=0.18
X2620 t_Xrx_Xdeser_Xwd15_m2 t_Xrx_Xdeser_wcap t_Xrx_Xdeser_Xwd15_s1 vss sky130_fd_pr__nfet_01v8 w=0.5 l=0.18
X2621 t_Xrx_Xdeser_Xwd15_m2 t_Xrx_Xdeser_wcapb t_Xrx_Xdeser_Xwd15_s1 vdd sky130_fd_pr__pfet_01v8 w=1 l=0.18
X2622 t_Xrx_Xdeser_Xwd15_qi t_Xrx_Xdeser_Xwd15_s1 vss vss sky130_fd_pr__nfet_01v8 w=0.55 l=0.18
X2623 t_Xrx_Xdeser_Xwd15_qi t_Xrx_Xdeser_Xwd15_s1 vdd vdd sky130_fd_pr__pfet_01v8 w=1.2 l=0.18
X2624 t_Xrx_Xdeser_Xwd15_s2 t_Xrx_Xdeser_Xwd15_qi t_Xrx_Xdeser_Xwd15_Xsfb_mid vss sky130_fd_pr__nfet_01v8 w=0.7 l=0.18
X2625 t_Xrx_Xdeser_Xwd15_Xsfb_mid rst_n vss vss sky130_fd_pr__nfet_01v8 w=0.7 l=0.18
X2626 t_Xrx_Xdeser_Xwd15_s2 t_Xrx_Xdeser_Xwd15_qi vdd vdd sky130_fd_pr__pfet_01v8 w=0.95 l=0.18
X2627 t_Xrx_Xdeser_Xwd15_s2 rst_n vdd vdd sky130_fd_pr__pfet_01v8 w=0.95 l=0.18
X2628 t_Xrx_Xdeser_Xwd15_s2 t_Xrx_Xdeser_wcapb t_Xrx_Xdeser_Xwd15_s1 vss sky130_fd_pr__nfet_01v8 w=0.45 l=0.18
X2629 t_Xrx_Xdeser_Xwd15_s2 t_Xrx_Xdeser_wcap t_Xrx_Xdeser_Xwd15_s1 vdd sky130_fd_pr__pfet_01v8 w=0.9 l=0.18
X2630 wd15 t_Xrx_Xdeser_Xwd15_s1 vss vss sky130_fd_pr__nfet_01v8 w=0.75 l=0.18
X2631 wd15 t_Xrx_Xdeser_Xwd15_s1 vdd vdd sky130_fd_pr__pfet_01v8 w=1.6 l=0.18
X2632 t_Xrx_Xdeser_e3_4 t_Xrx_Xdeser_wcapb t_Xrx_Xdeser_Xwe0_m1 vss sky130_fd_pr__nfet_01v8 w=0.5 l=0.18
X2633 t_Xrx_Xdeser_e3_4 t_Xrx_Xdeser_wcap t_Xrx_Xdeser_Xwe0_m1 vdd sky130_fd_pr__pfet_01v8 w=1 l=0.18
X2634 t_Xrx_Xdeser_Xwe0_m2 t_Xrx_Xdeser_Xwe0_m1 t_Xrx_Xdeser_Xwe0_Xm2_mid vss sky130_fd_pr__nfet_01v8 w=0.75 l=0.18
X2635 t_Xrx_Xdeser_Xwe0_Xm2_mid rst_n vss vss sky130_fd_pr__nfet_01v8 w=0.75 l=0.18
X2636 t_Xrx_Xdeser_Xwe0_m2 t_Xrx_Xdeser_Xwe0_m1 vdd vdd sky130_fd_pr__pfet_01v8 w=1 l=0.18
X2637 t_Xrx_Xdeser_Xwe0_m2 rst_n vdd vdd sky130_fd_pr__pfet_01v8 w=1 l=0.18
X2638 t_Xrx_Xdeser_Xwe0_m3 t_Xrx_Xdeser_Xwe0_m2 vss vss sky130_fd_pr__nfet_01v8 w=0.45 l=0.18
X2639 t_Xrx_Xdeser_Xwe0_m3 t_Xrx_Xdeser_Xwe0_m2 vdd vdd sky130_fd_pr__pfet_01v8 w=0.9 l=0.18
X2640 t_Xrx_Xdeser_Xwe0_m3 t_Xrx_Xdeser_wcap t_Xrx_Xdeser_Xwe0_m1 vss sky130_fd_pr__nfet_01v8 w=0.45 l=0.18
X2641 t_Xrx_Xdeser_Xwe0_m3 t_Xrx_Xdeser_wcapb t_Xrx_Xdeser_Xwe0_m1 vdd sky130_fd_pr__pfet_01v8 w=0.9 l=0.18
X2642 t_Xrx_Xdeser_Xwe0_m2 t_Xrx_Xdeser_wcap t_Xrx_Xdeser_Xwe0_s1 vss sky130_fd_pr__nfet_01v8 w=0.5 l=0.18
X2643 t_Xrx_Xdeser_Xwe0_m2 t_Xrx_Xdeser_wcapb t_Xrx_Xdeser_Xwe0_s1 vdd sky130_fd_pr__pfet_01v8 w=1 l=0.18
X2644 t_Xrx_Xdeser_Xwe0_qi t_Xrx_Xdeser_Xwe0_s1 vss vss sky130_fd_pr__nfet_01v8 w=0.55 l=0.18
X2645 t_Xrx_Xdeser_Xwe0_qi t_Xrx_Xdeser_Xwe0_s1 vdd vdd sky130_fd_pr__pfet_01v8 w=1.2 l=0.18
X2646 t_Xrx_Xdeser_Xwe0_s2 t_Xrx_Xdeser_Xwe0_qi t_Xrx_Xdeser_Xwe0_Xsfb_mid vss sky130_fd_pr__nfet_01v8 w=0.7 l=0.18
X2647 t_Xrx_Xdeser_Xwe0_Xsfb_mid rst_n vss vss sky130_fd_pr__nfet_01v8 w=0.7 l=0.18
X2648 t_Xrx_Xdeser_Xwe0_s2 t_Xrx_Xdeser_Xwe0_qi vdd vdd sky130_fd_pr__pfet_01v8 w=0.95 l=0.18
X2649 t_Xrx_Xdeser_Xwe0_s2 rst_n vdd vdd sky130_fd_pr__pfet_01v8 w=0.95 l=0.18
X2650 t_Xrx_Xdeser_Xwe0_s2 t_Xrx_Xdeser_wcapb t_Xrx_Xdeser_Xwe0_s1 vss sky130_fd_pr__nfet_01v8 w=0.45 l=0.18
X2651 t_Xrx_Xdeser_Xwe0_s2 t_Xrx_Xdeser_wcap t_Xrx_Xdeser_Xwe0_s1 vdd sky130_fd_pr__pfet_01v8 w=0.9 l=0.18
X2652 we0 t_Xrx_Xdeser_Xwe0_s1 vss vss sky130_fd_pr__nfet_01v8 w=0.75 l=0.18
X2653 we0 t_Xrx_Xdeser_Xwe0_s1 vdd vdd sky130_fd_pr__pfet_01v8 w=1.6 l=0.18
X2654 t_Xrx_Xdeser_e0_3 t_Xrx_Xdeser_wcapb t_Xrx_Xdeser_Xwe1_m1 vss sky130_fd_pr__nfet_01v8 w=0.5 l=0.18
X2655 t_Xrx_Xdeser_e0_3 t_Xrx_Xdeser_wcap t_Xrx_Xdeser_Xwe1_m1 vdd sky130_fd_pr__pfet_01v8 w=1 l=0.18
X2656 t_Xrx_Xdeser_Xwe1_m2 t_Xrx_Xdeser_Xwe1_m1 t_Xrx_Xdeser_Xwe1_Xm2_mid vss sky130_fd_pr__nfet_01v8 w=0.75 l=0.18
X2657 t_Xrx_Xdeser_Xwe1_Xm2_mid rst_n vss vss sky130_fd_pr__nfet_01v8 w=0.75 l=0.18
X2658 t_Xrx_Xdeser_Xwe1_m2 t_Xrx_Xdeser_Xwe1_m1 vdd vdd sky130_fd_pr__pfet_01v8 w=1 l=0.18
X2659 t_Xrx_Xdeser_Xwe1_m2 rst_n vdd vdd sky130_fd_pr__pfet_01v8 w=1 l=0.18
X2660 t_Xrx_Xdeser_Xwe1_m3 t_Xrx_Xdeser_Xwe1_m2 vss vss sky130_fd_pr__nfet_01v8 w=0.45 l=0.18
X2661 t_Xrx_Xdeser_Xwe1_m3 t_Xrx_Xdeser_Xwe1_m2 vdd vdd sky130_fd_pr__pfet_01v8 w=0.9 l=0.18
X2662 t_Xrx_Xdeser_Xwe1_m3 t_Xrx_Xdeser_wcap t_Xrx_Xdeser_Xwe1_m1 vss sky130_fd_pr__nfet_01v8 w=0.45 l=0.18
X2663 t_Xrx_Xdeser_Xwe1_m3 t_Xrx_Xdeser_wcapb t_Xrx_Xdeser_Xwe1_m1 vdd sky130_fd_pr__pfet_01v8 w=0.9 l=0.18
X2664 t_Xrx_Xdeser_Xwe1_m2 t_Xrx_Xdeser_wcap t_Xrx_Xdeser_Xwe1_s1 vss sky130_fd_pr__nfet_01v8 w=0.5 l=0.18
X2665 t_Xrx_Xdeser_Xwe1_m2 t_Xrx_Xdeser_wcapb t_Xrx_Xdeser_Xwe1_s1 vdd sky130_fd_pr__pfet_01v8 w=1 l=0.18
X2666 t_Xrx_Xdeser_Xwe1_qi t_Xrx_Xdeser_Xwe1_s1 vss vss sky130_fd_pr__nfet_01v8 w=0.55 l=0.18
X2667 t_Xrx_Xdeser_Xwe1_qi t_Xrx_Xdeser_Xwe1_s1 vdd vdd sky130_fd_pr__pfet_01v8 w=1.2 l=0.18
X2668 t_Xrx_Xdeser_Xwe1_s2 t_Xrx_Xdeser_Xwe1_qi t_Xrx_Xdeser_Xwe1_Xsfb_mid vss sky130_fd_pr__nfet_01v8 w=0.7 l=0.18
X2669 t_Xrx_Xdeser_Xwe1_Xsfb_mid rst_n vss vss sky130_fd_pr__nfet_01v8 w=0.7 l=0.18
X2670 t_Xrx_Xdeser_Xwe1_s2 t_Xrx_Xdeser_Xwe1_qi vdd vdd sky130_fd_pr__pfet_01v8 w=0.95 l=0.18
X2671 t_Xrx_Xdeser_Xwe1_s2 rst_n vdd vdd sky130_fd_pr__pfet_01v8 w=0.95 l=0.18
X2672 t_Xrx_Xdeser_Xwe1_s2 t_Xrx_Xdeser_wcapb t_Xrx_Xdeser_Xwe1_s1 vss sky130_fd_pr__nfet_01v8 w=0.45 l=0.18
X2673 t_Xrx_Xdeser_Xwe1_s2 t_Xrx_Xdeser_wcap t_Xrx_Xdeser_Xwe1_s1 vdd sky130_fd_pr__pfet_01v8 w=0.9 l=0.18
X2674 we1 t_Xrx_Xdeser_Xwe1_s1 vss vss sky130_fd_pr__nfet_01v8 w=0.75 l=0.18
X2675 we1 t_Xrx_Xdeser_Xwe1_s1 vdd vdd sky130_fd_pr__pfet_01v8 w=1.6 l=0.18
X2676 t_Xrx_Xdeser_e1_3 t_Xrx_Xdeser_wcapb t_Xrx_Xdeser_Xwe2_m1 vss sky130_fd_pr__nfet_01v8 w=0.5 l=0.18
X2677 t_Xrx_Xdeser_e1_3 t_Xrx_Xdeser_wcap t_Xrx_Xdeser_Xwe2_m1 vdd sky130_fd_pr__pfet_01v8 w=1 l=0.18
X2678 t_Xrx_Xdeser_Xwe2_m2 t_Xrx_Xdeser_Xwe2_m1 t_Xrx_Xdeser_Xwe2_Xm2_mid vss sky130_fd_pr__nfet_01v8 w=0.75 l=0.18
X2679 t_Xrx_Xdeser_Xwe2_Xm2_mid rst_n vss vss sky130_fd_pr__nfet_01v8 w=0.75 l=0.18
X2680 t_Xrx_Xdeser_Xwe2_m2 t_Xrx_Xdeser_Xwe2_m1 vdd vdd sky130_fd_pr__pfet_01v8 w=1 l=0.18
X2681 t_Xrx_Xdeser_Xwe2_m2 rst_n vdd vdd sky130_fd_pr__pfet_01v8 w=1 l=0.18
X2682 t_Xrx_Xdeser_Xwe2_m3 t_Xrx_Xdeser_Xwe2_m2 vss vss sky130_fd_pr__nfet_01v8 w=0.45 l=0.18
X2683 t_Xrx_Xdeser_Xwe2_m3 t_Xrx_Xdeser_Xwe2_m2 vdd vdd sky130_fd_pr__pfet_01v8 w=0.9 l=0.18
X2684 t_Xrx_Xdeser_Xwe2_m3 t_Xrx_Xdeser_wcap t_Xrx_Xdeser_Xwe2_m1 vss sky130_fd_pr__nfet_01v8 w=0.45 l=0.18
X2685 t_Xrx_Xdeser_Xwe2_m3 t_Xrx_Xdeser_wcapb t_Xrx_Xdeser_Xwe2_m1 vdd sky130_fd_pr__pfet_01v8 w=0.9 l=0.18
X2686 t_Xrx_Xdeser_Xwe2_m2 t_Xrx_Xdeser_wcap t_Xrx_Xdeser_Xwe2_s1 vss sky130_fd_pr__nfet_01v8 w=0.5 l=0.18
X2687 t_Xrx_Xdeser_Xwe2_m2 t_Xrx_Xdeser_wcapb t_Xrx_Xdeser_Xwe2_s1 vdd sky130_fd_pr__pfet_01v8 w=1 l=0.18
X2688 t_Xrx_Xdeser_Xwe2_qi t_Xrx_Xdeser_Xwe2_s1 vss vss sky130_fd_pr__nfet_01v8 w=0.55 l=0.18
X2689 t_Xrx_Xdeser_Xwe2_qi t_Xrx_Xdeser_Xwe2_s1 vdd vdd sky130_fd_pr__pfet_01v8 w=1.2 l=0.18
X2690 t_Xrx_Xdeser_Xwe2_s2 t_Xrx_Xdeser_Xwe2_qi t_Xrx_Xdeser_Xwe2_Xsfb_mid vss sky130_fd_pr__nfet_01v8 w=0.7 l=0.18
X2691 t_Xrx_Xdeser_Xwe2_Xsfb_mid rst_n vss vss sky130_fd_pr__nfet_01v8 w=0.7 l=0.18
X2692 t_Xrx_Xdeser_Xwe2_s2 t_Xrx_Xdeser_Xwe2_qi vdd vdd sky130_fd_pr__pfet_01v8 w=0.95 l=0.18
X2693 t_Xrx_Xdeser_Xwe2_s2 rst_n vdd vdd sky130_fd_pr__pfet_01v8 w=0.95 l=0.18
X2694 t_Xrx_Xdeser_Xwe2_s2 t_Xrx_Xdeser_wcapb t_Xrx_Xdeser_Xwe2_s1 vss sky130_fd_pr__nfet_01v8 w=0.45 l=0.18
X2695 t_Xrx_Xdeser_Xwe2_s2 t_Xrx_Xdeser_wcap t_Xrx_Xdeser_Xwe2_s1 vdd sky130_fd_pr__pfet_01v8 w=0.9 l=0.18
X2696 we2 t_Xrx_Xdeser_Xwe2_s1 vss vss sky130_fd_pr__nfet_01v8 w=0.75 l=0.18
X2697 we2 t_Xrx_Xdeser_Xwe2_s1 vdd vdd sky130_fd_pr__pfet_01v8 w=1.6 l=0.18
X2698 t_Xrx_Xdeser_e2_3 t_Xrx_Xdeser_wcapb t_Xrx_Xdeser_Xwe3_m1 vss sky130_fd_pr__nfet_01v8 w=0.5 l=0.18
X2699 t_Xrx_Xdeser_e2_3 t_Xrx_Xdeser_wcap t_Xrx_Xdeser_Xwe3_m1 vdd sky130_fd_pr__pfet_01v8 w=1 l=0.18
X2700 t_Xrx_Xdeser_Xwe3_m2 t_Xrx_Xdeser_Xwe3_m1 t_Xrx_Xdeser_Xwe3_Xm2_mid vss sky130_fd_pr__nfet_01v8 w=0.75 l=0.18
X2701 t_Xrx_Xdeser_Xwe3_Xm2_mid rst_n vss vss sky130_fd_pr__nfet_01v8 w=0.75 l=0.18
X2702 t_Xrx_Xdeser_Xwe3_m2 t_Xrx_Xdeser_Xwe3_m1 vdd vdd sky130_fd_pr__pfet_01v8 w=1 l=0.18
X2703 t_Xrx_Xdeser_Xwe3_m2 rst_n vdd vdd sky130_fd_pr__pfet_01v8 w=1 l=0.18
X2704 t_Xrx_Xdeser_Xwe3_m3 t_Xrx_Xdeser_Xwe3_m2 vss vss sky130_fd_pr__nfet_01v8 w=0.45 l=0.18
X2705 t_Xrx_Xdeser_Xwe3_m3 t_Xrx_Xdeser_Xwe3_m2 vdd vdd sky130_fd_pr__pfet_01v8 w=0.9 l=0.18
X2706 t_Xrx_Xdeser_Xwe3_m3 t_Xrx_Xdeser_wcap t_Xrx_Xdeser_Xwe3_m1 vss sky130_fd_pr__nfet_01v8 w=0.45 l=0.18
X2707 t_Xrx_Xdeser_Xwe3_m3 t_Xrx_Xdeser_wcapb t_Xrx_Xdeser_Xwe3_m1 vdd sky130_fd_pr__pfet_01v8 w=0.9 l=0.18
X2708 t_Xrx_Xdeser_Xwe3_m2 t_Xrx_Xdeser_wcap t_Xrx_Xdeser_Xwe3_s1 vss sky130_fd_pr__nfet_01v8 w=0.5 l=0.18
X2709 t_Xrx_Xdeser_Xwe3_m2 t_Xrx_Xdeser_wcapb t_Xrx_Xdeser_Xwe3_s1 vdd sky130_fd_pr__pfet_01v8 w=1 l=0.18
X2710 t_Xrx_Xdeser_Xwe3_qi t_Xrx_Xdeser_Xwe3_s1 vss vss sky130_fd_pr__nfet_01v8 w=0.55 l=0.18
X2711 t_Xrx_Xdeser_Xwe3_qi t_Xrx_Xdeser_Xwe3_s1 vdd vdd sky130_fd_pr__pfet_01v8 w=1.2 l=0.18
X2712 t_Xrx_Xdeser_Xwe3_s2 t_Xrx_Xdeser_Xwe3_qi t_Xrx_Xdeser_Xwe3_Xsfb_mid vss sky130_fd_pr__nfet_01v8 w=0.7 l=0.18
X2713 t_Xrx_Xdeser_Xwe3_Xsfb_mid rst_n vss vss sky130_fd_pr__nfet_01v8 w=0.7 l=0.18
X2714 t_Xrx_Xdeser_Xwe3_s2 t_Xrx_Xdeser_Xwe3_qi vdd vdd sky130_fd_pr__pfet_01v8 w=0.95 l=0.18
X2715 t_Xrx_Xdeser_Xwe3_s2 rst_n vdd vdd sky130_fd_pr__pfet_01v8 w=0.95 l=0.18
X2716 t_Xrx_Xdeser_Xwe3_s2 t_Xrx_Xdeser_wcapb t_Xrx_Xdeser_Xwe3_s1 vss sky130_fd_pr__nfet_01v8 w=0.45 l=0.18
X2717 t_Xrx_Xdeser_Xwe3_s2 t_Xrx_Xdeser_wcap t_Xrx_Xdeser_Xwe3_s1 vdd sky130_fd_pr__pfet_01v8 w=0.9 l=0.18
X2718 we3 t_Xrx_Xdeser_Xwe3_s1 vss vss sky130_fd_pr__nfet_01v8 w=0.75 l=0.18
X2719 we3 t_Xrx_Xdeser_Xwe3_s1 vdd vdd sky130_fd_pr__pfet_01v8 w=1.6 l=0.18
X2720 t_Xrx_Xdeser_e3_3 t_Xrx_Xdeser_wcapb t_Xrx_Xdeser_Xwe4_m1 vss sky130_fd_pr__nfet_01v8 w=0.5 l=0.18
X2721 t_Xrx_Xdeser_e3_3 t_Xrx_Xdeser_wcap t_Xrx_Xdeser_Xwe4_m1 vdd sky130_fd_pr__pfet_01v8 w=1 l=0.18
X2722 t_Xrx_Xdeser_Xwe4_m2 t_Xrx_Xdeser_Xwe4_m1 t_Xrx_Xdeser_Xwe4_Xm2_mid vss sky130_fd_pr__nfet_01v8 w=0.75 l=0.18
X2723 t_Xrx_Xdeser_Xwe4_Xm2_mid rst_n vss vss sky130_fd_pr__nfet_01v8 w=0.75 l=0.18
X2724 t_Xrx_Xdeser_Xwe4_m2 t_Xrx_Xdeser_Xwe4_m1 vdd vdd sky130_fd_pr__pfet_01v8 w=1 l=0.18
X2725 t_Xrx_Xdeser_Xwe4_m2 rst_n vdd vdd sky130_fd_pr__pfet_01v8 w=1 l=0.18
X2726 t_Xrx_Xdeser_Xwe4_m3 t_Xrx_Xdeser_Xwe4_m2 vss vss sky130_fd_pr__nfet_01v8 w=0.45 l=0.18
X2727 t_Xrx_Xdeser_Xwe4_m3 t_Xrx_Xdeser_Xwe4_m2 vdd vdd sky130_fd_pr__pfet_01v8 w=0.9 l=0.18
X2728 t_Xrx_Xdeser_Xwe4_m3 t_Xrx_Xdeser_wcap t_Xrx_Xdeser_Xwe4_m1 vss sky130_fd_pr__nfet_01v8 w=0.45 l=0.18
X2729 t_Xrx_Xdeser_Xwe4_m3 t_Xrx_Xdeser_wcapb t_Xrx_Xdeser_Xwe4_m1 vdd sky130_fd_pr__pfet_01v8 w=0.9 l=0.18
X2730 t_Xrx_Xdeser_Xwe4_m2 t_Xrx_Xdeser_wcap t_Xrx_Xdeser_Xwe4_s1 vss sky130_fd_pr__nfet_01v8 w=0.5 l=0.18
X2731 t_Xrx_Xdeser_Xwe4_m2 t_Xrx_Xdeser_wcapb t_Xrx_Xdeser_Xwe4_s1 vdd sky130_fd_pr__pfet_01v8 w=1 l=0.18
X2732 t_Xrx_Xdeser_Xwe4_qi t_Xrx_Xdeser_Xwe4_s1 vss vss sky130_fd_pr__nfet_01v8 w=0.55 l=0.18
X2733 t_Xrx_Xdeser_Xwe4_qi t_Xrx_Xdeser_Xwe4_s1 vdd vdd sky130_fd_pr__pfet_01v8 w=1.2 l=0.18
X2734 t_Xrx_Xdeser_Xwe4_s2 t_Xrx_Xdeser_Xwe4_qi t_Xrx_Xdeser_Xwe4_Xsfb_mid vss sky130_fd_pr__nfet_01v8 w=0.7 l=0.18
X2735 t_Xrx_Xdeser_Xwe4_Xsfb_mid rst_n vss vss sky130_fd_pr__nfet_01v8 w=0.7 l=0.18
X2736 t_Xrx_Xdeser_Xwe4_s2 t_Xrx_Xdeser_Xwe4_qi vdd vdd sky130_fd_pr__pfet_01v8 w=0.95 l=0.18
X2737 t_Xrx_Xdeser_Xwe4_s2 rst_n vdd vdd sky130_fd_pr__pfet_01v8 w=0.95 l=0.18
X2738 t_Xrx_Xdeser_Xwe4_s2 t_Xrx_Xdeser_wcapb t_Xrx_Xdeser_Xwe4_s1 vss sky130_fd_pr__nfet_01v8 w=0.45 l=0.18
X2739 t_Xrx_Xdeser_Xwe4_s2 t_Xrx_Xdeser_wcap t_Xrx_Xdeser_Xwe4_s1 vdd sky130_fd_pr__pfet_01v8 w=0.9 l=0.18
X2740 we4 t_Xrx_Xdeser_Xwe4_s1 vss vss sky130_fd_pr__nfet_01v8 w=0.75 l=0.18
X2741 we4 t_Xrx_Xdeser_Xwe4_s1 vdd vdd sky130_fd_pr__pfet_01v8 w=1.6 l=0.18
X2742 t_Xrx_Xdeser_e0_2 t_Xrx_Xdeser_wcapb t_Xrx_Xdeser_Xwe5_m1 vss sky130_fd_pr__nfet_01v8 w=0.5 l=0.18
X2743 t_Xrx_Xdeser_e0_2 t_Xrx_Xdeser_wcap t_Xrx_Xdeser_Xwe5_m1 vdd sky130_fd_pr__pfet_01v8 w=1 l=0.18
X2744 t_Xrx_Xdeser_Xwe5_m2 t_Xrx_Xdeser_Xwe5_m1 t_Xrx_Xdeser_Xwe5_Xm2_mid vss sky130_fd_pr__nfet_01v8 w=0.75 l=0.18
X2745 t_Xrx_Xdeser_Xwe5_Xm2_mid rst_n vss vss sky130_fd_pr__nfet_01v8 w=0.75 l=0.18
X2746 t_Xrx_Xdeser_Xwe5_m2 t_Xrx_Xdeser_Xwe5_m1 vdd vdd sky130_fd_pr__pfet_01v8 w=1 l=0.18
X2747 t_Xrx_Xdeser_Xwe5_m2 rst_n vdd vdd sky130_fd_pr__pfet_01v8 w=1 l=0.18
X2748 t_Xrx_Xdeser_Xwe5_m3 t_Xrx_Xdeser_Xwe5_m2 vss vss sky130_fd_pr__nfet_01v8 w=0.45 l=0.18
X2749 t_Xrx_Xdeser_Xwe5_m3 t_Xrx_Xdeser_Xwe5_m2 vdd vdd sky130_fd_pr__pfet_01v8 w=0.9 l=0.18
X2750 t_Xrx_Xdeser_Xwe5_m3 t_Xrx_Xdeser_wcap t_Xrx_Xdeser_Xwe5_m1 vss sky130_fd_pr__nfet_01v8 w=0.45 l=0.18
X2751 t_Xrx_Xdeser_Xwe5_m3 t_Xrx_Xdeser_wcapb t_Xrx_Xdeser_Xwe5_m1 vdd sky130_fd_pr__pfet_01v8 w=0.9 l=0.18
X2752 t_Xrx_Xdeser_Xwe5_m2 t_Xrx_Xdeser_wcap t_Xrx_Xdeser_Xwe5_s1 vss sky130_fd_pr__nfet_01v8 w=0.5 l=0.18
X2753 t_Xrx_Xdeser_Xwe5_m2 t_Xrx_Xdeser_wcapb t_Xrx_Xdeser_Xwe5_s1 vdd sky130_fd_pr__pfet_01v8 w=1 l=0.18
X2754 t_Xrx_Xdeser_Xwe5_qi t_Xrx_Xdeser_Xwe5_s1 vss vss sky130_fd_pr__nfet_01v8 w=0.55 l=0.18
X2755 t_Xrx_Xdeser_Xwe5_qi t_Xrx_Xdeser_Xwe5_s1 vdd vdd sky130_fd_pr__pfet_01v8 w=1.2 l=0.18
X2756 t_Xrx_Xdeser_Xwe5_s2 t_Xrx_Xdeser_Xwe5_qi t_Xrx_Xdeser_Xwe5_Xsfb_mid vss sky130_fd_pr__nfet_01v8 w=0.7 l=0.18
X2757 t_Xrx_Xdeser_Xwe5_Xsfb_mid rst_n vss vss sky130_fd_pr__nfet_01v8 w=0.7 l=0.18
X2758 t_Xrx_Xdeser_Xwe5_s2 t_Xrx_Xdeser_Xwe5_qi vdd vdd sky130_fd_pr__pfet_01v8 w=0.95 l=0.18
X2759 t_Xrx_Xdeser_Xwe5_s2 rst_n vdd vdd sky130_fd_pr__pfet_01v8 w=0.95 l=0.18
X2760 t_Xrx_Xdeser_Xwe5_s2 t_Xrx_Xdeser_wcapb t_Xrx_Xdeser_Xwe5_s1 vss sky130_fd_pr__nfet_01v8 w=0.45 l=0.18
X2761 t_Xrx_Xdeser_Xwe5_s2 t_Xrx_Xdeser_wcap t_Xrx_Xdeser_Xwe5_s1 vdd sky130_fd_pr__pfet_01v8 w=0.9 l=0.18
X2762 we5 t_Xrx_Xdeser_Xwe5_s1 vss vss sky130_fd_pr__nfet_01v8 w=0.75 l=0.18
X2763 we5 t_Xrx_Xdeser_Xwe5_s1 vdd vdd sky130_fd_pr__pfet_01v8 w=1.6 l=0.18
X2764 t_Xrx_Xdeser_e1_2 t_Xrx_Xdeser_wcapb t_Xrx_Xdeser_Xwe6_m1 vss sky130_fd_pr__nfet_01v8 w=0.5 l=0.18
X2765 t_Xrx_Xdeser_e1_2 t_Xrx_Xdeser_wcap t_Xrx_Xdeser_Xwe6_m1 vdd sky130_fd_pr__pfet_01v8 w=1 l=0.18
X2766 t_Xrx_Xdeser_Xwe6_m2 t_Xrx_Xdeser_Xwe6_m1 t_Xrx_Xdeser_Xwe6_Xm2_mid vss sky130_fd_pr__nfet_01v8 w=0.75 l=0.18
X2767 t_Xrx_Xdeser_Xwe6_Xm2_mid rst_n vss vss sky130_fd_pr__nfet_01v8 w=0.75 l=0.18
X2768 t_Xrx_Xdeser_Xwe6_m2 t_Xrx_Xdeser_Xwe6_m1 vdd vdd sky130_fd_pr__pfet_01v8 w=1 l=0.18
X2769 t_Xrx_Xdeser_Xwe6_m2 rst_n vdd vdd sky130_fd_pr__pfet_01v8 w=1 l=0.18
X2770 t_Xrx_Xdeser_Xwe6_m3 t_Xrx_Xdeser_Xwe6_m2 vss vss sky130_fd_pr__nfet_01v8 w=0.45 l=0.18
X2771 t_Xrx_Xdeser_Xwe6_m3 t_Xrx_Xdeser_Xwe6_m2 vdd vdd sky130_fd_pr__pfet_01v8 w=0.9 l=0.18
X2772 t_Xrx_Xdeser_Xwe6_m3 t_Xrx_Xdeser_wcap t_Xrx_Xdeser_Xwe6_m1 vss sky130_fd_pr__nfet_01v8 w=0.45 l=0.18
X2773 t_Xrx_Xdeser_Xwe6_m3 t_Xrx_Xdeser_wcapb t_Xrx_Xdeser_Xwe6_m1 vdd sky130_fd_pr__pfet_01v8 w=0.9 l=0.18
X2774 t_Xrx_Xdeser_Xwe6_m2 t_Xrx_Xdeser_wcap t_Xrx_Xdeser_Xwe6_s1 vss sky130_fd_pr__nfet_01v8 w=0.5 l=0.18
X2775 t_Xrx_Xdeser_Xwe6_m2 t_Xrx_Xdeser_wcapb t_Xrx_Xdeser_Xwe6_s1 vdd sky130_fd_pr__pfet_01v8 w=1 l=0.18
X2776 t_Xrx_Xdeser_Xwe6_qi t_Xrx_Xdeser_Xwe6_s1 vss vss sky130_fd_pr__nfet_01v8 w=0.55 l=0.18
X2777 t_Xrx_Xdeser_Xwe6_qi t_Xrx_Xdeser_Xwe6_s1 vdd vdd sky130_fd_pr__pfet_01v8 w=1.2 l=0.18
X2778 t_Xrx_Xdeser_Xwe6_s2 t_Xrx_Xdeser_Xwe6_qi t_Xrx_Xdeser_Xwe6_Xsfb_mid vss sky130_fd_pr__nfet_01v8 w=0.7 l=0.18
X2779 t_Xrx_Xdeser_Xwe6_Xsfb_mid rst_n vss vss sky130_fd_pr__nfet_01v8 w=0.7 l=0.18
X2780 t_Xrx_Xdeser_Xwe6_s2 t_Xrx_Xdeser_Xwe6_qi vdd vdd sky130_fd_pr__pfet_01v8 w=0.95 l=0.18
X2781 t_Xrx_Xdeser_Xwe6_s2 rst_n vdd vdd sky130_fd_pr__pfet_01v8 w=0.95 l=0.18
X2782 t_Xrx_Xdeser_Xwe6_s2 t_Xrx_Xdeser_wcapb t_Xrx_Xdeser_Xwe6_s1 vss sky130_fd_pr__nfet_01v8 w=0.45 l=0.18
X2783 t_Xrx_Xdeser_Xwe6_s2 t_Xrx_Xdeser_wcap t_Xrx_Xdeser_Xwe6_s1 vdd sky130_fd_pr__pfet_01v8 w=0.9 l=0.18
X2784 we6 t_Xrx_Xdeser_Xwe6_s1 vss vss sky130_fd_pr__nfet_01v8 w=0.75 l=0.18
X2785 we6 t_Xrx_Xdeser_Xwe6_s1 vdd vdd sky130_fd_pr__pfet_01v8 w=1.6 l=0.18
X2786 t_Xrx_Xdeser_e2_2 t_Xrx_Xdeser_wcapb t_Xrx_Xdeser_Xwe7_m1 vss sky130_fd_pr__nfet_01v8 w=0.5 l=0.18
X2787 t_Xrx_Xdeser_e2_2 t_Xrx_Xdeser_wcap t_Xrx_Xdeser_Xwe7_m1 vdd sky130_fd_pr__pfet_01v8 w=1 l=0.18
X2788 t_Xrx_Xdeser_Xwe7_m2 t_Xrx_Xdeser_Xwe7_m1 t_Xrx_Xdeser_Xwe7_Xm2_mid vss sky130_fd_pr__nfet_01v8 w=0.75 l=0.18
X2789 t_Xrx_Xdeser_Xwe7_Xm2_mid rst_n vss vss sky130_fd_pr__nfet_01v8 w=0.75 l=0.18
X2790 t_Xrx_Xdeser_Xwe7_m2 t_Xrx_Xdeser_Xwe7_m1 vdd vdd sky130_fd_pr__pfet_01v8 w=1 l=0.18
X2791 t_Xrx_Xdeser_Xwe7_m2 rst_n vdd vdd sky130_fd_pr__pfet_01v8 w=1 l=0.18
X2792 t_Xrx_Xdeser_Xwe7_m3 t_Xrx_Xdeser_Xwe7_m2 vss vss sky130_fd_pr__nfet_01v8 w=0.45 l=0.18
X2793 t_Xrx_Xdeser_Xwe7_m3 t_Xrx_Xdeser_Xwe7_m2 vdd vdd sky130_fd_pr__pfet_01v8 w=0.9 l=0.18
X2794 t_Xrx_Xdeser_Xwe7_m3 t_Xrx_Xdeser_wcap t_Xrx_Xdeser_Xwe7_m1 vss sky130_fd_pr__nfet_01v8 w=0.45 l=0.18
X2795 t_Xrx_Xdeser_Xwe7_m3 t_Xrx_Xdeser_wcapb t_Xrx_Xdeser_Xwe7_m1 vdd sky130_fd_pr__pfet_01v8 w=0.9 l=0.18
X2796 t_Xrx_Xdeser_Xwe7_m2 t_Xrx_Xdeser_wcap t_Xrx_Xdeser_Xwe7_s1 vss sky130_fd_pr__nfet_01v8 w=0.5 l=0.18
X2797 t_Xrx_Xdeser_Xwe7_m2 t_Xrx_Xdeser_wcapb t_Xrx_Xdeser_Xwe7_s1 vdd sky130_fd_pr__pfet_01v8 w=1 l=0.18
X2798 t_Xrx_Xdeser_Xwe7_qi t_Xrx_Xdeser_Xwe7_s1 vss vss sky130_fd_pr__nfet_01v8 w=0.55 l=0.18
X2799 t_Xrx_Xdeser_Xwe7_qi t_Xrx_Xdeser_Xwe7_s1 vdd vdd sky130_fd_pr__pfet_01v8 w=1.2 l=0.18
X2800 t_Xrx_Xdeser_Xwe7_s2 t_Xrx_Xdeser_Xwe7_qi t_Xrx_Xdeser_Xwe7_Xsfb_mid vss sky130_fd_pr__nfet_01v8 w=0.7 l=0.18
X2801 t_Xrx_Xdeser_Xwe7_Xsfb_mid rst_n vss vss sky130_fd_pr__nfet_01v8 w=0.7 l=0.18
X2802 t_Xrx_Xdeser_Xwe7_s2 t_Xrx_Xdeser_Xwe7_qi vdd vdd sky130_fd_pr__pfet_01v8 w=0.95 l=0.18
X2803 t_Xrx_Xdeser_Xwe7_s2 rst_n vdd vdd sky130_fd_pr__pfet_01v8 w=0.95 l=0.18
X2804 t_Xrx_Xdeser_Xwe7_s2 t_Xrx_Xdeser_wcapb t_Xrx_Xdeser_Xwe7_s1 vss sky130_fd_pr__nfet_01v8 w=0.45 l=0.18
X2805 t_Xrx_Xdeser_Xwe7_s2 t_Xrx_Xdeser_wcap t_Xrx_Xdeser_Xwe7_s1 vdd sky130_fd_pr__pfet_01v8 w=0.9 l=0.18
X2806 we7 t_Xrx_Xdeser_Xwe7_s1 vss vss sky130_fd_pr__nfet_01v8 w=0.75 l=0.18
X2807 we7 t_Xrx_Xdeser_Xwe7_s1 vdd vdd sky130_fd_pr__pfet_01v8 w=1.6 l=0.18
X2808 t_Xrx_Xdeser_e3_2 t_Xrx_Xdeser_wcapb t_Xrx_Xdeser_Xwe8_m1 vss sky130_fd_pr__nfet_01v8 w=0.5 l=0.18
X2809 t_Xrx_Xdeser_e3_2 t_Xrx_Xdeser_wcap t_Xrx_Xdeser_Xwe8_m1 vdd sky130_fd_pr__pfet_01v8 w=1 l=0.18
X2810 t_Xrx_Xdeser_Xwe8_m2 t_Xrx_Xdeser_Xwe8_m1 t_Xrx_Xdeser_Xwe8_Xm2_mid vss sky130_fd_pr__nfet_01v8 w=0.75 l=0.18
X2811 t_Xrx_Xdeser_Xwe8_Xm2_mid rst_n vss vss sky130_fd_pr__nfet_01v8 w=0.75 l=0.18
X2812 t_Xrx_Xdeser_Xwe8_m2 t_Xrx_Xdeser_Xwe8_m1 vdd vdd sky130_fd_pr__pfet_01v8 w=1 l=0.18
X2813 t_Xrx_Xdeser_Xwe8_m2 rst_n vdd vdd sky130_fd_pr__pfet_01v8 w=1 l=0.18
X2814 t_Xrx_Xdeser_Xwe8_m3 t_Xrx_Xdeser_Xwe8_m2 vss vss sky130_fd_pr__nfet_01v8 w=0.45 l=0.18
X2815 t_Xrx_Xdeser_Xwe8_m3 t_Xrx_Xdeser_Xwe8_m2 vdd vdd sky130_fd_pr__pfet_01v8 w=0.9 l=0.18
X2816 t_Xrx_Xdeser_Xwe8_m3 t_Xrx_Xdeser_wcap t_Xrx_Xdeser_Xwe8_m1 vss sky130_fd_pr__nfet_01v8 w=0.45 l=0.18
X2817 t_Xrx_Xdeser_Xwe8_m3 t_Xrx_Xdeser_wcapb t_Xrx_Xdeser_Xwe8_m1 vdd sky130_fd_pr__pfet_01v8 w=0.9 l=0.18
X2818 t_Xrx_Xdeser_Xwe8_m2 t_Xrx_Xdeser_wcap t_Xrx_Xdeser_Xwe8_s1 vss sky130_fd_pr__nfet_01v8 w=0.5 l=0.18
X2819 t_Xrx_Xdeser_Xwe8_m2 t_Xrx_Xdeser_wcapb t_Xrx_Xdeser_Xwe8_s1 vdd sky130_fd_pr__pfet_01v8 w=1 l=0.18
X2820 t_Xrx_Xdeser_Xwe8_qi t_Xrx_Xdeser_Xwe8_s1 vss vss sky130_fd_pr__nfet_01v8 w=0.55 l=0.18
X2821 t_Xrx_Xdeser_Xwe8_qi t_Xrx_Xdeser_Xwe8_s1 vdd vdd sky130_fd_pr__pfet_01v8 w=1.2 l=0.18
X2822 t_Xrx_Xdeser_Xwe8_s2 t_Xrx_Xdeser_Xwe8_qi t_Xrx_Xdeser_Xwe8_Xsfb_mid vss sky130_fd_pr__nfet_01v8 w=0.7 l=0.18
X2823 t_Xrx_Xdeser_Xwe8_Xsfb_mid rst_n vss vss sky130_fd_pr__nfet_01v8 w=0.7 l=0.18
X2824 t_Xrx_Xdeser_Xwe8_s2 t_Xrx_Xdeser_Xwe8_qi vdd vdd sky130_fd_pr__pfet_01v8 w=0.95 l=0.18
X2825 t_Xrx_Xdeser_Xwe8_s2 rst_n vdd vdd sky130_fd_pr__pfet_01v8 w=0.95 l=0.18
X2826 t_Xrx_Xdeser_Xwe8_s2 t_Xrx_Xdeser_wcapb t_Xrx_Xdeser_Xwe8_s1 vss sky130_fd_pr__nfet_01v8 w=0.45 l=0.18
X2827 t_Xrx_Xdeser_Xwe8_s2 t_Xrx_Xdeser_wcap t_Xrx_Xdeser_Xwe8_s1 vdd sky130_fd_pr__pfet_01v8 w=0.9 l=0.18
X2828 we8 t_Xrx_Xdeser_Xwe8_s1 vss vss sky130_fd_pr__nfet_01v8 w=0.75 l=0.18
X2829 we8 t_Xrx_Xdeser_Xwe8_s1 vdd vdd sky130_fd_pr__pfet_01v8 w=1.6 l=0.18
X2830 t_Xrx_Xdeser_e0_1 t_Xrx_Xdeser_wcapb t_Xrx_Xdeser_Xwe9_m1 vss sky130_fd_pr__nfet_01v8 w=0.5 l=0.18
X2831 t_Xrx_Xdeser_e0_1 t_Xrx_Xdeser_wcap t_Xrx_Xdeser_Xwe9_m1 vdd sky130_fd_pr__pfet_01v8 w=1 l=0.18
X2832 t_Xrx_Xdeser_Xwe9_m2 t_Xrx_Xdeser_Xwe9_m1 t_Xrx_Xdeser_Xwe9_Xm2_mid vss sky130_fd_pr__nfet_01v8 w=0.75 l=0.18
X2833 t_Xrx_Xdeser_Xwe9_Xm2_mid rst_n vss vss sky130_fd_pr__nfet_01v8 w=0.75 l=0.18
X2834 t_Xrx_Xdeser_Xwe9_m2 t_Xrx_Xdeser_Xwe9_m1 vdd vdd sky130_fd_pr__pfet_01v8 w=1 l=0.18
X2835 t_Xrx_Xdeser_Xwe9_m2 rst_n vdd vdd sky130_fd_pr__pfet_01v8 w=1 l=0.18
X2836 t_Xrx_Xdeser_Xwe9_m3 t_Xrx_Xdeser_Xwe9_m2 vss vss sky130_fd_pr__nfet_01v8 w=0.45 l=0.18
X2837 t_Xrx_Xdeser_Xwe9_m3 t_Xrx_Xdeser_Xwe9_m2 vdd vdd sky130_fd_pr__pfet_01v8 w=0.9 l=0.18
X2838 t_Xrx_Xdeser_Xwe9_m3 t_Xrx_Xdeser_wcap t_Xrx_Xdeser_Xwe9_m1 vss sky130_fd_pr__nfet_01v8 w=0.45 l=0.18
X2839 t_Xrx_Xdeser_Xwe9_m3 t_Xrx_Xdeser_wcapb t_Xrx_Xdeser_Xwe9_m1 vdd sky130_fd_pr__pfet_01v8 w=0.9 l=0.18
X2840 t_Xrx_Xdeser_Xwe9_m2 t_Xrx_Xdeser_wcap t_Xrx_Xdeser_Xwe9_s1 vss sky130_fd_pr__nfet_01v8 w=0.5 l=0.18
X2841 t_Xrx_Xdeser_Xwe9_m2 t_Xrx_Xdeser_wcapb t_Xrx_Xdeser_Xwe9_s1 vdd sky130_fd_pr__pfet_01v8 w=1 l=0.18
X2842 t_Xrx_Xdeser_Xwe9_qi t_Xrx_Xdeser_Xwe9_s1 vss vss sky130_fd_pr__nfet_01v8 w=0.55 l=0.18
X2843 t_Xrx_Xdeser_Xwe9_qi t_Xrx_Xdeser_Xwe9_s1 vdd vdd sky130_fd_pr__pfet_01v8 w=1.2 l=0.18
X2844 t_Xrx_Xdeser_Xwe9_s2 t_Xrx_Xdeser_Xwe9_qi t_Xrx_Xdeser_Xwe9_Xsfb_mid vss sky130_fd_pr__nfet_01v8 w=0.7 l=0.18
X2845 t_Xrx_Xdeser_Xwe9_Xsfb_mid rst_n vss vss sky130_fd_pr__nfet_01v8 w=0.7 l=0.18
X2846 t_Xrx_Xdeser_Xwe9_s2 t_Xrx_Xdeser_Xwe9_qi vdd vdd sky130_fd_pr__pfet_01v8 w=0.95 l=0.18
X2847 t_Xrx_Xdeser_Xwe9_s2 rst_n vdd vdd sky130_fd_pr__pfet_01v8 w=0.95 l=0.18
X2848 t_Xrx_Xdeser_Xwe9_s2 t_Xrx_Xdeser_wcapb t_Xrx_Xdeser_Xwe9_s1 vss sky130_fd_pr__nfet_01v8 w=0.45 l=0.18
X2849 t_Xrx_Xdeser_Xwe9_s2 t_Xrx_Xdeser_wcap t_Xrx_Xdeser_Xwe9_s1 vdd sky130_fd_pr__pfet_01v8 w=0.9 l=0.18
X2850 we9 t_Xrx_Xdeser_Xwe9_s1 vss vss sky130_fd_pr__nfet_01v8 w=0.75 l=0.18
X2851 we9 t_Xrx_Xdeser_Xwe9_s1 vdd vdd sky130_fd_pr__pfet_01v8 w=1.6 l=0.18
X2852 t_Xrx_Xdeser_e1_1 t_Xrx_Xdeser_wcapb t_Xrx_Xdeser_Xwe10_m1 vss sky130_fd_pr__nfet_01v8 w=0.5 l=0.18
X2853 t_Xrx_Xdeser_e1_1 t_Xrx_Xdeser_wcap t_Xrx_Xdeser_Xwe10_m1 vdd sky130_fd_pr__pfet_01v8 w=1 l=0.18
X2854 t_Xrx_Xdeser_Xwe10_m2 t_Xrx_Xdeser_Xwe10_m1 t_Xrx_Xdeser_Xwe10_Xm2_mid vss sky130_fd_pr__nfet_01v8 w=0.75 l=0.18
X2855 t_Xrx_Xdeser_Xwe10_Xm2_mid rst_n vss vss sky130_fd_pr__nfet_01v8 w=0.75 l=0.18
X2856 t_Xrx_Xdeser_Xwe10_m2 t_Xrx_Xdeser_Xwe10_m1 vdd vdd sky130_fd_pr__pfet_01v8 w=1 l=0.18
X2857 t_Xrx_Xdeser_Xwe10_m2 rst_n vdd vdd sky130_fd_pr__pfet_01v8 w=1 l=0.18
X2858 t_Xrx_Xdeser_Xwe10_m3 t_Xrx_Xdeser_Xwe10_m2 vss vss sky130_fd_pr__nfet_01v8 w=0.45 l=0.18
X2859 t_Xrx_Xdeser_Xwe10_m3 t_Xrx_Xdeser_Xwe10_m2 vdd vdd sky130_fd_pr__pfet_01v8 w=0.9 l=0.18
X2860 t_Xrx_Xdeser_Xwe10_m3 t_Xrx_Xdeser_wcap t_Xrx_Xdeser_Xwe10_m1 vss sky130_fd_pr__nfet_01v8 w=0.45 l=0.18
X2861 t_Xrx_Xdeser_Xwe10_m3 t_Xrx_Xdeser_wcapb t_Xrx_Xdeser_Xwe10_m1 vdd sky130_fd_pr__pfet_01v8 w=0.9 l=0.18
X2862 t_Xrx_Xdeser_Xwe10_m2 t_Xrx_Xdeser_wcap t_Xrx_Xdeser_Xwe10_s1 vss sky130_fd_pr__nfet_01v8 w=0.5 l=0.18
X2863 t_Xrx_Xdeser_Xwe10_m2 t_Xrx_Xdeser_wcapb t_Xrx_Xdeser_Xwe10_s1 vdd sky130_fd_pr__pfet_01v8 w=1 l=0.18
X2864 t_Xrx_Xdeser_Xwe10_qi t_Xrx_Xdeser_Xwe10_s1 vss vss sky130_fd_pr__nfet_01v8 w=0.55 l=0.18
X2865 t_Xrx_Xdeser_Xwe10_qi t_Xrx_Xdeser_Xwe10_s1 vdd vdd sky130_fd_pr__pfet_01v8 w=1.2 l=0.18
X2866 t_Xrx_Xdeser_Xwe10_s2 t_Xrx_Xdeser_Xwe10_qi t_Xrx_Xdeser_Xwe10_Xsfb_mid vss sky130_fd_pr__nfet_01v8 w=0.7 l=0.18
X2867 t_Xrx_Xdeser_Xwe10_Xsfb_mid rst_n vss vss sky130_fd_pr__nfet_01v8 w=0.7 l=0.18
X2868 t_Xrx_Xdeser_Xwe10_s2 t_Xrx_Xdeser_Xwe10_qi vdd vdd sky130_fd_pr__pfet_01v8 w=0.95 l=0.18
X2869 t_Xrx_Xdeser_Xwe10_s2 rst_n vdd vdd sky130_fd_pr__pfet_01v8 w=0.95 l=0.18
X2870 t_Xrx_Xdeser_Xwe10_s2 t_Xrx_Xdeser_wcapb t_Xrx_Xdeser_Xwe10_s1 vss sky130_fd_pr__nfet_01v8 w=0.45 l=0.18
X2871 t_Xrx_Xdeser_Xwe10_s2 t_Xrx_Xdeser_wcap t_Xrx_Xdeser_Xwe10_s1 vdd sky130_fd_pr__pfet_01v8 w=0.9 l=0.18
X2872 we10 t_Xrx_Xdeser_Xwe10_s1 vss vss sky130_fd_pr__nfet_01v8 w=0.75 l=0.18
X2873 we10 t_Xrx_Xdeser_Xwe10_s1 vdd vdd sky130_fd_pr__pfet_01v8 w=1.6 l=0.18
X2874 t_Xrx_Xdeser_e2_1 t_Xrx_Xdeser_wcapb t_Xrx_Xdeser_Xwe11_m1 vss sky130_fd_pr__nfet_01v8 w=0.5 l=0.18
X2875 t_Xrx_Xdeser_e2_1 t_Xrx_Xdeser_wcap t_Xrx_Xdeser_Xwe11_m1 vdd sky130_fd_pr__pfet_01v8 w=1 l=0.18
X2876 t_Xrx_Xdeser_Xwe11_m2 t_Xrx_Xdeser_Xwe11_m1 t_Xrx_Xdeser_Xwe11_Xm2_mid vss sky130_fd_pr__nfet_01v8 w=0.75 l=0.18
X2877 t_Xrx_Xdeser_Xwe11_Xm2_mid rst_n vss vss sky130_fd_pr__nfet_01v8 w=0.75 l=0.18
X2878 t_Xrx_Xdeser_Xwe11_m2 t_Xrx_Xdeser_Xwe11_m1 vdd vdd sky130_fd_pr__pfet_01v8 w=1 l=0.18
X2879 t_Xrx_Xdeser_Xwe11_m2 rst_n vdd vdd sky130_fd_pr__pfet_01v8 w=1 l=0.18
X2880 t_Xrx_Xdeser_Xwe11_m3 t_Xrx_Xdeser_Xwe11_m2 vss vss sky130_fd_pr__nfet_01v8 w=0.45 l=0.18
X2881 t_Xrx_Xdeser_Xwe11_m3 t_Xrx_Xdeser_Xwe11_m2 vdd vdd sky130_fd_pr__pfet_01v8 w=0.9 l=0.18
X2882 t_Xrx_Xdeser_Xwe11_m3 t_Xrx_Xdeser_wcap t_Xrx_Xdeser_Xwe11_m1 vss sky130_fd_pr__nfet_01v8 w=0.45 l=0.18
X2883 t_Xrx_Xdeser_Xwe11_m3 t_Xrx_Xdeser_wcapb t_Xrx_Xdeser_Xwe11_m1 vdd sky130_fd_pr__pfet_01v8 w=0.9 l=0.18
X2884 t_Xrx_Xdeser_Xwe11_m2 t_Xrx_Xdeser_wcap t_Xrx_Xdeser_Xwe11_s1 vss sky130_fd_pr__nfet_01v8 w=0.5 l=0.18
X2885 t_Xrx_Xdeser_Xwe11_m2 t_Xrx_Xdeser_wcapb t_Xrx_Xdeser_Xwe11_s1 vdd sky130_fd_pr__pfet_01v8 w=1 l=0.18
X2886 t_Xrx_Xdeser_Xwe11_qi t_Xrx_Xdeser_Xwe11_s1 vss vss sky130_fd_pr__nfet_01v8 w=0.55 l=0.18
X2887 t_Xrx_Xdeser_Xwe11_qi t_Xrx_Xdeser_Xwe11_s1 vdd vdd sky130_fd_pr__pfet_01v8 w=1.2 l=0.18
X2888 t_Xrx_Xdeser_Xwe11_s2 t_Xrx_Xdeser_Xwe11_qi t_Xrx_Xdeser_Xwe11_Xsfb_mid vss sky130_fd_pr__nfet_01v8 w=0.7 l=0.18
X2889 t_Xrx_Xdeser_Xwe11_Xsfb_mid rst_n vss vss sky130_fd_pr__nfet_01v8 w=0.7 l=0.18
X2890 t_Xrx_Xdeser_Xwe11_s2 t_Xrx_Xdeser_Xwe11_qi vdd vdd sky130_fd_pr__pfet_01v8 w=0.95 l=0.18
X2891 t_Xrx_Xdeser_Xwe11_s2 rst_n vdd vdd sky130_fd_pr__pfet_01v8 w=0.95 l=0.18
X2892 t_Xrx_Xdeser_Xwe11_s2 t_Xrx_Xdeser_wcapb t_Xrx_Xdeser_Xwe11_s1 vss sky130_fd_pr__nfet_01v8 w=0.45 l=0.18
X2893 t_Xrx_Xdeser_Xwe11_s2 t_Xrx_Xdeser_wcap t_Xrx_Xdeser_Xwe11_s1 vdd sky130_fd_pr__pfet_01v8 w=0.9 l=0.18
X2894 we11 t_Xrx_Xdeser_Xwe11_s1 vss vss sky130_fd_pr__nfet_01v8 w=0.75 l=0.18
X2895 we11 t_Xrx_Xdeser_Xwe11_s1 vdd vdd sky130_fd_pr__pfet_01v8 w=1.6 l=0.18
X2896 t_Xrx_Xdeser_e3_1 t_Xrx_Xdeser_wcapb t_Xrx_Xdeser_Xwe12_m1 vss sky130_fd_pr__nfet_01v8 w=0.5 l=0.18
X2897 t_Xrx_Xdeser_e3_1 t_Xrx_Xdeser_wcap t_Xrx_Xdeser_Xwe12_m1 vdd sky130_fd_pr__pfet_01v8 w=1 l=0.18
X2898 t_Xrx_Xdeser_Xwe12_m2 t_Xrx_Xdeser_Xwe12_m1 t_Xrx_Xdeser_Xwe12_Xm2_mid vss sky130_fd_pr__nfet_01v8 w=0.75 l=0.18
X2899 t_Xrx_Xdeser_Xwe12_Xm2_mid rst_n vss vss sky130_fd_pr__nfet_01v8 w=0.75 l=0.18
X2900 t_Xrx_Xdeser_Xwe12_m2 t_Xrx_Xdeser_Xwe12_m1 vdd vdd sky130_fd_pr__pfet_01v8 w=1 l=0.18
X2901 t_Xrx_Xdeser_Xwe12_m2 rst_n vdd vdd sky130_fd_pr__pfet_01v8 w=1 l=0.18
X2902 t_Xrx_Xdeser_Xwe12_m3 t_Xrx_Xdeser_Xwe12_m2 vss vss sky130_fd_pr__nfet_01v8 w=0.45 l=0.18
X2903 t_Xrx_Xdeser_Xwe12_m3 t_Xrx_Xdeser_Xwe12_m2 vdd vdd sky130_fd_pr__pfet_01v8 w=0.9 l=0.18
X2904 t_Xrx_Xdeser_Xwe12_m3 t_Xrx_Xdeser_wcap t_Xrx_Xdeser_Xwe12_m1 vss sky130_fd_pr__nfet_01v8 w=0.45 l=0.18
X2905 t_Xrx_Xdeser_Xwe12_m3 t_Xrx_Xdeser_wcapb t_Xrx_Xdeser_Xwe12_m1 vdd sky130_fd_pr__pfet_01v8 w=0.9 l=0.18
X2906 t_Xrx_Xdeser_Xwe12_m2 t_Xrx_Xdeser_wcap t_Xrx_Xdeser_Xwe12_s1 vss sky130_fd_pr__nfet_01v8 w=0.5 l=0.18
X2907 t_Xrx_Xdeser_Xwe12_m2 t_Xrx_Xdeser_wcapb t_Xrx_Xdeser_Xwe12_s1 vdd sky130_fd_pr__pfet_01v8 w=1 l=0.18
X2908 t_Xrx_Xdeser_Xwe12_qi t_Xrx_Xdeser_Xwe12_s1 vss vss sky130_fd_pr__nfet_01v8 w=0.55 l=0.18
X2909 t_Xrx_Xdeser_Xwe12_qi t_Xrx_Xdeser_Xwe12_s1 vdd vdd sky130_fd_pr__pfet_01v8 w=1.2 l=0.18
X2910 t_Xrx_Xdeser_Xwe12_s2 t_Xrx_Xdeser_Xwe12_qi t_Xrx_Xdeser_Xwe12_Xsfb_mid vss sky130_fd_pr__nfet_01v8 w=0.7 l=0.18
X2911 t_Xrx_Xdeser_Xwe12_Xsfb_mid rst_n vss vss sky130_fd_pr__nfet_01v8 w=0.7 l=0.18
X2912 t_Xrx_Xdeser_Xwe12_s2 t_Xrx_Xdeser_Xwe12_qi vdd vdd sky130_fd_pr__pfet_01v8 w=0.95 l=0.18
X2913 t_Xrx_Xdeser_Xwe12_s2 rst_n vdd vdd sky130_fd_pr__pfet_01v8 w=0.95 l=0.18
X2914 t_Xrx_Xdeser_Xwe12_s2 t_Xrx_Xdeser_wcapb t_Xrx_Xdeser_Xwe12_s1 vss sky130_fd_pr__nfet_01v8 w=0.45 l=0.18
X2915 t_Xrx_Xdeser_Xwe12_s2 t_Xrx_Xdeser_wcap t_Xrx_Xdeser_Xwe12_s1 vdd sky130_fd_pr__pfet_01v8 w=0.9 l=0.18
X2916 we12 t_Xrx_Xdeser_Xwe12_s1 vss vss sky130_fd_pr__nfet_01v8 w=0.75 l=0.18
X2917 we12 t_Xrx_Xdeser_Xwe12_s1 vdd vdd sky130_fd_pr__pfet_01v8 w=1.6 l=0.18
X2918 t_Xrx_Xdeser_e0_0 t_Xrx_Xdeser_wcapb t_Xrx_Xdeser_Xwe13_m1 vss sky130_fd_pr__nfet_01v8 w=0.5 l=0.18
X2919 t_Xrx_Xdeser_e0_0 t_Xrx_Xdeser_wcap t_Xrx_Xdeser_Xwe13_m1 vdd sky130_fd_pr__pfet_01v8 w=1 l=0.18
X2920 t_Xrx_Xdeser_Xwe13_m2 t_Xrx_Xdeser_Xwe13_m1 t_Xrx_Xdeser_Xwe13_Xm2_mid vss sky130_fd_pr__nfet_01v8 w=0.75 l=0.18
X2921 t_Xrx_Xdeser_Xwe13_Xm2_mid rst_n vss vss sky130_fd_pr__nfet_01v8 w=0.75 l=0.18
X2922 t_Xrx_Xdeser_Xwe13_m2 t_Xrx_Xdeser_Xwe13_m1 vdd vdd sky130_fd_pr__pfet_01v8 w=1 l=0.18
X2923 t_Xrx_Xdeser_Xwe13_m2 rst_n vdd vdd sky130_fd_pr__pfet_01v8 w=1 l=0.18
X2924 t_Xrx_Xdeser_Xwe13_m3 t_Xrx_Xdeser_Xwe13_m2 vss vss sky130_fd_pr__nfet_01v8 w=0.45 l=0.18
X2925 t_Xrx_Xdeser_Xwe13_m3 t_Xrx_Xdeser_Xwe13_m2 vdd vdd sky130_fd_pr__pfet_01v8 w=0.9 l=0.18
X2926 t_Xrx_Xdeser_Xwe13_m3 t_Xrx_Xdeser_wcap t_Xrx_Xdeser_Xwe13_m1 vss sky130_fd_pr__nfet_01v8 w=0.45 l=0.18
X2927 t_Xrx_Xdeser_Xwe13_m3 t_Xrx_Xdeser_wcapb t_Xrx_Xdeser_Xwe13_m1 vdd sky130_fd_pr__pfet_01v8 w=0.9 l=0.18
X2928 t_Xrx_Xdeser_Xwe13_m2 t_Xrx_Xdeser_wcap t_Xrx_Xdeser_Xwe13_s1 vss sky130_fd_pr__nfet_01v8 w=0.5 l=0.18
X2929 t_Xrx_Xdeser_Xwe13_m2 t_Xrx_Xdeser_wcapb t_Xrx_Xdeser_Xwe13_s1 vdd sky130_fd_pr__pfet_01v8 w=1 l=0.18
X2930 t_Xrx_Xdeser_Xwe13_qi t_Xrx_Xdeser_Xwe13_s1 vss vss sky130_fd_pr__nfet_01v8 w=0.55 l=0.18
X2931 t_Xrx_Xdeser_Xwe13_qi t_Xrx_Xdeser_Xwe13_s1 vdd vdd sky130_fd_pr__pfet_01v8 w=1.2 l=0.18
X2932 t_Xrx_Xdeser_Xwe13_s2 t_Xrx_Xdeser_Xwe13_qi t_Xrx_Xdeser_Xwe13_Xsfb_mid vss sky130_fd_pr__nfet_01v8 w=0.7 l=0.18
X2933 t_Xrx_Xdeser_Xwe13_Xsfb_mid rst_n vss vss sky130_fd_pr__nfet_01v8 w=0.7 l=0.18
X2934 t_Xrx_Xdeser_Xwe13_s2 t_Xrx_Xdeser_Xwe13_qi vdd vdd sky130_fd_pr__pfet_01v8 w=0.95 l=0.18
X2935 t_Xrx_Xdeser_Xwe13_s2 rst_n vdd vdd sky130_fd_pr__pfet_01v8 w=0.95 l=0.18
X2936 t_Xrx_Xdeser_Xwe13_s2 t_Xrx_Xdeser_wcapb t_Xrx_Xdeser_Xwe13_s1 vss sky130_fd_pr__nfet_01v8 w=0.45 l=0.18
X2937 t_Xrx_Xdeser_Xwe13_s2 t_Xrx_Xdeser_wcap t_Xrx_Xdeser_Xwe13_s1 vdd sky130_fd_pr__pfet_01v8 w=0.9 l=0.18
X2938 we13 t_Xrx_Xdeser_Xwe13_s1 vss vss sky130_fd_pr__nfet_01v8 w=0.75 l=0.18
X2939 we13 t_Xrx_Xdeser_Xwe13_s1 vdd vdd sky130_fd_pr__pfet_01v8 w=1.6 l=0.18
X2940 t_Xrx_Xdeser_e1_0 t_Xrx_Xdeser_wcapb t_Xrx_Xdeser_Xwe14_m1 vss sky130_fd_pr__nfet_01v8 w=0.5 l=0.18
X2941 t_Xrx_Xdeser_e1_0 t_Xrx_Xdeser_wcap t_Xrx_Xdeser_Xwe14_m1 vdd sky130_fd_pr__pfet_01v8 w=1 l=0.18
X2942 t_Xrx_Xdeser_Xwe14_m2 t_Xrx_Xdeser_Xwe14_m1 t_Xrx_Xdeser_Xwe14_Xm2_mid vss sky130_fd_pr__nfet_01v8 w=0.75 l=0.18
X2943 t_Xrx_Xdeser_Xwe14_Xm2_mid rst_n vss vss sky130_fd_pr__nfet_01v8 w=0.75 l=0.18
X2944 t_Xrx_Xdeser_Xwe14_m2 t_Xrx_Xdeser_Xwe14_m1 vdd vdd sky130_fd_pr__pfet_01v8 w=1 l=0.18
X2945 t_Xrx_Xdeser_Xwe14_m2 rst_n vdd vdd sky130_fd_pr__pfet_01v8 w=1 l=0.18
X2946 t_Xrx_Xdeser_Xwe14_m3 t_Xrx_Xdeser_Xwe14_m2 vss vss sky130_fd_pr__nfet_01v8 w=0.45 l=0.18
X2947 t_Xrx_Xdeser_Xwe14_m3 t_Xrx_Xdeser_Xwe14_m2 vdd vdd sky130_fd_pr__pfet_01v8 w=0.9 l=0.18
X2948 t_Xrx_Xdeser_Xwe14_m3 t_Xrx_Xdeser_wcap t_Xrx_Xdeser_Xwe14_m1 vss sky130_fd_pr__nfet_01v8 w=0.45 l=0.18
X2949 t_Xrx_Xdeser_Xwe14_m3 t_Xrx_Xdeser_wcapb t_Xrx_Xdeser_Xwe14_m1 vdd sky130_fd_pr__pfet_01v8 w=0.9 l=0.18
X2950 t_Xrx_Xdeser_Xwe14_m2 t_Xrx_Xdeser_wcap t_Xrx_Xdeser_Xwe14_s1 vss sky130_fd_pr__nfet_01v8 w=0.5 l=0.18
X2951 t_Xrx_Xdeser_Xwe14_m2 t_Xrx_Xdeser_wcapb t_Xrx_Xdeser_Xwe14_s1 vdd sky130_fd_pr__pfet_01v8 w=1 l=0.18
X2952 t_Xrx_Xdeser_Xwe14_qi t_Xrx_Xdeser_Xwe14_s1 vss vss sky130_fd_pr__nfet_01v8 w=0.55 l=0.18
X2953 t_Xrx_Xdeser_Xwe14_qi t_Xrx_Xdeser_Xwe14_s1 vdd vdd sky130_fd_pr__pfet_01v8 w=1.2 l=0.18
X2954 t_Xrx_Xdeser_Xwe14_s2 t_Xrx_Xdeser_Xwe14_qi t_Xrx_Xdeser_Xwe14_Xsfb_mid vss sky130_fd_pr__nfet_01v8 w=0.7 l=0.18
X2955 t_Xrx_Xdeser_Xwe14_Xsfb_mid rst_n vss vss sky130_fd_pr__nfet_01v8 w=0.7 l=0.18
X2956 t_Xrx_Xdeser_Xwe14_s2 t_Xrx_Xdeser_Xwe14_qi vdd vdd sky130_fd_pr__pfet_01v8 w=0.95 l=0.18
X2957 t_Xrx_Xdeser_Xwe14_s2 rst_n vdd vdd sky130_fd_pr__pfet_01v8 w=0.95 l=0.18
X2958 t_Xrx_Xdeser_Xwe14_s2 t_Xrx_Xdeser_wcapb t_Xrx_Xdeser_Xwe14_s1 vss sky130_fd_pr__nfet_01v8 w=0.45 l=0.18
X2959 t_Xrx_Xdeser_Xwe14_s2 t_Xrx_Xdeser_wcap t_Xrx_Xdeser_Xwe14_s1 vdd sky130_fd_pr__pfet_01v8 w=0.9 l=0.18
X2960 we14 t_Xrx_Xdeser_Xwe14_s1 vss vss sky130_fd_pr__nfet_01v8 w=0.75 l=0.18
X2961 we14 t_Xrx_Xdeser_Xwe14_s1 vdd vdd sky130_fd_pr__pfet_01v8 w=1.6 l=0.18
X2962 t_Xrx_Xdeser_e2_0 t_Xrx_Xdeser_wcapb t_Xrx_Xdeser_Xwe15_m1 vss sky130_fd_pr__nfet_01v8 w=0.5 l=0.18
X2963 t_Xrx_Xdeser_e2_0 t_Xrx_Xdeser_wcap t_Xrx_Xdeser_Xwe15_m1 vdd sky130_fd_pr__pfet_01v8 w=1 l=0.18
X2964 t_Xrx_Xdeser_Xwe15_m2 t_Xrx_Xdeser_Xwe15_m1 t_Xrx_Xdeser_Xwe15_Xm2_mid vss sky130_fd_pr__nfet_01v8 w=0.75 l=0.18
X2965 t_Xrx_Xdeser_Xwe15_Xm2_mid rst_n vss vss sky130_fd_pr__nfet_01v8 w=0.75 l=0.18
X2966 t_Xrx_Xdeser_Xwe15_m2 t_Xrx_Xdeser_Xwe15_m1 vdd vdd sky130_fd_pr__pfet_01v8 w=1 l=0.18
X2967 t_Xrx_Xdeser_Xwe15_m2 rst_n vdd vdd sky130_fd_pr__pfet_01v8 w=1 l=0.18
X2968 t_Xrx_Xdeser_Xwe15_m3 t_Xrx_Xdeser_Xwe15_m2 vss vss sky130_fd_pr__nfet_01v8 w=0.45 l=0.18
X2969 t_Xrx_Xdeser_Xwe15_m3 t_Xrx_Xdeser_Xwe15_m2 vdd vdd sky130_fd_pr__pfet_01v8 w=0.9 l=0.18
X2970 t_Xrx_Xdeser_Xwe15_m3 t_Xrx_Xdeser_wcap t_Xrx_Xdeser_Xwe15_m1 vss sky130_fd_pr__nfet_01v8 w=0.45 l=0.18
X2971 t_Xrx_Xdeser_Xwe15_m3 t_Xrx_Xdeser_wcapb t_Xrx_Xdeser_Xwe15_m1 vdd sky130_fd_pr__pfet_01v8 w=0.9 l=0.18
X2972 t_Xrx_Xdeser_Xwe15_m2 t_Xrx_Xdeser_wcap t_Xrx_Xdeser_Xwe15_s1 vss sky130_fd_pr__nfet_01v8 w=0.5 l=0.18
X2973 t_Xrx_Xdeser_Xwe15_m2 t_Xrx_Xdeser_wcapb t_Xrx_Xdeser_Xwe15_s1 vdd sky130_fd_pr__pfet_01v8 w=1 l=0.18
X2974 t_Xrx_Xdeser_Xwe15_qi t_Xrx_Xdeser_Xwe15_s1 vss vss sky130_fd_pr__nfet_01v8 w=0.55 l=0.18
X2975 t_Xrx_Xdeser_Xwe15_qi t_Xrx_Xdeser_Xwe15_s1 vdd vdd sky130_fd_pr__pfet_01v8 w=1.2 l=0.18
X2976 t_Xrx_Xdeser_Xwe15_s2 t_Xrx_Xdeser_Xwe15_qi t_Xrx_Xdeser_Xwe15_Xsfb_mid vss sky130_fd_pr__nfet_01v8 w=0.7 l=0.18
X2977 t_Xrx_Xdeser_Xwe15_Xsfb_mid rst_n vss vss sky130_fd_pr__nfet_01v8 w=0.7 l=0.18
X2978 t_Xrx_Xdeser_Xwe15_s2 t_Xrx_Xdeser_Xwe15_qi vdd vdd sky130_fd_pr__pfet_01v8 w=0.95 l=0.18
X2979 t_Xrx_Xdeser_Xwe15_s2 rst_n vdd vdd sky130_fd_pr__pfet_01v8 w=0.95 l=0.18
X2980 t_Xrx_Xdeser_Xwe15_s2 t_Xrx_Xdeser_wcapb t_Xrx_Xdeser_Xwe15_s1 vss sky130_fd_pr__nfet_01v8 w=0.45 l=0.18
X2981 t_Xrx_Xdeser_Xwe15_s2 t_Xrx_Xdeser_wcap t_Xrx_Xdeser_Xwe15_s1 vdd sky130_fd_pr__pfet_01v8 w=0.9 l=0.18
X2982 we15 t_Xrx_Xdeser_Xwe15_s1 vss vss sky130_fd_pr__nfet_01v8 w=0.75 l=0.18
X2983 we15 t_Xrx_Xdeser_Xwe15_s1 vdd vdd sky130_fd_pr__pfet_01v8 w=1.6 l=0.18
.ends serdes_rx_cmos_top_pdk
