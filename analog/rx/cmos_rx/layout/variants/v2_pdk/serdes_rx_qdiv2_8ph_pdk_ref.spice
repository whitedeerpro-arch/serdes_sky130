* Exact flattened LVS reference netlist for serdes_rx_qdiv2_8ph_pdk
* Source subckt: serdes_rx_qdiv2_8ph (frozen analog/rx/cmos_rx/spice/*.spice)
.subckt serdes_rx_qdiv2_8ph_pdk dp dn ep en rst_n ckd0 ckd1 ckd2 ckd3 cke0 cke1 cke2 cke3 vdd vss
X1 t_rst rst_n vss vss sky130_fd_pr__nfet_01v8 w=0.6 l=0.18
X2 t_rst rst_n vdd vdd sky130_fd_pr__pfet_01v8 w=1.2 l=0.18
X3 t_dp_ckb dp t_Xg_dpb_mid vss sky130_fd_pr__nfet_01v8_lvt w=1.4 l=0.15
X4 t_Xg_dpb_mid rst_n vss vss sky130_fd_pr__nfet_01v8_lvt w=1.4 l=0.15
X5 t_dp_ckb dp vdd vdd sky130_fd_pr__pfet_01v8 w=4.6 l=0.15
X6 t_dp_ckb rst_n vdd vdd sky130_fd_pr__pfet_01v8 w=4.6 l=0.15
X7 t_dn_ckb dn t_Xg_dnb_mid vss sky130_fd_pr__nfet_01v8_lvt w=1.4 l=0.15
X8 t_Xg_dnb_mid rst_n vss vss sky130_fd_pr__nfet_01v8_lvt w=1.4 l=0.15
X9 t_dn_ckb dn vdd vdd sky130_fd_pr__pfet_01v8 w=4.6 l=0.15
X10 t_dn_ckb rst_n vdd vdd sky130_fd_pr__pfet_01v8 w=4.6 l=0.15
X11 t_ep_ckb ep t_Xg_epb_mid vss sky130_fd_pr__nfet_01v8_lvt w=1.4 l=0.15
X12 t_Xg_epb_mid rst_n vss vss sky130_fd_pr__nfet_01v8_lvt w=1.4 l=0.15
X13 t_ep_ckb ep vdd vdd sky130_fd_pr__pfet_01v8 w=4.6 l=0.15
X14 t_ep_ckb rst_n vdd vdd sky130_fd_pr__pfet_01v8 w=4.6 l=0.15
X15 t_en_ckb en t_Xg_enb_mid vss sky130_fd_pr__nfet_01v8_lvt w=1.4 l=0.15
X16 t_Xg_enb_mid rst_n vss vss sky130_fd_pr__nfet_01v8_lvt w=1.4 l=0.15
X17 t_en_ckb en vdd vdd sky130_fd_pr__pfet_01v8 w=4.6 l=0.15
X18 t_en_ckb rst_n vdd vdd sky130_fd_pr__pfet_01v8 w=4.6 l=0.15
X19 t_dn_ckb t_dp_ckb vss vss sky130_fd_pr__nfet_01v8_lvt w=0.5 l=0.15
X20 t_dn_ckb t_dp_ckb vdd vdd sky130_fd_pr__pfet_01v8 w=1.5 l=0.15
X21 t_dp_ckb t_dn_ckb vss vss sky130_fd_pr__nfet_01v8_lvt w=0.5 l=0.15
X22 t_dp_ckb t_dn_ckb vdd vdd sky130_fd_pr__pfet_01v8 w=1.5 l=0.15
X23 t_en_ckb t_ep_ckb vss vss sky130_fd_pr__nfet_01v8_lvt w=0.5 l=0.15
X24 t_en_ckb t_ep_ckb vdd vdd sky130_fd_pr__pfet_01v8 w=1.5 l=0.15
X25 t_ep_ckb t_en_ckb vss vss sky130_fd_pr__nfet_01v8_lvt w=0.5 l=0.15
X26 t_ep_ckb t_en_ckb vdd vdd sky130_fd_pr__pfet_01v8 w=1.5 l=0.15
X27 t_dp_ck t_dp_ckb vss vss sky130_fd_pr__nfet_01v8_lvt w=2 l=0.15
X28 t_dp_ck t_dp_ckb vdd vdd sky130_fd_pr__pfet_01v8 w=6.9 l=0.15
X29 t_dn_ck t_dn_ckb vss vss sky130_fd_pr__nfet_01v8_lvt w=2 l=0.15
X30 t_dn_ck t_dn_ckb vdd vdd sky130_fd_pr__pfet_01v8 w=6.9 l=0.15
X31 t_ep_ck t_ep_ckb vss vss sky130_fd_pr__nfet_01v8_lvt w=2 l=0.15
X32 t_ep_ck t_ep_ckb vdd vdd sky130_fd_pr__pfet_01v8 w=6.9 l=0.15
X33 t_en_ck t_en_ckb vss vss sky130_fd_pr__nfet_01v8_lvt w=2 l=0.15
X34 t_en_ck t_en_ckb vdd vdd sky130_fd_pr__pfet_01v8 w=6.9 l=0.15
X35 t_dn_ck t_dp_ck vss vss sky130_fd_pr__nfet_01v8_lvt w=0.5 l=0.15
X36 t_dn_ck t_dp_ck vdd vdd sky130_fd_pr__pfet_01v8 w=1.5 l=0.15
X37 t_dp_ck t_dn_ck vss vss sky130_fd_pr__nfet_01v8_lvt w=0.5 l=0.15
X38 t_dp_ck t_dn_ck vdd vdd sky130_fd_pr__pfet_01v8 w=1.5 l=0.15
X39 t_en_ck t_ep_ck vss vss sky130_fd_pr__nfet_01v8_lvt w=0.5 l=0.15
X40 t_en_ck t_ep_ck vdd vdd sky130_fd_pr__pfet_01v8 w=1.5 l=0.15
X41 t_ep_ck t_en_ck vss vss sky130_fd_pr__nfet_01v8_lvt w=0.5 l=0.15
X42 t_ep_ck t_en_ck vdd vdd sky130_fd_pr__pfet_01v8 w=1.5 l=0.15
X43 t_d3 t_dp_ck t_Xld0_int_p vss sky130_fd_pr__nfet_01v8_lvt w=2.4 l=0.15
X44 t_d3 t_dn_ck t_Xld0_int_p vdd sky130_fd_pr__pfet_01v8 w=4.8 l=0.15
X45 t_d1 t_dp_ck t_Xld0_int_n vss sky130_fd_pr__nfet_01v8_lvt w=2.4 l=0.15
X46 t_d1 t_dn_ck t_Xld0_int_n vdd sky130_fd_pr__pfet_01v8 w=4.8 l=0.15
X47 t_Xld0_int_p t_Xld0_int_n vdd vdd sky130_fd_pr__pfet_01v8 w=0.45 l=0.25
X48 t_Xld0_int_p t_Xld0_int_n vss vss sky130_fd_pr__nfet_01v8_lvt w=0.42 l=0.25
X49 t_Xld0_int_n t_Xld0_int_p vdd vdd sky130_fd_pr__pfet_01v8 w=0.45 l=0.25
X50 t_Xld0_int_n t_Xld0_int_p vss vss sky130_fd_pr__nfet_01v8_lvt w=0.42 l=0.25
X51 t_Xld0_int_p t_rst vss vss sky130_fd_pr__nfet_01v8 w=1 l=0.18
X52 t_Xld0_int_n rst_n vdd vdd sky130_fd_pr__pfet_01v8 w=1.8 l=0.18
X53 t_d0 t_Xld0_int_n vss vss sky130_fd_pr__nfet_01v8_lvt w=3 l=0.15
X54 t_d0 t_Xld0_int_n vdd vdd sky130_fd_pr__pfet_01v8 w=9 l=0.15
X55 t_d2 t_Xld0_int_p vss vss sky130_fd_pr__nfet_01v8_lvt w=3 l=0.15
X56 t_d2 t_Xld0_int_p vdd vdd sky130_fd_pr__pfet_01v8 w=9 l=0.15
X57 t_d2 t_d0 vss vss sky130_fd_pr__nfet_01v8_lvt w=0.42 l=0.15
X58 t_d2 t_d0 vdd vdd sky130_fd_pr__pfet_01v8 w=1 l=0.15
X59 t_d0 t_d2 vss vss sky130_fd_pr__nfet_01v8_lvt w=0.42 l=0.15
X60 t_d0 t_d2 vdd vdd sky130_fd_pr__pfet_01v8 w=1 l=0.15
X61 t_d0 t_dn_ck t_Xld1_int_p vss sky130_fd_pr__nfet_01v8_lvt w=2.4 l=0.15
X62 t_d0 t_dp_ck t_Xld1_int_p vdd sky130_fd_pr__pfet_01v8 w=4.8 l=0.15
X63 t_d2 t_dn_ck t_Xld1_int_n vss sky130_fd_pr__nfet_01v8_lvt w=2.4 l=0.15
X64 t_d2 t_dp_ck t_Xld1_int_n vdd sky130_fd_pr__pfet_01v8 w=4.8 l=0.15
X65 t_Xld1_int_p t_Xld1_int_n vdd vdd sky130_fd_pr__pfet_01v8 w=0.45 l=0.25
X66 t_Xld1_int_p t_Xld1_int_n vss vss sky130_fd_pr__nfet_01v8_lvt w=0.42 l=0.25
X67 t_Xld1_int_n t_Xld1_int_p vdd vdd sky130_fd_pr__pfet_01v8 w=0.45 l=0.25
X68 t_Xld1_int_n t_Xld1_int_p vss vss sky130_fd_pr__nfet_01v8_lvt w=0.42 l=0.25
X69 t_Xld1_int_p t_rst vss vss sky130_fd_pr__nfet_01v8 w=1 l=0.18
X70 t_Xld1_int_n rst_n vdd vdd sky130_fd_pr__pfet_01v8 w=1.8 l=0.18
X71 t_d1 t_Xld1_int_n vss vss sky130_fd_pr__nfet_01v8_lvt w=3 l=0.15
X72 t_d1 t_Xld1_int_n vdd vdd sky130_fd_pr__pfet_01v8 w=9 l=0.15
X73 t_d3 t_Xld1_int_p vss vss sky130_fd_pr__nfet_01v8_lvt w=3 l=0.15
X74 t_d3 t_Xld1_int_p vdd vdd sky130_fd_pr__pfet_01v8 w=9 l=0.15
X75 t_d3 t_d1 vss vss sky130_fd_pr__nfet_01v8_lvt w=0.42 l=0.15
X76 t_d3 t_d1 vdd vdd sky130_fd_pr__pfet_01v8 w=1 l=0.15
X77 t_d1 t_d3 vss vss sky130_fd_pr__nfet_01v8_lvt w=0.42 l=0.15
X78 t_d1 t_d3 vdd vdd sky130_fd_pr__pfet_01v8 w=1 l=0.15
X79 t_d0 t_ep_ck t_Xle0_int_p vss sky130_fd_pr__nfet_01v8_lvt w=2.4 l=0.15
X80 t_d0 t_en_ck t_Xle0_int_p vdd sky130_fd_pr__pfet_01v8 w=4.8 l=0.15
X81 t_d2 t_ep_ck t_Xle0_int_n vss sky130_fd_pr__nfet_01v8_lvt w=2.4 l=0.15
X82 t_d2 t_en_ck t_Xle0_int_n vdd sky130_fd_pr__pfet_01v8 w=4.8 l=0.15
X83 t_Xle0_int_p t_Xle0_int_n vdd vdd sky130_fd_pr__pfet_01v8 w=0.45 l=0.25
X84 t_Xle0_int_p t_Xle0_int_n vss vss sky130_fd_pr__nfet_01v8_lvt w=0.42 l=0.25
X85 t_Xle0_int_n t_Xle0_int_p vdd vdd sky130_fd_pr__pfet_01v8 w=0.45 l=0.25
X86 t_Xle0_int_n t_Xle0_int_p vss vss sky130_fd_pr__nfet_01v8_lvt w=0.42 l=0.25
X87 t_Xle0_int_p t_rst vss vss sky130_fd_pr__nfet_01v8 w=1 l=0.18
X88 t_Xle0_int_n rst_n vdd vdd sky130_fd_pr__pfet_01v8 w=1.8 l=0.18
X89 t_e0 t_Xle0_int_n vss vss sky130_fd_pr__nfet_01v8_lvt w=3 l=0.15
X90 t_e0 t_Xle0_int_n vdd vdd sky130_fd_pr__pfet_01v8 w=9 l=0.15
X91 t_e2 t_Xle0_int_p vss vss sky130_fd_pr__nfet_01v8_lvt w=3 l=0.15
X92 t_e2 t_Xle0_int_p vdd vdd sky130_fd_pr__pfet_01v8 w=9 l=0.15
X93 t_e2 t_e0 vss vss sky130_fd_pr__nfet_01v8_lvt w=0.42 l=0.15
X94 t_e2 t_e0 vdd vdd sky130_fd_pr__pfet_01v8 w=1 l=0.15
X95 t_e0 t_e2 vss vss sky130_fd_pr__nfet_01v8_lvt w=0.42 l=0.15
X96 t_e0 t_e2 vdd vdd sky130_fd_pr__pfet_01v8 w=1 l=0.15
X97 t_d1 t_en_ck t_Xle1_int_p vss sky130_fd_pr__nfet_01v8_lvt w=2.4 l=0.15
X98 t_d1 t_ep_ck t_Xle1_int_p vdd sky130_fd_pr__pfet_01v8 w=4.8 l=0.15
X99 t_d3 t_en_ck t_Xle1_int_n vss sky130_fd_pr__nfet_01v8_lvt w=2.4 l=0.15
X100 t_d3 t_ep_ck t_Xle1_int_n vdd sky130_fd_pr__pfet_01v8 w=4.8 l=0.15
X101 t_Xle1_int_p t_Xle1_int_n vdd vdd sky130_fd_pr__pfet_01v8 w=0.45 l=0.25
X102 t_Xle1_int_p t_Xle1_int_n vss vss sky130_fd_pr__nfet_01v8_lvt w=0.42 l=0.25
X103 t_Xle1_int_n t_Xle1_int_p vdd vdd sky130_fd_pr__pfet_01v8 w=0.45 l=0.25
X104 t_Xle1_int_n t_Xle1_int_p vss vss sky130_fd_pr__nfet_01v8_lvt w=0.42 l=0.25
X105 t_Xle1_int_p t_rst vss vss sky130_fd_pr__nfet_01v8 w=1 l=0.18
X106 t_Xle1_int_n rst_n vdd vdd sky130_fd_pr__pfet_01v8 w=1.8 l=0.18
X107 t_e1 t_Xle1_int_n vss vss sky130_fd_pr__nfet_01v8_lvt w=3 l=0.15
X108 t_e1 t_Xle1_int_n vdd vdd sky130_fd_pr__pfet_01v8 w=9 l=0.15
X109 t_e3 t_Xle1_int_p vss vss sky130_fd_pr__nfet_01v8_lvt w=3 l=0.15
X110 t_e3 t_Xle1_int_p vdd vdd sky130_fd_pr__pfet_01v8 w=9 l=0.15
X111 t_e3 t_e1 vss vss sky130_fd_pr__nfet_01v8_lvt w=0.42 l=0.15
X112 t_e3 t_e1 vdd vdd sky130_fd_pr__pfet_01v8 w=1 l=0.15
X113 t_e1 t_e3 vss vss sky130_fd_pr__nfet_01v8_lvt w=0.42 l=0.15
X114 t_e1 t_e3 vdd vdd sky130_fd_pr__pfet_01v8 w=1 l=0.15
X115 ckd0 t_d2 vss vss sky130_fd_pr__nfet_01v8_lvt w=2.6 l=0.15
X116 ckd0 t_d2 vdd vdd sky130_fd_pr__pfet_01v8 w=6.8 l=0.15
X117 ckd2 t_d0 vss vss sky130_fd_pr__nfet_01v8_lvt w=2.6 l=0.15
X118 ckd2 t_d0 vdd vdd sky130_fd_pr__pfet_01v8 w=6.8 l=0.15
X119 ckd1 t_d3 vss vss sky130_fd_pr__nfet_01v8_lvt w=2.6 l=0.15
X120 ckd1 t_d3 vdd vdd sky130_fd_pr__pfet_01v8 w=6.8 l=0.15
X121 ckd3 t_d1 vss vss sky130_fd_pr__nfet_01v8_lvt w=2.6 l=0.15
X122 ckd3 t_d1 vdd vdd sky130_fd_pr__pfet_01v8 w=6.8 l=0.15
X123 cke0 t_e2 vss vss sky130_fd_pr__nfet_01v8_lvt w=2.6 l=0.15
X124 cke0 t_e2 vdd vdd sky130_fd_pr__pfet_01v8 w=6.8 l=0.15
X125 cke2 t_e0 vss vss sky130_fd_pr__nfet_01v8_lvt w=2.6 l=0.15
X126 cke2 t_e0 vdd vdd sky130_fd_pr__pfet_01v8 w=6.8 l=0.15
X127 cke1 t_e3 vss vss sky130_fd_pr__nfet_01v8_lvt w=2.6 l=0.15
X128 cke1 t_e3 vdd vdd sky130_fd_pr__pfet_01v8 w=6.8 l=0.15
X129 cke3 t_e1 vss vss sky130_fd_pr__nfet_01v8_lvt w=2.6 l=0.15
X130 cke3 t_e1 vdd vdd sky130_fd_pr__pfet_01v8 w=6.8 l=0.15
X131 ckd2 ckd0 vss vss sky130_fd_pr__nfet_01v8_lvt w=0.45 l=0.15
X132 ckd2 ckd0 vdd vdd sky130_fd_pr__pfet_01v8 w=1.1 l=0.15
X133 ckd0 ckd2 vss vss sky130_fd_pr__nfet_01v8_lvt w=0.45 l=0.15
X134 ckd0 ckd2 vdd vdd sky130_fd_pr__pfet_01v8 w=1.1 l=0.15
X135 ckd3 ckd1 vss vss sky130_fd_pr__nfet_01v8_lvt w=0.45 l=0.15
X136 ckd3 ckd1 vdd vdd sky130_fd_pr__pfet_01v8 w=1.1 l=0.15
X137 ckd1 ckd3 vss vss sky130_fd_pr__nfet_01v8_lvt w=0.45 l=0.15
X138 ckd1 ckd3 vdd vdd sky130_fd_pr__pfet_01v8 w=1.1 l=0.15
X139 cke2 cke0 vss vss sky130_fd_pr__nfet_01v8_lvt w=0.45 l=0.15
X140 cke2 cke0 vdd vdd sky130_fd_pr__pfet_01v8 w=1.1 l=0.15
X141 cke0 cke2 vss vss sky130_fd_pr__nfet_01v8_lvt w=0.45 l=0.15
X142 cke0 cke2 vdd vdd sky130_fd_pr__pfet_01v8 w=1.1 l=0.15
X143 cke3 cke1 vss vss sky130_fd_pr__nfet_01v8_lvt w=0.45 l=0.15
X144 cke3 cke1 vdd vdd sky130_fd_pr__pfet_01v8 w=1.1 l=0.15
X145 cke1 cke3 vss vss sky130_fd_pr__nfet_01v8_lvt w=0.45 l=0.15
X146 cke1 cke3 vdd vdd sky130_fd_pr__pfet_01v8 w=1.1 l=0.15
.ends serdes_rx_qdiv2_8ph_pdk
