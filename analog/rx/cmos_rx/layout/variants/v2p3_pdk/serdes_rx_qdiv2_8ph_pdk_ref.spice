* Exact flattened LVS reference netlist for serdes_rx_qdiv2_8ph_pdk
* Source subckt: serdes_rx_qdiv2_8ph (frozen analog/rx/cmos_rx/spice/*.spice)
.subckt serdes_rx_qdiv2_8ph_pdk dp dn ep en rst_n ckd0 ckd1 ckd2 ckd3 cke0 cke1 cke2 cke3 vdd vss
X1 t_rst rst_n vss vss sky130_fd_pr__nfet_01v8 w=0.6 l=0.18
X2 t_rst rst_n vdd vdd sky130_fd_pr__pfet_01v8 w=1.2 l=0.18
X3 dp rst_n t_Xg_dpb_ck_g vss sky130_fd_pr__nfet_01v8_lvt w=2.4 l=0.15
X4 dp t_rst t_Xg_dpb_ck_g vdd sky130_fd_pr__pfet_01v8_lvt w=6 l=0.35
X5 t_Xg_dpb_ck_g t_rst vss vss sky130_fd_pr__nfet_01v8 w=0.8 l=0.18
X6 t_dp_ckb t_Xg_dpb_ck_g vss vss sky130_fd_pr__nfet_01v8_lvt w=1.4 l=0.15
X7 t_dp_ckb t_Xg_dpb_ck_g vdd vdd sky130_fd_pr__pfet_01v8 w=4.6 l=0.15
X8 dn rst_n t_Xg_dnb_ck_g vss sky130_fd_pr__nfet_01v8_lvt w=2.4 l=0.15
X9 dn t_rst t_Xg_dnb_ck_g vdd sky130_fd_pr__pfet_01v8_lvt w=6 l=0.35
X10 t_Xg_dnb_ck_g rst_n vdd vdd sky130_fd_pr__pfet_01v8 w=1.6 l=0.18
X11 t_dn_ckb t_Xg_dnb_ck_g vss vss sky130_fd_pr__nfet_01v8_lvt w=1.4 l=0.15
X12 t_dn_ckb t_Xg_dnb_ck_g vdd vdd sky130_fd_pr__pfet_01v8 w=4.6 l=0.15
X13 ep rst_n t_Xg_epb_ck_g vss sky130_fd_pr__nfet_01v8_lvt w=2.4 l=0.15
X14 ep t_rst t_Xg_epb_ck_g vdd sky130_fd_pr__pfet_01v8_lvt w=6 l=0.35
X15 t_Xg_epb_ck_g t_rst vss vss sky130_fd_pr__nfet_01v8 w=0.8 l=0.18
X16 t_ep_ckb t_Xg_epb_ck_g vss vss sky130_fd_pr__nfet_01v8_lvt w=1.4 l=0.15
X17 t_ep_ckb t_Xg_epb_ck_g vdd vdd sky130_fd_pr__pfet_01v8 w=4.6 l=0.15
X18 en rst_n t_Xg_enb_ck_g vss sky130_fd_pr__nfet_01v8_lvt w=2.4 l=0.15
X19 en t_rst t_Xg_enb_ck_g vdd sky130_fd_pr__pfet_01v8_lvt w=6 l=0.35
X20 t_Xg_enb_ck_g rst_n vdd vdd sky130_fd_pr__pfet_01v8 w=1.6 l=0.18
X21 t_en_ckb t_Xg_enb_ck_g vss vss sky130_fd_pr__nfet_01v8_lvt w=1.4 l=0.15
X22 t_en_ckb t_Xg_enb_ck_g vdd vdd sky130_fd_pr__pfet_01v8 w=4.6 l=0.15
X23 t_dn_ckb t_dp_ckb vss vss sky130_fd_pr__nfet_01v8_lvt w=0.5 l=0.15
X24 t_dn_ckb t_dp_ckb vdd vdd sky130_fd_pr__pfet_01v8 w=1.5 l=0.15
X25 t_dp_ckb t_dn_ckb vss vss sky130_fd_pr__nfet_01v8_lvt w=0.5 l=0.15
X26 t_dp_ckb t_dn_ckb vdd vdd sky130_fd_pr__pfet_01v8 w=1.5 l=0.15
X27 t_en_ckb t_ep_ckb vss vss sky130_fd_pr__nfet_01v8_lvt w=0.5 l=0.15
X28 t_en_ckb t_ep_ckb vdd vdd sky130_fd_pr__pfet_01v8 w=1.5 l=0.15
X29 t_ep_ckb t_en_ckb vss vss sky130_fd_pr__nfet_01v8_lvt w=0.5 l=0.15
X30 t_ep_ckb t_en_ckb vdd vdd sky130_fd_pr__pfet_01v8 w=1.5 l=0.15
X31 t_dp_ck t_dp_ckb vss vss sky130_fd_pr__nfet_01v8_lvt w=2 l=0.15
X32 t_dp_ck t_dp_ckb vdd vdd sky130_fd_pr__pfet_01v8 w=6.9 l=0.15
X33 t_dn_ck t_dn_ckb vss vss sky130_fd_pr__nfet_01v8_lvt w=2 l=0.15
X34 t_dn_ck t_dn_ckb vdd vdd sky130_fd_pr__pfet_01v8 w=6.9 l=0.15
X35 t_ep_ck t_ep_ckb vss vss sky130_fd_pr__nfet_01v8_lvt w=2 l=0.15
X36 t_ep_ck t_ep_ckb vdd vdd sky130_fd_pr__pfet_01v8 w=6.9 l=0.15
X37 t_en_ck t_en_ckb vss vss sky130_fd_pr__nfet_01v8_lvt w=2 l=0.15
X38 t_en_ck t_en_ckb vdd vdd sky130_fd_pr__pfet_01v8 w=6.9 l=0.15
X39 t_dn_ck t_dp_ck vss vss sky130_fd_pr__nfet_01v8_lvt w=0.5 l=0.15
X40 t_dn_ck t_dp_ck vdd vdd sky130_fd_pr__pfet_01v8 w=1.5 l=0.15
X41 t_dp_ck t_dn_ck vss vss sky130_fd_pr__nfet_01v8_lvt w=0.5 l=0.15
X42 t_dp_ck t_dn_ck vdd vdd sky130_fd_pr__pfet_01v8 w=1.5 l=0.15
X43 t_en_ck t_ep_ck vss vss sky130_fd_pr__nfet_01v8_lvt w=0.5 l=0.15
X44 t_en_ck t_ep_ck vdd vdd sky130_fd_pr__pfet_01v8 w=1.5 l=0.15
X45 t_ep_ck t_en_ck vss vss sky130_fd_pr__nfet_01v8_lvt w=0.5 l=0.15
X46 t_ep_ck t_en_ck vdd vdd sky130_fd_pr__pfet_01v8 w=1.5 l=0.15
X47 t_d3 t_dp_ck t_Xld0_int_p vss sky130_fd_pr__nfet_01v8_lvt w=2.4 l=0.15
X48 t_d3 t_dn_ck t_Xld0_int_p vdd sky130_fd_pr__pfet_01v8 w=4.8 l=0.15
X49 t_d1 t_dp_ck t_Xld0_int_n vss sky130_fd_pr__nfet_01v8_lvt w=2.4 l=0.15
X50 t_d1 t_dn_ck t_Xld0_int_n vdd sky130_fd_pr__pfet_01v8 w=4.8 l=0.15
X51 t_Xld0_int_p t_Xld0_int_n vdd vdd sky130_fd_pr__pfet_01v8 w=0.45 l=0.25
X52 t_Xld0_int_p t_Xld0_int_n vss vss sky130_fd_pr__nfet_01v8_lvt w=0.42 l=0.25
X53 t_Xld0_int_n t_Xld0_int_p vdd vdd sky130_fd_pr__pfet_01v8 w=0.45 l=0.25
X54 t_Xld0_int_n t_Xld0_int_p vss vss sky130_fd_pr__nfet_01v8_lvt w=0.42 l=0.25
X55 t_Xld0_int_p t_rst vss vss sky130_fd_pr__nfet_01v8 w=1 l=0.18
X56 t_Xld0_int_n rst_n vdd vdd sky130_fd_pr__pfet_01v8 w=1.8 l=0.18
X57 t_d0 t_Xld0_int_n vss vss sky130_fd_pr__nfet_01v8_lvt w=3 l=0.15
X58 t_d0 t_Xld0_int_n vdd vdd sky130_fd_pr__pfet_01v8 w=9 l=0.15
X59 t_d2 t_Xld0_int_p vss vss sky130_fd_pr__nfet_01v8_lvt w=3 l=0.15
X60 t_d2 t_Xld0_int_p vdd vdd sky130_fd_pr__pfet_01v8 w=9 l=0.15
X61 t_d2 t_d0 vss vss sky130_fd_pr__nfet_01v8_lvt w=0.42 l=0.15
X62 t_d2 t_d0 vdd vdd sky130_fd_pr__pfet_01v8 w=1 l=0.15
X63 t_d0 t_d2 vss vss sky130_fd_pr__nfet_01v8_lvt w=0.42 l=0.15
X64 t_d0 t_d2 vdd vdd sky130_fd_pr__pfet_01v8 w=1 l=0.15
X65 t_d0 t_dn_ck t_Xld1_int_p vss sky130_fd_pr__nfet_01v8_lvt w=2.4 l=0.15
X66 t_d0 t_dp_ck t_Xld1_int_p vdd sky130_fd_pr__pfet_01v8 w=4.8 l=0.15
X67 t_d2 t_dn_ck t_Xld1_int_n vss sky130_fd_pr__nfet_01v8_lvt w=2.4 l=0.15
X68 t_d2 t_dp_ck t_Xld1_int_n vdd sky130_fd_pr__pfet_01v8 w=4.8 l=0.15
X69 t_Xld1_int_p t_Xld1_int_n vdd vdd sky130_fd_pr__pfet_01v8 w=0.45 l=0.25
X70 t_Xld1_int_p t_Xld1_int_n vss vss sky130_fd_pr__nfet_01v8_lvt w=0.42 l=0.25
X71 t_Xld1_int_n t_Xld1_int_p vdd vdd sky130_fd_pr__pfet_01v8 w=0.45 l=0.25
X72 t_Xld1_int_n t_Xld1_int_p vss vss sky130_fd_pr__nfet_01v8_lvt w=0.42 l=0.25
X73 t_Xld1_int_p t_rst vss vss sky130_fd_pr__nfet_01v8 w=1 l=0.18
X74 t_Xld1_int_n rst_n vdd vdd sky130_fd_pr__pfet_01v8 w=1.8 l=0.18
X75 t_d1 t_Xld1_int_n vss vss sky130_fd_pr__nfet_01v8_lvt w=3 l=0.15
X76 t_d1 t_Xld1_int_n vdd vdd sky130_fd_pr__pfet_01v8 w=9 l=0.15
X77 t_d3 t_Xld1_int_p vss vss sky130_fd_pr__nfet_01v8_lvt w=3 l=0.15
X78 t_d3 t_Xld1_int_p vdd vdd sky130_fd_pr__pfet_01v8 w=9 l=0.15
X79 t_d3 t_d1 vss vss sky130_fd_pr__nfet_01v8_lvt w=0.42 l=0.15
X80 t_d3 t_d1 vdd vdd sky130_fd_pr__pfet_01v8 w=1 l=0.15
X81 t_d1 t_d3 vss vss sky130_fd_pr__nfet_01v8_lvt w=0.42 l=0.15
X82 t_d1 t_d3 vdd vdd sky130_fd_pr__pfet_01v8 w=1 l=0.15
X83 t_d0 t_ep_ck t_Xle0_int_p vss sky130_fd_pr__nfet_01v8_lvt w=2.4 l=0.15
X84 t_d0 t_en_ck t_Xle0_int_p vdd sky130_fd_pr__pfet_01v8 w=4.8 l=0.15
X85 t_d2 t_ep_ck t_Xle0_int_n vss sky130_fd_pr__nfet_01v8_lvt w=2.4 l=0.15
X86 t_d2 t_en_ck t_Xle0_int_n vdd sky130_fd_pr__pfet_01v8 w=4.8 l=0.15
X87 t_Xle0_int_p t_Xle0_int_n vdd vdd sky130_fd_pr__pfet_01v8 w=0.45 l=0.25
X88 t_Xle0_int_p t_Xle0_int_n vss vss sky130_fd_pr__nfet_01v8_lvt w=0.42 l=0.25
X89 t_Xle0_int_n t_Xle0_int_p vdd vdd sky130_fd_pr__pfet_01v8 w=0.45 l=0.25
X90 t_Xle0_int_n t_Xle0_int_p vss vss sky130_fd_pr__nfet_01v8_lvt w=0.42 l=0.25
X91 t_Xle0_int_p t_rst vss vss sky130_fd_pr__nfet_01v8 w=1 l=0.18
X92 t_Xle0_int_n rst_n vdd vdd sky130_fd_pr__pfet_01v8 w=1.8 l=0.18
X93 t_e0 t_Xle0_int_n vss vss sky130_fd_pr__nfet_01v8_lvt w=3 l=0.15
X94 t_e0 t_Xle0_int_n vdd vdd sky130_fd_pr__pfet_01v8 w=9 l=0.15
X95 t_e2 t_Xle0_int_p vss vss sky130_fd_pr__nfet_01v8_lvt w=3 l=0.15
X96 t_e2 t_Xle0_int_p vdd vdd sky130_fd_pr__pfet_01v8 w=9 l=0.15
X97 t_e2 t_e0 vss vss sky130_fd_pr__nfet_01v8_lvt w=0.42 l=0.15
X98 t_e2 t_e0 vdd vdd sky130_fd_pr__pfet_01v8 w=1 l=0.15
X99 t_e0 t_e2 vss vss sky130_fd_pr__nfet_01v8_lvt w=0.42 l=0.15
X100 t_e0 t_e2 vdd vdd sky130_fd_pr__pfet_01v8 w=1 l=0.15
X101 t_d1 t_en_ck t_Xle1_int_p vss sky130_fd_pr__nfet_01v8_lvt w=2.4 l=0.15
X102 t_d1 t_ep_ck t_Xle1_int_p vdd sky130_fd_pr__pfet_01v8 w=4.8 l=0.15
X103 t_d3 t_en_ck t_Xle1_int_n vss sky130_fd_pr__nfet_01v8_lvt w=2.4 l=0.15
X104 t_d3 t_ep_ck t_Xle1_int_n vdd sky130_fd_pr__pfet_01v8 w=4.8 l=0.15
X105 t_Xle1_int_p t_Xle1_int_n vdd vdd sky130_fd_pr__pfet_01v8 w=0.45 l=0.25
X106 t_Xle1_int_p t_Xle1_int_n vss vss sky130_fd_pr__nfet_01v8_lvt w=0.42 l=0.25
X107 t_Xle1_int_n t_Xle1_int_p vdd vdd sky130_fd_pr__pfet_01v8 w=0.45 l=0.25
X108 t_Xle1_int_n t_Xle1_int_p vss vss sky130_fd_pr__nfet_01v8_lvt w=0.42 l=0.25
X109 t_Xle1_int_p t_rst vss vss sky130_fd_pr__nfet_01v8 w=1 l=0.18
X110 t_Xle1_int_n rst_n vdd vdd sky130_fd_pr__pfet_01v8 w=1.8 l=0.18
X111 t_e1 t_Xle1_int_n vss vss sky130_fd_pr__nfet_01v8_lvt w=3 l=0.15
X112 t_e1 t_Xle1_int_n vdd vdd sky130_fd_pr__pfet_01v8 w=9 l=0.15
X113 t_e3 t_Xle1_int_p vss vss sky130_fd_pr__nfet_01v8_lvt w=3 l=0.15
X114 t_e3 t_Xle1_int_p vdd vdd sky130_fd_pr__pfet_01v8 w=9 l=0.15
X115 t_e3 t_e1 vss vss sky130_fd_pr__nfet_01v8_lvt w=0.42 l=0.15
X116 t_e3 t_e1 vdd vdd sky130_fd_pr__pfet_01v8 w=1 l=0.15
X117 t_e1 t_e3 vss vss sky130_fd_pr__nfet_01v8_lvt w=0.42 l=0.15
X118 t_e1 t_e3 vdd vdd sky130_fd_pr__pfet_01v8 w=1 l=0.15
X119 ckd0 t_d2 vss vss sky130_fd_pr__nfet_01v8_lvt w=2.6 l=0.15
X120 ckd0 t_d2 vdd vdd sky130_fd_pr__pfet_01v8 w=9.6 l=0.15
X121 ckd2 t_d0 vss vss sky130_fd_pr__nfet_01v8_lvt w=2.6 l=0.15
X122 ckd2 t_d0 vdd vdd sky130_fd_pr__pfet_01v8 w=9.6 l=0.15
X123 ckd1 t_d3 vss vss sky130_fd_pr__nfet_01v8_lvt w=2.6 l=0.15
X124 ckd1 t_d3 vdd vdd sky130_fd_pr__pfet_01v8 w=9.6 l=0.15
X125 ckd3 t_d1 vss vss sky130_fd_pr__nfet_01v8_lvt w=2.6 l=0.15
X126 ckd3 t_d1 vdd vdd sky130_fd_pr__pfet_01v8 w=9.6 l=0.15
X127 cke0 t_e2 vss vss sky130_fd_pr__nfet_01v8_lvt w=2.6 l=0.15
X128 cke0 t_e2 vdd vdd sky130_fd_pr__pfet_01v8 w=9.6 l=0.15
X129 cke2 t_e0 vss vss sky130_fd_pr__nfet_01v8_lvt w=2.6 l=0.15
X130 cke2 t_e0 vdd vdd sky130_fd_pr__pfet_01v8 w=9.6 l=0.15
X131 cke1 t_e3 vss vss sky130_fd_pr__nfet_01v8_lvt w=2.6 l=0.15
X132 cke1 t_e3 vdd vdd sky130_fd_pr__pfet_01v8 w=9.6 l=0.15
X133 cke3 t_e1 vss vss sky130_fd_pr__nfet_01v8_lvt w=2.6 l=0.15
X134 cke3 t_e1 vdd vdd sky130_fd_pr__pfet_01v8 w=9.6 l=0.15
X135 ckd2 ckd0 vss vss sky130_fd_pr__nfet_01v8_lvt w=0.45 l=0.15
X136 ckd2 ckd0 vdd vdd sky130_fd_pr__pfet_01v8 w=1.1 l=0.15
X137 ckd0 ckd2 vss vss sky130_fd_pr__nfet_01v8_lvt w=0.45 l=0.15
X138 ckd0 ckd2 vdd vdd sky130_fd_pr__pfet_01v8 w=1.1 l=0.15
X139 ckd3 ckd1 vss vss sky130_fd_pr__nfet_01v8_lvt w=0.45 l=0.15
X140 ckd3 ckd1 vdd vdd sky130_fd_pr__pfet_01v8 w=1.1 l=0.15
X141 ckd1 ckd3 vss vss sky130_fd_pr__nfet_01v8_lvt w=0.45 l=0.15
X142 ckd1 ckd3 vdd vdd sky130_fd_pr__pfet_01v8 w=1.1 l=0.15
X143 cke2 cke0 vss vss sky130_fd_pr__nfet_01v8_lvt w=0.45 l=0.15
X144 cke2 cke0 vdd vdd sky130_fd_pr__pfet_01v8 w=1.1 l=0.15
X145 cke0 cke2 vss vss sky130_fd_pr__nfet_01v8_lvt w=0.45 l=0.15
X146 cke0 cke2 vdd vdd sky130_fd_pr__pfet_01v8 w=1.1 l=0.15
X147 cke3 cke1 vss vss sky130_fd_pr__nfet_01v8_lvt w=0.45 l=0.15
X148 cke3 cke1 vdd vdd sky130_fd_pr__pfet_01v8 w=1.1 l=0.15
X149 cke1 cke3 vss vss sky130_fd_pr__nfet_01v8_lvt w=0.45 l=0.15
X150 cke1 cke3 vdd vdd sky130_fd_pr__pfet_01v8 w=1.1 l=0.15
.ends serdes_rx_qdiv2_8ph_pdk
