* NGSPICE file created from serdes_rx_octature_4to8_2p5g_pdk.ext - technology: sky130A

.subckt serdes_rx_octature_4to8_2p5g_pdk ip qp in qn cb0 cb1 cb2 cb3 cb4 cb5 cb6 cb7
+ vdd vss
X0 cb2 cb6 vdd vdd sky130_fd_pr__pfet_01v8 ad=0.1122 pd=1.01 as=0.2108 ps=1.98 w=0.68 l=0.15
X1 a_6063_3075# a_5993_2925# vdd vdd sky130_fd_pr__pfet_01v8_lvt ad=0.23925 pd=1.94 as=0.23925 ps=1.94 w=1.65 l=0.35
X2 vss a_6063_8395# cb3 vss sky130_fd_pr__nfet_01v8_lvt ad=0.372 pd=3.02 as=0.198 ps=1.53 w=1.2 l=0.15
X3 vdd a_323_1340# a_3663_7850# vdd sky130_fd_pr__pfet_01v8_lvt ad=0.1595 pd=1.39 as=0.1595 ps=1.39 w=1.1 l=0.35
X4 vdd a_5993_6009# a_6063_6035# vdd sky130_fd_pr__pfet_01v8_lvt ad=0.23925 pd=1.94 as=0.23925 ps=1.94 w=1.65 l=0.35
X5 a_323_3700# vss sky130_fd_pr__cap_mim_m3_1 l=1.75 w=1.75
X6 vdd cb1 cb5 vdd sky130_fd_pr__pfet_01v8 ad=0.1122 pd=1.01 as=0.1122 ps=1.01 w=0.68 l=0.15
X7 a_2903_1370# a_323_1340# vdd vdd sky130_fd_pr__pfet_01v8_lvt ad=0.1595 pd=1.39 as=0.1595 ps=1.39 w=1.1 l=0.35
X8 vdd in a_323_6060# vdd sky130_fd_pr__pfet_01v8_lvt ad=0.203 pd=1.69 as=0.203 ps=1.69 w=1.4 l=0.35
X9 a_5993_7645# a_5214_7840# sky130_fd_pr__cap_mim_m3_1 l=4.2 w=4.2
X10 vdd a_6063_6035# cb2 vdd sky130_fd_pr__pfet_01v8 ad=0.297 pd=2.13 as=0.297 ps=2.13 w=1.8 l=0.15
X11 a_3663_3130# a_323_8420# vdd vdd sky130_fd_pr__pfet_01v8_lvt ad=0.1595 pd=1.39 as=0.1595 ps=1.39 w=1.1 l=0.35
X12 vdd a_5993_3649# a_6063_3675# vdd sky130_fd_pr__pfet_01v8_lvt ad=0.23925 pd=1.94 as=0.23925 ps=1.94 w=1.65 l=0.35
X13 a_3663_1370# a_323_1340# vdd vdd sky130_fd_pr__pfet_01v8_lvt ad=0.1595 pd=1.39 as=0.319 ps=2.78 w=1.1 l=0.35
X14 vss qn a_323_8420# vss sky130_fd_pr__nfet_01v8_lvt ad=0.217 pd=2.02 as=0.1155 ps=1.03 w=0.7 l=0.15
X15 vdd qp a_323_3700# vdd sky130_fd_pr__pfet_01v8_lvt ad=0.406 pd=3.38 as=0.203 ps=1.69 w=1.4 l=0.35
X16 a_5993_5285# a_5214_5480# sky130_fd_pr__cap_mim_m3_1 l=4.2 w=4.2
X17 a_2903_7850# a_323_8420# vdd vdd sky130_fd_pr__pfet_01v8_lvt ad=0.1595 pd=1.39 as=0.319 ps=2.78 w=1.1 l=0.35
X18 vdd a_6063_8395# cb3 vdd sky130_fd_pr__pfet_01v8 ad=0.558 pd=4.22 as=0.297 ps=2.13 w=1.8 l=0.15
X19 vdd a_323_1340# a_2903_3730# vdd sky130_fd_pr__pfet_01v8_lvt ad=0.319 pd=2.78 as=0.1595 ps=1.39 w=1.1 l=0.35
X20 vss a_5993_2925# a_6063_3075# vss sky130_fd_pr__nfet_01v8_lvt ad=0.2573 pd=2.28 as=0.13695 ps=1.16 w=0.83 l=0.15
X21 cb6 a_6063_5435# vdd vdd sky130_fd_pr__pfet_01v8 ad=0.297 pd=2.13 as=0.558 ps=4.22 w=1.8 l=0.15
X22 a_2903_8450# a_323_3700# vdd vdd sky130_fd_pr__pfet_01v8_lvt ad=0.1595 pd=1.39 as=0.1595 ps=1.39 w=1.1 l=0.35
X23 vdd a_323_8420# a_2903_5490# vdd sky130_fd_pr__pfet_01v8_lvt ad=0.319 pd=2.78 as=0.1595 ps=1.39 w=1.1 l=0.35
X24 cb2 a_6063_6035# vss vss sky130_fd_pr__nfet_01v8_lvt ad=0.198 pd=1.53 as=0.372 ps=3.02 w=1.2 l=0.15
X25 cb2 cb6 vss vss sky130_fd_pr__nfet_01v8_lvt ad=0.1305 pd=1.48 as=0.1305 ps=1.48 w=0.45 l=0.15
X26 cb4 cb0 vdd vdd sky130_fd_pr__pfet_01v8 ad=0.1122 pd=1.01 as=0.2108 ps=1.98 w=0.68 l=0.15
X27 vdd a_6063_3675# cb1 vdd sky130_fd_pr__pfet_01v8 ad=0.297 pd=2.13 as=0.297 ps=2.13 w=1.8 l=0.15
X28 vss in a_323_6060# vss sky130_fd_pr__nfet_01v8_lvt ad=0.217 pd=2.02 as=0.1155 ps=1.03 w=0.7 l=0.15
X29 cb7 a_6063_7795# vdd vdd sky130_fd_pr__pfet_01v8 ad=0.297 pd=2.13 as=0.297 ps=2.13 w=1.8 l=0.15
X30 vdd a_323_3700# a_3663_3730# vdd sky130_fd_pr__pfet_01v8_lvt ad=0.1595 pd=1.39 as=0.1595 ps=1.39 w=1.1 l=0.35
X31 a_2903_3130# a_323_6060# vss vss sky130_fd_pr__nfet_01v8_lvt ad=0.319 pd=2.78 as=0.319 ps=2.78 w=1.1 l=0.15
X32 a_6063_7795# a_5993_7645# vdd vdd sky130_fd_pr__pfet_01v8_lvt ad=0.23925 pd=1.94 as=0.23925 ps=1.94 w=1.65 l=0.35
X33 cb1 cb5 vdd vdd sky130_fd_pr__pfet_01v8 ad=0.1122 pd=1.01 as=0.2108 ps=1.98 w=0.68 l=0.15
X34 a_3663_8450# a_323_6060# vdd vdd sky130_fd_pr__pfet_01v8_lvt ad=0.1595 pd=1.39 as=0.319 ps=2.78 w=1.1 l=0.35
X35 vdd a_323_8420# a_3663_5490# vdd sky130_fd_pr__pfet_01v8_lvt ad=0.1595 pd=1.39 as=0.1595 ps=1.39 w=1.1 l=0.35
X36 cb1 cb5 vss vss sky130_fd_pr__nfet_01v8_lvt ad=0.1305 pd=1.48 as=0.1305 ps=1.48 w=0.45 l=0.15
X37 cb2 a_6063_6035# vdd vdd sky130_fd_pr__pfet_01v8 ad=0.297 pd=2.13 as=0.297 ps=2.13 w=1.8 l=0.15
X38 a_2903_3730# a_323_1340# vdd vdd sky130_fd_pr__pfet_01v8_lvt ad=0.1595 pd=1.39 as=0.319 ps=2.78 w=1.1 l=0.35
X39 a_3663_7850# a_323_1340# vdd vdd sky130_fd_pr__pfet_01v8_lvt ad=0.1595 pd=1.39 as=0.1595 ps=1.39 w=1.1 l=0.35
X40 a_2903_5490# a_323_8420# vdd vdd sky130_fd_pr__pfet_01v8_lvt ad=0.1595 pd=1.39 as=0.319 ps=2.78 w=1.1 l=0.35
X41 a_6063_6035# a_5993_6009# vdd vdd sky130_fd_pr__pfet_01v8_lvt ad=0.23925 pd=1.94 as=0.23925 ps=1.94 w=1.65 l=0.35
X42 cb0 a_6063_1315# vdd vdd sky130_fd_pr__pfet_01v8 ad=0.297 pd=2.13 as=0.558 ps=4.22 w=1.8 l=0.15
X43 vdd ip a_323_1340# vdd sky130_fd_pr__pfet_01v8_lvt ad=0.406 pd=3.38 as=0.203 ps=1.69 w=1.4 l=0.35
X44 a_323_3700# qp vss vss sky130_fd_pr__nfet_01v8_lvt ad=0.1155 pd=1.03 as=0.217 ps=2.02 w=0.7 l=0.15
X45 vdd a_323_1340# a_2903_1370# vdd sky130_fd_pr__pfet_01v8_lvt ad=0.319 pd=2.78 as=0.1595 ps=1.39 w=1.1 l=0.35
X46 cb5 a_6063_3075# vdd vdd sky130_fd_pr__pfet_01v8 ad=0.297 pd=2.13 as=0.558 ps=4.22 w=1.8 l=0.15
X47 cb1 a_6063_3675# vdd vdd sky130_fd_pr__pfet_01v8 ad=0.297 pd=2.13 as=0.297 ps=2.13 w=1.8 l=0.15
X48 a_2903_6090# a_323_3700# vdd vdd sky130_fd_pr__pfet_01v8_lvt ad=0.1595 pd=1.39 as=0.1595 ps=1.39 w=1.1 l=0.35
X49 vdd cb3 cb7 vdd sky130_fd_pr__pfet_01v8 ad=0.1122 pd=1.01 as=0.1122 ps=1.01 w=0.68 l=0.15
X50 cb1 a_6063_3675# vss vss sky130_fd_pr__nfet_01v8_lvt ad=0.198 pd=1.53 as=0.372 ps=3.02 w=1.2 l=0.15
X51 a_6063_3675# a_5993_3649# vdd vdd sky130_fd_pr__pfet_01v8_lvt ad=0.23925 pd=1.94 as=0.23925 ps=1.94 w=1.65 l=0.35
X52 vdd a_323_1340# a_3663_1370# vdd sky130_fd_pr__pfet_01v8_lvt ad=0.1595 pd=1.39 as=0.1595 ps=1.39 w=1.1 l=0.35
X53 a_323_1340# ip vss vss sky130_fd_pr__nfet_01v8_lvt ad=0.1155 pd=1.03 as=0.217 ps=2.02 w=0.7 l=0.15
X54 a_3663_6090# a_323_3700# vdd vdd sky130_fd_pr__pfet_01v8_lvt ad=0.1595 pd=1.39 as=0.319 ps=2.78 w=1.1 l=0.35
X55 cb3 cb7 vdd vdd sky130_fd_pr__pfet_01v8 ad=0.1122 pd=1.01 as=0.2108 ps=1.98 w=0.68 l=0.15
X56 vdd qn a_323_8420# vdd sky130_fd_pr__pfet_01v8_lvt ad=0.406 pd=3.38 as=0.203 ps=1.69 w=1.4 l=0.35
X57 vdd a_5993_8369# a_6063_8395# vdd sky130_fd_pr__pfet_01v8_lvt ad=0.23925 pd=1.94 as=0.23925 ps=1.94 w=1.65 l=0.35
X58 vss a_5993_7645# a_6063_7795# vss sky130_fd_pr__nfet_01v8_lvt ad=0.2573 pd=2.28 as=0.13695 ps=1.16 w=0.83 l=0.15
X59 a_3663_3730# a_323_3700# vdd vdd sky130_fd_pr__pfet_01v8_lvt ad=0.1595 pd=1.39 as=0.1595 ps=1.39 w=1.1 l=0.35
X60 vdd a_323_3700# a_2903_8450# vdd sky130_fd_pr__pfet_01v8_lvt ad=0.319 pd=2.78 as=0.1595 ps=1.39 w=1.1 l=0.35
X61 vdd a_5993_565# a_6063_715# vdd sky130_fd_pr__pfet_01v8_lvt ad=0.23925 pd=1.94 as=0.23925 ps=1.94 w=1.65 l=0.35
X62 a_2903_1370# a_323_1340# vdd vdd sky130_fd_pr__pfet_01v8_lvt ad=0.1595 pd=1.39 as=0.319 ps=2.78 w=1.1 l=0.35
X63 a_3663_5490# a_323_8420# vdd vdd sky130_fd_pr__pfet_01v8_lvt ad=0.1595 pd=1.39 as=0.1595 ps=1.39 w=1.1 l=0.35
X64 vdd a_6063_8395# cb3 vdd sky130_fd_pr__pfet_01v8 ad=0.297 pd=2.13 as=0.297 ps=2.13 w=1.8 l=0.15
X65 cb6 cb2 vdd vdd sky130_fd_pr__pfet_01v8 ad=0.1122 pd=1.01 as=0.2108 ps=1.98 w=0.68 l=0.15
X66 a_323_1340# vss sky130_fd_pr__cap_mim_m3_1 l=1.75 w=1.75
X67 a_3663_770# a_323_6060# vdd vdd sky130_fd_pr__pfet_01v8_lvt ad=0.1595 pd=1.39 as=0.1595 ps=1.39 w=1.1 l=0.35
X68 vdd a_323_6060# a_3663_8450# vdd sky130_fd_pr__pfet_01v8_lvt ad=0.1595 pd=1.39 as=0.1595 ps=1.39 w=1.1 l=0.35
X69 vdd a_323_6060# a_2903_770# vdd sky130_fd_pr__pfet_01v8_lvt ad=0.1595 pd=1.39 as=0.1595 ps=1.39 w=1.1 l=0.35
X70 vss a_5993_5285# a_6063_5435# vss sky130_fd_pr__nfet_01v8_lvt ad=0.2573 pd=2.28 as=0.13695 ps=1.16 w=0.83 l=0.15
X71 a_5993_3649# a_6063_3675# vss sky130_fd_pr__res_high_po_0p35 l=9.5
X72 a_3663_7850# a_323_1340# vss vss sky130_fd_pr__nfet_01v8_lvt ad=0.319 pd=2.78 as=0.319 ps=2.78 w=1.1 l=0.15
X73 cb7 a_6063_7795# vdd vdd sky130_fd_pr__pfet_01v8 ad=0.297 pd=2.13 as=0.558 ps=4.22 w=1.8 l=0.15
X74 cb3 a_6063_8395# vss vss sky130_fd_pr__nfet_01v8_lvt ad=0.198 pd=1.53 as=0.372 ps=3.02 w=1.2 l=0.15
X75 cb3 cb7 vss vss sky130_fd_pr__nfet_01v8_lvt ad=0.1305 pd=1.48 as=0.1305 ps=1.48 w=0.45 l=0.15
X76 cb5 cb1 vdd vdd sky130_fd_pr__pfet_01v8 ad=0.1122 pd=1.01 as=0.2108 ps=1.98 w=0.68 l=0.15
X77 a_2903_8450# a_323_3700# vdd vdd sky130_fd_pr__pfet_01v8_lvt ad=0.1595 pd=1.39 as=0.319 ps=2.78 w=1.1 l=0.35
X78 vdd in a_323_6060# vdd sky130_fd_pr__pfet_01v8_lvt ad=0.406 pd=3.38 as=0.203 ps=1.69 w=1.4 l=0.35
X79 cb2 a_6063_6035# vdd vdd sky130_fd_pr__pfet_01v8 ad=0.297 pd=2.13 as=0.558 ps=4.22 w=1.8 l=0.15
X80 a_3663_5490# a_323_8420# vss vss sky130_fd_pr__nfet_01v8_lvt ad=0.319 pd=2.78 as=0.319 ps=2.78 w=1.1 l=0.15
X81 a_323_8420# qn vss vss sky130_fd_pr__nfet_01v8_lvt ad=0.1155 pd=1.03 as=0.217 ps=2.02 w=0.7 l=0.15
X82 vdd a_323_3700# a_2903_6090# vdd sky130_fd_pr__pfet_01v8_lvt ad=0.319 pd=2.78 as=0.1595 ps=1.39 w=1.1 l=0.35
X83 a_3663_1370# a_323_1340# vdd vdd sky130_fd_pr__pfet_01v8_lvt ad=0.1595 pd=1.39 as=0.1595 ps=1.39 w=1.1 l=0.35
X84 cb3 a_6063_8395# vdd vdd sky130_fd_pr__pfet_01v8 ad=0.297 pd=2.13 as=0.297 ps=2.13 w=1.8 l=0.15
X85 a_6063_3075# a_5993_2925# vss vss sky130_fd_pr__nfet_01v8_lvt ad=0.13695 pd=1.16 as=0.2573 ps=2.28 w=0.83 l=0.15
X86 a_6063_8395# a_5993_8369# vdd vdd sky130_fd_pr__pfet_01v8_lvt ad=0.23925 pd=1.94 as=0.23925 ps=1.94 w=1.65 l=0.35
X87 vdd a_323_3700# a_3663_6090# vdd sky130_fd_pr__pfet_01v8_lvt ad=0.1595 pd=1.39 as=0.1595 ps=1.39 w=1.1 l=0.35
X88 cb1 a_6063_3675# vdd vdd sky130_fd_pr__pfet_01v8 ad=0.297 pd=2.13 as=0.558 ps=4.22 w=1.8 l=0.15
X89 a_323_6060# in vss vss sky130_fd_pr__nfet_01v8_lvt ad=0.1155 pd=1.03 as=0.217 ps=2.02 w=0.7 l=0.15
X90 vdd a_5993_5285# a_6063_5435# vdd sky130_fd_pr__pfet_01v8_lvt ad=0.4785 pd=3.88 as=0.23925 ps=1.94 w=1.65 l=0.35
X91 a_5993_6009# a_5214_5948# sky130_fd_pr__cap_mim_m3_1 l=4.2 w=4.2
X92 a_2903_770# a_5214_760# vss sky130_fd_pr__res_high_po_0p69 l=1.5
X93 a_3663_8450# a_323_6060# vdd vdd sky130_fd_pr__pfet_01v8_lvt ad=0.1595 pd=1.39 as=0.1595 ps=1.39 w=1.1 l=0.35
X94 a_2903_1370# a_5214_1228# vss sky130_fd_pr__res_high_po_0p69 l=1.5
X95 a_2903_6090# a_323_3700# vdd vdd sky130_fd_pr__pfet_01v8_lvt ad=0.1595 pd=1.39 as=0.319 ps=2.78 w=1.1 l=0.35
X96 vdd a_323_6060# a_2903_3130# vdd sky130_fd_pr__pfet_01v8_lvt ad=0.1595 pd=1.39 as=0.1595 ps=1.39 w=1.1 l=0.35
X97 a_3663_3130# a_323_8420# vss vss sky130_fd_pr__nfet_01v8_lvt ad=0.319 pd=2.78 as=0.319 ps=2.78 w=1.1 l=0.15
X98 a_2903_1370# a_323_1340# vss vss sky130_fd_pr__nfet_01v8_lvt ad=0.319 pd=2.78 as=0.319 ps=2.78 w=1.1 l=0.15
X99 a_5993_8369# a_6063_8395# vss sky130_fd_pr__res_high_po_0p35 l=9.5
X100 a_6063_5435# a_5993_5285# vdd vdd sky130_fd_pr__pfet_01v8_lvt ad=0.23925 pd=1.94 as=0.4785 ps=3.88 w=1.65 l=0.35
X101 vss a_6063_7795# cb7 vss sky130_fd_pr__nfet_01v8_lvt ad=0.372 pd=3.02 as=0.198 ps=1.53 w=1.2 l=0.15
X102 a_3663_3730# a_5214_3588# vss sky130_fd_pr__res_high_po_0p69 l=1.5
X103 a_5993_2925# a_6063_3075# vss sky130_fd_pr__res_high_po_0p35 l=9.5
X104 vdd a_5993_1289# a_6063_1315# vdd sky130_fd_pr__pfet_01v8_lvt ad=0.4785 pd=3.88 as=0.23925 ps=1.94 w=1.65 l=0.35
X105 cb7 cb3 vdd vdd sky130_fd_pr__pfet_01v8 ad=0.1122 pd=1.01 as=0.2108 ps=1.98 w=0.68 l=0.15
X106 a_2903_8450# a_5214_8308# vss sky130_fd_pr__res_high_po_0p69 l=1.5
X107 vdd a_5993_2925# a_6063_3075# vdd sky130_fd_pr__pfet_01v8_lvt ad=0.4785 pd=3.88 as=0.23925 ps=1.94 w=1.65 l=0.35
X108 a_5993_3649# a_5214_3588# sky130_fd_pr__cap_mim_m3_1 l=4.2 w=4.2
X109 vss a_6063_5435# cb6 vss sky130_fd_pr__nfet_01v8_lvt ad=0.372 pd=3.02 as=0.198 ps=1.53 w=1.2 l=0.15
X110 vdd a_5993_565# a_6063_715# vdd sky130_fd_pr__pfet_01v8_lvt ad=0.4785 pd=3.88 as=0.23925 ps=1.94 w=1.65 l=0.35
X111 vdd a_6063_5435# cb6 vdd sky130_fd_pr__pfet_01v8 ad=0.297 pd=2.13 as=0.297 ps=2.13 w=1.8 l=0.15
X112 a_5993_565# a_5214_760# sky130_fd_pr__cap_mim_m3_1 l=4.2 w=4.2
X113 a_3663_6090# a_323_3700# vdd vdd sky130_fd_pr__pfet_01v8_lvt ad=0.1595 pd=1.39 as=0.1595 ps=1.39 w=1.1 l=0.35
X114 a_2903_6090# a_5214_5948# vss sky130_fd_pr__res_high_po_0p69 l=1.5
X115 a_3663_770# a_323_6060# vss vss sky130_fd_pr__nfet_01v8_lvt ad=0.319 pd=2.78 as=0.319 ps=2.78 w=1.1 l=0.15
X116 a_6063_7795# a_5993_7645# vss vss sky130_fd_pr__nfet_01v8_lvt ad=0.13695 pd=1.16 as=0.2573 ps=2.28 w=0.83 l=0.15
X117 vdd a_323_8420# a_3663_3130# vdd sky130_fd_pr__pfet_01v8_lvt ad=0.319 pd=2.78 as=0.1595 ps=1.39 w=1.1 l=0.35
X118 vdd a_323_6060# a_2903_770# vdd sky130_fd_pr__pfet_01v8_lvt ad=0.319 pd=2.78 as=0.1595 ps=1.39 w=1.1 l=0.35
X119 vdd a_323_8420# a_2903_7850# vdd sky130_fd_pr__pfet_01v8_lvt ad=0.1595 pd=1.39 as=0.1595 ps=1.39 w=1.1 l=0.35
X120 cb3 a_6063_8395# vdd vdd sky130_fd_pr__pfet_01v8 ad=0.297 pd=2.13 as=0.558 ps=4.22 w=1.8 l=0.15
X121 a_6063_1315# a_5993_1289# vdd vdd sky130_fd_pr__pfet_01v8_lvt ad=0.23925 pd=1.94 as=0.4785 ps=3.88 w=1.65 l=0.35
X122 a_6063_5435# a_5993_5285# vss vss sky130_fd_pr__nfet_01v8_lvt ad=0.13695 pd=1.16 as=0.2573 ps=2.28 w=0.83 l=0.15
X123 a_6063_3075# a_5993_2925# vdd vdd sky130_fd_pr__pfet_01v8_lvt ad=0.23925 pd=1.94 as=0.4785 ps=3.88 w=1.65 l=0.35
X124 a_3663_1370# a_5214_1228# vss sky130_fd_pr__res_high_po_0p69 l=1.5
X125 a_323_3700# qp vdd vdd sky130_fd_pr__pfet_01v8_lvt ad=0.203 pd=1.69 as=0.406 ps=3.38 w=1.4 l=0.35
X126 a_323_8420# vss sky130_fd_pr__cap_mim_m3_1 l=1.75 w=1.75
X127 cb0 cb4 vdd vdd sky130_fd_pr__pfet_01v8 ad=0.2108 pd=1.98 as=0.1122 ps=1.01 w=0.68 l=0.15
X128 vdd a_5993_7645# a_6063_7795# vdd sky130_fd_pr__pfet_01v8_lvt ad=0.4785 pd=3.88 as=0.23925 ps=1.94 w=1.65 l=0.35
X129 vdd cb4 cb0 vdd sky130_fd_pr__pfet_01v8 ad=0.1122 pd=1.01 as=0.1122 ps=1.01 w=0.68 l=0.15
X130 vdd a_6063_1315# cb0 vdd sky130_fd_pr__pfet_01v8 ad=0.297 pd=2.13 as=0.297 ps=2.13 w=1.8 l=0.15
X131 vss a_6063_3075# cb5 vss sky130_fd_pr__nfet_01v8_lvt ad=0.372 pd=3.02 as=0.198 ps=1.53 w=1.2 l=0.15
X132 a_2903_6090# a_323_3700# vss vss sky130_fd_pr__nfet_01v8_lvt ad=0.319 pd=2.78 as=0.319 ps=2.78 w=1.1 l=0.15
X133 vdd a_6063_3075# cb5 vdd sky130_fd_pr__pfet_01v8 ad=0.297 pd=2.13 as=0.297 ps=2.13 w=1.8 l=0.15
X134 a_2903_3730# a_5214_3588# vss sky130_fd_pr__res_high_po_0p69 l=1.5
X135 cb0 cb4 vdd vdd sky130_fd_pr__pfet_01v8 ad=0.1122 pd=1.01 as=0.2108 ps=1.98 w=0.68 l=0.15
X136 vdd a_323_1340# a_2903_3730# vdd sky130_fd_pr__pfet_01v8_lvt ad=0.1595 pd=1.39 as=0.1595 ps=1.39 w=1.1 l=0.35
X137 a_3663_8450# a_5214_8308# vss sky130_fd_pr__res_high_po_0p69 l=1.5
X138 a_5993_7645# a_6063_7795# vss sky130_fd_pr__res_high_po_0p35 l=9.5
X139 a_3663_770# a_5214_760# vss sky130_fd_pr__res_high_po_0p69 l=1.5
X140 vdd a_323_1340# a_3663_7850# vdd sky130_fd_pr__pfet_01v8_lvt ad=0.319 pd=2.78 as=0.1595 ps=1.39 w=1.1 l=0.35
X141 vdd a_323_8420# a_2903_5490# vdd sky130_fd_pr__pfet_01v8_lvt ad=0.1595 pd=1.39 as=0.1595 ps=1.39 w=1.1 l=0.35
X142 vdd a_5993_6009# a_6063_6035# vdd sky130_fd_pr__pfet_01v8_lvt ad=0.4785 pd=3.88 as=0.23925 ps=1.94 w=1.65 l=0.35
X143 a_6063_7795# a_5993_7645# vdd vdd sky130_fd_pr__pfet_01v8_lvt ad=0.23925 pd=1.94 as=0.4785 ps=3.88 w=1.65 l=0.35
X144 vdd a_5993_3649# a_6063_3675# vdd sky130_fd_pr__pfet_01v8_lvt ad=0.4785 pd=3.88 as=0.23925 ps=1.94 w=1.65 l=0.35
X145 a_323_1340# ip vdd vdd sky130_fd_pr__pfet_01v8_lvt ad=0.203 pd=1.69 as=0.406 ps=3.38 w=1.4 l=0.35
X146 a_6063_1315# a_5993_1289# vss sky130_fd_pr__res_high_po_0p35 l=9.5
X147 a_2903_3730# a_323_1340# vss vss sky130_fd_pr__nfet_01v8_lvt ad=0.319 pd=2.78 as=0.319 ps=2.78 w=1.1 l=0.15
X148 a_6063_6035# a_5993_6009# vdd vdd sky130_fd_pr__pfet_01v8_lvt ad=0.23925 pd=1.94 as=0.4785 ps=3.88 w=1.65 l=0.35
X149 vdd a_6063_7795# cb7 vdd sky130_fd_pr__pfet_01v8 ad=0.297 pd=2.13 as=0.297 ps=2.13 w=1.8 l=0.15
X150 vss a_5993_1289# a_6063_1315# vss sky130_fd_pr__nfet_01v8_lvt ad=0.2573 pd=2.28 as=0.13695 ps=1.16 w=0.83 l=0.15
X151 vdd a_323_3700# a_3663_3730# vdd sky130_fd_pr__pfet_01v8_lvt ad=0.319 pd=2.78 as=0.1595 ps=1.39 w=1.1 l=0.35
X152 vdd a_323_1340# a_2903_1370# vdd sky130_fd_pr__pfet_01v8_lvt ad=0.1595 pd=1.39 as=0.1595 ps=1.39 w=1.1 l=0.35
X153 a_3663_6090# a_5214_5948# vss sky130_fd_pr__res_high_po_0p69 l=1.5
X154 cb2 cb6 vdd vdd sky130_fd_pr__pfet_01v8 ad=0.2108 pd=1.98 as=0.1122 ps=1.01 w=0.68 l=0.15
X155 cb5 cb1 vss vss sky130_fd_pr__nfet_01v8_lvt ad=0.1305 pd=1.48 as=0.1305 ps=1.48 w=0.45 l=0.15
X156 a_323_8420# qn vdd vdd sky130_fd_pr__pfet_01v8_lvt ad=0.203 pd=1.69 as=0.406 ps=3.38 w=1.4 l=0.35
X157 vdd a_323_8420# a_3663_5490# vdd sky130_fd_pr__pfet_01v8_lvt ad=0.319 pd=2.78 as=0.1595 ps=1.39 w=1.1 l=0.35
X158 a_2903_5490# a_5214_5480# vss sky130_fd_pr__res_high_po_0p69 l=1.5
X159 cb7 a_6063_7795# vss vss sky130_fd_pr__nfet_01v8_lvt ad=0.198 pd=1.53 as=0.372 ps=3.02 w=1.2 l=0.15
X160 a_2903_770# a_323_6060# vdd vdd sky130_fd_pr__pfet_01v8_lvt ad=0.1595 pd=1.39 as=0.1595 ps=1.39 w=1.1 l=0.35
X161 a_6063_3675# a_5993_3649# vdd vdd sky130_fd_pr__pfet_01v8_lvt ad=0.23925 pd=1.94 as=0.4785 ps=3.88 w=1.65 l=0.35
X162 a_3663_1370# a_323_1340# vss vss sky130_fd_pr__nfet_01v8_lvt ad=0.319 pd=2.78 as=0.319 ps=2.78 w=1.1 l=0.15
X163 vss a_5993_565# a_6063_715# vss sky130_fd_pr__nfet_01v8_lvt ad=0.2573 pd=2.28 as=0.13695 ps=1.16 w=0.83 l=0.15
X164 vdd a_6063_715# cb4 vdd sky130_fd_pr__pfet_01v8 ad=0.297 pd=2.13 as=0.297 ps=2.13 w=1.8 l=0.15
X165 a_6063_715# a_5993_565# vss sky130_fd_pr__res_high_po_0p35 l=9.5
X166 vdd a_323_6060# a_3663_770# vdd sky130_fd_pr__pfet_01v8_lvt ad=0.1595 pd=1.39 as=0.1595 ps=1.39 w=1.1 l=0.35
X167 vdd a_6063_6035# cb2 vdd sky130_fd_pr__pfet_01v8 ad=0.297 pd=2.13 as=0.297 ps=2.13 w=1.8 l=0.15
X168 vdd a_6063_715# cb4 vdd sky130_fd_pr__pfet_01v8 ad=0.558 pd=4.22 as=0.297 ps=2.13 w=1.8 l=0.15
X169 cb4 a_6063_715# vdd vdd sky130_fd_pr__pfet_01v8 ad=0.297 pd=2.13 as=0.297 ps=2.13 w=1.8 l=0.15
X170 cb4 cb0 vss vss sky130_fd_pr__nfet_01v8_lvt ad=0.1305 pd=1.48 as=0.1305 ps=1.48 w=0.45 l=0.15
X171 cb6 a_6063_5435# vss vss sky130_fd_pr__nfet_01v8_lvt ad=0.198 pd=1.53 as=0.372 ps=3.02 w=1.2 l=0.15
X172 a_6063_715# a_5993_565# vss vss sky130_fd_pr__nfet_01v8_lvt ad=0.13695 pd=1.16 as=0.2573 ps=2.28 w=0.83 l=0.15
X173 cb6 a_6063_5435# vdd vdd sky130_fd_pr__pfet_01v8 ad=0.297 pd=2.13 as=0.297 ps=2.13 w=1.8 l=0.15
X174 cb4 a_6063_715# vdd vdd sky130_fd_pr__pfet_01v8 ad=0.297 pd=2.13 as=0.297 ps=2.13 w=1.8 l=0.15
X175 a_6063_715# a_5993_565# vdd vdd sky130_fd_pr__pfet_01v8_lvt ad=0.23925 pd=1.94 as=0.4785 ps=3.88 w=1.65 l=0.35
X176 vdd a_323_3700# a_2903_8450# vdd sky130_fd_pr__pfet_01v8_lvt ad=0.1595 pd=1.39 as=0.1595 ps=1.39 w=1.1 l=0.35
X177 vdd a_6063_3675# cb1 vdd sky130_fd_pr__pfet_01v8 ad=0.297 pd=2.13 as=0.297 ps=2.13 w=1.8 l=0.15
X178 vss a_6063_715# cb4 vss sky130_fd_pr__nfet_01v8_lvt ad=0.372 pd=3.02 as=0.198 ps=1.53 w=1.2 l=0.15
X179 a_2903_8450# a_323_3700# vss vss sky130_fd_pr__nfet_01v8_lvt ad=0.319 pd=2.78 as=0.319 ps=2.78 w=1.1 l=0.15
X180 cb4 a_6063_715# vss vss sky130_fd_pr__nfet_01v8_lvt ad=0.198 pd=1.53 as=0.372 ps=3.02 w=1.2 l=0.15
X181 cb4 cb0 vdd vdd sky130_fd_pr__pfet_01v8 ad=0.2108 pd=1.98 as=0.1122 ps=1.01 w=0.68 l=0.15
X182 a_2903_770# a_323_6060# vdd vdd sky130_fd_pr__pfet_01v8_lvt ad=0.1595 pd=1.39 as=0.319 ps=2.78 w=1.1 l=0.35
X183 vdd a_323_1340# a_3663_1370# vdd sky130_fd_pr__pfet_01v8_lvt ad=0.319 pd=2.78 as=0.1595 ps=1.39 w=1.1 l=0.35
X184 a_5993_2925# a_5214_3120# sky130_fd_pr__cap_mim_m3_1 l=4.2 w=4.2
X185 cb1 cb5 vdd vdd sky130_fd_pr__pfet_01v8 ad=0.2108 pd=1.98 as=0.1122 ps=1.01 w=0.68 l=0.15
X186 vss a_5993_8369# a_6063_8395# vss sky130_fd_pr__nfet_01v8_lvt ad=0.2573 pd=2.28 as=0.13695 ps=1.16 w=0.83 l=0.15
X187 vdd a_5993_8369# a_6063_8395# vdd sky130_fd_pr__pfet_01v8_lvt ad=0.4785 pd=3.88 as=0.23925 ps=1.94 w=1.65 l=0.35
X188 a_323_6060# in vdd vdd sky130_fd_pr__pfet_01v8_lvt ad=0.203 pd=1.69 as=0.406 ps=3.38 w=1.4 l=0.35
X189 a_2903_3130# a_5214_3120# vss sky130_fd_pr__res_high_po_0p69 l=1.5
X190 a_6063_6035# a_5993_6009# vss sky130_fd_pr__res_high_po_0p35 l=9.5
X191 a_323_3700# qp vdd vdd sky130_fd_pr__pfet_01v8_lvt ad=0.203 pd=1.69 as=0.203 ps=1.69 w=1.4 l=0.35
X192 cb0 a_6063_1315# vdd vdd sky130_fd_pr__pfet_01v8 ad=0.297 pd=2.13 as=0.297 ps=2.13 w=1.8 l=0.15
X193 cb5 a_6063_3075# vss vss sky130_fd_pr__nfet_01v8_lvt ad=0.198 pd=1.53 as=0.372 ps=3.02 w=1.2 l=0.15
X194 vss a_5993_6009# a_6063_6035# vss sky130_fd_pr__nfet_01v8_lvt ad=0.2573 pd=2.28 as=0.13695 ps=1.16 w=0.83 l=0.15
X195 cb5 a_6063_3075# vdd vdd sky130_fd_pr__pfet_01v8 ad=0.297 pd=2.13 as=0.297 ps=2.13 w=1.8 l=0.15
X196 vdd a_323_6060# a_3663_8450# vdd sky130_fd_pr__pfet_01v8_lvt ad=0.319 pd=2.78 as=0.1595 ps=1.39 w=1.1 l=0.35
X197 vdd a_323_3700# a_2903_6090# vdd sky130_fd_pr__pfet_01v8_lvt ad=0.1595 pd=1.39 as=0.1595 ps=1.39 w=1.1 l=0.35
X198 vdd a_6063_5435# cb6 vdd sky130_fd_pr__pfet_01v8 ad=0.558 pd=4.22 as=0.297 ps=2.13 w=1.8 l=0.15
X199 cb7 cb3 vss vss sky130_fd_pr__nfet_01v8_lvt ad=0.1305 pd=1.48 as=0.1305 ps=1.48 w=0.45 l=0.15
X200 a_6063_8395# a_5993_8369# vdd vdd sky130_fd_pr__pfet_01v8_lvt ad=0.23925 pd=1.94 as=0.4785 ps=3.88 w=1.65 l=0.35
X201 a_6063_5435# a_5993_5285# vss sky130_fd_pr__res_high_po_0p35 l=9.5
X202 vss a_6063_1315# cb0 vss sky130_fd_pr__nfet_01v8_lvt ad=0.372 pd=3.02 as=0.198 ps=1.53 w=1.2 l=0.15
X203 a_3663_6090# a_323_3700# vss vss sky130_fd_pr__nfet_01v8_lvt ad=0.319 pd=2.78 as=0.319 ps=2.78 w=1.1 l=0.15
X204 cb3 cb7 vdd vdd sky130_fd_pr__pfet_01v8 ad=0.2108 pd=1.98 as=0.1122 ps=1.01 w=0.68 l=0.15
X205 cb6 cb2 vss vss sky130_fd_pr__nfet_01v8_lvt ad=0.1305 pd=1.48 as=0.1305 ps=1.48 w=0.45 l=0.15
X206 a_3663_770# a_323_6060# vdd vdd sky130_fd_pr__pfet_01v8_lvt ad=0.1595 pd=1.39 as=0.319 ps=2.78 w=1.1 l=0.35
X207 a_323_1340# ip vdd vdd sky130_fd_pr__pfet_01v8_lvt ad=0.203 pd=1.69 as=0.203 ps=1.69 w=1.4 l=0.35
X208 vdd a_6063_8395# cb3 vdd sky130_fd_pr__pfet_01v8 ad=0.297 pd=2.13 as=0.297 ps=2.13 w=1.8 l=0.15
X209 a_5993_8369# a_5214_8308# sky130_fd_pr__cap_mim_m3_1 l=4.2 w=4.2
X210 vdd a_6063_1315# cb0 vdd sky130_fd_pr__pfet_01v8 ad=0.558 pd=4.22 as=0.297 ps=2.13 w=1.8 l=0.15
X211 cb6 cb2 vdd vdd sky130_fd_pr__pfet_01v8 ad=0.2108 pd=1.98 as=0.1122 ps=1.01 w=0.68 l=0.15
X212 vss a_5993_3649# a_6063_3675# vss sky130_fd_pr__nfet_01v8_lvt ad=0.2573 pd=2.28 as=0.13695 ps=1.16 w=0.83 l=0.15
X213 a_2903_770# a_323_6060# vss vss sky130_fd_pr__nfet_01v8_lvt ad=0.319 pd=2.78 as=0.319 ps=2.78 w=1.1 l=0.15
X214 vdd a_323_3700# a_3663_6090# vdd sky130_fd_pr__pfet_01v8_lvt ad=0.319 pd=2.78 as=0.1595 ps=1.39 w=1.1 l=0.35
X215 cb7 a_6063_7795# vdd vdd sky130_fd_pr__pfet_01v8 ad=0.297 pd=2.13 as=0.297 ps=2.13 w=1.8 l=0.15
X216 a_6063_1315# a_5993_1289# vss vss sky130_fd_pr__nfet_01v8_lvt ad=0.13695 pd=1.16 as=0.2573 ps=2.28 w=0.83 l=0.15
X217 vdd a_6063_3075# cb5 vdd sky130_fd_pr__pfet_01v8 ad=0.558 pd=4.22 as=0.297 ps=2.13 w=1.8 l=0.15
X218 vdd a_323_6060# a_3663_770# vdd sky130_fd_pr__pfet_01v8_lvt ad=0.319 pd=2.78 as=0.1595 ps=1.39 w=1.1 l=0.35
X219 a_2903_7850# a_5214_7840# vss sky130_fd_pr__res_high_po_0p69 l=1.5
X220 vdd cb6 cb2 vdd sky130_fd_pr__pfet_01v8 ad=0.1122 pd=1.01 as=0.1122 ps=1.01 w=0.68 l=0.15
X221 a_2903_3130# a_323_6060# vdd vdd sky130_fd_pr__pfet_01v8_lvt ad=0.1595 pd=1.39 as=0.1595 ps=1.39 w=1.1 l=0.35
X222 cb5 cb1 vdd vdd sky130_fd_pr__pfet_01v8 ad=0.2108 pd=1.98 as=0.1122 ps=1.01 w=0.68 l=0.15
X223 a_3663_3730# a_323_3700# vss vss sky130_fd_pr__nfet_01v8_lvt ad=0.319 pd=2.78 as=0.319 ps=2.78 w=1.1 l=0.15
X224 a_323_8420# qn vdd vdd sky130_fd_pr__pfet_01v8_lvt ad=0.203 pd=1.69 as=0.203 ps=1.69 w=1.4 l=0.35
X225 vdd a_5993_5285# a_6063_5435# vdd sky130_fd_pr__pfet_01v8_lvt ad=0.23925 pd=1.94 as=0.23925 ps=1.94 w=1.65 l=0.35
X226 cb2 a_6063_6035# vdd vdd sky130_fd_pr__pfet_01v8 ad=0.297 pd=2.13 as=0.297 ps=2.13 w=1.8 l=0.15
X227 vdd qp a_323_3700# vdd sky130_fd_pr__pfet_01v8_lvt ad=0.203 pd=1.69 as=0.203 ps=1.69 w=1.4 l=0.35
X228 a_3663_3130# a_323_8420# vdd vdd sky130_fd_pr__pfet_01v8_lvt ad=0.1595 pd=1.39 as=0.319 ps=2.78 w=1.1 l=0.35
X229 a_6063_715# a_5993_565# vdd vdd sky130_fd_pr__pfet_01v8_lvt ad=0.23925 pd=1.94 as=0.23925 ps=1.94 w=1.65 l=0.35
X230 vdd a_6063_715# cb4 vdd sky130_fd_pr__pfet_01v8 ad=0.297 pd=2.13 as=0.297 ps=2.13 w=1.8 l=0.15
X231 a_3663_3130# a_5214_3120# vss sky130_fd_pr__res_high_po_0p69 l=1.5
X232 vdd a_6063_5435# cb6 vdd sky130_fd_pr__pfet_01v8 ad=0.297 pd=2.13 as=0.297 ps=2.13 w=1.8 l=0.15
X233 cb4 a_6063_715# vdd vdd sky130_fd_pr__pfet_01v8 ad=0.297 pd=2.13 as=0.558 ps=4.22 w=1.8 l=0.15
X234 cb1 a_6063_3675# vdd vdd sky130_fd_pr__pfet_01v8 ad=0.297 pd=2.13 as=0.297 ps=2.13 w=1.8 l=0.15
X235 vss a_6063_6035# cb2 vss sky130_fd_pr__nfet_01v8_lvt ad=0.372 pd=3.02 as=0.198 ps=1.53 w=1.2 l=0.15
X236 vdd cb0 cb4 vdd sky130_fd_pr__pfet_01v8 ad=0.1122 pd=1.01 as=0.1122 ps=1.01 w=0.68 l=0.15
X237 vdd a_6063_7795# cb7 vdd sky130_fd_pr__pfet_01v8 ad=0.558 pd=4.22 as=0.297 ps=2.13 w=1.8 l=0.15
X238 vdd cb5 cb1 vdd sky130_fd_pr__pfet_01v8 ad=0.1122 pd=1.01 as=0.1122 ps=1.01 w=0.68 l=0.15
X239 a_6063_8395# a_5993_8369# vss vss sky130_fd_pr__nfet_01v8_lvt ad=0.13695 pd=1.16 as=0.2573 ps=2.28 w=0.83 l=0.15
X240 a_2903_7850# a_323_8420# vdd vdd sky130_fd_pr__pfet_01v8_lvt ad=0.1595 pd=1.39 as=0.1595 ps=1.39 w=1.1 l=0.35
X241 a_3663_8450# a_323_6060# vss vss sky130_fd_pr__nfet_01v8_lvt ad=0.319 pd=2.78 as=0.319 ps=2.78 w=1.1 l=0.15
X242 vdd a_5993_1289# a_6063_1315# vdd sky130_fd_pr__pfet_01v8_lvt ad=0.23925 pd=1.94 as=0.23925 ps=1.94 w=1.65 l=0.35
X243 a_3663_7850# a_323_1340# vdd vdd sky130_fd_pr__pfet_01v8_lvt ad=0.1595 pd=1.39 as=0.319 ps=2.78 w=1.1 l=0.35
X244 a_323_6060# in vdd vdd sky130_fd_pr__pfet_01v8_lvt ad=0.203 pd=1.69 as=0.203 ps=1.69 w=1.4 l=0.35
X245 vdd a_6063_6035# cb2 vdd sky130_fd_pr__pfet_01v8 ad=0.558 pd=4.22 as=0.297 ps=2.13 w=1.8 l=0.15
X246 vdd a_5993_2925# a_6063_3075# vdd sky130_fd_pr__pfet_01v8_lvt ad=0.23925 pd=1.94 as=0.23925 ps=1.94 w=1.65 l=0.35
X247 vdd ip a_323_1340# vdd sky130_fd_pr__pfet_01v8_lvt ad=0.203 pd=1.69 as=0.203 ps=1.69 w=1.4 l=0.35
X248 a_6063_6035# a_5993_6009# vss vss sky130_fd_pr__nfet_01v8_lvt ad=0.13695 pd=1.16 as=0.2573 ps=2.28 w=0.83 l=0.15
X249 vdd a_323_6060# a_2903_3130# vdd sky130_fd_pr__pfet_01v8_lvt ad=0.319 pd=2.78 as=0.1595 ps=1.39 w=1.1 l=0.35
X250 vdd a_6063_1315# cb0 vdd sky130_fd_pr__pfet_01v8 ad=0.297 pd=2.13 as=0.297 ps=2.13 w=1.8 l=0.15
X251 cb6 a_6063_5435# vdd vdd sky130_fd_pr__pfet_01v8 ad=0.297 pd=2.13 as=0.297 ps=2.13 w=1.8 l=0.15
X252 vss qp a_323_3700# vss sky130_fd_pr__nfet_01v8_lvt ad=0.217 pd=2.02 as=0.1155 ps=1.03 w=0.7 l=0.15
X253 a_3663_7850# a_5214_7840# vss sky130_fd_pr__res_high_po_0p69 l=1.5
X254 a_5993_1289# a_5214_1228# sky130_fd_pr__cap_mim_m3_1 l=4.2 w=4.2
X255 vdd a_6063_3075# cb5 vdd sky130_fd_pr__pfet_01v8 ad=0.297 pd=2.13 as=0.297 ps=2.13 w=1.8 l=0.15
X256 vdd a_6063_3675# cb1 vdd sky130_fd_pr__pfet_01v8 ad=0.558 pd=4.22 as=0.297 ps=2.13 w=1.8 l=0.15
X257 a_6063_5435# a_5993_5285# vdd vdd sky130_fd_pr__pfet_01v8_lvt ad=0.23925 pd=1.94 as=0.23925 ps=1.94 w=1.65 l=0.35
X258 cb7 cb3 vdd vdd sky130_fd_pr__pfet_01v8 ad=0.2108 pd=1.98 as=0.1122 ps=1.01 w=0.68 l=0.15
X259 vss a_6063_3675# cb1 vss sky130_fd_pr__nfet_01v8_lvt ad=0.372 pd=3.02 as=0.198 ps=1.53 w=1.2 l=0.15
X260 vdd a_323_8420# a_3663_3130# vdd sky130_fd_pr__pfet_01v8_lvt ad=0.1595 pd=1.39 as=0.1595 ps=1.39 w=1.1 l=0.35
X261 a_2903_3730# a_323_1340# vdd vdd sky130_fd_pr__pfet_01v8_lvt ad=0.1595 pd=1.39 as=0.1595 ps=1.39 w=1.1 l=0.35
X262 cb0 a_6063_1315# vss vss sky130_fd_pr__nfet_01v8_lvt ad=0.198 pd=1.53 as=0.372 ps=3.02 w=1.2 l=0.15
X263 vdd qn a_323_8420# vdd sky130_fd_pr__pfet_01v8_lvt ad=0.203 pd=1.69 as=0.203 ps=1.69 w=1.4 l=0.35
X264 vdd cb7 cb3 vdd sky130_fd_pr__pfet_01v8 ad=0.1122 pd=1.01 as=0.1122 ps=1.01 w=0.68 l=0.15
X265 vss ip a_323_1340# vss sky130_fd_pr__nfet_01v8_lvt ad=0.217 pd=2.02 as=0.1155 ps=1.03 w=0.7 l=0.15
X266 a_2903_5490# a_323_8420# vdd vdd sky130_fd_pr__pfet_01v8_lvt ad=0.1595 pd=1.39 as=0.1595 ps=1.39 w=1.1 l=0.35
X267 a_3663_3730# a_323_3700# vdd vdd sky130_fd_pr__pfet_01v8_lvt ad=0.1595 pd=1.39 as=0.319 ps=2.78 w=1.1 l=0.35
X268 a_3663_5490# a_323_8420# vdd vdd sky130_fd_pr__pfet_01v8_lvt ad=0.1595 pd=1.39 as=0.319 ps=2.78 w=1.1 l=0.35
X269 a_2903_3130# a_323_6060# vdd vdd sky130_fd_pr__pfet_01v8_lvt ad=0.1595 pd=1.39 as=0.319 ps=2.78 w=1.1 l=0.35
X270 vdd a_5993_7645# a_6063_7795# vdd sky130_fd_pr__pfet_01v8_lvt ad=0.23925 pd=1.94 as=0.23925 ps=1.94 w=1.65 l=0.35
X271 a_2903_7850# a_323_8420# vss vss sky130_fd_pr__nfet_01v8_lvt ad=0.319 pd=2.78 as=0.319 ps=2.78 w=1.1 l=0.15
X272 cb3 a_6063_8395# vdd vdd sky130_fd_pr__pfet_01v8 ad=0.297 pd=2.13 as=0.297 ps=2.13 w=1.8 l=0.15
X273 cb0 a_6063_1315# vdd vdd sky130_fd_pr__pfet_01v8 ad=0.297 pd=2.13 as=0.297 ps=2.13 w=1.8 l=0.15
X274 vdd cb2 cb6 vdd sky130_fd_pr__pfet_01v8 ad=0.1122 pd=1.01 as=0.1122 ps=1.01 w=0.68 l=0.15
X275 a_6063_3675# a_5993_3649# vss vss sky130_fd_pr__nfet_01v8_lvt ad=0.13695 pd=1.16 as=0.2573 ps=2.28 w=0.83 l=0.15
X276 vdd a_323_8420# a_2903_7850# vdd sky130_fd_pr__pfet_01v8_lvt ad=0.319 pd=2.78 as=0.1595 ps=1.39 w=1.1 l=0.35
X277 cb0 cb4 vss vss sky130_fd_pr__nfet_01v8_lvt ad=0.1305 pd=1.48 as=0.1305 ps=1.48 w=0.45 l=0.15
X278 cb5 a_6063_3075# vdd vdd sky130_fd_pr__pfet_01v8 ad=0.297 pd=2.13 as=0.297 ps=2.13 w=1.8 l=0.15
X279 a_6063_1315# a_5993_1289# vdd vdd sky130_fd_pr__pfet_01v8_lvt ad=0.23925 pd=1.94 as=0.23925 ps=1.94 w=1.65 l=0.35
X280 a_3663_5490# a_5214_5480# vss sky130_fd_pr__res_high_po_0p69 l=1.5
X281 vdd a_6063_7795# cb7 vdd sky130_fd_pr__pfet_01v8 ad=0.297 pd=2.13 as=0.297 ps=2.13 w=1.8 l=0.15
X282 a_2903_5490# a_323_8420# vss vss sky130_fd_pr__nfet_01v8_lvt ad=0.319 pd=2.78 as=0.319 ps=2.78 w=1.1 l=0.15
X283 a_323_6060# vss sky130_fd_pr__cap_mim_m3_1 l=1.75 w=1.75
.ends
