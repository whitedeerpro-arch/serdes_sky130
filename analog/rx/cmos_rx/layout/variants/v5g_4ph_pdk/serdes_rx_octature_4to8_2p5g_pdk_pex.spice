* NGSPICE file created from serdes_rx_octature_4to8_2p5g_pdk.ext - technology: sky130A

.subckt serdes_rx_octature_4to8_2p5g_pdk ip qp in qn cb0 cb1 cb2 cb3 cb4 cb5 cb6 cb7
+ vdd vss
X0 cb2 cb6 vdd vdd sky130_fd_pr__pfet_01v8 ad=0.1122 pd=1.01 as=0.2108 ps=1.98 w=0.68 l=0.15
X1 a_6063_3075# a_5993_2925# vdd vdd sky130_fd_pr__pfet_01v8_lvt ad=0.23925 pd=1.94 as=0.23925 ps=1.94 w=1.65 l=0.35
X2 vss a_6063_8395# cb3 vss sky130_fd_pr__nfet_01v8_lvt ad=0.372 pd=3.02 as=0.198 ps=1.53 w=1.2 l=0.15
X3 vdd a_323_1340# a_3663_7850# vdd sky130_fd_pr__pfet_01v8_lvt ad=0.1595 pd=1.39 as=0.1595 ps=1.39 w=1.1 l=0.35
X4 vdd a_5993_6009# a_6063_6035# vdd sky130_fd_pr__pfet_01v8_lvt ad=0.23925 pd=1.94 as=0.23925 ps=1.94 w=1.65 l=0.35
X5 a_323_3700# vss sky130_fd_pr__cap_mim_m3_1 l=1.75 w=1.75
X6 vdd cb1 cb5 vdd sky130_fd_pr__pfet_01v8 ad=0.1122 pd=1.01 as=0.1122 ps=1.01 w=0.68 l=0.15
X7 a_2903_1370# a_323_1340# vdd vdd sky130_fd_pr__pfet_01v8_lvt ad=0.1595 pd=1.39 as=0.1595 ps=1.39 w=1.1 l=0.35
X8 vdd in a_323_6060# vdd sky130_fd_pr__pfet_01v8_lvt ad=0.203 pd=1.69 as=0.203 ps=1.69 w=1.4 l=0.35
X9 a_5993_7645# a_5214_7840# sky130_fd_pr__cap_mim_m3_1 l=4.2 w=4.2
X10 vdd a_6063_6035# cb2 vdd sky130_fd_pr__pfet_01v8 ad=0.297 pd=2.13 as=0.297 ps=2.13 w=1.8 l=0.15
X11 a_3663_3130# a_323_8420# vdd vdd sky130_fd_pr__pfet_01v8_lvt ad=0.1595 pd=1.39 as=0.1595 ps=1.39 w=1.1 l=0.35
X12 vdd a_5993_3649# a_6063_3675# vdd sky130_fd_pr__pfet_01v8_lvt ad=0.23925 pd=1.94 as=0.23925 ps=1.94 w=1.65 l=0.35
X13 a_3663_1370# a_323_1340# vdd vdd sky130_fd_pr__pfet_01v8_lvt ad=0.1595 pd=1.39 as=0.319 ps=2.78 w=1.1 l=0.35
X14 vss qn a_323_8420# vss sky130_fd_pr__nfet_01v8_lvt ad=0.217 pd=2.02 as=0.1155 ps=1.03 w=0.7 l=0.15
X15 vdd qp a_323_3700# vdd sky130_fd_pr__pfet_01v8_lvt ad=0.406 pd=3.38 as=0.203 ps=1.69 w=1.4 l=0.35
X16 a_5993_5285# a_5214_5480# sky130_fd_pr__cap_mim_m3_1 l=4.2 w=4.2
X17 a_2903_7850# a_323_8420# vdd vdd sky130_fd_pr__pfet_01v8_lvt ad=0.1595 pd=1.39 as=0.319 ps=2.78 w=1.1 l=0.35
X18 vdd a_6063_8395# cb3 vdd sky130_fd_pr__pfet_01v8 ad=0.558 pd=4.22 as=0.297 ps=2.13 w=1.8 l=0.15
X19 vdd a_323_1340# a_2903_3730# vdd sky130_fd_pr__pfet_01v8_lvt ad=0.319 pd=2.78 as=0.1595 ps=1.39 w=1.1 l=0.35
X20 vss a_5993_2925# a_6063_3075# vss sky130_fd_pr__nfet_01v8_lvt ad=0.2573 pd=2.28 as=0.13695 ps=1.16 w=0.83 l=0.15
X21 cb6 a_6063_5435# vdd vdd sky130_fd_pr__pfet_01v8 ad=0.297 pd=2.13 as=0.558 ps=4.22 w=1.8 l=0.15
X22 a_2903_8450# a_323_3700# vdd vdd sky130_fd_pr__pfet_01v8_lvt ad=0.1595 pd=1.39 as=0.1595 ps=1.39 w=1.1 l=0.35
X23 vdd a_323_8420# a_2903_5490# vdd sky130_fd_pr__pfet_01v8_lvt ad=0.319 pd=2.78 as=0.1595 ps=1.39 w=1.1 l=0.35
X24 cb2 a_6063_6035# vss vss sky130_fd_pr__nfet_01v8_lvt ad=0.198 pd=1.53 as=0.372 ps=3.02 w=1.2 l=0.15
X25 cb2 cb6 vss vss sky130_fd_pr__nfet_01v8_lvt ad=0.1305 pd=1.48 as=0.1305 ps=1.48 w=0.45 l=0.15
X26 cb4 cb0 vdd vdd sky130_fd_pr__pfet_01v8 ad=0.1122 pd=1.01 as=0.2108 ps=1.98 w=0.68 l=0.15
X27 vdd a_6063_3675# cb1 vdd sky130_fd_pr__pfet_01v8 ad=0.297 pd=2.13 as=0.297 ps=2.13 w=1.8 l=0.15
X28 vss in a_323_6060# vss sky130_fd_pr__nfet_01v8_lvt ad=0.217 pd=2.02 as=0.1155 ps=1.03 w=0.7 l=0.15
X29 cb7 a_6063_7795# vdd vdd sky130_fd_pr__pfet_01v8 ad=0.297 pd=2.13 as=0.297 ps=2.13 w=1.8 l=0.15
X30 vdd a_323_3700# a_3663_3730# vdd sky130_fd_pr__pfet_01v8_lvt ad=0.1595 pd=1.39 as=0.1595 ps=1.39 w=1.1 l=0.35
X31 a_2903_3130# a_323_6060# vss vss sky130_fd_pr__nfet_01v8_lvt ad=0.319 pd=2.78 as=0.319 ps=2.78 w=1.1 l=0.15
X32 a_6063_7795# a_5993_7645# vdd vdd sky130_fd_pr__pfet_01v8_lvt ad=0.23925 pd=1.94 as=0.23925 ps=1.94 w=1.65 l=0.35
X33 cb1 cb5 vdd vdd sky130_fd_pr__pfet_01v8 ad=0.1122 pd=1.01 as=0.2108 ps=1.98 w=0.68 l=0.15
X34 a_3663_8450# a_323_6060# vdd vdd sky130_fd_pr__pfet_01v8_lvt ad=0.1595 pd=1.39 as=0.319 ps=2.78 w=1.1 l=0.35
X35 vdd a_323_8420# a_3663_5490# vdd sky130_fd_pr__pfet_01v8_lvt ad=0.1595 pd=1.39 as=0.1595 ps=1.39 w=1.1 l=0.35
X36 cb1 cb5 vss vss sky130_fd_pr__nfet_01v8_lvt ad=0.1305 pd=1.48 as=0.1305 ps=1.48 w=0.45 l=0.15
X37 cb2 a_6063_6035# vdd vdd sky130_fd_pr__pfet_01v8 ad=0.297 pd=2.13 as=0.297 ps=2.13 w=1.8 l=0.15
X38 a_2903_3730# a_323_1340# vdd vdd sky130_fd_pr__pfet_01v8_lvt ad=0.1595 pd=1.39 as=0.319 ps=2.78 w=1.1 l=0.35
X39 a_3663_7850# a_323_1340# vdd vdd sky130_fd_pr__pfet_01v8_lvt ad=0.1595 pd=1.39 as=0.1595 ps=1.39 w=1.1 l=0.35
X40 a_2903_5490# a_323_8420# vdd vdd sky130_fd_pr__pfet_01v8_lvt ad=0.1595 pd=1.39 as=0.319 ps=2.78 w=1.1 l=0.35
X41 a_6063_6035# a_5993_6009# vdd vdd sky130_fd_pr__pfet_01v8_lvt ad=0.23925 pd=1.94 as=0.23925 ps=1.94 w=1.65 l=0.35
X42 cb0 a_6063_1315# vdd vdd sky130_fd_pr__pfet_01v8 ad=0.297 pd=2.13 as=0.558 ps=4.22 w=1.8 l=0.15
X43 vdd ip a_323_1340# vdd sky130_fd_pr__pfet_01v8_lvt ad=0.406 pd=3.38 as=0.203 ps=1.69 w=1.4 l=0.35
X44 a_323_3700# qp vss vss sky130_fd_pr__nfet_01v8_lvt ad=0.1155 pd=1.03 as=0.217 ps=2.02 w=0.7 l=0.15
X45 vdd a_323_1340# a_2903_1370# vdd sky130_fd_pr__pfet_01v8_lvt ad=0.319 pd=2.78 as=0.1595 ps=1.39 w=1.1 l=0.35
X46 cb5 a_6063_3075# vdd vdd sky130_fd_pr__pfet_01v8 ad=0.297 pd=2.13 as=0.558 ps=4.22 w=1.8 l=0.15
X47 cb1 a_6063_3675# vdd vdd sky130_fd_pr__pfet_01v8 ad=0.297 pd=2.13 as=0.297 ps=2.13 w=1.8 l=0.15
X48 a_2903_6090# a_323_3700# vdd vdd sky130_fd_pr__pfet_01v8_lvt ad=0.1595 pd=1.39 as=0.1595 ps=1.39 w=1.1 l=0.35
X49 vdd cb3 cb7 vdd sky130_fd_pr__pfet_01v8 ad=0.1122 pd=1.01 as=0.1122 ps=1.01 w=0.68 l=0.15
X50 cb1 a_6063_3675# vss vss sky130_fd_pr__nfet_01v8_lvt ad=0.198 pd=1.53 as=0.372 ps=3.02 w=1.2 l=0.15
X51 a_6063_3675# a_5993_3649# vdd vdd sky130_fd_pr__pfet_01v8_lvt ad=0.23925 pd=1.94 as=0.23925 ps=1.94 w=1.65 l=0.35
X52 vdd a_323_1340# a_3663_1370# vdd sky130_fd_pr__pfet_01v8_lvt ad=0.1595 pd=1.39 as=0.1595 ps=1.39 w=1.1 l=0.35
X53 a_323_1340# ip vss vss sky130_fd_pr__nfet_01v8_lvt ad=0.1155 pd=1.03 as=0.217 ps=2.02 w=0.7 l=0.15
X54 a_3663_6090# a_323_3700# vdd vdd sky130_fd_pr__pfet_01v8_lvt ad=0.1595 pd=1.39 as=0.319 ps=2.78 w=1.1 l=0.35
X55 cb3 cb7 vdd vdd sky130_fd_pr__pfet_01v8 ad=0.1122 pd=1.01 as=0.2108 ps=1.98 w=0.68 l=0.15
X56 vdd qn a_323_8420# vdd sky130_fd_pr__pfet_01v8_lvt ad=0.406 pd=3.38 as=0.203 ps=1.69 w=1.4 l=0.35
X57 vdd a_5993_8369# a_6063_8395# vdd sky130_fd_pr__pfet_01v8_lvt ad=0.23925 pd=1.94 as=0.23925 ps=1.94 w=1.65 l=0.35
X58 vss a_5993_7645# a_6063_7795# vss sky130_fd_pr__nfet_01v8_lvt ad=0.2573 pd=2.28 as=0.13695 ps=1.16 w=0.83 l=0.15
X59 a_3663_3730# a_323_3700# vdd vdd sky130_fd_pr__pfet_01v8_lvt ad=0.1595 pd=1.39 as=0.1595 ps=1.39 w=1.1 l=0.35
X60 vdd a_323_3700# a_2903_8450# vdd sky130_fd_pr__pfet_01v8_lvt ad=0.319 pd=2.78 as=0.1595 ps=1.39 w=1.1 l=0.35
X61 vdd a_5993_565# a_6063_715# vdd sky130_fd_pr__pfet_01v8_lvt ad=0.23925 pd=1.94 as=0.23925 ps=1.94 w=1.65 l=0.35
X62 a_2903_1370# a_323_1340# vdd vdd sky130_fd_pr__pfet_01v8_lvt ad=0.1595 pd=1.39 as=0.319 ps=2.78 w=1.1 l=0.35
X63 a_3663_5490# a_323_8420# vdd vdd sky130_fd_pr__pfet_01v8_lvt ad=0.1595 pd=1.39 as=0.1595 ps=1.39 w=1.1 l=0.35
X64 vdd a_6063_8395# cb3 vdd sky130_fd_pr__pfet_01v8 ad=0.297 pd=2.13 as=0.297 ps=2.13 w=1.8 l=0.15
X65 cb6 cb2 vdd vdd sky130_fd_pr__pfet_01v8 ad=0.1122 pd=1.01 as=0.2108 ps=1.98 w=0.68 l=0.15
X66 a_323_1340# vss sky130_fd_pr__cap_mim_m3_1 l=1.75 w=1.75
X67 a_3663_770# a_323_6060# vdd vdd sky130_fd_pr__pfet_01v8_lvt ad=0.1595 pd=1.39 as=0.1595 ps=1.39 w=1.1 l=0.35
X68 vdd a_323_6060# a_3663_8450# vdd sky130_fd_pr__pfet_01v8_lvt ad=0.1595 pd=1.39 as=0.1595 ps=1.39 w=1.1 l=0.35
X69 vdd a_323_6060# a_2903_770# vdd sky130_fd_pr__pfet_01v8_lvt ad=0.1595 pd=1.39 as=0.1595 ps=1.39 w=1.1 l=0.35
X70 vss a_5993_5285# a_6063_5435# vss sky130_fd_pr__nfet_01v8_lvt ad=0.2573 pd=2.28 as=0.13695 ps=1.16 w=0.83 l=0.15
X71 a_5993_3649# a_6063_3675# vss sky130_fd_pr__res_high_po_0p35 l=9.5
X72 a_3663_7850# a_323_1340# vss vss sky130_fd_pr__nfet_01v8_lvt ad=0.319 pd=2.78 as=0.319 ps=2.78 w=1.1 l=0.15
X73 cb7 a_6063_7795# vdd vdd sky130_fd_pr__pfet_01v8 ad=0.297 pd=2.13 as=0.558 ps=4.22 w=1.8 l=0.15
X74 cb3 a_6063_8395# vss vss sky130_fd_pr__nfet_01v8_lvt ad=0.198 pd=1.53 as=0.372 ps=3.02 w=1.2 l=0.15
X75 cb3 cb7 vss vss sky130_fd_pr__nfet_01v8_lvt ad=0.1305 pd=1.48 as=0.1305 ps=1.48 w=0.45 l=0.15
X76 cb5 cb1 vdd vdd sky130_fd_pr__pfet_01v8 ad=0.1122 pd=1.01 as=0.2108 ps=1.98 w=0.68 l=0.15
X77 a_2903_8450# a_323_3700# vdd vdd sky130_fd_pr__pfet_01v8_lvt ad=0.1595 pd=1.39 as=0.319 ps=2.78 w=1.1 l=0.35
X78 vdd in a_323_6060# vdd sky130_fd_pr__pfet_01v8_lvt ad=0.406 pd=3.38 as=0.203 ps=1.69 w=1.4 l=0.35
X79 cb2 a_6063_6035# vdd vdd sky130_fd_pr__pfet_01v8 ad=0.297 pd=2.13 as=0.558 ps=4.22 w=1.8 l=0.15
X80 a_3663_5490# a_323_8420# vss vss sky130_fd_pr__nfet_01v8_lvt ad=0.319 pd=2.78 as=0.319 ps=2.78 w=1.1 l=0.15
X81 a_323_8420# qn vss vss sky130_fd_pr__nfet_01v8_lvt ad=0.1155 pd=1.03 as=0.217 ps=2.02 w=0.7 l=0.15
X82 vdd a_323_3700# a_2903_6090# vdd sky130_fd_pr__pfet_01v8_lvt ad=0.319 pd=2.78 as=0.1595 ps=1.39 w=1.1 l=0.35
X83 a_3663_1370# a_323_1340# vdd vdd sky130_fd_pr__pfet_01v8_lvt ad=0.1595 pd=1.39 as=0.1595 ps=1.39 w=1.1 l=0.35
X84 cb3 a_6063_8395# vdd vdd sky130_fd_pr__pfet_01v8 ad=0.297 pd=2.13 as=0.297 ps=2.13 w=1.8 l=0.15
X85 a_6063_3075# a_5993_2925# vss vss sky130_fd_pr__nfet_01v8_lvt ad=0.13695 pd=1.16 as=0.2573 ps=2.28 w=0.83 l=0.15
X86 a_6063_8395# a_5993_8369# vdd vdd sky130_fd_pr__pfet_01v8_lvt ad=0.23925 pd=1.94 as=0.23925 ps=1.94 w=1.65 l=0.35
X87 vdd a_323_3700# a_3663_6090# vdd sky130_fd_pr__pfet_01v8_lvt ad=0.1595 pd=1.39 as=0.1595 ps=1.39 w=1.1 l=0.35
X88 cb1 a_6063_3675# vdd vdd sky130_fd_pr__pfet_01v8 ad=0.297 pd=2.13 as=0.558 ps=4.22 w=1.8 l=0.15
X89 a_323_6060# in vss vss sky130_fd_pr__nfet_01v8_lvt ad=0.1155 pd=1.03 as=0.217 ps=2.02 w=0.7 l=0.15
X90 vdd a_5993_5285# a_6063_5435# vdd sky130_fd_pr__pfet_01v8_lvt ad=0.4785 pd=3.88 as=0.23925 ps=1.94 w=1.65 l=0.35
X91 a_5993_6009# a_5214_5948# sky130_fd_pr__cap_mim_m3_1 l=4.2 w=4.2
X92 a_2903_770# a_5214_760# vss sky130_fd_pr__res_high_po_0p69 l=1.5
X93 a_3663_8450# a_323_6060# vdd vdd sky130_fd_pr__pfet_01v8_lvt ad=0.1595 pd=1.39 as=0.1595 ps=1.39 w=1.1 l=0.35
X94 a_2903_1370# a_5214_1228# vss sky130_fd_pr__res_high_po_0p69 l=1.5
X95 a_2903_6090# a_323_3700# vdd vdd sky130_fd_pr__pfet_01v8_lvt ad=0.1595 pd=1.39 as=0.319 ps=2.78 w=1.1 l=0.35
X96 vdd a_323_6060# a_2903_3130# vdd sky130_fd_pr__pfet_01v8_lvt ad=0.1595 pd=1.39 as=0.1595 ps=1.39 w=1.1 l=0.35
X97 a_3663_3130# a_323_8420# vss vss sky130_fd_pr__nfet_01v8_lvt ad=0.319 pd=2.78 as=0.319 ps=2.78 w=1.1 l=0.15
X98 a_2903_1370# a_323_1340# vss vss sky130_fd_pr__nfet_01v8_lvt ad=0.319 pd=2.78 as=0.319 ps=2.78 w=1.1 l=0.15
X99 a_5993_8369# a_6063_8395# vss sky130_fd_pr__res_high_po_0p35 l=9.5
X100 a_6063_5435# a_5993_5285# vdd vdd sky130_fd_pr__pfet_01v8_lvt ad=0.23925 pd=1.94 as=0.4785 ps=3.88 w=1.65 l=0.35
X101 vss a_6063_7795# cb7 vss sky130_fd_pr__nfet_01v8_lvt ad=0.372 pd=3.02 as=0.198 ps=1.53 w=1.2 l=0.15
X102 a_3663_3730# a_5214_3588# vss sky130_fd_pr__res_high_po_0p69 l=1.5
X103 a_5993_2925# a_6063_3075# vss sky130_fd_pr__res_high_po_0p35 l=9.5
X104 vdd a_5993_1289# a_6063_1315# vdd sky130_fd_pr__pfet_01v8_lvt ad=0.4785 pd=3.88 as=0.23925 ps=1.94 w=1.65 l=0.35
X105 cb7 cb3 vdd vdd sky130_fd_pr__pfet_01v8 ad=0.1122 pd=1.01 as=0.2108 ps=1.98 w=0.68 l=0.15
X106 a_2903_8450# a_5214_8308# vss sky130_fd_pr__res_high_po_0p69 l=1.5
X107 vdd a_5993_2925# a_6063_3075# vdd sky130_fd_pr__pfet_01v8_lvt ad=0.4785 pd=3.88 as=0.23925 ps=1.94 w=1.65 l=0.35
X108 a_5993_3649# a_5214_3588# sky130_fd_pr__cap_mim_m3_1 l=4.2 w=4.2
X109 vss a_6063_5435# cb6 vss sky130_fd_pr__nfet_01v8_lvt ad=0.372 pd=3.02 as=0.198 ps=1.53 w=1.2 l=0.15
X110 vdd a_5993_565# a_6063_715# vdd sky130_fd_pr__pfet_01v8_lvt ad=0.4785 pd=3.88 as=0.23925 ps=1.94 w=1.65 l=0.35
X111 vdd a_6063_5435# cb6 vdd sky130_fd_pr__pfet_01v8 ad=0.297 pd=2.13 as=0.297 ps=2.13 w=1.8 l=0.15
X112 a_5993_565# a_5214_760# sky130_fd_pr__cap_mim_m3_1 l=4.2 w=4.2
X113 a_3663_6090# a_323_3700# vdd vdd sky130_fd_pr__pfet_01v8_lvt ad=0.1595 pd=1.39 as=0.1595 ps=1.39 w=1.1 l=0.35
X114 a_2903_6090# a_5214_5948# vss sky130_fd_pr__res_high_po_0p69 l=1.5
X115 a_3663_770# a_323_6060# vss vss sky130_fd_pr__nfet_01v8_lvt ad=0.319 pd=2.78 as=0.319 ps=2.78 w=1.1 l=0.15
X116 a_6063_7795# a_5993_7645# vss vss sky130_fd_pr__nfet_01v8_lvt ad=0.13695 pd=1.16 as=0.2573 ps=2.28 w=0.83 l=0.15
X117 vdd a_323_8420# a_3663_3130# vdd sky130_fd_pr__pfet_01v8_lvt ad=0.319 pd=2.78 as=0.1595 ps=1.39 w=1.1 l=0.35
X118 vdd a_323_6060# a_2903_770# vdd sky130_fd_pr__pfet_01v8_lvt ad=0.319 pd=2.78 as=0.1595 ps=1.39 w=1.1 l=0.35
X119 vdd a_323_8420# a_2903_7850# vdd sky130_fd_pr__pfet_01v8_lvt ad=0.1595 pd=1.39 as=0.1595 ps=1.39 w=1.1 l=0.35
X120 cb3 a_6063_8395# vdd vdd sky130_fd_pr__pfet_01v8 ad=0.297 pd=2.13 as=0.558 ps=4.22 w=1.8 l=0.15
X121 a_6063_1315# a_5993_1289# vdd vdd sky130_fd_pr__pfet_01v8_lvt ad=0.23925 pd=1.94 as=0.4785 ps=3.88 w=1.65 l=0.35
X122 a_6063_5435# a_5993_5285# vss vss sky130_fd_pr__nfet_01v8_lvt ad=0.13695 pd=1.16 as=0.2573 ps=2.28 w=0.83 l=0.15
X123 a_6063_3075# a_5993_2925# vdd vdd sky130_fd_pr__pfet_01v8_lvt ad=0.23925 pd=1.94 as=0.4785 ps=3.88 w=1.65 l=0.35
X124 a_3663_1370# a_5214_1228# vss sky130_fd_pr__res_high_po_0p69 l=1.5
X125 a_323_3700# qp vdd vdd sky130_fd_pr__pfet_01v8_lvt ad=0.203 pd=1.69 as=0.406 ps=3.38 w=1.4 l=0.35
X126 a_323_8420# vss sky130_fd_pr__cap_mim_m3_1 l=1.75 w=1.75
X127 cb0 cb4 vdd vdd sky130_fd_pr__pfet_01v8 ad=0.2108 pd=1.98 as=0.1122 ps=1.01 w=0.68 l=0.15
X128 vdd a_5993_7645# a_6063_7795# vdd sky130_fd_pr__pfet_01v8_lvt ad=0.4785 pd=3.88 as=0.23925 ps=1.94 w=1.65 l=0.35
X129 vdd cb4 cb0 vdd sky130_fd_pr__pfet_01v8 ad=0.1122 pd=1.01 as=0.1122 ps=1.01 w=0.68 l=0.15
X130 vdd a_6063_1315# cb0 vdd sky130_fd_pr__pfet_01v8 ad=0.297 pd=2.13 as=0.297 ps=2.13 w=1.8 l=0.15
X131 vss a_6063_3075# cb5 vss sky130_fd_pr__nfet_01v8_lvt ad=0.372 pd=3.02 as=0.198 ps=1.53 w=1.2 l=0.15
X132 a_2903_6090# a_323_3700# vss vss sky130_fd_pr__nfet_01v8_lvt ad=0.319 pd=2.78 as=0.319 ps=2.78 w=1.1 l=0.15
X133 vdd a_6063_3075# cb5 vdd sky130_fd_pr__pfet_01v8 ad=0.297 pd=2.13 as=0.297 ps=2.13 w=1.8 l=0.15
X134 a_2903_3730# a_5214_3588# vss sky130_fd_pr__res_high_po_0p69 l=1.5
X135 cb0 cb4 vdd vdd sky130_fd_pr__pfet_01v8 ad=0.1122 pd=1.01 as=0.2108 ps=1.98 w=0.68 l=0.15
X136 vdd a_323_1340# a_2903_3730# vdd sky130_fd_pr__pfet_01v8_lvt ad=0.1595 pd=1.39 as=0.1595 ps=1.39 w=1.1 l=0.35
X137 a_3663_8450# a_5214_8308# vss sky130_fd_pr__res_high_po_0p69 l=1.5
X138 a_5993_7645# a_6063_7795# vss sky130_fd_pr__res_high_po_0p35 l=9.5
X139 a_3663_770# a_5214_760# vss sky130_fd_pr__res_high_po_0p69 l=1.5
X140 vdd a_323_1340# a_3663_7850# vdd sky130_fd_pr__pfet_01v8_lvt ad=0.319 pd=2.78 as=0.1595 ps=1.39 w=1.1 l=0.35
X141 vdd a_323_8420# a_2903_5490# vdd sky130_fd_pr__pfet_01v8_lvt ad=0.1595 pd=1.39 as=0.1595 ps=1.39 w=1.1 l=0.35
X142 vdd a_5993_6009# a_6063_6035# vdd sky130_fd_pr__pfet_01v8_lvt ad=0.4785 pd=3.88 as=0.23925 ps=1.94 w=1.65 l=0.35
X143 a_6063_7795# a_5993_7645# vdd vdd sky130_fd_pr__pfet_01v8_lvt ad=0.23925 pd=1.94 as=0.4785 ps=3.88 w=1.65 l=0.35
X144 vdd a_5993_3649# a_6063_3675# vdd sky130_fd_pr__pfet_01v8_lvt ad=0.4785 pd=3.88 as=0.23925 ps=1.94 w=1.65 l=0.35
X145 a_323_1340# ip vdd vdd sky130_fd_pr__pfet_01v8_lvt ad=0.203 pd=1.69 as=0.406 ps=3.38 w=1.4 l=0.35
X146 a_6063_1315# a_5993_1289# vss sky130_fd_pr__res_high_po_0p35 l=9.5
X147 a_2903_3730# a_323_1340# vss vss sky130_fd_pr__nfet_01v8_lvt ad=0.319 pd=2.78 as=0.319 ps=2.78 w=1.1 l=0.15
X148 a_6063_6035# a_5993_6009# vdd vdd sky130_fd_pr__pfet_01v8_lvt ad=0.23925 pd=1.94 as=0.4785 ps=3.88 w=1.65 l=0.35
X149 vdd a_6063_7795# cb7 vdd sky130_fd_pr__pfet_01v8 ad=0.297 pd=2.13 as=0.297 ps=2.13 w=1.8 l=0.15
X150 vss a_5993_1289# a_6063_1315# vss sky130_fd_pr__nfet_01v8_lvt ad=0.2573 pd=2.28 as=0.13695 ps=1.16 w=0.83 l=0.15
X151 vdd a_323_3700# a_3663_3730# vdd sky130_fd_pr__pfet_01v8_lvt ad=0.319 pd=2.78 as=0.1595 ps=1.39 w=1.1 l=0.35
X152 vdd a_323_1340# a_2903_1370# vdd sky130_fd_pr__pfet_01v8_lvt ad=0.1595 pd=1.39 as=0.1595 ps=1.39 w=1.1 l=0.35
X153 a_3663_6090# a_5214_5948# vss sky130_fd_pr__res_high_po_0p69 l=1.5
X154 cb2 cb6 vdd vdd sky130_fd_pr__pfet_01v8 ad=0.2108 pd=1.98 as=0.1122 ps=1.01 w=0.68 l=0.15
X155 cb5 cb1 vss vss sky130_fd_pr__nfet_01v8_lvt ad=0.1305 pd=1.48 as=0.1305 ps=1.48 w=0.45 l=0.15
X156 a_323_8420# qn vdd vdd sky130_fd_pr__pfet_01v8_lvt ad=0.203 pd=1.69 as=0.406 ps=3.38 w=1.4 l=0.35
X157 vdd a_323_8420# a_3663_5490# vdd sky130_fd_pr__pfet_01v8_lvt ad=0.319 pd=2.78 as=0.1595 ps=1.39 w=1.1 l=0.35
X158 a_2903_5490# a_5214_5480# vss sky130_fd_pr__res_high_po_0p69 l=1.5
X159 cb7 a_6063_7795# vss vss sky130_fd_pr__nfet_01v8_lvt ad=0.198 pd=1.53 as=0.372 ps=3.02 w=1.2 l=0.15
X160 a_2903_770# a_323_6060# vdd vdd sky130_fd_pr__pfet_01v8_lvt ad=0.1595 pd=1.39 as=0.1595 ps=1.39 w=1.1 l=0.35
X161 a_6063_3675# a_5993_3649# vdd vdd sky130_fd_pr__pfet_01v8_lvt ad=0.23925 pd=1.94 as=0.4785 ps=3.88 w=1.65 l=0.35
X162 a_3663_1370# a_323_1340# vss vss sky130_fd_pr__nfet_01v8_lvt ad=0.319 pd=2.78 as=0.319 ps=2.78 w=1.1 l=0.15
X163 vss a_5993_565# a_6063_715# vss sky130_fd_pr__nfet_01v8_lvt ad=0.2573 pd=2.28 as=0.13695 ps=1.16 w=0.83 l=0.15
X164 vdd a_6063_715# cb4 vdd sky130_fd_pr__pfet_01v8 ad=0.297 pd=2.13 as=0.297 ps=2.13 w=1.8 l=0.15
X165 a_6063_715# a_5993_565# vss sky130_fd_pr__res_high_po_0p35 l=9.5
X166 vdd a_323_6060# a_3663_770# vdd sky130_fd_pr__pfet_01v8_lvt ad=0.1595 pd=1.39 as=0.1595 ps=1.39 w=1.1 l=0.35
X167 vdd a_6063_6035# cb2 vdd sky130_fd_pr__pfet_01v8 ad=0.297 pd=2.13 as=0.297 ps=2.13 w=1.8 l=0.15
X168 vdd a_6063_715# cb4 vdd sky130_fd_pr__pfet_01v8 ad=0.558 pd=4.22 as=0.297 ps=2.13 w=1.8 l=0.15
X169 cb4 a_6063_715# vdd vdd sky130_fd_pr__pfet_01v8 ad=0.297 pd=2.13 as=0.297 ps=2.13 w=1.8 l=0.15
X170 cb4 cb0 vss vss sky130_fd_pr__nfet_01v8_lvt ad=0.1305 pd=1.48 as=0.1305 ps=1.48 w=0.45 l=0.15
X171 cb6 a_6063_5435# vss vss sky130_fd_pr__nfet_01v8_lvt ad=0.198 pd=1.53 as=0.372 ps=3.02 w=1.2 l=0.15
X172 a_6063_715# a_5993_565# vss vss sky130_fd_pr__nfet_01v8_lvt ad=0.13695 pd=1.16 as=0.2573 ps=2.28 w=0.83 l=0.15
X173 cb6 a_6063_5435# vdd vdd sky130_fd_pr__pfet_01v8 ad=0.297 pd=2.13 as=0.297 ps=2.13 w=1.8 l=0.15
X174 cb4 a_6063_715# vdd vdd sky130_fd_pr__pfet_01v8 ad=0.297 pd=2.13 as=0.297 ps=2.13 w=1.8 l=0.15
X175 a_6063_715# a_5993_565# vdd vdd sky130_fd_pr__pfet_01v8_lvt ad=0.23925 pd=1.94 as=0.4785 ps=3.88 w=1.65 l=0.35
X176 vdd a_323_3700# a_2903_8450# vdd sky130_fd_pr__pfet_01v8_lvt ad=0.1595 pd=1.39 as=0.1595 ps=1.39 w=1.1 l=0.35
X177 vdd a_6063_3675# cb1 vdd sky130_fd_pr__pfet_01v8 ad=0.297 pd=2.13 as=0.297 ps=2.13 w=1.8 l=0.15
X178 vss a_6063_715# cb4 vss sky130_fd_pr__nfet_01v8_lvt ad=0.372 pd=3.02 as=0.198 ps=1.53 w=1.2 l=0.15
X179 a_2903_8450# a_323_3700# vss vss sky130_fd_pr__nfet_01v8_lvt ad=0.319 pd=2.78 as=0.319 ps=2.78 w=1.1 l=0.15
X180 cb4 a_6063_715# vss vss sky130_fd_pr__nfet_01v8_lvt ad=0.198 pd=1.53 as=0.372 ps=3.02 w=1.2 l=0.15
X181 cb4 cb0 vdd vdd sky130_fd_pr__pfet_01v8 ad=0.2108 pd=1.98 as=0.1122 ps=1.01 w=0.68 l=0.15
X182 a_2903_770# a_323_6060# vdd vdd sky130_fd_pr__pfet_01v8_lvt ad=0.1595 pd=1.39 as=0.319 ps=2.78 w=1.1 l=0.35
X183 vdd a_323_1340# a_3663_1370# vdd sky130_fd_pr__pfet_01v8_lvt ad=0.319 pd=2.78 as=0.1595 ps=1.39 w=1.1 l=0.35
X184 a_5993_2925# a_5214_3120# sky130_fd_pr__cap_mim_m3_1 l=4.2 w=4.2
X185 cb1 cb5 vdd vdd sky130_fd_pr__pfet_01v8 ad=0.2108 pd=1.98 as=0.1122 ps=1.01 w=0.68 l=0.15
X186 vss a_5993_8369# a_6063_8395# vss sky130_fd_pr__nfet_01v8_lvt ad=0.2573 pd=2.28 as=0.13695 ps=1.16 w=0.83 l=0.15
X187 vdd a_5993_8369# a_6063_8395# vdd sky130_fd_pr__pfet_01v8_lvt ad=0.4785 pd=3.88 as=0.23925 ps=1.94 w=1.65 l=0.35
X188 a_323_6060# in vdd vdd sky130_fd_pr__pfet_01v8_lvt ad=0.203 pd=1.69 as=0.406 ps=3.38 w=1.4 l=0.35
X189 a_2903_3130# a_5214_3120# vss sky130_fd_pr__res_high_po_0p69 l=1.5
X190 a_6063_6035# a_5993_6009# vss sky130_fd_pr__res_high_po_0p35 l=9.5
X191 a_323_3700# qp vdd vdd sky130_fd_pr__pfet_01v8_lvt ad=0.203 pd=1.69 as=0.203 ps=1.69 w=1.4 l=0.35
X192 cb0 a_6063_1315# vdd vdd sky130_fd_pr__pfet_01v8 ad=0.297 pd=2.13 as=0.297 ps=2.13 w=1.8 l=0.15
X193 cb5 a_6063_3075# vss vss sky130_fd_pr__nfet_01v8_lvt ad=0.198 pd=1.53 as=0.372 ps=3.02 w=1.2 l=0.15
X194 vss a_5993_6009# a_6063_6035# vss sky130_fd_pr__nfet_01v8_lvt ad=0.2573 pd=2.28 as=0.13695 ps=1.16 w=0.83 l=0.15
X195 cb5 a_6063_3075# vdd vdd sky130_fd_pr__pfet_01v8 ad=0.297 pd=2.13 as=0.297 ps=2.13 w=1.8 l=0.15
X196 vdd a_323_6060# a_3663_8450# vdd sky130_fd_pr__pfet_01v8_lvt ad=0.319 pd=2.78 as=0.1595 ps=1.39 w=1.1 l=0.35
X197 vdd a_323_3700# a_2903_6090# vdd sky130_fd_pr__pfet_01v8_lvt ad=0.1595 pd=1.39 as=0.1595 ps=1.39 w=1.1 l=0.35
X198 vdd a_6063_5435# cb6 vdd sky130_fd_pr__pfet_01v8 ad=0.558 pd=4.22 as=0.297 ps=2.13 w=1.8 l=0.15
X199 cb7 cb3 vss vss sky130_fd_pr__nfet_01v8_lvt ad=0.1305 pd=1.48 as=0.1305 ps=1.48 w=0.45 l=0.15
X200 a_6063_8395# a_5993_8369# vdd vdd sky130_fd_pr__pfet_01v8_lvt ad=0.23925 pd=1.94 as=0.4785 ps=3.88 w=1.65 l=0.35
X201 a_6063_5435# a_5993_5285# vss sky130_fd_pr__res_high_po_0p35 l=9.5
X202 vss a_6063_1315# cb0 vss sky130_fd_pr__nfet_01v8_lvt ad=0.372 pd=3.02 as=0.198 ps=1.53 w=1.2 l=0.15
X203 a_3663_6090# a_323_3700# vss vss sky130_fd_pr__nfet_01v8_lvt ad=0.319 pd=2.78 as=0.319 ps=2.78 w=1.1 l=0.15
X204 cb3 cb7 vdd vdd sky130_fd_pr__pfet_01v8 ad=0.2108 pd=1.98 as=0.1122 ps=1.01 w=0.68 l=0.15
X205 cb6 cb2 vss vss sky130_fd_pr__nfet_01v8_lvt ad=0.1305 pd=1.48 as=0.1305 ps=1.48 w=0.45 l=0.15
X206 a_3663_770# a_323_6060# vdd vdd sky130_fd_pr__pfet_01v8_lvt ad=0.1595 pd=1.39 as=0.319 ps=2.78 w=1.1 l=0.35
X207 a_323_1340# ip vdd vdd sky130_fd_pr__pfet_01v8_lvt ad=0.203 pd=1.69 as=0.203 ps=1.69 w=1.4 l=0.35
X208 vdd a_6063_8395# cb3 vdd sky130_fd_pr__pfet_01v8 ad=0.297 pd=2.13 as=0.297 ps=2.13 w=1.8 l=0.15
X209 a_5993_8369# a_5214_8308# sky130_fd_pr__cap_mim_m3_1 l=4.2 w=4.2
X210 vdd a_6063_1315# cb0 vdd sky130_fd_pr__pfet_01v8 ad=0.558 pd=4.22 as=0.297 ps=2.13 w=1.8 l=0.15
X211 cb6 cb2 vdd vdd sky130_fd_pr__pfet_01v8 ad=0.2108 pd=1.98 as=0.1122 ps=1.01 w=0.68 l=0.15
X212 vss a_5993_3649# a_6063_3675# vss sky130_fd_pr__nfet_01v8_lvt ad=0.2573 pd=2.28 as=0.13695 ps=1.16 w=0.83 l=0.15
X213 a_2903_770# a_323_6060# vss vss sky130_fd_pr__nfet_01v8_lvt ad=0.319 pd=2.78 as=0.319 ps=2.78 w=1.1 l=0.15
X214 vdd a_323_3700# a_3663_6090# vdd sky130_fd_pr__pfet_01v8_lvt ad=0.319 pd=2.78 as=0.1595 ps=1.39 w=1.1 l=0.35
X215 cb7 a_6063_7795# vdd vdd sky130_fd_pr__pfet_01v8 ad=0.297 pd=2.13 as=0.297 ps=2.13 w=1.8 l=0.15
X216 a_6063_1315# a_5993_1289# vss vss sky130_fd_pr__nfet_01v8_lvt ad=0.13695 pd=1.16 as=0.2573 ps=2.28 w=0.83 l=0.15
X217 vdd a_6063_3075# cb5 vdd sky130_fd_pr__pfet_01v8 ad=0.558 pd=4.22 as=0.297 ps=2.13 w=1.8 l=0.15
X218 vdd a_323_6060# a_3663_770# vdd sky130_fd_pr__pfet_01v8_lvt ad=0.319 pd=2.78 as=0.1595 ps=1.39 w=1.1 l=0.35
X219 a_2903_7850# a_5214_7840# vss sky130_fd_pr__res_high_po_0p69 l=1.5
X220 vdd cb6 cb2 vdd sky130_fd_pr__pfet_01v8 ad=0.1122 pd=1.01 as=0.1122 ps=1.01 w=0.68 l=0.15
X221 a_2903_3130# a_323_6060# vdd vdd sky130_fd_pr__pfet_01v8_lvt ad=0.1595 pd=1.39 as=0.1595 ps=1.39 w=1.1 l=0.35
X222 cb5 cb1 vdd vdd sky130_fd_pr__pfet_01v8 ad=0.2108 pd=1.98 as=0.1122 ps=1.01 w=0.68 l=0.15
X223 a_3663_3730# a_323_3700# vss vss sky130_fd_pr__nfet_01v8_lvt ad=0.319 pd=2.78 as=0.319 ps=2.78 w=1.1 l=0.15
X224 a_323_8420# qn vdd vdd sky130_fd_pr__pfet_01v8_lvt ad=0.203 pd=1.69 as=0.203 ps=1.69 w=1.4 l=0.35
X225 vdd a_5993_5285# a_6063_5435# vdd sky130_fd_pr__pfet_01v8_lvt ad=0.23925 pd=1.94 as=0.23925 ps=1.94 w=1.65 l=0.35
X226 cb2 a_6063_6035# vdd vdd sky130_fd_pr__pfet_01v8 ad=0.297 pd=2.13 as=0.297 ps=2.13 w=1.8 l=0.15
X227 vdd qp a_323_3700# vdd sky130_fd_pr__pfet_01v8_lvt ad=0.203 pd=1.69 as=0.203 ps=1.69 w=1.4 l=0.35
X228 a_3663_3130# a_323_8420# vdd vdd sky130_fd_pr__pfet_01v8_lvt ad=0.1595 pd=1.39 as=0.319 ps=2.78 w=1.1 l=0.35
X229 a_6063_715# a_5993_565# vdd vdd sky130_fd_pr__pfet_01v8_lvt ad=0.23925 pd=1.94 as=0.23925 ps=1.94 w=1.65 l=0.35
X230 vdd a_6063_715# cb4 vdd sky130_fd_pr__pfet_01v8 ad=0.297 pd=2.13 as=0.297 ps=2.13 w=1.8 l=0.15
X231 a_3663_3130# a_5214_3120# vss sky130_fd_pr__res_high_po_0p69 l=1.5
X232 vdd a_6063_5435# cb6 vdd sky130_fd_pr__pfet_01v8 ad=0.297 pd=2.13 as=0.297 ps=2.13 w=1.8 l=0.15
X233 cb4 a_6063_715# vdd vdd sky130_fd_pr__pfet_01v8 ad=0.297 pd=2.13 as=0.558 ps=4.22 w=1.8 l=0.15
X234 cb1 a_6063_3675# vdd vdd sky130_fd_pr__pfet_01v8 ad=0.297 pd=2.13 as=0.297 ps=2.13 w=1.8 l=0.15
X235 vss a_6063_6035# cb2 vss sky130_fd_pr__nfet_01v8_lvt ad=0.372 pd=3.02 as=0.198 ps=1.53 w=1.2 l=0.15
X236 vdd cb0 cb4 vdd sky130_fd_pr__pfet_01v8 ad=0.1122 pd=1.01 as=0.1122 ps=1.01 w=0.68 l=0.15
X237 vdd a_6063_7795# cb7 vdd sky130_fd_pr__pfet_01v8 ad=0.558 pd=4.22 as=0.297 ps=2.13 w=1.8 l=0.15
X238 vdd cb5 cb1 vdd sky130_fd_pr__pfet_01v8 ad=0.1122 pd=1.01 as=0.1122 ps=1.01 w=0.68 l=0.15
X239 a_6063_8395# a_5993_8369# vss vss sky130_fd_pr__nfet_01v8_lvt ad=0.13695 pd=1.16 as=0.2573 ps=2.28 w=0.83 l=0.15
X240 a_2903_7850# a_323_8420# vdd vdd sky130_fd_pr__pfet_01v8_lvt ad=0.1595 pd=1.39 as=0.1595 ps=1.39 w=1.1 l=0.35
X241 a_3663_8450# a_323_6060# vss vss sky130_fd_pr__nfet_01v8_lvt ad=0.319 pd=2.78 as=0.319 ps=2.78 w=1.1 l=0.15
X242 vdd a_5993_1289# a_6063_1315# vdd sky130_fd_pr__pfet_01v8_lvt ad=0.23925 pd=1.94 as=0.23925 ps=1.94 w=1.65 l=0.35
X243 a_3663_7850# a_323_1340# vdd vdd sky130_fd_pr__pfet_01v8_lvt ad=0.1595 pd=1.39 as=0.319 ps=2.78 w=1.1 l=0.35
X244 a_323_6060# in vdd vdd sky130_fd_pr__pfet_01v8_lvt ad=0.203 pd=1.69 as=0.203 ps=1.69 w=1.4 l=0.35
X245 vdd a_6063_6035# cb2 vdd sky130_fd_pr__pfet_01v8 ad=0.558 pd=4.22 as=0.297 ps=2.13 w=1.8 l=0.15
X246 vdd a_5993_2925# a_6063_3075# vdd sky130_fd_pr__pfet_01v8_lvt ad=0.23925 pd=1.94 as=0.23925 ps=1.94 w=1.65 l=0.35
X247 vdd ip a_323_1340# vdd sky130_fd_pr__pfet_01v8_lvt ad=0.203 pd=1.69 as=0.203 ps=1.69 w=1.4 l=0.35
X248 a_6063_6035# a_5993_6009# vss vss sky130_fd_pr__nfet_01v8_lvt ad=0.13695 pd=1.16 as=0.2573 ps=2.28 w=0.83 l=0.15
X249 vdd a_323_6060# a_2903_3130# vdd sky130_fd_pr__pfet_01v8_lvt ad=0.319 pd=2.78 as=0.1595 ps=1.39 w=1.1 l=0.35
X250 vdd a_6063_1315# cb0 vdd sky130_fd_pr__pfet_01v8 ad=0.297 pd=2.13 as=0.297 ps=2.13 w=1.8 l=0.15
X251 cb6 a_6063_5435# vdd vdd sky130_fd_pr__pfet_01v8 ad=0.297 pd=2.13 as=0.297 ps=2.13 w=1.8 l=0.15
X252 vss qp a_323_3700# vss sky130_fd_pr__nfet_01v8_lvt ad=0.217 pd=2.02 as=0.1155 ps=1.03 w=0.7 l=0.15
X253 a_3663_7850# a_5214_7840# vss sky130_fd_pr__res_high_po_0p69 l=1.5
X254 a_5993_1289# a_5214_1228# sky130_fd_pr__cap_mim_m3_1 l=4.2 w=4.2
X255 vdd a_6063_3075# cb5 vdd sky130_fd_pr__pfet_01v8 ad=0.297 pd=2.13 as=0.297 ps=2.13 w=1.8 l=0.15
X256 vdd a_6063_3675# cb1 vdd sky130_fd_pr__pfet_01v8 ad=0.558 pd=4.22 as=0.297 ps=2.13 w=1.8 l=0.15
X257 a_6063_5435# a_5993_5285# vdd vdd sky130_fd_pr__pfet_01v8_lvt ad=0.23925 pd=1.94 as=0.23925 ps=1.94 w=1.65 l=0.35
X258 cb7 cb3 vdd vdd sky130_fd_pr__pfet_01v8 ad=0.2108 pd=1.98 as=0.1122 ps=1.01 w=0.68 l=0.15
X259 vss a_6063_3675# cb1 vss sky130_fd_pr__nfet_01v8_lvt ad=0.372 pd=3.02 as=0.198 ps=1.53 w=1.2 l=0.15
X260 vdd a_323_8420# a_3663_3130# vdd sky130_fd_pr__pfet_01v8_lvt ad=0.1595 pd=1.39 as=0.1595 ps=1.39 w=1.1 l=0.35
X261 a_2903_3730# a_323_1340# vdd vdd sky130_fd_pr__pfet_01v8_lvt ad=0.1595 pd=1.39 as=0.1595 ps=1.39 w=1.1 l=0.35
X262 cb0 a_6063_1315# vss vss sky130_fd_pr__nfet_01v8_lvt ad=0.198 pd=1.53 as=0.372 ps=3.02 w=1.2 l=0.15
X263 vdd qn a_323_8420# vdd sky130_fd_pr__pfet_01v8_lvt ad=0.203 pd=1.69 as=0.203 ps=1.69 w=1.4 l=0.35
X264 vdd cb7 cb3 vdd sky130_fd_pr__pfet_01v8 ad=0.1122 pd=1.01 as=0.1122 ps=1.01 w=0.68 l=0.15
X265 vss ip a_323_1340# vss sky130_fd_pr__nfet_01v8_lvt ad=0.217 pd=2.02 as=0.1155 ps=1.03 w=0.7 l=0.15
X266 a_2903_5490# a_323_8420# vdd vdd sky130_fd_pr__pfet_01v8_lvt ad=0.1595 pd=1.39 as=0.1595 ps=1.39 w=1.1 l=0.35
X267 a_3663_3730# a_323_3700# vdd vdd sky130_fd_pr__pfet_01v8_lvt ad=0.1595 pd=1.39 as=0.319 ps=2.78 w=1.1 l=0.35
X268 a_3663_5490# a_323_8420# vdd vdd sky130_fd_pr__pfet_01v8_lvt ad=0.1595 pd=1.39 as=0.319 ps=2.78 w=1.1 l=0.35
X269 a_2903_3130# a_323_6060# vdd vdd sky130_fd_pr__pfet_01v8_lvt ad=0.1595 pd=1.39 as=0.319 ps=2.78 w=1.1 l=0.35
X270 vdd a_5993_7645# a_6063_7795# vdd sky130_fd_pr__pfet_01v8_lvt ad=0.23925 pd=1.94 as=0.23925 ps=1.94 w=1.65 l=0.35
X271 a_2903_7850# a_323_8420# vss vss sky130_fd_pr__nfet_01v8_lvt ad=0.319 pd=2.78 as=0.319 ps=2.78 w=1.1 l=0.15
X272 cb3 a_6063_8395# vdd vdd sky130_fd_pr__pfet_01v8 ad=0.297 pd=2.13 as=0.297 ps=2.13 w=1.8 l=0.15
X273 cb0 a_6063_1315# vdd vdd sky130_fd_pr__pfet_01v8 ad=0.297 pd=2.13 as=0.297 ps=2.13 w=1.8 l=0.15
X274 vdd cb2 cb6 vdd sky130_fd_pr__pfet_01v8 ad=0.1122 pd=1.01 as=0.1122 ps=1.01 w=0.68 l=0.15
X275 a_6063_3675# a_5993_3649# vss vss sky130_fd_pr__nfet_01v8_lvt ad=0.13695 pd=1.16 as=0.2573 ps=2.28 w=0.83 l=0.15
X276 vdd a_323_8420# a_2903_7850# vdd sky130_fd_pr__pfet_01v8_lvt ad=0.319 pd=2.78 as=0.1595 ps=1.39 w=1.1 l=0.35
X277 cb0 cb4 vss vss sky130_fd_pr__nfet_01v8_lvt ad=0.1305 pd=1.48 as=0.1305 ps=1.48 w=0.45 l=0.15
X278 cb5 a_6063_3075# vdd vdd sky130_fd_pr__pfet_01v8 ad=0.297 pd=2.13 as=0.297 ps=2.13 w=1.8 l=0.15
X279 a_6063_1315# a_5993_1289# vdd vdd sky130_fd_pr__pfet_01v8_lvt ad=0.23925 pd=1.94 as=0.23925 ps=1.94 w=1.65 l=0.35
X280 a_3663_5490# a_5214_5480# vss sky130_fd_pr__res_high_po_0p69 l=1.5
X281 vdd a_6063_7795# cb7 vdd sky130_fd_pr__pfet_01v8 ad=0.297 pd=2.13 as=0.297 ps=2.13 w=1.8 l=0.15
X282 a_2903_5490# a_323_8420# vss vss sky130_fd_pr__nfet_01v8_lvt ad=0.319 pd=2.78 as=0.319 ps=2.78 w=1.1 l=0.15
X283 a_323_6060# vss sky130_fd_pr__cap_mim_m3_1 l=1.75 w=1.75
C0 a_323_3700# a_2903_3730# 0.10132f
C1 in qn 0
C2 a_2903_3130# a_3663_3130# 0.25738f
C3 a_323_1340# a_323_8420# 0.86015f
C4 a_5993_1289# a_6063_1315# 0.49446f
C5 ip a_323_1340# 0.32625f
C6 a_323_6060# a_3663_8450# 0.29099f
C7 a_6063_715# a_6063_5435# 0.0033f
C8 a_323_3700# a_3663_8450# 0.00289f
C9 vdd a_5993_1289# 0.70341f
C10 a_5214_1228# a_3663_3130# 0.00196f
C11 a_5993_5285# a_323_8420# 0
C12 a_323_6060# a_2903_7850# 0.00459f
C13 cb7 a_6063_7795# 0.36902f
C14 a_2903_3130# a_5993_2925# 0.00485f
C15 a_2903_5490# a_2903_6090# 0.30672f
C16 a_323_3700# a_2903_7850# 0.00339f
C17 vdd a_2903_5490# 0.9495f
C18 vdd a_2903_3730# 0.9495f
C19 a_6063_1315# a_6063_3675# 0.45674f
C20 a_5993_7645# a_6063_8395# 0.01366f
C21 a_6063_715# a_5993_2925# 0.2252f
C22 a_5993_1289# a_5214_3120# 0.01165f
C23 a_5214_1228# a_5993_2925# 0.01165f
C24 a_6063_5435# cb1 0
C25 vdd a_3663_8450# 0.37254f
C26 a_3663_1370# a_2903_1370# 0.25738f
C27 vdd a_6063_3675# 1.16009f
C28 a_323_6060# a_5993_8369# 0
C29 a_5214_3120# a_2903_3730# 0.01703f
C30 a_2903_7850# a_5214_7840# 0.16302f
C31 a_5993_565# a_3663_770# 0.00506f
C32 a_2903_5490# a_323_8420# 0.43704f
C33 a_2903_6090# a_2903_7850# 0.00156f
C34 vdd a_2903_7850# 0.9495f
C35 a_323_8420# a_2903_3730# 0.00602f
C36 a_323_6060# a_5993_565# 0
C37 a_5993_3649# a_6063_7795# 0.00139f
C38 a_6063_6035# a_5214_5948# 0.0144f
C39 cb0 a_6063_1315# 0.37254f
C40 a_5214_3588# a_5214_5480# 0.14832f
C41 a_5214_8308# a_6063_6035# 0
C42 a_6063_8395# cb7 0.00758f
C43 a_3663_3730# a_5214_5480# 0.00196f
C44 vdd cb0 1.54177f
C45 a_2903_3130# a_323_1340# 0.00317f
C46 a_5993_8369# a_5214_7840# 0.01845f
C47 a_5993_565# a_6063_1315# 0.01052f
C48 a_6063_8395# a_6063_7795# 0.24354f
C49 qp in 0
C50 vdd a_5993_8369# 0.73001f
C51 vdd cb6 1.41928f
C52 cb2 cb7 0.0023f
C53 a_2903_7850# a_323_8420# 0.33692f
C54 a_323_3700# a_5214_3588# 0.05299f
C55 a_323_6060# a_2903_1370# 0.0075f
C56 qn a_323_1340# 0
C57 a_5214_1228# a_323_1340# 0.06847f
C58 a_323_3700# a_3663_3730# 0.29099f
C59 cb2 a_6063_7795# 0.00121f
C60 vdd a_5993_565# 0.64886f
C61 a_323_3700# a_2903_1370# 0
C62 a_5993_1289# a_5214_760# 0.01895f
C63 a_6063_3075# a_5993_3649# 0.01128f
C64 cb3 a_5993_8369# 0.00552f
C65 cb5 a_5993_3649# 0
C66 a_6063_6035# a_6063_5435# 0.24543f
C67 a_5214_3588# a_6063_1315# 0
C68 a_6063_8395# a_5993_3649# 0
C69 cb5 a_6063_3075# 0.36902f
C70 vdd a_5214_3588# 0.09217f
C71 cb4 a_5993_1289# 0
C72 vdd a_3663_3730# 0.37193f
C73 a_323_3700# a_3663_6090# 0.29388f
C74 vdd a_2903_1370# 0.9495f
C75 a_6063_715# a_5993_1289# 0.03035f
C76 a_6063_6035# a_5993_6009# 0.49446f
C77 a_2903_3130# a_2903_3730# 0.30672f
C78 a_6063_7795# a_5214_5480# 0.00214f
C79 a_5214_1228# a_5993_1289# 1.96153f
C80 a_5993_7645# a_5214_7840# 1.96247f
C81 a_5214_3588# a_5214_3120# 0.34199f
C82 cb2 a_6063_8395# 0
C83 vdd a_5993_7645# 0.70393f
C84 cb4 a_6063_3675# 0.00228f
C85 a_3663_6090# a_5214_7840# 0.00196f
C86 a_3663_3730# a_323_8420# 0.00219f
C87 a_323_8420# a_2903_1370# 0.00172f
C88 a_2903_6090# a_3663_6090# 0.25738f
C89 vdd a_3663_6090# 0.37193f
C90 a_5993_3649# a_5214_5480# 0.01165f
C91 a_6063_715# a_6063_3675# 0.02144f
C92 a_5993_565# a_5214_760# 1.96265f
C93 qp a_323_1340# 0.00535f
C94 vdd cb7 1.4201f
C95 cb4 cb0 0.55416f
C96 a_323_3700# a_5993_3649# 0
C97 a_6063_7795# a_5214_7840# 0.0145f
C98 a_6063_5435# a_5214_5948# 0
C99 a_3663_6090# a_323_8420# 0.00133f
C100 vdd a_6063_7795# 1.09292f
C101 a_6063_715# cb0 0.01035f
C102 cb7 cb3 0.55416f
C103 a_6063_3675# cb1 0.37258f
C104 a_5214_8308# a_6063_5435# 0.00403f
C105 a_6063_6035# a_5993_5285# 0.01052f
C106 cb4 a_5993_565# 0.00131f
C107 a_6063_1315# a_5993_3649# 0.18591f
C108 cb3 a_6063_7795# 0.01009f
C109 a_5214_760# a_2903_1370# 0.01703f
C110 a_5214_8308# a_2903_8450# 0.16302f
C111 a_6063_715# a_5993_565# 0.52464f
C112 a_6063_3075# a_6063_1315# 0.33949f
C113 cb5 a_6063_1315# 0.00137f
C114 vdd a_5993_3649# 0.71819f
C115 a_5214_1228# a_5993_565# 0.01883f
C116 a_5993_6009# a_5214_5948# 1.96153f
C117 a_323_1340# a_2903_770# 0.00703f
C118 cb0 cb1 0
C119 a_5214_3588# a_2903_3130# 0.01703f
C120 vdd a_6063_3075# 1.09229f
C121 vdd cb5 1.41953f
C122 a_323_6060# a_3663_1370# 0.00133f
C123 cb6 cb1 0.0023f
C124 a_2903_3130# a_2903_1370# 0.00156f
C125 vdd a_6063_8395# 1.16407f
C126 a_5993_3649# a_5214_3120# 0.01845f
C127 a_5214_3588# a_6063_715# 0.00403f
C128 a_5214_1228# a_2903_1370# 0.16302f
C129 a_6063_3075# a_5214_3120# 0.0145f
C130 a_3663_3130# a_5993_2925# 0.00506f
C131 vdd cb2 1.54649f
C132 a_6063_8395# cb3 0.37258f
C133 a_3663_7850# a_5214_5948# 0.00196f
C134 a_5993_6009# a_6063_5435# 0.03035f
C135 a_5993_5285# a_3663_5490# 0.00506f
C136 cb2 cb3 0
C137 vdd a_3663_1370# 0.37193f
C138 a_5993_1289# a_2903_770# 0.00351f
C139 a_323_6060# a_3663_770# 0.29388f
C140 a_323_6060# a_323_3700# 1.03153f
C141 a_5993_5285# a_5214_5948# 0.01883f
C142 in a_323_1340# 0
C143 a_3663_1370# a_5214_3120# 0.00196f
C144 a_6063_6035# a_5993_8369# 0.18591f
C145 a_6063_6035# cb6 0.00687f
C146 a_2903_6090# a_5214_5480# 0.01703f
C147 vdd a_5214_5480# 0.09217f
C148 a_3663_1370# a_323_8420# 0
C149 a_2903_5490# a_3663_5490# 0.25738f
C150 a_3663_5490# a_2903_3730# 0
C151 a_323_1340# a_3663_3130# 0
C152 a_5214_760# a_6063_3075# 0.00214f
C153 vdd a_3663_770# 0.36814f
C154 a_323_6060# a_2903_6090# 0
C155 vdd a_323_6060# 3.92362f
C156 a_323_3700# a_2903_6090# 0.43592f
C157 a_2903_8450# a_323_1340# 0.00387f
C158 vdd a_323_3700# 4.25929f
C159 a_2903_5490# a_5214_5948# 0.01703f
C160 a_323_8420# a_5214_5480# 0.06847f
C161 a_2903_3130# a_5993_3649# 0.00351f
C162 a_5993_5285# a_6063_5435# 0.4901f
C163 vdd a_6063_1315# 1.09244f
C164 a_323_6060# a_5214_3120# 0.01548f
C165 a_6063_715# a_5993_3649# 0.01443f
C166 cb4 cb5 0.00155f
C167 a_323_6060# a_323_8420# 1.01124f
C168 vdd a_5214_7840# 0.09217f
C169 a_6063_715# a_6063_3075# 0.4572f
C170 a_323_6060# ip 0
C171 a_323_3700# a_323_8420# 0.67977f
C172 a_6063_715# cb5 0
C173 vdd a_2903_6090# 0.9495f
C174 a_5993_565# a_2903_770# 0.00485f
C175 a_5214_8308# a_3663_8450# 0.33733f
C176 a_323_3700# ip 0.00544f
C177 a_5214_1228# a_6063_3075# 0
C178 a_6063_6035# a_5993_7645# 0.20832f
C179 a_6063_1315# a_5214_3120# 0
C180 a_5993_6009# a_5993_5285# 0.14441f
C181 vdd cb3 1.54669f
C182 a_5214_8308# a_2903_7850# 0.01703f
C183 a_5993_3649# cb1 0.00552f
C184 vdd a_5214_3120# 0.09217f
C185 a_5993_1289# a_5993_2925# 0.11296f
C186 a_323_8420# a_5214_7840# 0.01548f
C187 a_2903_3130# a_3663_1370# 0
C188 a_3663_7850# a_323_1340# 0.29099f
C189 a_2903_6090# a_323_8420# 0.00805f
C190 vdd a_323_8420# 4.08666f
C191 a_6063_3075# cb1 0.01009f
C192 cb5 cb1 0.55416f
C193 a_2903_1370# a_2903_770# 0.30672f
C194 a_6063_5435# a_6063_3675# 0.01066f
C195 vdd ip 0.58015f
C196 a_5214_8308# a_5993_8369# 1.95675f
C197 a_6063_6035# cb7 0.00137f
C198 a_5993_2925# a_2903_3730# 0.00351f
C199 a_5214_760# a_3663_770# 0.33733f
C200 a_2903_8450# a_3663_8450# 0.25738f
C201 a_5214_1228# a_3663_1370# 0.33733f
C202 a_323_6060# a_5214_760# 0.06847f
C203 a_2903_5490# a_5993_6009# 0.00351f
C204 a_5214_3588# a_3663_5490# 0.00196f
C205 a_6063_6035# a_6063_7795# 0.33949f
C206 a_323_8420# a_5214_3120# 0.05299f
C207 a_3663_3730# a_3663_5490# 0.00947f
C208 cb2 cb1 0
C209 a_2903_8450# a_2903_7850# 0.30672f
C210 a_5993_2925# a_6063_3675# 0.01366f
C211 ip a_323_8420# 0
C212 a_5993_6009# a_6063_3675# 0
C213 a_5993_8369# a_6063_5435# 0.01443f
C214 cb6 a_6063_5435# 0.36851f
C215 a_323_6060# a_2903_3130# 0.33533f
C216 a_323_3700# a_2903_3130# 0.00489f
C217 a_5993_1289# a_323_1340# 0
C218 vdd a_5214_760# 0.08415f
C219 a_2903_8450# a_5993_8369# 0.00485f
C220 a_323_6060# qn 0.0015f
C221 a_5993_7645# a_5214_5948# 0.01165f
C222 a_323_3700# qn 0.00439f
C223 a_2903_5490# a_323_1340# 0
C224 cb4 a_6063_1315# 0.00687f
C225 a_323_1340# a_2903_3730# 0.3346f
C226 a_6063_6035# a_6063_8395# 0.45674f
C227 a_5214_8308# a_5993_7645# 0.01906f
C228 a_6063_715# a_6063_1315# 0.24543f
C229 cb6 a_5993_6009# 0
C230 a_3663_6090# a_5214_5948# 0.33733f
C231 a_5993_565# a_5993_2925# 0
C232 cb4 vdd 1.39842f
C233 vdd a_2903_3130# 0.9495f
C234 a_5214_1228# a_6063_1315# 0.0144f
C235 a_323_1340# a_3663_8450# 0.00133f
C236 a_2903_5490# a_5993_5285# 0.00485f
C237 a_6063_6035# cb2 0.37254f
C238 a_3663_3130# a_2903_1370# 0
C239 a_3663_7850# a_2903_7850# 0.25738f
C240 vdd a_6063_715# 1.30551f
C241 vdd a_5214_1228# 0.09217f
C242 vdd qn 0.58099f
C243 a_2903_7850# a_323_1340# 0.10102f
C244 a_2903_3130# a_5214_3120# 0.16302f
C245 a_5993_7645# a_6063_5435# 0.2252f
C246 a_5993_5285# a_6063_3675# 0.00121f
C247 a_5214_3588# a_5993_2925# 0.01906f
C248 a_6063_1315# cb1 0
C249 a_2903_3130# a_323_8420# 0.10241f
C250 a_5214_5948# a_6063_7795# 0
C251 a_6063_715# a_5214_3120# 0.00111f
C252 a_5993_7645# a_2903_8450# 0.00351f
C253 a_5214_1228# a_5214_3120# 0.14832f
C254 a_2903_5490# a_2903_3730# 0.00156f
C255 vdd cb1 1.54623f
C256 qn a_323_8420# 0.3194f
C257 a_5993_1289# a_6063_3675# 0.20445f
C258 a_5993_7645# a_5993_6009# 0.11296f
C259 cb7 a_6063_5435# 0
C260 cb6 a_5993_5285# 0.00131f
C261 qp a_323_6060# 0.00528f
C262 qp a_323_3700# 0.32109f
C263 a_6063_5435# a_6063_7795# 0.4572f
C264 a_5993_6009# a_3663_6090# 0.00506f
C265 a_5993_1289# cb0 0.00372f
C266 a_5214_3588# a_323_1340# 0.01548f
C267 a_3663_3730# a_323_1340# 0.00289f
C268 a_323_1340# a_2903_1370# 0.43562f
C269 a_5214_8308# a_6063_8395# 0.0144f
C270 a_6063_715# a_5214_760# 0.01766f
C271 a_5993_7645# a_3663_7850# 0.00506f
C272 a_6063_5435# a_5993_3649# 0.0023f
C273 a_5214_1228# a_5214_760# 0.34199f
C274 a_5993_1289# a_5993_565# 0.14441f
C275 a_6063_6035# a_5214_7840# 0
C276 vdd qp 0.58015f
C277 a_5214_3588# a_5993_5285# 0.01165f
C278 vdd a_6063_6035# 1.09262f
C279 a_5993_7645# a_323_1340# 0
C280 a_5993_6009# a_6063_7795# 0.22642f
C281 a_2903_770# a_3663_770# 0.25738f
C282 a_3663_7850# a_3663_6090# 0.00947f
C283 cb0 a_6063_3675# 0
C284 a_323_6060# a_2903_770# 0.43636f
C285 a_3663_5490# a_5214_5480# 0.33733f
C286 a_5993_8369# a_3663_8450# 0.00506f
C287 a_323_3700# a_2903_770# 0
C288 a_6063_6035# cb3 0
C289 a_323_1340# a_3663_6090# 0
C290 cb6 a_6063_3675# 0
C291 a_6063_8395# a_6063_5435# 0.02144f
C292 cb4 a_6063_715# 0.36851f
C293 a_5993_7645# a_5993_5285# 0
C294 a_5993_2925# a_5993_3649# 0.1452f
C295 a_2903_7850# a_5993_8369# 0.00351f
C296 qp a_323_8420# 0
C297 a_5993_565# a_6063_3675# 0
C298 a_5993_1289# a_2903_1370# 0.00485f
C299 a_5993_6009# a_5993_3649# 0
C300 a_6063_3075# a_5993_2925# 0.47936f
C301 a_323_6060# a_3663_5490# 0
C302 qp ip 0
C303 cb2 a_6063_5435# 0.01035f
C304 a_6063_715# a_5214_1228# 0
C305 a_5214_5948# a_5214_5480# 0.34199f
C306 cb5 a_5993_2925# 0.00253f
C307 a_323_3700# a_3663_5490# 0.00219f
C308 a_5214_3588# a_2903_3730# 0.16302f
C309 a_2903_5490# a_3663_3730# 0
C310 a_3663_3730# a_2903_3730# 0.25738f
C311 vdd a_2903_770# 0.93315f
C312 a_3663_1370# a_3663_3130# 0.00947f
C313 a_5993_6009# a_6063_8395# 0.20445f
C314 a_5214_3588# a_6063_3675# 0.0144f
C315 a_323_3700# a_5214_5948# 0.06847f
C316 a_5214_8308# a_323_6060# 0.05299f
C317 cb2 a_5993_6009# 0.00372f
C318 a_5214_8308# a_323_3700# 0.01548f
C319 vdd a_3663_5490# 0.37193f
C320 a_5993_5285# a_6063_7795# 0.18149f
C321 a_6063_5435# a_5214_5480# 0.01483f
C322 a_323_8420# a_2903_770# 0.00106f
C323 a_323_6060# in 0.31953f
C324 a_323_3700# in 0.00584f
C325 a_5214_5948# a_5214_7840# 0.14832f
C326 a_5993_7645# a_2903_7850# 0.00485f
C327 a_2903_6090# a_5214_5948# 0.16302f
C328 vdd a_5214_5948# 0.09217f
C329 a_323_6060# a_3663_3130# 0.00289f
C330 a_5214_8308# a_5214_7840# 0.34199f
C331 a_5993_5285# a_5993_3649# 0.10952f
C332 a_323_3700# a_3663_3130# 0.00135f
C333 a_323_8420# a_3663_5490# 0.29388f
C334 vdd a_5214_8308# 0.09329f
C335 a_323_6060# a_2903_8450# 0.10185f
C336 a_2903_7850# a_3663_6090# 0
C337 a_5993_6009# a_5214_5480# 0.01895f
C338 a_323_3700# a_2903_8450# 0.3348f
C339 a_5993_565# a_2903_1370# 0.00351f
C340 vdd in 0.58015f
C341 a_6063_1315# a_6063_5435# 0
C342 a_5993_7645# a_5993_8369# 0.1452f
C343 a_6063_8395# a_5993_5285# 0
C344 a_6063_7795# a_6063_3675# 0
C345 a_6063_5435# a_5214_7840# 0.00111f
C346 a_3663_1370# a_323_1340# 0.29388f
C347 a_5214_760# a_2903_770# 0.16302f
C348 vdd a_6063_5435# 1.55996f
C349 vdd a_3663_3130# 0.37193f
C350 a_323_3700# a_5993_6009# 0
C351 a_5993_1289# a_6063_3075# 0.22642f
C352 a_5993_3649# a_2903_3730# 0.00485f
C353 a_5214_3588# a_3663_3730# 0.33733f
C354 a_2903_8450# a_5214_7840# 0.01703f
C355 a_6063_1315# a_5993_2925# 0.20832f
C356 vdd a_2903_8450# 0.95022f
C357 in a_323_8420# 0.00515f
C358 a_3663_3130# a_5214_3120# 0.33733f
C359 cb7 a_5993_8369# 0
C360 a_5993_3649# a_6063_3675# 0.53796f
C361 cb6 cb7 0.00155f
C362 vdd a_5993_2925# 0.70393f
C363 a_3663_3130# a_323_8420# 0.29099f
C364 a_5993_6009# a_5214_7840# 0.01165f
C365 a_5993_6009# a_2903_6090# 0.00485f
C366 a_5993_8369# a_6063_7795# 0.01128f
C367 vdd a_5993_6009# 0.70393f
C368 a_6063_3075# a_6063_3675# 0.24354f
C369 a_323_6060# a_3663_7850# 0.00133f
C370 cb5 a_6063_3675# 0.00758f
C371 a_323_1340# a_3663_770# 0.00135f
C372 a_323_3700# a_3663_7850# 0
C373 a_5993_1289# a_3663_1370# 0.00506f
C374 a_5214_1228# a_2903_770# 0.01703f
C375 a_2903_8450# a_323_8420# 0.0036f
C376 a_323_6060# a_323_1340# 0.75112f
C377 a_5993_5285# a_5214_5480# 1.96265f
C378 a_6063_8395# a_6063_3675# 0.00345f
C379 a_5993_2925# a_5214_3120# 1.96247f
C380 a_323_3700# a_323_1340# 0.87896f
C381 a_323_8420# a_5993_2925# 0
C382 cb0 a_6063_3075# 0.00121f
C383 a_3663_7850# a_5214_7840# 0.33733f
C384 cb0 cb5 0.0023f
C385 a_2903_6090# a_3663_7850# 0
C386 vdd a_3663_7850# 0.37193f
C387 cb6 cb5 0.00155f
C388 a_323_1340# a_5214_7840# 0.05299f
C389 a_2903_6090# a_323_1340# 0
C390 vdd a_323_1340# 4.25758f
C391 a_2903_5490# a_5214_5480# 0.16302f
C392 a_6063_8395# a_5993_8369# 0.53796f
C393 cb6 a_6063_8395# 0.00228f
C394 a_5993_565# a_6063_3075# 0.18149f
C395 a_5993_7645# cb7 0.00253f
C396 a_5993_7645# a_6063_7795# 0.47936f
C397 cb6 cb2 0.55416f
C398 a_5214_3588# a_5993_3649# 1.95675f
C399 a_2903_5490# a_323_6060# 0.0016f
C400 a_2903_6090# a_5993_5285# 0.00351f
C401 vdd a_5993_5285# 0.72088f
C402 a_3663_7850# a_323_8420# 0.00291f
C403 a_323_6060# a_2903_3730# 0.0032f
C404 a_2903_5490# a_323_3700# 0.00683f
C405 a_3663_3730# a_5993_3649# 0.00506f
C406 cb4 vss 1.70084f
C407 cb0 vss 1.41854f
C408 ip vss 0.82855f
C409 cb5 vss 1.6853f
C410 cb1 vss 1.40708f
C411 qp vss 0.82798f
C412 cb6 vss 1.67831f
C413 cb2 vss 1.4153f
C414 in vss 0.82798f
C415 cb7 vss 1.68933f
C416 cb3 vss 1.41237f
C417 qn vss 0.82693f
C418 vdd vss 69.5596f
C419 a_6063_715# vss 2.28023f
C420 a_5993_565# vss 1.61787f
C421 a_5214_760# vss 1.97104f
C422 a_5214_1228# vss 1.75457f
C423 a_3663_770# vss 0.79261f
C424 a_2903_770# vss 0.67f
C425 a_6063_1315# vss 1.93569f
C426 a_5993_1289# vss 1.43367f
C427 a_3663_1370# vss 0.76249f
C428 a_2903_1370# vss 0.65591f
C429 a_6063_3075# vss 1.93187f
C430 a_5993_2925# vss 1.3617f
C431 a_5214_3120# vss 1.75306f
C432 a_5214_3588# vss 1.75658f
C433 a_3663_3130# vss 0.76249f
C434 a_2903_3130# vss 0.65572f
C435 a_5993_3649# vss 1.6268f
C436 a_3663_3730# vss 0.76249f
C437 a_2903_3730# vss 0.65591f
C438 a_6063_3675# vss 2.7043f
C439 a_6063_5435# vss 2.20999f
C440 a_5993_5285# vss 1.37239f
C441 a_5214_5480# vss 1.74644f
C442 a_5214_5948# vss 1.75457f
C443 a_3663_5490# vss 0.76249f
C444 a_2903_5490# vss 0.65572f
C445 a_6063_6035# vss 1.93512f
C446 a_5993_6009# vss 1.43098f
C447 a_3663_6090# vss 0.76249f
C448 a_2903_6090# vss 0.65591f
C449 a_6063_7795# vss 1.928f
C450 a_5993_7645# vss 1.3617f
C451 a_5214_7840# vss 1.75306f
C452 a_5214_8308# vss 1.90414f
C453 a_3663_7850# vss 0.76249f
C454 a_2903_7850# vss 0.65577f
C455 a_323_1340# vss 10.4325f
C456 a_5993_8369# vss 1.85805f
C457 a_3663_8450# vss 0.79128f
C458 a_2903_8450# vss 0.6614f
C459 a_323_8420# vss 10.2896f
C460 a_6063_8395# vss 2.72631f
C461 a_323_6060# vss 10.4088f
C462 a_323_3700# vss 10.3919f
.ends
