* NGSPICE file created from serdes_rx_pi_4ph_5g_pdk.ext - technology: sky130A

.subckt serdes_rx_pi_4ph_5g_pdk ip qp in qn a0 a1 a2 a3 a4 a5 a6 a7 b0 b1 b2 b3 b4
+ b5 b6 b7 f0 f1 f2 f3 f4 f5 f6 f7 rst_n dp dn ep en ckd0 ckd1 ckd2 ckd3 cke0 cke1
+ cke2 cke3 vdd vss
X0 a_2903_6910# a_323_4520# vdd vdd sky130_fd_pr__pfet_01v8_lvt ad=0.1595 pd=1.39 as=0.319 ps=2.78 w=1.1 l=0.35
X1 a_22775_8270# f4 a_14091_9376# vdd sky130_fd_pr__pfet_01v8_lvt ad=0.261 pd=2.38 as=0.261 ps=2.38 w=0.9 l=0.35
X2 vdd a_12367_7364# a_14091_6504# vdd sky130_fd_pr__pfet_01v8 ad=0.682 pd=5.02 as=0.363 ps=2.53 w=2.2 l=0.15
X3 a_3663_2190# a_323_2160# vdd vdd sky130_fd_pr__pfet_01v8_lvt ad=0.1595 pd=1.39 as=0.319 ps=2.78 w=1.1 l=0.35
X4 a_29262_11162# rst_n vdd vdd sky130_fd_pr__pfet_01v8 ad=0.522 pd=4.18 as=0.522 ps=4.18 w=1.8 l=0.18
X5 a_5993_4469# a_5214_4408# sky130_fd_pr__cap_mim_m3_1 l=4.2 w=4.2
X6 ckd1 a_9827_11933# vdd vdd sky130_fd_pr__pfet_01v8 ad=0.4158 pd=2.85 as=0.7812 ps=5.66 w=2.52 l=0.15
X7 a_23191_10050# f5 a_14091_9376# vss sky130_fd_pr__nfet_01v8_lvt ad=0.145 pd=1.58 as=0.145 ps=1.58 w=0.5 l=0.15
X8 vdd a_5993_4469# a_6063_4495# vdd sky130_fd_pr__pfet_01v8_lvt ad=0.23925 pd=1.94 as=0.23925 ps=1.94 w=1.65 l=0.35
X9 vss a_25471_3750# vss vss sky130_fd_pr__nfet_01v8_lvt ad=0.1595 pd=1.68 as=68.5236 ps=630.62 w=0.55 l=0.15
X10 vdd a_25471_3430# vdd vdd sky130_fd_pr__pfet_01v8 ad=0.667 pd=5.18 as=224.26759 ps=1.7335k w=2.3 l=0.15
X11 vdd qp a_323_4520# vdd sky130_fd_pr__pfet_01v8_lvt ad=0.406 pd=3.38 as=0.203 ps=1.69 w=1.4 l=0.35
X12 vss a_20911_1650# vss vss sky130_fd_pr__nfet_01v8_lvt ad=0.1595 pd=1.68 as=0 ps=0 w=0.55 l=0.15
X13 a_11519_11933# a_16702_11162# vss vss sky130_fd_pr__nfet_01v8_lvt ad=0.2805 pd=2.03 as=0.527 ps=4.02 w=1.7 l=0.15
X14 a_6063_9215# a_5993_9189# vdd vdd sky130_fd_pr__pfet_01v8_lvt ad=0.23925 pd=1.94 as=0.23925 ps=1.94 w=1.65 l=0.35
X15 a_24731_7210# a_29784_6336# vss sky130_fd_pr__res_high_po_0p69 l=6.4
X16 vdd a_23191_1650# vdd vdd sky130_fd_pr__pfet_01v8 ad=0.667 pd=5.18 as=0 ps=0 w=2.3 l=0.15
X17 a_2903_8670# a_323_9240# vdd vdd sky130_fd_pr__pfet_01v8_lvt ad=0.1595 pd=1.39 as=0.319 ps=2.78 w=1.1 l=0.35
X18 vdd a_10422_11162# a_10451_12720# vdd sky130_fd_pr__pfet_01v8 ad=1.1067 pd=7.76 as=0.58905 ps=3.9 w=3.57 l=0.15
X19 a_14067_11933# a_6858_11170# dn vdd sky130_fd_pr__pfet_01v8_lvt ad=0.32915 pd=2.56 as=0.6583 ps=5.12 w=2.27 l=0.35
X20 a_10422_11162# a_9221_11939# a_11519_11933# vss sky130_fd_pr__nfet_01v8_lvt ad=0.434 pd=3.42 as=0.231 ps=1.73 w=1.4 l=0.15
X21 a_16199_11933# a_9221_11939# a_10451_12720# vdd sky130_fd_pr__pfet_01v8 ad=0.7037 pd=5.16 as=0.37455 ps=2.6 w=2.27 l=0.15
X22 a_18631_5530# a_18173_1814# a_17251_4856# vss sky130_fd_pr__nfet_01v8_lvt ad=0.145 pd=1.58 as=0.145 ps=1.58 w=0.5 l=0.15
X23 dn a_6858_11170# a_14067_11933# vdd sky130_fd_pr__pfet_01v8_lvt ad=0.32915 pd=2.56 as=0.32915 ps=2.56 w=2.27 l=0.35
X24 vdd a_323_2160# a_2903_4550# vdd sky130_fd_pr__pfet_01v8_lvt ad=0.319 pd=2.78 as=0.1595 ps=1.39 w=1.1 l=0.35
X25 vss a_5993_3745# a_6063_3895# vss sky130_fd_pr__nfet_01v8_lvt ad=0.2573 pd=2.28 as=0.13695 ps=1.16 w=0.83 l=0.15
X26 a_8035_3880# b3 a_15527_4276# vss sky130_fd_pr__nfet_01v8_lvt ad=0.248 pd=2.22 as=0.132 ps=1.13 w=0.8 l=0.15
X27 vss a_11519_11933# ckd3 vss sky130_fd_pr__nfet_01v8_lvt ad=0.372 pd=3.02 as=0.198 ps=1.53 w=1.2 l=0.15
X28 vdd a_16199_11933# a_9827_11933# vdd sky130_fd_pr__pfet_01v8 ad=1.1067 pd=7.76 as=0.58905 ps=3.9 w=3.57 l=0.15
X29 a_8035_1520# a_13181_1968# a_12367_8796# vdd sky130_fd_pr__pfet_01v8_lvt ad=0.609 pd=4.78 as=0.3045 ps=2.39 w=2.1 l=0.35
X30 a_15527_8796# b1 a_8035_4480# vss sky130_fd_pr__nfet_01v8_lvt ad=0.132 pd=1.13 as=0.248 ps=2.22 w=0.8 l=0.15
X31 vdd a_25471_8270# vdd vdd sky130_fd_pr__pfet_01v8 ad=0.667 pd=5.18 as=0 ps=0 w=2.3 l=0.15
X32 a_8035_6240# a_6063_6255# vdd vdd sky130_fd_pr__pfet_01v8 ad=0.297 pd=2.13 as=0.558 ps=4.22 w=1.8 l=0.15
X33 a_21269_11950# a_26135_12811# vss vss sky130_fd_pr__nfet_01v8_lvt ad=0.1305 pd=1.48 as=0.1305 ps=1.48 w=0.45 l=0.15
X34 a_22451_8265# a_20495_8270# vss vss sky130_fd_pr__nfet_01v8_lvt ad=0.1595 pd=1.68 as=0.1595 ps=1.68 w=0.55 l=0.15
X35 vdd a_20911_6170# vdd vdd sky130_fd_pr__pfet_01v8 ad=0.667 pd=5.18 as=0 ps=0 w=2.3 l=0.15
X36 a_20347_11933# a_6858_11170# vss vss sky130_fd_pr__nfet_01v8 ad=0.232 pd=2.18 as=0.232 ps=2.18 w=0.8 l=0.18
X37 a_25055_8270# f6 a_14091_9376# vdd sky130_fd_pr__pfet_01v8_lvt ad=0.261 pd=2.38 as=0.261 ps=2.38 w=0.9 l=0.35
X38 a_8035_6840# a_6063_6855# vdd vdd sky130_fd_pr__pfet_01v8 ad=0.297 pd=2.13 as=0.297 ps=2.13 w=1.8 l=0.15
X39 a_24771_12720# a_22982_11162# vdd vdd sky130_fd_pr__pfet_01v8 ad=0.6293 pd=4.68 as=0.33495 ps=2.36 w=2.03 l=0.15
X40 a_23191_6170# f5 a_14091_6504# vss sky130_fd_pr__nfet_01v8_lvt ad=0.145 pd=1.58 as=0.145 ps=1.58 w=0.5 l=0.15
X41 a_9889_11686# a_9221_11939# vdd vdd sky130_fd_pr__pfet_01v8 ad=0.5481 pd=4.36 as=0.5481 ps=4.36 w=1.89 l=0.15
X42 a_27011_6165# a_25055_6170# vss vss sky130_fd_pr__nfet_01v8_lvt ad=0.1595 pd=1.68 as=0.1595 ps=1.68 w=0.55 l=0.15
X43 vdd a_6063_4495# a_8035_4480# vdd sky130_fd_pr__pfet_01v8 ad=0.297 pd=2.13 as=0.297 ps=2.13 w=1.8 l=0.15
X44 vdd a_18631_3750# vdd vdd sky130_fd_pr__pfet_01v8 ad=0.667 pd=5.18 as=0 ps=0 w=2.3 l=0.15
X45 a_27011_9310# a_25055_10050# vdd vdd sky130_fd_pr__pfet_01v8 ad=0.667 pd=5.18 as=0.667 ps=5.18 w=2.3 l=0.15
X46 a_3663_1590# a_323_6880# vdd vdd sky130_fd_pr__pfet_01v8_lvt ad=0.1595 pd=1.39 as=0.1595 ps=1.39 w=1.1 l=0.35
X47 a_20453_3298# f2 vss vss sky130_fd_pr__nfet_01v8 ad=0.1305 pd=1.48 as=0.1305 ps=1.48 w=0.45 l=0.18
X48 a_8035_1520# a_8035_2120# vdd vdd sky130_fd_pr__pfet_01v8 ad=0.1122 pd=1.01 as=0.2108 ps=1.98 w=0.68 l=0.15
X49 a_25471_5530# a_25013_1814# a_14091_4856# vdd sky130_fd_pr__pfet_01v8_lvt ad=0.261 pd=2.38 as=0.261 ps=2.38 w=0.9 l=0.35
X50 vdd a_26135_12811# a_22449_11686# vdd sky130_fd_pr__pfet_01v8 ad=0.6851 pd=5.04 as=0.36465 ps=2.54 w=2.21 l=0.15
X51 a_2903_9270# a_323_4520# vdd vdd sky130_fd_pr__pfet_01v8_lvt ad=0.1595 pd=1.39 as=0.1595 ps=1.39 w=1.1 l=0.35
X52 a_8035_6840# a_6063_6855# vss vss sky130_fd_pr__nfet_01v8_lvt ad=0.198 pd=1.53 as=0.372 ps=3.02 w=1.2 l=0.15
X53 vss a_29021_12720# cke1 vss sky130_fd_pr__nfet_01v8_lvt ad=0.372 pd=3.02 as=0.198 ps=1.53 w=1.2 l=0.15
X54 a_29784_1816# vss sky130_fd_pr__cap_mim_m3_1 l=2.8 w=2.8
X55 a_18215_1650# a_18173_1814# a_14091_1984# vss sky130_fd_pr__nfet_01v8_lvt ad=0.145 pd=1.58 as=0.145 ps=1.58 w=0.5 l=0.15
X56 a_18215_3750# f0 a_14091_4856# vdd sky130_fd_pr__pfet_01v8_lvt ad=0.261 pd=2.38 as=0.261 ps=2.38 w=0.9 l=0.35
X57 vss in a_323_6880# vss sky130_fd_pr__nfet_01v8_lvt ad=0.217 pd=2.02 as=0.1155 ps=1.03 w=0.7 l=0.15
X58 a_6063_6855# a_5993_6829# vdd vdd sky130_fd_pr__pfet_01v8_lvt ad=0.23925 pd=1.94 as=0.23925 ps=1.94 w=1.65 l=0.35
X59 a_20911_3430# a_20453_3298# a_14091_1984# vdd sky130_fd_pr__pfet_01v8_lvt ad=0.261 pd=2.38 as=0.261 ps=2.38 w=0.9 l=0.35
X60 vss a_18631_10050# vss vss sky130_fd_pr__nfet_01v8_lvt ad=0.1595 pd=1.68 as=0 ps=0 w=0.55 l=0.15
X61 vdd a_12367_8796# a_14091_9376# vdd sky130_fd_pr__pfet_01v8 ad=0.682 pd=5.02 as=0.363 ps=2.53 w=2.2 l=0.15
X62 vdd a_323_4520# a_3663_4550# vdd sky130_fd_pr__pfet_01v8_lvt ad=0.1595 pd=1.39 as=0.1595 ps=1.39 w=1.1 l=0.35
X63 a_8701_12720# a_21781_11939# a_22982_11162# vss sky130_fd_pr__nfet_01v8_lvt ad=0.231 pd=1.73 as=0.434 ps=3.42 w=1.4 l=0.15
X64 a_24731_1645# a_29784_1816# vss sky130_fd_pr__res_high_po_0p69 l=6.4
X65 a_11519_11933# a_9827_11933# vdd vdd sky130_fd_pr__pfet_01v8 ad=0.5104 pd=4.1 as=0.5104 ps=4.1 w=1.76 l=0.15
X66 a_25471_6170# a_25013_1814# a_14091_6504# vdd sky130_fd_pr__pfet_01v8_lvt ad=0.261 pd=2.38 as=0.261 ps=2.38 w=0.9 l=0.35
X67 a_15527_2844# a_16341_1968# a_8035_9200# vdd sky130_fd_pr__pfet_01v8_lvt ad=0.3045 pd=2.39 as=0.609 ps=4.78 w=2.1 l=0.35
X68 ckd0 ckd2 vdd vdd sky130_fd_pr__pfet_01v8 ad=0.5481 pd=4.36 as=0.5481 ps=4.36 w=1.89 l=0.15
X69 a_18631_8270# f0 a_14091_9376# vss sky130_fd_pr__nfet_01v8_lvt ad=0.145 pd=1.58 as=0.145 ps=1.58 w=0.5 l=0.15
X70 a_22775_6170# a_22733_1814# a_14091_6504# vss sky130_fd_pr__nfet_01v8_lvt ad=0.145 pd=1.58 as=0.145 ps=1.58 w=0.5 l=0.15
X71 a_29262_11162# a_28759_11933# vdd vdd sky130_fd_pr__pfet_01v8 ad=0.1218 pd=1.42 as=0.1218 ps=1.42 w=0.42 l=0.28
X72 a_8035_3880# a_6063_3895# vdd vdd sky130_fd_pr__pfet_01v8 ad=0.297 pd=2.13 as=0.558 ps=4.22 w=1.8 l=0.15
X73 a_3663_9270# a_323_6880# vdd vdd sky130_fd_pr__pfet_01v8_lvt ad=0.1595 pd=1.39 as=0.319 ps=2.78 w=1.1 l=0.35
X74 a_22982_11162# a_22479_11933# vss vss sky130_fd_pr__nfet_01v8 ad=0.1218 pd=1.42 as=0.1218 ps=1.42 w=0.42 l=0.28
X75 a_23191_5530# f5 a_14091_4856# vss sky130_fd_pr__nfet_01v8_lvt ad=0.145 pd=1.58 as=0.145 ps=1.58 w=0.5 l=0.15
X76 a_3663_3950# a_323_9240# vss vss sky130_fd_pr__nfet_01v8_lvt ad=0.319 pd=2.78 as=0.319 ps=2.78 w=1.1 l=0.15
X77 a_20495_1650# f3 a_17251_1984# vss sky130_fd_pr__nfet_01v8_lvt ad=0.145 pd=1.58 as=0.145 ps=1.58 w=0.5 l=0.15
X78 a_18631_1650# a_18173_1814# a_14091_1984# vdd sky130_fd_pr__pfet_01v8_lvt ad=0.261 pd=2.38 as=0.261 ps=2.38 w=0.9 l=0.35
X79 a_30771_12720# a_29021_12720# vdd vdd sky130_fd_pr__pfet_01v8 ad=0.5104 pd=4.1 as=0.5104 ps=4.1 w=1.76 l=0.15
X80 a_20495_3430# f2 a_14091_1984# vdd sky130_fd_pr__pfet_01v8_lvt ad=0.261 pd=2.38 as=0.261 ps=2.38 w=0.9 l=0.35
X81 a_20495_3750# a_20453_3298# a_17251_4856# vdd sky130_fd_pr__pfet_01v8_lvt ad=0.261 pd=2.38 as=0.261 ps=2.38 w=0.9 l=0.35
X82 a_21781_11939# a_22449_11686# vss vss sky130_fd_pr__nfet_01v8_lvt ad=0.1305 pd=1.48 as=0.1305 ps=1.48 w=0.45 l=0.15
X83 a_8035_6240# a_12741_1968# a_12367_7364# vdd sky130_fd_pr__pfet_01v8_lvt ad=0.609 pd=4.78 as=0.3045 ps=2.39 w=2.1 l=0.35
X84 a_30722_6944# a_30722_8944# vdd vdd sky130_fd_pr__pfet_01v8_lvt ad=0.23925 pd=1.94 as=0.4785 ps=3.88 w=1.65 l=0.35
X85 a_27011_4790# a_25055_5530# vss vss sky130_fd_pr__nfet_01v8_lvt ad=0.1595 pd=1.68 as=0.1595 ps=1.68 w=0.55 l=0.15
X86 vdd a_11519_11933# ckd3 vdd sky130_fd_pr__pfet_01v8 ad=0.7812 pd=5.66 as=0.4158 ps=2.85 w=2.52 l=0.15
X87 a_8035_4480# b5 a_15527_7364# vss sky130_fd_pr__nfet_01v8_lvt ad=0.248 pd=2.22 as=0.132 ps=1.13 w=0.8 l=0.15
X88 a_20911_1650# a_20453_1814# a_17251_1984# vss sky130_fd_pr__nfet_01v8_lvt ad=0.145 pd=1.58 as=0.145 ps=1.58 w=0.5 l=0.15
X89 a_8035_4480# a_8035_3880# vss vss sky130_fd_pr__nfet_01v8_lvt ad=0.1305 pd=1.48 as=0.1305 ps=1.48 w=0.45 l=0.15
X90 a_20911_3750# f2 a_17251_4856# vdd sky130_fd_pr__pfet_01v8_lvt ad=0.261 pd=2.38 as=0.261 ps=2.38 w=0.9 l=0.35
X91 cke0 a_23021_12720# vss vss sky130_fd_pr__nfet_01v8_lvt ad=0.198 pd=1.53 as=0.372 ps=3.02 w=1.2 l=0.15
X92 ckd0 a_8701_12720# vdd vdd sky130_fd_pr__pfet_01v8 ad=0.4158 pd=2.85 as=0.7812 ps=5.66 w=2.52 l=0.15
X93 a_23021_12720# a_22479_11933# vdd vdd sky130_fd_pr__pfet_01v8 ad=0.6293 pd=4.68 as=0.33495 ps=2.36 w=2.03 l=0.15
X94 vss a_23191_8270# vss vss sky130_fd_pr__nfet_01v8_lvt ad=0.1595 pd=1.68 as=0 ps=0 w=0.55 l=0.15
X95 a_15527_4276# b5 a_8035_8600# vss sky130_fd_pr__nfet_01v8_lvt ad=0.132 pd=1.13 as=0.248 ps=2.22 w=0.8 l=0.15
X96 a_9221_11939# a_9889_11686# vss vss sky130_fd_pr__nfet_01v8_lvt ad=0.1305 pd=1.48 as=0.1305 ps=1.48 w=0.45 l=0.15
X97 cke3 cke1 vdd vdd sky130_fd_pr__pfet_01v8 ad=0.5481 pd=4.36 as=0.5481 ps=4.36 w=1.89 l=0.15
X98 a_25013_1814# f7 vdd vdd sky130_fd_pr__pfet_01v8 ad=0.261 pd=2.38 as=0.261 ps=2.38 w=0.9 l=0.18
X99 a_3663_6910# a_323_4520# vdd vdd sky130_fd_pr__pfet_01v8_lvt ad=0.1595 pd=1.39 as=0.1595 ps=1.39 w=1.1 l=0.35
X100 a_25055_6170# a_25013_1814# a_14091_6504# vss sky130_fd_pr__nfet_01v8_lvt ad=0.145 pd=1.58 as=0.145 ps=1.58 w=0.5 l=0.15
X101 a_323_9240# vss sky130_fd_pr__cap_mim_m3_1 l=1.75 w=1.75
X102 a_22775_5530# a_22733_1814# a_14091_4856# vss sky130_fd_pr__nfet_01v8_lvt ad=0.145 pd=1.58 as=0.145 ps=1.58 w=0.5 l=0.15
X103 a_2903_4550# a_323_2160# vdd vdd sky130_fd_pr__pfet_01v8_lvt ad=0.1595 pd=1.39 as=0.319 ps=2.78 w=1.1 l=0.35
X104 a_7787_11933# a_6858_11170# dp vdd sky130_fd_pr__pfet_01v8_lvt ad=0.32915 pd=2.56 as=0.6583 ps=5.12 w=2.27 l=0.35
X105 a_12367_8796# a4 a_8035_1520# vss sky130_fd_pr__nfet_01v8_lvt ad=0.132 pd=1.13 as=0.248 ps=2.22 w=0.8 l=0.15
X106 vdd a_8701_12720# ckd0 vdd sky130_fd_pr__pfet_01v8 ad=0.4158 pd=2.85 as=0.4158 ps=2.85 w=2.52 l=0.15
X107 a_3663_8670# a_323_2160# vdd vdd sky130_fd_pr__pfet_01v8_lvt ad=0.1595 pd=1.39 as=0.1595 ps=1.39 w=1.1 l=0.35
X108 vdd ip a_323_2160# vdd sky130_fd_pr__pfet_01v8_lvt ad=0.406 pd=3.38 as=0.203 ps=1.69 w=1.4 l=0.35
X109 a_8035_2120# a_6063_2135# vdd vdd sky130_fd_pr__pfet_01v8 ad=0.297 pd=2.13 as=0.558 ps=4.22 w=1.8 l=0.15
X110 a_8035_8600# a_8035_9200# vdd vdd sky130_fd_pr__pfet_01v8 ad=0.1122 pd=1.01 as=0.2108 ps=1.98 w=0.68 l=0.15
X111 a_17251_9376# a_15527_8796# vss vss sky130_fd_pr__nfet_01v8_lvt ad=0.165 pd=1.33 as=0.31 ps=2.62 w=1 l=0.15
X112 a_23191_1650# a_22733_1814# a_17251_1984# vss sky130_fd_pr__nfet_01v8_lvt ad=0.145 pd=1.58 as=0.145 ps=1.58 w=0.5 l=0.15
X113 a_24731_6165# a_22775_6170# vss vss sky130_fd_pr__nfet_01v8_lvt ad=0.1595 pd=1.68 as=0.1595 ps=1.68 w=0.55 l=0.15
X114 a_12367_2844# a0 a_8035_6240# vss sky130_fd_pr__nfet_01v8_lvt ad=0.132 pd=1.13 as=0.248 ps=2.22 w=0.8 l=0.15
X115 a_23191_3750# f4 a_17251_4856# vdd sky130_fd_pr__pfet_01v8_lvt ad=0.261 pd=2.38 as=0.261 ps=2.38 w=0.9 l=0.35
X116 cke2 a_24771_12720# vdd vdd sky130_fd_pr__pfet_01v8 ad=0.4158 pd=2.85 as=0.4158 ps=2.85 w=2.52 l=0.15
X117 a_16702_11162# a_9889_11686# a_8701_12720# vss sky130_fd_pr__nfet_01v8_lvt ad=0.434 pd=3.42 as=0.231 ps=1.73 w=1.4 l=0.15
X118 a_24731_9310# a_22775_10050# vdd vdd sky130_fd_pr__pfet_01v8 ad=0.667 pd=5.18 as=0.667 ps=5.18 w=2.3 l=0.15
X119 a_323_6880# vss sky130_fd_pr__cap_mim_m3_1 l=1.75 w=1.75
X120 vdd a_10451_12720# ckd2 vdd sky130_fd_pr__pfet_01v8 ad=0.7812 pd=5.66 as=0.4158 ps=2.85 w=2.52 l=0.15
X121 a_30888_8944# a_30888_6944# vdd vdd sky130_fd_pr__pfet_01v8_lvt ad=0.23925 pd=1.94 as=0.4785 ps=3.88 w=1.65 l=0.35
X122 a_323_4520# qp vss vss sky130_fd_pr__nfet_01v8_lvt ad=0.1155 pd=1.03 as=0.217 ps=2.02 w=0.7 l=0.15
X123 a_23191_10050# a_22733_1814# a_14091_9376# vdd sky130_fd_pr__pfet_01v8_lvt ad=0.261 pd=2.38 as=0.261 ps=2.38 w=0.9 l=0.35
X124 vdd a_323_2160# a_2903_2190# vdd sky130_fd_pr__pfet_01v8_lvt ad=0.319 pd=2.78 as=0.1595 ps=1.39 w=1.1 l=0.35
X125 a_15527_4276# a_15348_205# a_8035_9200# vdd sky130_fd_pr__pfet_01v8_lvt ad=0.3045 pd=2.39 as=0.609 ps=4.78 w=2.1 l=0.35
X126 vss a_5993_1385# a_6063_1535# vss sky130_fd_pr__nfet_01v8_lvt ad=0.2573 pd=2.28 as=0.13695 ps=1.16 w=0.83 l=0.15
X127 vss a_18631_1650# vss vss sky130_fd_pr__nfet_01v8_lvt ad=0.1595 pd=1.68 as=0 ps=0 w=0.55 l=0.15
X128 vdd a_11855_12811# a_9889_11686# vdd sky130_fd_pr__pfet_01v8 ad=0.36465 pd=2.54 as=0.36465 ps=2.54 w=2.21 l=0.15
X129 a_22449_11686# a_26135_12811# vss vss sky130_fd_pr__nfet_01v8_lvt ad=0.17325 pd=1.38 as=0.3255 ps=2.72 w=1.05 l=0.15
X130 a_18631_7950# a_18173_3298# a_17251_6504# vss sky130_fd_pr__nfet_01v8_lvt ad=0.145 pd=1.58 as=0.145 ps=1.58 w=0.5 l=0.15
X131 a_20171_7210# a_18215_7950# vdd vdd sky130_fd_pr__pfet_01v8 ad=0.667 pd=5.18 as=0.667 ps=5.18 w=2.3 l=0.15
X132 a_8035_2120# a_13621_1968# a_12367_4276# vdd sky130_fd_pr__pfet_01v8_lvt ad=0.609 pd=4.78 as=0.3045 ps=2.39 w=2.1 l=0.35
X133 a_8035_9200# b1 a_15527_4276# vss sky130_fd_pr__nfet_01v8_lvt ad=0.248 pd=2.22 as=0.132 ps=1.13 w=0.8 l=0.15
X134 a_8035_6840# a_12741_1968# a_12367_8796# vdd sky130_fd_pr__pfet_01v8_lvt ad=0.609 pd=4.78 as=0.3045 ps=2.39 w=2.1 l=0.35
X135 a_8035_4480# a_6063_4495# vdd vdd sky130_fd_pr__pfet_01v8 ad=0.297 pd=2.13 as=0.297 ps=2.13 w=1.8 l=0.15
X136 a_17251_1984# a_15527_2844# vdd vdd sky130_fd_pr__pfet_01v8 ad=0.363 pd=2.53 as=0.682 ps=5.02 w=2.2 l=0.15
X137 a_18215_3750# f0 a_17251_4856# vss sky130_fd_pr__nfet_01v8_lvt ad=0.145 pd=1.58 as=0.145 ps=1.58 w=0.5 l=0.15
X138 a_25055_5530# a_25013_1814# a_14091_4856# vss sky130_fd_pr__nfet_01v8_lvt ad=0.145 pd=1.58 as=0.145 ps=1.58 w=0.5 l=0.15
X139 a_18215_5530# f1 a_14091_4856# vdd sky130_fd_pr__pfet_01v8_lvt ad=0.261 pd=2.38 as=0.261 ps=2.38 w=0.9 l=0.35
X140 vdd a_18631_6170# vdd vdd sky130_fd_pr__pfet_01v8 ad=0.667 pd=5.18 as=0 ps=0 w=2.3 l=0.15
X141 a_8035_2120# a0 a_12367_8796# vss sky130_fd_pr__nfet_01v8_lvt ad=0.248 pd=2.22 as=0.132 ps=1.13 w=0.8 l=0.15
X142 a_15527_7364# b3 a_8035_8600# vss sky130_fd_pr__nfet_01v8_lvt ad=0.132 pd=1.13 as=0.248 ps=2.22 w=0.8 l=0.15
X143 a_8035_4480# a_6063_4495# vss vss sky130_fd_pr__nfet_01v8_lvt ad=0.198 pd=1.53 as=0.372 ps=3.02 w=1.2 l=0.15
X144 a_15527_2844# b7 a_8035_3880# vss sky130_fd_pr__nfet_01v8_lvt ad=0.132 pd=1.13 as=0.248 ps=2.22 w=0.8 l=0.15
X145 vss a_16702_11162# a_11519_11933# vss sky130_fd_pr__nfet_01v8_lvt ad=0.527 pd=4.02 as=0.2805 ps=2.03 w=1.7 l=0.15
X146 a_22775_8270# f4 a_17251_9376# vss sky130_fd_pr__nfet_01v8_lvt ad=0.145 pd=1.58 as=0.145 ps=1.58 w=0.5 l=0.15
X147 a_8035_6240# a_8035_6840# vdd vdd sky130_fd_pr__pfet_01v8 ad=0.1122 pd=1.01 as=0.2108 ps=1.98 w=0.68 l=0.15
X148 a_6063_4495# a_5993_4469# vdd vdd sky130_fd_pr__pfet_01v8_lvt ad=0.23925 pd=1.94 as=0.23925 ps=1.94 w=1.65 l=0.35
X149 a_25013_1814# f7 vss vss sky130_fd_pr__nfet_01v8 ad=0.1305 pd=1.48 as=0.1305 ps=1.48 w=0.45 l=0.18
X150 cke1 cke3 vdd vdd sky130_fd_pr__pfet_01v8 ad=0.5481 pd=4.36 as=0.5481 ps=4.36 w=1.89 l=0.15
X151 a_22479_11933# a_6858_11170# vss vss sky130_fd_pr__nfet_01v8 ad=0.29 pd=2.58 as=0.29 ps=2.58 w=1 l=0.18
X152 a_22775_10050# f5 a_14091_9376# vdd sky130_fd_pr__pfet_01v8_lvt ad=0.261 pd=2.38 as=0.261 ps=2.38 w=0.9 l=0.35
X153 a_12367_7364# a_12218_205# a_8035_1520# vdd sky130_fd_pr__pfet_01v8_lvt ad=0.3045 pd=2.39 as=0.609 ps=4.78 w=2.1 l=0.35
X154 a_12367_7364# a_13181_1968# a_8035_2120# vdd sky130_fd_pr__pfet_01v8_lvt ad=0.3045 pd=2.39 as=0.609 ps=4.78 w=2.1 l=0.35
X155 a_18215_6170# f1 a_14091_6504# vdd sky130_fd_pr__pfet_01v8_lvt ad=0.261 pd=2.38 as=0.261 ps=2.38 w=0.9 l=0.35
X156 vdd a_323_2160# a_3663_2190# vdd sky130_fd_pr__pfet_01v8_lvt ad=0.1595 pd=1.39 as=0.1595 ps=1.39 w=1.1 l=0.35
X157 a_24731_4790# a_22775_5530# vss vss sky130_fd_pr__nfet_01v8_lvt ad=0.1595 pd=1.68 as=0.1595 ps=1.68 w=0.55 l=0.15
X158 a_8701_12720# a_9919_11933# vdd vdd sky130_fd_pr__pfet_01v8 ad=0.58905 pd=3.9 as=1.1067 ps=7.76 w=3.57 l=0.15
X159 a_323_2160# ip vss vss sky130_fd_pr__nfet_01v8_lvt ad=0.1155 pd=1.03 as=0.217 ps=2.02 w=0.7 l=0.15
X160 a_22775_1650# a_22733_1814# a_17251_1984# vdd sky130_fd_pr__pfet_01v8_lvt ad=0.261 pd=2.38 as=0.261 ps=2.38 w=0.9 l=0.35
X161 a_18631_3430# a_18173_3298# a_14091_1984# vdd sky130_fd_pr__pfet_01v8_lvt ad=0.261 pd=2.38 as=0.261 ps=2.38 w=0.9 l=0.35
X162 a_25471_3430# f6 a_14091_1984# vss sky130_fd_pr__nfet_01v8_lvt ad=0.145 pd=1.58 as=0.145 ps=1.58 w=0.5 l=0.15
X163 a_20171_2690# a_18215_3430# vss vss sky130_fd_pr__nfet_01v8_lvt ad=0.1595 pd=1.68 as=0.1595 ps=1.68 w=0.55 l=0.15
X164 a_21269_11950# a_20347_11933# vdd vdd sky130_fd_pr__pfet_01v8 ad=0.3465 pd=2.43 as=0.651 ps=4.82 w=2.1 l=0.15
X165 vdd a_5993_1385# a_6063_1535# vdd sky130_fd_pr__pfet_01v8_lvt ad=0.4785 pd=3.88 as=0.23925 ps=1.94 w=1.65 l=0.35
X166 a_20495_5530# a_20453_1814# a_17251_4856# vdd sky130_fd_pr__pfet_01v8_lvt ad=0.261 pd=2.38 as=0.261 ps=2.38 w=0.9 l=0.35
X167 a_8035_3880# a_15901_1968# a_15527_4276# vdd sky130_fd_pr__pfet_01v8_lvt ad=0.609 pd=4.78 as=0.3045 ps=2.39 w=2.1 l=0.35
X168 a_27011_2690# a_29784_1816# vss sky130_fd_pr__res_high_po_0p69 l=6.4
X169 a_8035_8600# b7 a_15527_8796# vss sky130_fd_pr__nfet_01v8_lvt ad=0.248 pd=2.22 as=0.132 ps=1.13 w=0.8 l=0.15
X170 a_3663_1590# a_323_6880# vss vss sky130_fd_pr__nfet_01v8_lvt ad=0.319 pd=2.78 as=0.319 ps=2.78 w=1.1 l=0.15
X171 a_20911_5530# f3 a_17251_4856# vdd sky130_fd_pr__pfet_01v8_lvt ad=0.261 pd=2.38 as=0.261 ps=2.38 w=0.9 l=0.35
X172 a_14067_11933# rst_n vdd vdd sky130_fd_pr__pfet_01v8 ad=0.464 pd=3.78 as=0.464 ps=3.78 w=1.6 l=0.18
X173 a_21781_11939# a_21269_11950# vss vss sky130_fd_pr__nfet_01v8_lvt ad=0.17325 pd=1.38 as=0.3255 ps=2.72 w=1.05 l=0.15
X174 a_29262_11162# a_28759_11933# vss vss sky130_fd_pr__nfet_01v8 ad=0.1218 pd=1.42 as=0.1218 ps=1.42 w=0.42 l=0.28
X175 vdd a_15527_7364# a_17251_6504# vdd sky130_fd_pr__pfet_01v8 ad=0.363 pd=2.53 as=0.363 ps=2.53 w=2.2 l=0.15
X176 vss a_25471_6170# vss vss sky130_fd_pr__nfet_01v8_lvt ad=0.1595 pd=1.68 as=0 ps=0 w=0.55 l=0.15
X177 a_9827_11933# a_21781_11939# a_29262_11162# vdd sky130_fd_pr__pfet_01v8 ad=0.37455 pd=2.6 as=0.7037 ps=5.16 w=2.27 l=0.15
X178 vdd a_25471_10050# vdd vdd sky130_fd_pr__pfet_01v8 ad=0.667 pd=5.18 as=0 ps=0 w=2.3 l=0.15
X179 a_23191_7950# f4 a_14091_6504# vss sky130_fd_pr__nfet_01v8_lvt ad=0.145 pd=1.58 as=0.145 ps=1.58 w=0.5 l=0.15
X180 a_20495_6170# a_20453_1814# a_17251_6504# vdd sky130_fd_pr__pfet_01v8_lvt ad=0.261 pd=2.38 as=0.261 ps=2.38 w=0.9 l=0.35
X181 a_27011_7210# a_25055_7950# vss vss sky130_fd_pr__nfet_01v8_lvt ad=0.1595 pd=1.68 as=0.1595 ps=1.68 w=0.55 l=0.15
X182 a_25055_8270# f6 a_17251_9376# vss sky130_fd_pr__nfet_01v8_lvt ad=0.145 pd=1.58 as=0.145 ps=1.58 w=0.5 l=0.15
X183 vdd a_20911_7950# vdd vdd sky130_fd_pr__pfet_01v8 ad=0.667 pd=5.18 as=0 ps=0 w=2.3 l=0.15
X184 a_15678_205# b2 vdd vdd sky130_fd_pr__pfet_01v8 ad=0.261 pd=2.38 as=0.261 ps=2.38 w=0.9 l=0.18
X185 vdd qn a_323_9240# vdd sky130_fd_pr__pfet_01v8_lvt ad=0.406 pd=3.38 as=0.203 ps=1.69 w=1.4 l=0.35
X186 a_8035_9200# a_6063_9215# vdd vdd sky130_fd_pr__pfet_01v8 ad=0.297 pd=2.13 as=0.558 ps=4.22 w=1.8 l=0.15
X187 a_25055_10050# f7 a_14091_9376# vdd sky130_fd_pr__pfet_01v8_lvt ad=0.261 pd=2.38 as=0.261 ps=2.38 w=0.9 l=0.35
X188 a_20911_6170# f3 a_17251_6504# vdd sky130_fd_pr__pfet_01v8_lvt ad=0.261 pd=2.38 as=0.261 ps=2.38 w=0.9 l=0.35
X189 a_22982_11162# a_21781_11939# a_8701_12720# vss sky130_fd_pr__nfet_01v8_lvt ad=0.434 pd=3.42 as=0.231 ps=1.73 w=1.4 l=0.15
X190 a_25471_8270# a_25013_3298# a_17251_9376# vss sky130_fd_pr__nfet_01v8_lvt ad=0.145 pd=1.58 as=0.145 ps=1.58 w=0.5 l=0.15
X191 a_20171_9310# a_29784_8208# vss sky130_fd_pr__res_high_po_0p69 l=6.4
X192 dp a_30888_8944# vss vss sky130_fd_pr__nfet_01v8_lvt ad=0.2145 pd=1.63 as=0.403 ps=3.22 w=1.3 l=0.15
X193 a_3663_4550# a_323_4520# vdd vdd sky130_fd_pr__pfet_01v8_lvt ad=0.1595 pd=1.39 as=0.1595 ps=1.39 w=1.1 l=0.35
X194 a_30722_4424# a_30722_2424# vss sky130_fd_pr__res_high_po_0p35 l=8
X195 a_25055_1650# a_25013_1814# a_17251_1984# vdd sky130_fd_pr__pfet_01v8_lvt ad=0.261 pd=2.38 as=0.261 ps=2.38 w=0.9 l=0.35
X196 vdd a_323_4520# a_2903_9270# vdd sky130_fd_pr__pfet_01v8_lvt ad=0.319 pd=2.78 as=0.1595 ps=1.39 w=1.1 l=0.35
X197 vss a_5993_8465# a_6063_8615# vss sky130_fd_pr__nfet_01v8_lvt ad=0.2573 pd=2.28 as=0.13695 ps=1.16 w=0.83 l=0.15
X198 a_2903_2190# a_323_2160# vdd vdd sky130_fd_pr__pfet_01v8_lvt ad=0.1595 pd=1.39 as=0.319 ps=2.78 w=1.1 l=0.35
X199 a_16341_1968# b5 vdd vdd sky130_fd_pr__pfet_01v8 ad=0.261 pd=2.38 as=0.261 ps=2.38 w=0.9 l=0.18
X200 a_25471_1650# f7 a_17251_1984# vdd sky130_fd_pr__pfet_01v8_lvt ad=0.261 pd=2.38 as=0.261 ps=2.38 w=0.9 l=0.35
X201 a_8035_9200# a_16341_1968# a_15527_2844# vdd sky130_fd_pr__pfet_01v8_lvt ad=0.609 pd=4.78 as=0.3045 ps=2.39 w=2.1 l=0.35
X202 a_11519_11933# a_9889_11686# a_10422_11162# vdd sky130_fd_pr__pfet_01v8 ad=0.37455 pd=2.6 as=0.7037 ps=5.16 w=2.27 l=0.15
X203 a_12367_8796# a_12218_205# a_8035_2120# vdd sky130_fd_pr__pfet_01v8_lvt ad=0.3045 pd=2.39 as=0.609 ps=4.78 w=2.1 l=0.35
X204 a_22775_7950# a_22733_3298# a_14091_6504# vss sky130_fd_pr__nfet_01v8_lvt ad=0.145 pd=1.58 as=0.145 ps=1.58 w=0.5 l=0.15
X205 a_23191_5530# f5 a_17251_4856# vdd sky130_fd_pr__pfet_01v8_lvt ad=0.261 pd=2.38 as=0.261 ps=2.38 w=0.9 l=0.35
X206 a_12367_8796# a_13181_1968# a_8035_1520# vdd sky130_fd_pr__pfet_01v8_lvt ad=0.3045 pd=2.39 as=0.609 ps=4.78 w=2.1 l=0.35
X207 a_8035_6240# a4 a_12367_4276# vss sky130_fd_pr__nfet_01v8_lvt ad=0.248 pd=2.22 as=0.132 ps=1.13 w=0.8 l=0.15
X208 a_12367_8796# a2 a_8035_6840# vss sky130_fd_pr__nfet_01v8_lvt ad=0.132 pd=1.13 as=0.248 ps=2.22 w=0.8 l=0.15
X209 a_14091_6504# a_12367_7364# vss vss sky130_fd_pr__nfet_01v8_lvt ad=0.165 pd=1.33 as=0.31 ps=2.62 w=1 l=0.15
X210 a_25471_7950# a_25013_3298# a_14091_6504# vdd sky130_fd_pr__pfet_01v8_lvt ad=0.261 pd=2.38 as=0.261 ps=2.38 w=0.9 l=0.35
X211 vss a_25471_5530# vss vss sky130_fd_pr__nfet_01v8_lvt ad=0.1595 pd=1.68 as=0 ps=0 w=0.55 l=0.15
X212 vss a_20911_3430# vss vss sky130_fd_pr__nfet_01v8_lvt ad=0.1595 pd=1.68 as=0 ps=0 w=0.55 l=0.15
X213 vss a_15527_4276# a_17251_4856# vss sky130_fd_pr__nfet_01v8_lvt ad=0.31 pd=2.62 as=0.165 ps=1.33 w=1 l=0.15
X214 vss a_23021_12720# cke0 vss sky130_fd_pr__nfet_01v8_lvt ad=0.372 pd=3.02 as=0.198 ps=1.53 w=1.2 l=0.15
X215 vdd in a_323_6880# vdd sky130_fd_pr__pfet_01v8_lvt ad=0.406 pd=3.38 as=0.203 ps=1.69 w=1.4 l=0.35
X216 a_8035_6840# a_6063_6855# vdd vdd sky130_fd_pr__pfet_01v8 ad=0.297 pd=2.13 as=0.558 ps=4.22 w=1.8 l=0.15
X217 a_23191_6170# f5 a_17251_6504# vdd sky130_fd_pr__pfet_01v8_lvt ad=0.261 pd=2.38 as=0.261 ps=2.38 w=0.9 l=0.35
X218 ckd2 ckd0 vss vss sky130_fd_pr__nfet_01v8_lvt ad=0.1305 pd=1.48 as=0.1305 ps=1.48 w=0.45 l=0.15
X219 a_25471_10050# f7 a_14091_9376# vss sky130_fd_pr__nfet_01v8_lvt ad=0.145 pd=1.58 as=0.145 ps=1.58 w=0.5 l=0.15
X220 a_11855_12811# a_8709_11950# vss vss sky130_fd_pr__nfet_01v8_lvt ad=0.1305 pd=1.48 as=0.1305 ps=1.48 w=0.45 l=0.15
X221 vdd a_323_6880# a_3663_9270# vdd sky130_fd_pr__pfet_01v8_lvt ad=0.1595 pd=1.39 as=0.1595 ps=1.39 w=1.1 l=0.35
X222 vdd a_15527_8796# a_17251_9376# vdd sky130_fd_pr__pfet_01v8 ad=0.363 pd=2.53 as=0.363 ps=2.53 w=2.2 l=0.15
X223 a_14091_6504# a_12367_7364# vdd vdd sky130_fd_pr__pfet_01v8 ad=0.363 pd=2.53 as=0.682 ps=5.02 w=2.2 l=0.15
X224 vdd a_30722_8944# a_30722_6944# vdd sky130_fd_pr__pfet_01v8_lvt ad=0.23925 pd=1.94 as=0.23925 ps=1.94 w=1.65 l=0.35
X225 a_8709_11950# a_11855_12811# vdd vdd sky130_fd_pr__pfet_01v8 ad=0.5481 pd=4.36 as=0.5481 ps=4.36 w=1.89 l=0.15
X226 a_323_9240# qn vss vss sky130_fd_pr__nfet_01v8_lvt ad=0.1155 pd=1.03 as=0.217 ps=2.02 w=0.7 l=0.15
X227 vss a_5993_6105# a_6063_6255# vss sky130_fd_pr__nfet_01v8_lvt ad=0.2573 pd=2.28 as=0.13695 ps=1.16 w=0.83 l=0.15
X228 vdd a_5993_8465# a_6063_8615# vdd sky130_fd_pr__pfet_01v8_lvt ad=0.4785 pd=3.88 as=0.23925 ps=1.94 w=1.65 l=0.35
X229 a_5993_4469# a_6063_4495# vss sky130_fd_pr__res_high_po_0p35 l=9.5
X230 a_18215_8270# a_18173_3298# a_17251_9376# vdd sky130_fd_pr__pfet_01v8_lvt ad=0.261 pd=2.38 as=0.261 ps=2.38 w=0.9 l=0.35
X231 a_25055_7950# a_25013_3298# a_14091_6504# vss sky130_fd_pr__nfet_01v8_lvt ad=0.145 pd=1.58 as=0.145 ps=1.58 w=0.5 l=0.15
X232 a_6063_1535# a_5993_1385# vdd vdd sky130_fd_pr__pfet_01v8_lvt ad=0.23925 pd=1.94 as=0.4785 ps=3.88 w=1.65 l=0.35
X233 vss a_6063_3895# a_8035_3880# vss sky130_fd_pr__nfet_01v8_lvt ad=0.372 pd=3.02 as=0.198 ps=1.53 w=1.2 l=0.15
X234 a_15678_205# b2 vss vss sky130_fd_pr__nfet_01v8 ad=0.1305 pd=1.48 as=0.1305 ps=1.48 w=0.45 l=0.18
X235 vdd a_12367_2844# a_14091_1984# vdd sky130_fd_pr__pfet_01v8 ad=0.363 pd=2.53 as=0.363 ps=2.53 w=2.2 l=0.15
X236 a_3663_8670# a_323_2160# vss vss sky130_fd_pr__nfet_01v8_lvt ad=0.319 pd=2.78 as=0.319 ps=2.78 w=1.1 l=0.15
X237 vdd a_30888_2424# a_30888_4424# vdd sky130_fd_pr__pfet_01v8_lvt ad=0.4785 pd=3.88 as=0.23925 ps=1.94 w=1.65 l=0.35
X238 a_12367_2844# a_13621_1968# a_8035_1520# vdd sky130_fd_pr__pfet_01v8_lvt ad=0.3045 pd=2.39 as=0.609 ps=4.78 w=2.1 l=0.35
X239 cke2 a_24771_12720# vss vss sky130_fd_pr__nfet_01v8_lvt ad=0.198 pd=1.53 as=0.372 ps=3.02 w=1.2 l=0.15
X240 ckd0 a_8701_12720# vdd vdd sky130_fd_pr__pfet_01v8 ad=0.4158 pd=2.85 as=0.4158 ps=2.85 w=2.52 l=0.15
X241 vdd a_29021_12720# cke1 vdd sky130_fd_pr__pfet_01v8 ad=0.7812 pd=5.66 as=0.4158 ps=2.85 w=2.52 l=0.15
X242 a_18631_8270# f0 a_17251_9376# vdd sky130_fd_pr__pfet_01v8_lvt ad=0.261 pd=2.38 as=0.261 ps=2.38 w=0.9 l=0.35
X243 a_22775_3430# a_22733_3298# a_17251_1984# vdd sky130_fd_pr__pfet_01v8_lvt ad=0.261 pd=2.38 as=0.261 ps=2.38 w=0.9 l=0.35
X244 vss a_12367_2844# a_14091_1984# vss sky130_fd_pr__nfet_01v8_lvt ad=0.31 pd=2.62 as=0.165 ps=1.33 w=1 l=0.15
X245 a_10451_12720# a_10422_11162# vdd vdd sky130_fd_pr__pfet_01v8 ad=0.58905 pd=3.9 as=1.1067 ps=7.76 w=3.57 l=0.15
X246 a_20171_6165# a_29784_6336# vss sky130_fd_pr__res_high_po_0p69 l=6.4
X247 a_8035_3880# a_8035_4480# vdd vdd sky130_fd_pr__pfet_01v8 ad=0.1122 pd=1.01 as=0.2108 ps=1.98 w=0.68 l=0.15
X248 a_18215_3430# a_18173_3298# a_14091_1984# vss sky130_fd_pr__nfet_01v8_lvt ad=0.145 pd=1.58 as=0.145 ps=1.58 w=0.5 l=0.15
X249 a_28759_11933# a_6858_11170# vss vss sky130_fd_pr__nfet_01v8 ad=0.29 pd=2.58 as=0.29 ps=2.58 w=1 l=0.18
X250 a_8035_9200# a_8035_8600# vss vss sky130_fd_pr__nfet_01v8_lvt ad=0.1305 pd=1.48 as=0.1305 ps=1.48 w=0.45 l=0.15
X251 a_8701_12720# a_9919_11933# vss vss sky130_fd_pr__nfet_01v8_lvt ad=0.2805 pd=2.03 as=0.527 ps=4.02 w=1.7 l=0.15
X252 dn a_30722_6944# vss vss sky130_fd_pr__nfet_01v8_lvt ad=0.2145 pd=1.63 as=0.403 ps=3.22 w=1.3 l=0.15
X253 a_9827_11933# a_16199_11933# vdd vdd sky130_fd_pr__pfet_01v8 ad=0.58905 pd=3.9 as=1.1067 ps=7.76 w=3.57 l=0.15
X254 a_21269_11950# a_20347_11933# vss vss sky130_fd_pr__nfet_01v8_lvt ad=0.435 pd=3.58 as=0.435 ps=3.58 w=1.5 l=0.15
X255 a_24731_7210# a_22775_7950# vss vss sky130_fd_pr__nfet_01v8_lvt ad=0.1595 pd=1.68 as=0.1595 ps=1.68 w=0.55 l=0.15
X256 a_2903_4550# a_5214_4408# vss sky130_fd_pr__res_high_po_0p69 l=1.5
X257 a_16341_1968# b5 vss vss sky130_fd_pr__nfet_01v8 ad=0.1305 pd=1.48 as=0.1305 ps=1.48 w=0.45 l=0.18
X258 a_26135_12811# a_26627_11933# vdd vdd sky130_fd_pr__pfet_01v8 ad=0.3465 pd=2.43 as=0.651 ps=4.82 w=2.1 l=0.15
X259 a_8035_6840# a6 a_12367_7364# vss sky130_fd_pr__nfet_01v8_lvt ad=0.248 pd=2.22 as=0.132 ps=1.13 w=0.8 l=0.15
X260 cke2 cke0 vdd vdd sky130_fd_pr__pfet_01v8 ad=0.5481 pd=4.36 as=0.5481 ps=4.36 w=1.89 l=0.15
X261 a_9889_11686# a_11855_12811# vdd vdd sky130_fd_pr__pfet_01v8 ad=0.36465 pd=2.54 as=0.36465 ps=2.54 w=2.21 l=0.15
X262 vss a_26135_12811# a_22449_11686# vss sky130_fd_pr__nfet_01v8_lvt ad=0.3255 pd=2.72 as=0.17325 ps=1.38 w=1.05 l=0.15
X263 a_17251_4856# a_15527_4276# vdd vdd sky130_fd_pr__pfet_01v8 ad=0.363 pd=2.53 as=0.363 ps=2.53 w=2.2 l=0.15
X264 a_8035_9200# a_15348_205# a_15527_4276# vdd sky130_fd_pr__pfet_01v8_lvt ad=0.609 pd=4.78 as=0.3045 ps=2.39 w=2.1 l=0.35
X265 a_20171_4790# a_18215_5530# vdd vdd sky130_fd_pr__pfet_01v8 ad=0.667 pd=5.18 as=0.667 ps=5.18 w=2.3 l=0.15
X266 ckd1 ckd3 vdd vdd sky130_fd_pr__pfet_01v8 ad=0.5481 pd=4.36 as=0.5481 ps=4.36 w=1.89 l=0.15
X267 a_24771_12720# a_22982_11162# vss vss sky130_fd_pr__nfet_01v8_lvt ad=0.4205 pd=3.48 as=0.4205 ps=3.48 w=1.45 l=0.15
X268 a_20911_3750# f2 a_14091_4856# vss sky130_fd_pr__nfet_01v8_lvt ad=0.145 pd=1.58 as=0.145 ps=1.58 w=0.5 l=0.15
X269 a_2903_9270# a_323_4520# vdd vdd sky130_fd_pr__pfet_01v8_lvt ad=0.1595 pd=1.39 as=0.319 ps=2.78 w=1.1 l=0.35
X270 a_12367_4276# a6 a_8035_2120# vss sky130_fd_pr__nfet_01v8_lvt ad=0.132 pd=1.13 as=0.248 ps=2.22 w=0.8 l=0.15
X271 a_22449_11686# a_26135_12811# vdd vdd sky130_fd_pr__pfet_01v8 ad=0.36465 pd=2.54 as=0.6851 ps=5.04 w=2.21 l=0.15
X272 a_27011_3745# a_25055_3750# vdd vdd sky130_fd_pr__pfet_01v8 ad=0.667 pd=5.18 as=0.667 ps=5.18 w=2.3 l=0.15
X273 vdd a_30888_6944# a_30888_8944# vdd sky130_fd_pr__pfet_01v8_lvt ad=0.23925 pd=1.94 as=0.23925 ps=1.94 w=1.65 l=0.35
X274 a_20495_3430# f2 a_17251_1984# vss sky130_fd_pr__nfet_01v8_lvt ad=0.145 pd=1.58 as=0.145 ps=1.58 w=0.5 l=0.15
X275 a_14091_9376# a_12367_8796# vdd vdd sky130_fd_pr__pfet_01v8 ad=0.363 pd=2.53 as=0.682 ps=5.02 w=2.2 l=0.15
X276 a_3663_6310# a_323_9240# vss vss sky130_fd_pr__nfet_01v8_lvt ad=0.319 pd=2.78 as=0.319 ps=2.78 w=1.1 l=0.15
X277 a_22451_4790# a_29784_3688# vss sky130_fd_pr__res_high_po_0p69 l=6.4
X278 a_25055_3430# a_25013_3298# a_17251_1984# vdd sky130_fd_pr__pfet_01v8_lvt ad=0.261 pd=2.38 as=0.261 ps=2.38 w=0.9 l=0.35
X279 vdd a_323_9240# a_2903_6310# vdd sky130_fd_pr__pfet_01v8_lvt ad=0.1595 pd=1.39 as=0.1595 ps=1.39 w=1.1 l=0.35
X280 vdd a_6063_1535# a_8035_1520# vdd sky130_fd_pr__pfet_01v8 ad=0.297 pd=2.13 as=0.297 ps=2.13 w=1.8 l=0.15
X281 a_20911_3430# a_20453_3298# a_17251_1984# vss sky130_fd_pr__nfet_01v8_lvt ad=0.145 pd=1.58 as=0.145 ps=1.58 w=0.5 l=0.15
X282 a_9827_11933# a_11519_11933# vss vss sky130_fd_pr__nfet_01v8_lvt ad=0.1218 pd=1.42 as=0.1218 ps=1.42 w=0.42 l=0.15
X283 a_25471_3430# f6 a_17251_1984# vdd sky130_fd_pr__pfet_01v8_lvt ad=0.261 pd=2.38 as=0.261 ps=2.38 w=0.9 l=0.35
X284 vdd a_18631_7950# vdd vdd sky130_fd_pr__pfet_01v8 ad=0.667 pd=5.18 as=0 ps=0 w=2.3 l=0.15
X285 a_8035_1520# a_12218_205# a_12367_7364# vdd sky130_fd_pr__pfet_01v8_lvt ad=0.609 pd=4.78 as=0.3045 ps=2.39 w=2.1 l=0.35
X286 a_3663_2190# a_323_2160# vdd vdd sky130_fd_pr__pfet_01v8_lvt ad=0.1595 pd=1.39 as=0.1595 ps=1.39 w=1.1 l=0.35
X287 a_20495_3750# a_20453_3298# a_14091_4856# vss sky130_fd_pr__nfet_01v8_lvt ad=0.145 pd=1.58 as=0.145 ps=1.58 w=0.5 l=0.15
X288 vdd a_20347_11933# a_21269_11950# vdd sky130_fd_pr__pfet_01v8 ad=0.3465 pd=2.43 as=0.3465 ps=2.43 w=2.1 l=0.15
X289 a_8035_8600# b3 a_15527_7364# vss sky130_fd_pr__nfet_01v8_lvt ad=0.248 pd=2.22 as=0.132 ps=1.13 w=0.8 l=0.15
X290 a_18215_6170# f1 a_17251_6504# vss sky130_fd_pr__nfet_01v8_lvt ad=0.145 pd=1.58 as=0.145 ps=1.58 w=0.5 l=0.15
X291 a_18215_7950# f0 a_14091_6504# vdd sky130_fd_pr__pfet_01v8_lvt ad=0.261 pd=2.38 as=0.261 ps=2.38 w=0.9 l=0.35
X292 a_8701_12720# a_9221_11939# a_16702_11162# vdd sky130_fd_pr__pfet_01v8 ad=0.37455 pd=2.6 as=0.7037 ps=5.16 w=2.27 l=0.15
X293 a_6063_3895# a_5993_3745# vss vss sky130_fd_pr__nfet_01v8_lvt ad=0.13695 pd=1.16 as=0.2573 ps=2.28 w=0.83 l=0.15
X294 a_18631_1650# a_18173_1814# a_17251_1984# vss sky130_fd_pr__nfet_01v8_lvt ad=0.145 pd=1.58 as=0.145 ps=1.58 w=0.5 l=0.15
X295 vss a_21269_11950# a_21781_11939# vss sky130_fd_pr__nfet_01v8_lvt ad=0.3255 pd=2.72 as=0.17325 ps=1.38 w=1.05 l=0.15
X296 a_12367_4276# a_12741_1968# a_8035_1520# vdd sky130_fd_pr__pfet_01v8_lvt ad=0.3045 pd=2.39 as=0.609 ps=4.78 w=2.1 l=0.35
X297 ep a_30888_4424# vdd vdd sky130_fd_pr__pfet_01v8_lvt ad=0.377 pd=2.89 as=0.754 ps=5.78 w=2.6 l=0.35
X298 a_6063_8615# a_5993_8465# vdd vdd sky130_fd_pr__pfet_01v8_lvt ad=0.23925 pd=1.94 as=0.4785 ps=3.88 w=1.65 l=0.35
X299 a_8035_1520# a2 a_12367_4276# vss sky130_fd_pr__nfet_01v8_lvt ad=0.248 pd=2.22 as=0.132 ps=1.13 w=0.8 l=0.15
X300 a_29262_11162# a_21781_11939# a_9827_11933# vdd sky130_fd_pr__pfet_01v8 ad=0.37455 pd=2.6 as=0.37455 ps=2.6 w=2.27 l=0.15
X301 a_7787_11933# a_6858_11170# vss vss sky130_fd_pr__nfet_01v8 ad=0.232 pd=2.18 as=0.232 ps=2.18 w=0.8 l=0.18
X302 vss a_25471_7950# vss vss sky130_fd_pr__nfet_01v8_lvt ad=0.1595 pd=1.68 as=0 ps=0 w=0.55 l=0.15
X303 a_323_2160# vss sky130_fd_pr__cap_mim_m3_1 l=1.75 w=1.75
X304 vdd a_9827_11933# ckd1 vdd sky130_fd_pr__pfet_01v8 ad=0.4158 pd=2.85 as=0.4158 ps=2.85 w=2.52 l=0.15
X305 a_21781_11939# a_21269_11950# vdd vdd sky130_fd_pr__pfet_01v8 ad=0.36465 pd=2.54 as=0.6851 ps=5.04 w=2.21 l=0.15
X306 a_8035_9200# a_16781_1968# a_15527_7364# vdd sky130_fd_pr__pfet_01v8_lvt ad=0.609 pd=4.78 as=0.3045 ps=2.39 w=2.1 l=0.35
X307 vdd a_323_6880# a_2903_3950# vdd sky130_fd_pr__pfet_01v8_lvt ad=0.1595 pd=1.39 as=0.1595 ps=1.39 w=1.1 l=0.35
X308 a_8035_4480# a_6063_4495# vdd vdd sky130_fd_pr__pfet_01v8 ad=0.297 pd=2.13 as=0.558 ps=4.22 w=1.8 l=0.15
X309 a_23191_3430# a_22733_3298# a_17251_1984# vss sky130_fd_pr__nfet_01v8_lvt ad=0.145 pd=1.58 as=0.145 ps=1.58 w=0.5 l=0.15
X310 a_23021_12720# a_22479_11933# vss vss sky130_fd_pr__nfet_01v8_lvt ad=0.4205 pd=3.48 as=0.4205 ps=3.48 w=1.45 l=0.15
X311 vdd a_20911_5530# vdd vdd sky130_fd_pr__pfet_01v8 ad=0.667 pd=5.18 as=0 ps=0 w=2.3 l=0.15
X312 en a_30722_2424# vdd vdd sky130_fd_pr__pfet_01v8_lvt ad=0.377 pd=2.89 as=0.754 ps=5.78 w=2.6 l=0.35
X313 vss a_18631_3430# vss vss sky130_fd_pr__nfet_01v8_lvt ad=0.1595 pd=1.68 as=0 ps=0 w=0.55 l=0.15
X314 a_323_6880# in vss vss sky130_fd_pr__nfet_01v8_lvt ad=0.1155 pd=1.03 as=0.217 ps=2.02 w=0.7 l=0.15
X315 a_20495_7950# a_20453_3298# a_17251_6504# vdd sky130_fd_pr__pfet_01v8_lvt ad=0.261 pd=2.38 as=0.261 ps=2.38 w=0.9 l=0.35
X316 a_8701_12720# a_10451_12720# vss vss sky130_fd_pr__nfet_01v8_lvt ad=0.1218 pd=1.42 as=0.1218 ps=1.42 w=0.42 l=0.15
X317 vdd a_5993_6105# a_6063_6255# vdd sky130_fd_pr__pfet_01v8_lvt ad=0.4785 pd=3.88 as=0.23925 ps=1.94 w=1.65 l=0.35
X318 a_18215_5530# f1 a_17251_4856# vss sky130_fd_pr__nfet_01v8_lvt ad=0.145 pd=1.58 as=0.145 ps=1.58 w=0.5 l=0.15
X319 vss a_6063_1535# a_8035_1520# vss sky130_fd_pr__nfet_01v8_lvt ad=0.372 pd=3.02 as=0.198 ps=1.53 w=1.2 l=0.15
X320 a_20911_7950# f2 a_17251_6504# vdd sky130_fd_pr__pfet_01v8_lvt ad=0.261 pd=2.38 as=0.261 ps=2.38 w=0.9 l=0.35
X321 a_10422_11162# a_9889_11686# a_11519_11933# vdd sky130_fd_pr__pfet_01v8 ad=0.37455 pd=2.6 as=0.37455 ps=2.6 w=2.27 l=0.15
X322 en a_6858_11170# a_26627_11933# vdd sky130_fd_pr__pfet_01v8_lvt ad=0.32915 pd=2.56 as=0.32915 ps=2.56 w=2.27 l=0.35
X323 a_5993_9189# a_6063_9215# vss sky130_fd_pr__res_high_po_0p35 l=9.5
X324 a_10451_12720# a_10422_11162# vss vss sky130_fd_pr__nfet_01v8_lvt ad=0.2805 pd=2.03 as=0.527 ps=4.02 w=1.7 l=0.15
X325 a_8035_2120# a_12218_205# a_12367_8796# vdd sky130_fd_pr__pfet_01v8_lvt ad=0.609 pd=4.78 as=0.3045 ps=2.39 w=2.1 l=0.35
X326 a_8035_6240# a_13181_1968# a_12367_4276# vdd sky130_fd_pr__pfet_01v8_lvt ad=0.609 pd=4.78 as=0.3045 ps=2.39 w=2.1 l=0.35
X327 a_11519_11933# a_16702_11162# vdd vdd sky130_fd_pr__pfet_01v8 ad=0.58905 pd=3.9 as=1.1067 ps=7.76 w=3.57 l=0.15
X328 a_12741_1968# a2 vdd vdd sky130_fd_pr__pfet_01v8 ad=0.261 pd=2.38 as=0.261 ps=2.38 w=0.9 l=0.18
X329 a_22451_3745# a_20495_3750# vss vss sky130_fd_pr__nfet_01v8_lvt ad=0.1595 pd=1.68 as=0.1595 ps=1.68 w=0.55 l=0.15
X330 a_22451_2690# a_20495_3430# vdd vdd sky130_fd_pr__pfet_01v8 ad=0.667 pd=5.18 as=0.667 ps=5.18 w=2.3 l=0.15
X331 a_24731_3745# a_22775_3750# vdd vdd sky130_fd_pr__pfet_01v8 ad=0.667 pd=5.18 as=0.667 ps=5.18 w=2.3 l=0.15
X332 ckd2 a_10451_12720# vdd vdd sky130_fd_pr__pfet_01v8 ad=0.4158 pd=2.85 as=0.7812 ps=5.66 w=2.52 l=0.15
X333 a_29784_8208# vss sky130_fd_pr__cap_mim_m3_1 l=2.8 w=2.8
X334 a_5993_3745# a_5214_3940# sky130_fd_pr__cap_mim_m3_1 l=4.2 w=4.2
X335 vss a_30722_2424# en vss sky130_fd_pr__nfet_01v8_lvt ad=0.403 pd=3.22 as=0.2145 ps=1.63 w=1.3 l=0.15
X336 a_23191_1650# f5 a_14091_1984# vss sky130_fd_pr__nfet_01v8_lvt ad=0.145 pd=1.58 as=0.145 ps=1.58 w=0.5 l=0.15
X337 a_9827_11933# a_16199_11933# vss vss sky130_fd_pr__nfet_01v8_lvt ad=0.2805 pd=2.03 as=0.527 ps=4.02 w=1.7 l=0.15
X338 a_26135_12811# a_26627_11933# vss vss sky130_fd_pr__nfet_01v8_lvt ad=0.435 pd=3.58 as=0.435 ps=3.58 w=1.5 l=0.15
X339 vdd a_6063_8615# a_8035_8600# vdd sky130_fd_pr__pfet_01v8 ad=0.297 pd=2.13 as=0.297 ps=2.13 w=1.8 l=0.15
X340 a_20171_8265# a_29784_8208# vss sky130_fd_pr__res_high_po_0p69 l=6.4
X341 a_2903_2190# a_5214_2048# vss sky130_fd_pr__res_high_po_0p69 l=1.5
X342 a_27011_1645# a_25055_1650# vss vss sky130_fd_pr__nfet_01v8_lvt ad=0.1595 pd=1.68 as=0.1595 ps=1.68 w=0.55 l=0.15
X343 a_23191_3750# a_22733_3298# a_14091_4856# vdd sky130_fd_pr__pfet_01v8_lvt ad=0.261 pd=2.38 as=0.261 ps=2.38 w=0.9 l=0.35
X344 vdd a_30771_12720# cke3 vdd sky130_fd_pr__pfet_01v8 ad=0.4158 pd=2.85 as=0.4158 ps=2.85 w=2.52 l=0.15
X345 a_18173_1814# f1 vdd vdd sky130_fd_pr__pfet_01v8 ad=0.261 pd=2.38 as=0.261 ps=2.38 w=0.9 l=0.18
X346 a_20171_1645# a_18215_1650# vdd vdd sky130_fd_pr__pfet_01v8 ad=0.667 pd=5.18 as=0.667 ps=5.18 w=2.3 l=0.15
X347 a_15527_7364# b5 a_8035_4480# vss sky130_fd_pr__nfet_01v8_lvt ad=0.132 pd=1.13 as=0.248 ps=2.22 w=0.8 l=0.15
X348 a_3663_9270# a_323_6880# vdd vdd sky130_fd_pr__pfet_01v8_lvt ad=0.1595 pd=1.39 as=0.1595 ps=1.39 w=1.1 l=0.35
X349 a_13868_205# a5 vdd vdd sky130_fd_pr__pfet_01v8 ad=0.261 pd=2.38 as=0.261 ps=2.38 w=0.9 l=0.18
X350 ckd0 a_8701_12720# vss vss sky130_fd_pr__nfet_01v8_lvt ad=0.198 pd=1.53 as=0.372 ps=3.02 w=1.2 l=0.15
X351 vdd a_8709_11950# a_9221_11939# vdd sky130_fd_pr__pfet_01v8 ad=0.6851 pd=5.04 as=0.36465 ps=2.54 w=2.21 l=0.15
X352 a_9827_11933# a_11519_11933# vdd vdd sky130_fd_pr__pfet_01v8 ad=0.5104 pd=4.1 as=0.5104 ps=4.1 w=1.76 l=0.15
X353 a_22451_8265# a_20495_8270# vdd vdd sky130_fd_pr__pfet_01v8 ad=0.667 pd=5.18 as=0.667 ps=5.18 w=2.3 l=0.15
X354 vdd a_5993_3745# a_6063_3895# vdd sky130_fd_pr__pfet_01v8_lvt ad=0.4785 pd=3.88 as=0.23925 ps=1.94 w=1.65 l=0.35
X355 vdd a_12367_4276# a_14091_4856# vdd sky130_fd_pr__pfet_01v8 ad=0.682 pd=5.02 as=0.363 ps=2.53 w=2.2 l=0.15
X356 vdd a_16702_11162# a_11519_11933# vdd sky130_fd_pr__pfet_01v8 ad=0.58905 pd=3.9 as=0.58905 ps=3.9 w=3.57 l=0.15
X357 a_3663_6910# a_5214_6768# vss sky130_fd_pr__res_high_po_0p69 l=1.5
X358 a_8035_8600# a_16781_1968# a_15527_8796# vdd sky130_fd_pr__pfet_01v8_lvt ad=0.609 pd=4.78 as=0.3045 ps=2.39 w=2.1 l=0.35
X359 a_23191_7950# f4 a_17251_6504# vdd sky130_fd_pr__pfet_01v8_lvt ad=0.261 pd=2.38 as=0.261 ps=2.38 w=0.9 l=0.35
X360 a_30722_6944# a_30722_8944# vdd vdd sky130_fd_pr__pfet_01v8_lvt ad=0.23925 pd=1.94 as=0.23925 ps=1.94 w=1.65 l=0.35
X361 a_14067_11933# rst_n dn vss sky130_fd_pr__nfet_01v8_lvt ad=0.2145 pd=1.63 as=0.403 ps=3.22 w=1.3 l=0.15
X362 a_20911_8270# a_20453_3298# a_14091_9376# vdd sky130_fd_pr__pfet_01v8_lvt ad=0.261 pd=2.38 as=0.261 ps=2.38 w=0.9 l=0.35
X363 a_25013_3298# f6 vdd vdd sky130_fd_pr__pfet_01v8 ad=0.261 pd=2.38 as=0.261 ps=2.38 w=0.9 l=0.18
X364 a_27011_6165# a_25055_6170# vdd vdd sky130_fd_pr__pfet_01v8 ad=0.667 pd=5.18 as=0.667 ps=5.18 w=2.3 l=0.15
X365 vdd a_323_9240# a_3663_6310# vdd sky130_fd_pr__pfet_01v8_lvt ad=0.319 pd=2.78 as=0.1595 ps=1.39 w=1.1 l=0.35
X366 a_30722_6944# a_30722_8944# vss vss sky130_fd_pr__nfet_01v8_lvt ad=0.4785 pd=3.88 as=0.4785 ps=3.88 w=1.65 l=0.15
X367 a_15527_2844# a_15348_205# a_8035_8600# vdd sky130_fd_pr__pfet_01v8_lvt ad=0.3045 pd=2.39 as=0.609 ps=4.78 w=2.1 l=0.35
X368 a_18631_3750# f0 a_14091_4856# vss sky130_fd_pr__nfet_01v8_lvt ad=0.145 pd=1.58 as=0.145 ps=1.58 w=0.5 l=0.15
X369 vss a_24771_12720# cke2 vss sky130_fd_pr__nfet_01v8_lvt ad=0.372 pd=3.02 as=0.198 ps=1.53 w=1.2 l=0.15
X370 a_2903_2190# a_323_2160# vss vss sky130_fd_pr__nfet_01v8_lvt ad=0.319 pd=2.78 as=0.319 ps=2.78 w=1.1 l=0.15
X371 a_22775_1650# a_22733_1814# a_14091_1984# vss sky130_fd_pr__nfet_01v8_lvt ad=0.145 pd=1.58 as=0.145 ps=1.58 w=0.5 l=0.15
X372 a_22775_3750# f4 a_14091_4856# vdd sky130_fd_pr__pfet_01v8_lvt ad=0.261 pd=2.38 as=0.261 ps=2.38 w=0.9 l=0.35
X373 a_8035_1520# a_13621_1968# a_12367_2844# vdd sky130_fd_pr__pfet_01v8_lvt ad=0.609 pd=4.78 as=0.3045 ps=2.39 w=2.1 l=0.35
X374 a_18215_10050# a_18173_1814# a_17251_9376# vdd sky130_fd_pr__pfet_01v8_lvt ad=0.261 pd=2.38 as=0.261 ps=2.38 w=0.9 l=0.35
X375 a_20347_11933# a_6858_11170# ep vdd sky130_fd_pr__pfet_01v8_lvt ad=0.6583 pd=5.12 as=0.32915 ps=2.56 w=2.27 l=0.35
X376 vss a_9919_11933# a_8701_12720# vss sky130_fd_pr__nfet_01v8_lvt ad=0.527 pd=4.02 as=0.2805 ps=2.03 w=1.7 l=0.15
X377 a_18631_10050# f1 a_17251_9376# vdd sky130_fd_pr__pfet_01v8_lvt ad=0.261 pd=2.38 as=0.261 ps=2.38 w=0.9 l=0.35
X378 a_24731_2690# a_29784_1816# vss sky130_fd_pr__res_high_po_0p69 l=6.4
X379 a_22479_11933# a_22449_11686# a_10451_12720# vdd sky130_fd_pr__pfet_01v8 ad=0.37455 pd=2.6 as=0.7037 ps=5.16 w=2.27 l=0.15
X380 vdd a_26627_11933# a_26135_12811# vdd sky130_fd_pr__pfet_01v8 ad=0.3465 pd=2.43 as=0.3465 ps=2.43 w=2.1 l=0.15
X381 a_20495_8270# f2 a_14091_9376# vdd sky130_fd_pr__pfet_01v8_lvt ad=0.261 pd=2.38 as=0.261 ps=2.38 w=0.9 l=0.35
X382 a_8035_3880# b1 a_15527_7364# vss sky130_fd_pr__nfet_01v8_lvt ad=0.248 pd=2.22 as=0.132 ps=1.13 w=0.8 l=0.15
X383 a_20171_7210# a_29784_6336# vss sky130_fd_pr__res_high_po_0p69 l=6.4
X384 a_8035_9200# b5 a_15527_2844# vss sky130_fd_pr__nfet_01v8_lvt ad=0.248 pd=2.22 as=0.132 ps=1.13 w=0.8 l=0.15
X385 a_6063_1535# a_5993_1385# vss vss sky130_fd_pr__nfet_01v8_lvt ad=0.13695 pd=1.16 as=0.2573 ps=2.28 w=0.83 l=0.15
X386 vss a_6063_8615# a_8035_8600# vss sky130_fd_pr__nfet_01v8_lvt ad=0.372 pd=3.02 as=0.198 ps=1.53 w=1.2 l=0.15
X387 a_12741_1968# a2 vss vss sky130_fd_pr__nfet_01v8 ad=0.1305 pd=1.48 as=0.1305 ps=1.48 w=0.45 l=0.18
X388 vss a_23191_3750# vss vss sky130_fd_pr__nfet_01v8_lvt ad=0.1595 pd=1.68 as=0 ps=0 w=0.55 l=0.15
X389 a_20171_9310# a_18215_10050# vss vss sky130_fd_pr__nfet_01v8_lvt ad=0.1595 pd=1.68 as=0.1595 ps=1.68 w=0.55 l=0.15
X390 a_6063_6255# a_5993_6105# vdd vdd sky130_fd_pr__pfet_01v8_lvt ad=0.23925 pd=1.94 as=0.4785 ps=3.88 w=1.65 l=0.35
X391 a_3663_4550# a_5214_4408# vss sky130_fd_pr__res_high_po_0p69 l=1.5
X392 vdd a_23191_3430# vdd vdd sky130_fd_pr__pfet_01v8 ad=0.667 pd=5.18 as=0 ps=0 w=2.3 l=0.15
X393 vdd a_25471_3750# vdd vdd sky130_fd_pr__pfet_01v8 ad=0.667 pd=5.18 as=0 ps=0 w=2.3 l=0.15
X394 a_15527_4276# b1 a_8035_9200# vss sky130_fd_pr__nfet_01v8_lvt ad=0.132 pd=1.13 as=0.248 ps=2.22 w=0.8 l=0.15
X395 a_5993_3745# a_6063_3895# vss sky130_fd_pr__res_high_po_0p35 l=9.5
X396 a_8701_12720# a_10451_12720# vdd vdd sky130_fd_pr__pfet_01v8 ad=0.5104 pd=4.1 as=0.5104 ps=4.1 w=1.76 l=0.15
X397 a_30771_12720# a_29262_11162# vdd vdd sky130_fd_pr__pfet_01v8 ad=0.33495 pd=2.36 as=0.6293 ps=4.68 w=2.03 l=0.15
X398 a_22451_6165# a_29784_6336# vss sky130_fd_pr__res_high_po_0p69 l=6.4
X399 a_25055_1650# a_25013_1814# a_14091_1984# vss sky130_fd_pr__nfet_01v8_lvt ad=0.145 pd=1.58 as=0.145 ps=1.58 w=0.5 l=0.15
X400 vdd a_20911_1650# vdd vdd sky130_fd_pr__pfet_01v8 ad=0.667 pd=5.18 as=0 ps=0 w=2.3 l=0.15
X401 vdd a_23021_12720# cke0 vdd sky130_fd_pr__pfet_01v8 ad=0.7812 pd=5.66 as=0.4158 ps=2.85 w=2.52 l=0.15
X402 vdd a_30722_6944# dn vdd sky130_fd_pr__pfet_01v8_lvt ad=0.377 pd=2.89 as=0.377 ps=2.89 w=2.6 l=0.35
X403 vdd a_323_9240# a_3663_3950# vdd sky130_fd_pr__pfet_01v8_lvt ad=0.319 pd=2.78 as=0.1595 ps=1.39 w=1.1 l=0.35
X404 vdd a_5993_2109# a_6063_2135# vdd sky130_fd_pr__pfet_01v8_lvt ad=0.4785 pd=3.88 as=0.23925 ps=1.94 w=1.65 l=0.35
X405 a_18173_1814# f1 vss vss sky130_fd_pr__nfet_01v8 ad=0.1305 pd=1.48 as=0.1305 ps=1.48 w=0.45 l=0.18
X406 a_25055_3750# f6 a_14091_4856# vdd sky130_fd_pr__pfet_01v8_lvt ad=0.261 pd=2.38 as=0.261 ps=2.38 w=0.9 l=0.35
X407 a_30888_8944# a_30888_6944# vdd vdd sky130_fd_pr__pfet_01v8_lvt ad=0.23925 pd=1.94 as=0.23925 ps=1.94 w=1.65 l=0.35
X408 vdd a_323_6880# a_2903_1590# vdd sky130_fd_pr__pfet_01v8_lvt ad=0.1595 pd=1.39 as=0.1595 ps=1.39 w=1.1 l=0.35
X409 a_8035_4480# a_15901_1968# a_15527_2844# vdd sky130_fd_pr__pfet_01v8_lvt ad=0.609 pd=4.78 as=0.3045 ps=2.39 w=2.1 l=0.35
X410 a_30888_8944# a_30888_6944# vss sky130_fd_pr__res_high_po_0p35 l=8
X411 a_12367_8796# a0 a_8035_2120# vss sky130_fd_pr__nfet_01v8_lvt ad=0.132 pd=1.13 as=0.248 ps=2.22 w=0.8 l=0.15
X412 a_13868_205# a5 vss vss sky130_fd_pr__nfet_01v8 ad=0.1305 pd=1.48 as=0.1305 ps=1.48 w=0.45 l=0.18
X413 vdd a_23191_8270# vdd vdd sky130_fd_pr__pfet_01v8 ad=0.667 pd=5.18 as=0 ps=0 w=2.3 l=0.15
X414 a_2903_9270# a_5214_9128# vss sky130_fd_pr__res_high_po_0p69 l=1.5
X415 a_25471_8270# f6 a_14091_9376# vss sky130_fd_pr__nfet_01v8_lvt ad=0.145 pd=1.58 as=0.145 ps=1.58 w=0.5 l=0.15
X416 vdd a_24771_12720# cke2 vdd sky130_fd_pr__pfet_01v8 ad=0.7812 pd=5.66 as=0.4158 ps=2.85 w=2.52 l=0.15
X417 a_20171_8265# a_18215_8270# vss vss sky130_fd_pr__nfet_01v8_lvt ad=0.1595 pd=1.68 as=0.1595 ps=1.68 w=0.55 l=0.15
X418 a_25013_3298# f6 vss vss sky130_fd_pr__nfet_01v8 ad=0.1305 pd=1.48 as=0.1305 ps=1.48 w=0.45 l=0.18
X419 vdd a_18631_5530# vdd vdd sky130_fd_pr__pfet_01v8 ad=0.667 pd=5.18 as=0 ps=0 w=2.3 l=0.15
X420 a_21269_11950# a_20347_11933# vdd vdd sky130_fd_pr__pfet_01v8 ad=0.651 pd=4.82 as=0.3465 ps=2.43 w=2.1 l=0.15
X421 a_20911_6170# f3 a_14091_6504# vss sky130_fd_pr__nfet_01v8_lvt ad=0.145 pd=1.58 as=0.145 ps=1.58 w=0.5 l=0.15
X422 a_24731_1645# a_22775_1650# vss vss sky130_fd_pr__nfet_01v8_lvt ad=0.1595 pd=1.68 as=0.1595 ps=1.68 w=0.55 l=0.15
X423 cke0 cke2 vss vss sky130_fd_pr__nfet_01v8_lvt ad=0.1305 pd=1.48 as=0.1305 ps=1.48 w=0.45 l=0.15
X424 a_16702_11162# a_9221_11939# a_8701_12720# vdd sky130_fd_pr__pfet_01v8 ad=0.37455 pd=2.6 as=0.37455 ps=2.6 w=2.27 l=0.15
X425 a_18215_7950# f0 a_17251_6504# vss sky130_fd_pr__nfet_01v8_lvt ad=0.145 pd=1.58 as=0.145 ps=1.58 w=0.5 l=0.15
X426 a_12218_205# a0 vdd vdd sky130_fd_pr__pfet_01v8 ad=0.261 pd=2.38 as=0.261 ps=2.38 w=0.9 l=0.18
X427 a_25471_1650# a_25013_1814# a_14091_1984# vdd sky130_fd_pr__pfet_01v8_lvt ad=0.261 pd=2.38 as=0.261 ps=2.38 w=0.9 l=0.35
X428 a_23191_5530# a_22733_1814# a_14091_4856# vdd sky130_fd_pr__pfet_01v8_lvt ad=0.261 pd=2.38 as=0.261 ps=2.38 w=0.9 l=0.35
X429 vss a_6063_6255# a_8035_6240# vss sky130_fd_pr__nfet_01v8_lvt ad=0.372 pd=3.02 as=0.198 ps=1.53 w=1.2 l=0.15
X430 a_6063_3895# a_5993_3745# vdd vdd sky130_fd_pr__pfet_01v8_lvt ad=0.23925 pd=1.94 as=0.4785 ps=3.88 w=1.65 l=0.35
X431 a_9827_11933# a_21781_11939# a_29262_11162# vdd sky130_fd_pr__pfet_01v8 ad=0.7037 pd=5.16 as=0.37455 ps=2.6 w=2.27 l=0.15
X432 a_20495_10050# f3 a_17251_9376# vss sky130_fd_pr__nfet_01v8_lvt ad=0.145 pd=1.58 as=0.145 ps=1.58 w=0.5 l=0.15
X433 a_15527_8796# b7 a_8035_8600# vss sky130_fd_pr__nfet_01v8_lvt ad=0.132 pd=1.13 as=0.248 ps=2.22 w=0.8 l=0.15
X434 a_8035_1520# a_12741_1968# a_12367_4276# vdd sky130_fd_pr__pfet_01v8_lvt ad=0.609 pd=4.78 as=0.3045 ps=2.39 w=2.1 l=0.35
X435 ckd1 a_9827_11933# vdd vdd sky130_fd_pr__pfet_01v8 ad=0.4158 pd=2.85 as=0.4158 ps=2.85 w=2.52 l=0.15
X436 a_9221_11939# a_8709_11950# vss vss sky130_fd_pr__nfet_01v8_lvt ad=0.17325 pd=1.38 as=0.3255 ps=2.72 w=1.05 l=0.15
X437 a_18631_10050# f1 a_14091_9376# vss sky130_fd_pr__nfet_01v8_lvt ad=0.145 pd=1.58 as=0.145 ps=1.58 w=0.5 l=0.15
X438 ckd3 a_11519_11933# vdd vdd sky130_fd_pr__pfet_01v8 ad=0.4158 pd=2.85 as=0.7812 ps=5.66 w=2.52 l=0.15
X439 a_2903_9270# a_323_4520# vss vss sky130_fd_pr__nfet_01v8_lvt ad=0.319 pd=2.78 as=0.319 ps=2.78 w=1.1 l=0.15
X440 a_24731_6165# a_22775_6170# vdd vdd sky130_fd_pr__pfet_01v8 ad=0.667 pd=5.18 as=0.667 ps=5.18 w=2.3 l=0.15
X441 vdd a_28759_11933# a_29021_12720# vdd sky130_fd_pr__pfet_01v8 ad=0.33495 pd=2.36 as=0.33495 ps=2.36 w=2.03 l=0.15
X442 vdd a_6063_6255# a_8035_6240# vdd sky130_fd_pr__pfet_01v8 ad=0.297 pd=2.13 as=0.297 ps=2.13 w=1.8 l=0.15
X443 a_13208_205# a3 vdd vdd sky130_fd_pr__pfet_01v8 ad=0.261 pd=2.38 as=0.261 ps=2.38 w=0.9 l=0.18
X444 a_29784_3688# vss sky130_fd_pr__cap_mim_m3_1 l=2.8 w=2.8
X445 a_20495_10050# a_20453_1814# a_14091_9376# vss sky130_fd_pr__nfet_01v8_lvt ad=0.145 pd=1.58 as=0.145 ps=1.58 w=0.5 l=0.15
X446 a_23191_6170# a_22733_1814# a_14091_6504# vdd sky130_fd_pr__pfet_01v8_lvt ad=0.261 pd=2.38 as=0.261 ps=2.38 w=0.9 l=0.35
X447 a_30722_2424# a_30722_4424# vdd vdd sky130_fd_pr__pfet_01v8_lvt ad=0.23925 pd=1.94 as=0.4785 ps=3.88 w=1.65 l=0.35
X448 a_20495_6170# a_20453_1814# a_14091_6504# vss sky130_fd_pr__nfet_01v8_lvt ad=0.145 pd=1.58 as=0.145 ps=1.58 w=0.5 l=0.15
X449 a_15527_2844# b3 a_8035_4480# vss sky130_fd_pr__nfet_01v8_lvt ad=0.132 pd=1.13 as=0.248 ps=2.22 w=0.8 l=0.15
X450 a_2903_6910# a_5214_6768# vss sky130_fd_pr__res_high_po_0p69 l=1.5
X451 vdd a_30888_8944# dp vdd sky130_fd_pr__pfet_01v8_lvt ad=0.377 pd=2.89 as=0.377 ps=2.89 w=2.6 l=0.35
X452 a_29021_12720# a_28759_11933# vdd vdd sky130_fd_pr__pfet_01v8 ad=0.33495 pd=2.36 as=0.6293 ps=4.68 w=2.03 l=0.15
X453 a_22775_3750# f4 a_17251_4856# vss sky130_fd_pr__nfet_01v8_lvt ad=0.145 pd=1.58 as=0.145 ps=1.58 w=0.5 l=0.15
X454 a_22775_5530# f5 a_14091_4856# vdd sky130_fd_pr__pfet_01v8_lvt ad=0.261 pd=2.38 as=0.261 ps=2.38 w=0.9 l=0.35
X455 a_20911_5530# f3 a_14091_4856# vss sky130_fd_pr__nfet_01v8_lvt ad=0.145 pd=1.58 as=0.145 ps=1.58 w=0.5 l=0.15
X456 cke1 a_29021_12720# vdd vdd sky130_fd_pr__pfet_01v8 ad=0.4158 pd=2.85 as=0.7812 ps=5.66 w=2.52 l=0.15
X457 a_11519_11933# a_9889_11686# a_10422_11162# vdd sky130_fd_pr__pfet_01v8 ad=0.7037 pd=5.16 as=0.37455 ps=2.6 w=2.27 l=0.15
X458 vdd a_323_4520# a_2903_6910# vdd sky130_fd_pr__pfet_01v8_lvt ad=0.1595 pd=1.39 as=0.1595 ps=1.39 w=1.1 l=0.35
X459 a_13621_1968# a6 vdd vdd sky130_fd_pr__pfet_01v8 ad=0.261 pd=2.38 as=0.261 ps=2.38 w=0.9 l=0.18
X460 a_6063_8615# a_5993_8465# vss vss sky130_fd_pr__nfet_01v8_lvt ad=0.13695 pd=1.16 as=0.2573 ps=2.28 w=0.83 l=0.15
X461 a_8035_2120# a4 a_12367_7364# vss sky130_fd_pr__nfet_01v8_lvt ad=0.248 pd=2.22 as=0.132 ps=1.13 w=0.8 l=0.15
X462 vss a_10422_11162# a_10451_12720# vss sky130_fd_pr__nfet_01v8_lvt ad=0.527 pd=4.02 as=0.2805 ps=2.03 w=1.7 l=0.15
X463 a_18631_8270# a_18173_3298# a_14091_9376# vdd sky130_fd_pr__pfet_01v8_lvt ad=0.261 pd=2.38 as=0.261 ps=2.38 w=0.9 l=0.35
X464 vss a_15527_7364# a_17251_6504# vss sky130_fd_pr__nfet_01v8_lvt ad=0.31 pd=2.62 as=0.165 ps=1.33 w=1 l=0.15
X465 a_22775_6170# f5 a_14091_6504# vdd sky130_fd_pr__pfet_01v8_lvt ad=0.261 pd=2.38 as=0.261 ps=2.38 w=0.9 l=0.35
X466 a_26627_11933# a_6858_11170# en vdd sky130_fd_pr__pfet_01v8_lvt ad=0.6583 pd=5.12 as=0.32915 ps=2.56 w=2.27 l=0.35
X467 vdd a_5993_9189# a_6063_9215# vdd sky130_fd_pr__pfet_01v8_lvt ad=0.4785 pd=3.88 as=0.23925 ps=1.94 w=1.65 l=0.35
X468 vss a_20911_8270# vss vss sky130_fd_pr__nfet_01v8_lvt ad=0.1595 pd=1.68 as=0 ps=0 w=0.55 l=0.15
X469 a_5993_9189# a_5214_9128# sky130_fd_pr__cap_mim_m3_1 l=4.2 w=4.2
X470 a_22451_2690# a_29784_1816# vss sky130_fd_pr__res_high_po_0p69 l=6.4
X471 a_12367_4276# a4 a_8035_6240# vss sky130_fd_pr__nfet_01v8_lvt ad=0.132 pd=1.13 as=0.248 ps=2.22 w=0.8 l=0.15
X472 vss a_16199_11933# a_9827_11933# vss sky130_fd_pr__nfet_01v8_lvt ad=0.527 pd=4.02 as=0.2805 ps=2.03 w=1.7 l=0.15
X473 vdd a_323_9240# a_2903_8670# vdd sky130_fd_pr__pfet_01v8_lvt ad=0.1595 pd=1.39 as=0.1595 ps=1.39 w=1.1 l=0.35
X474 a_6063_2135# a_5993_2109# vdd vdd sky130_fd_pr__pfet_01v8_lvt ad=0.23925 pd=1.94 as=0.4785 ps=3.88 w=1.65 l=0.35
X475 vss a_25471_1650# vss vss sky130_fd_pr__nfet_01v8_lvt ad=0.1595 pd=1.68 as=0 ps=0 w=0.55 l=0.15
X476 vdd a_6063_3895# a_8035_3880# vdd sky130_fd_pr__pfet_01v8 ad=0.297 pd=2.13 as=0.297 ps=2.13 w=1.8 l=0.15
X477 cke3 a_30771_12720# vdd vdd sky130_fd_pr__pfet_01v8 ad=0.4158 pd=2.85 as=0.4158 ps=2.85 w=2.52 l=0.15
X478 a_15527_7364# a_15901_1968# a_8035_8600# vdd sky130_fd_pr__pfet_01v8_lvt ad=0.3045 pd=2.39 as=0.609 ps=4.78 w=2.1 l=0.35
X479 a_24731_4790# a_29784_3688# vss sky130_fd_pr__res_high_po_0p69 l=6.4
X480 a_15527_7364# a_16781_1968# a_8035_9200# vdd sky130_fd_pr__pfet_01v8_lvt ad=0.3045 pd=2.39 as=0.609 ps=4.78 w=2.1 l=0.35
X481 a_17251_4856# a_15527_4276# vss vss sky130_fd_pr__nfet_01v8_lvt ad=0.165 pd=1.33 as=0.31 ps=2.62 w=1 l=0.15
X482 a_26135_12811# a_21269_11950# vss vss sky130_fd_pr__nfet_01v8_lvt ad=0.1305 pd=1.48 as=0.1305 ps=1.48 w=0.45 l=0.15
X483 a_28759_11933# a_21781_11939# a_11519_11933# vdd sky130_fd_pr__pfet_01v8 ad=0.37455 pd=2.6 as=0.7037 ps=5.16 w=2.27 l=0.15
X484 a_20495_5530# a_20453_1814# a_14091_4856# vss sky130_fd_pr__nfet_01v8_lvt ad=0.145 pd=1.58 as=0.145 ps=1.58 w=0.5 l=0.15
X485 a_12218_205# a0 vss vss sky130_fd_pr__nfet_01v8 ad=0.1305 pd=1.48 as=0.1305 ps=1.48 w=0.45 l=0.18
X486 a_25055_3750# f6 a_17251_4856# vss sky130_fd_pr__nfet_01v8_lvt ad=0.145 pd=1.58 as=0.145 ps=1.58 w=0.5 l=0.15
X487 vss a_8701_12720# ckd0 vss sky130_fd_pr__nfet_01v8_lvt ad=0.372 pd=3.02 as=0.198 ps=1.53 w=1.2 l=0.15
X488 a_9919_11933# a_9221_11939# a_9827_11933# vss sky130_fd_pr__nfet_01v8_lvt ad=0.231 pd=1.73 as=0.434 ps=3.42 w=1.4 l=0.15
X489 a_23021_12720# a_24771_12720# vss vss sky130_fd_pr__nfet_01v8_lvt ad=0.1218 pd=1.42 as=0.1218 ps=1.42 w=0.42 l=0.15
X490 a_25055_5530# f7 a_14091_4856# vdd sky130_fd_pr__pfet_01v8_lvt ad=0.261 pd=2.38 as=0.261 ps=2.38 w=0.9 l=0.35
X491 a_11519_11933# a_16702_11162# vdd vdd sky130_fd_pr__pfet_01v8 ad=0.58905 pd=3.9 as=0.58905 ps=3.9 w=3.57 l=0.15
X492 a_22733_3298# f4 vdd vdd sky130_fd_pr__pfet_01v8 ad=0.261 pd=2.38 as=0.261 ps=2.38 w=0.9 l=0.18
X493 a_8035_2120# a_8035_1520# vdd vdd sky130_fd_pr__pfet_01v8 ad=0.2108 pd=1.98 as=0.1122 ps=1.01 w=0.68 l=0.15
X494 dn rst_n a_14067_11933# vss sky130_fd_pr__nfet_01v8_lvt ad=0.403 pd=3.22 as=0.2145 ps=1.63 w=1.3 l=0.15
X495 a_3663_2190# a_5214_2048# vss sky130_fd_pr__res_high_po_0p69 l=1.5
X496 a_20171_4790# a_29784_3688# vss sky130_fd_pr__res_high_po_0p69 l=6.4
X497 a_18631_3430# a_18173_3298# a_17251_1984# vss sky130_fd_pr__nfet_01v8_lvt ad=0.145 pd=1.58 as=0.145 ps=1.58 w=0.5 l=0.15
X498 a_25471_3750# a_25013_3298# a_17251_4856# vss sky130_fd_pr__nfet_01v8_lvt ad=0.145 pd=1.58 as=0.145 ps=1.58 w=0.5 l=0.15
X499 vdd a_25471_6170# vdd vdd sky130_fd_pr__pfet_01v8 ad=0.667 pd=5.18 as=0 ps=0 w=2.3 l=0.15
X500 a_22451_8265# a_29784_8208# vss sky130_fd_pr__res_high_po_0p69 l=6.4
X501 a_6063_6255# a_5993_6105# vss vss sky130_fd_pr__nfet_01v8_lvt ad=0.13695 pd=1.16 as=0.2573 ps=2.28 w=0.83 l=0.15
X502 a_5993_6829# a_5214_6768# sky130_fd_pr__cap_mim_m3_1 l=4.2 w=4.2
X503 a_13208_205# a3 vss vss sky130_fd_pr__nfet_01v8 ad=0.1305 pd=1.48 as=0.1305 ps=1.48 w=0.45 l=0.18
X504 a_22451_6165# a_20495_6170# vss vss sky130_fd_pr__nfet_01v8_lvt ad=0.1595 pd=1.68 as=0.1595 ps=1.68 w=0.55 l=0.15
X505 vdd a_323_6880# a_3663_1590# vdd sky130_fd_pr__pfet_01v8_lvt ad=0.319 pd=2.78 as=0.1595 ps=1.39 w=1.1 l=0.35
X506 a_8035_3880# a_6063_3895# vss vss sky130_fd_pr__nfet_01v8_lvt ad=0.198 pd=1.53 as=0.372 ps=3.02 w=1.2 l=0.15
X507 a_5993_8465# a_6063_8615# vss sky130_fd_pr__res_high_po_0p35 l=9.5
X508 a_22451_9310# a_20495_10050# vdd vdd sky130_fd_pr__pfet_01v8 ad=0.667 pd=5.18 as=0.667 ps=5.18 w=2.3 l=0.15
X509 a_25055_6170# f7 a_14091_6504# vdd sky130_fd_pr__pfet_01v8_lvt ad=0.261 pd=2.38 as=0.261 ps=2.38 w=0.9 l=0.35
X510 a_323_4520# qp vdd vdd sky130_fd_pr__pfet_01v8_lvt ad=0.203 pd=1.69 as=0.406 ps=3.38 w=1.4 l=0.35
X511 a_17251_1984# a_15527_2844# vdd vdd sky130_fd_pr__pfet_01v8 ad=0.363 pd=2.53 as=0.363 ps=2.53 w=2.2 l=0.15
X512 a_20347_11933# a_6858_11170# ep vdd sky130_fd_pr__pfet_01v8_lvt ad=0.32915 pd=2.56 as=0.6583 ps=5.12 w=2.27 l=0.35
X513 a_18215_8270# a_18173_3298# a_14091_9376# vss sky130_fd_pr__nfet_01v8_lvt ad=0.145 pd=1.58 as=0.145 ps=1.58 w=0.5 l=0.15
X514 a_2903_1590# a_5214_1580# vss sky130_fd_pr__res_high_po_0p69 l=1.5
X515 a_12367_4276# a_12218_205# a_8035_6840# vdd sky130_fd_pr__pfet_01v8_lvt ad=0.3045 pd=2.39 as=0.609 ps=4.78 w=2.1 l=0.35
X516 a_8035_8600# a_15348_205# a_15527_2844# vdd sky130_fd_pr__pfet_01v8_lvt ad=0.609 pd=4.78 as=0.3045 ps=2.39 w=2.1 l=0.35
X517 vdd a_5993_6829# a_6063_6855# vdd sky130_fd_pr__pfet_01v8_lvt ad=0.4785 pd=3.88 as=0.23925 ps=1.94 w=1.65 l=0.35
X518 a_20911_10050# a_20453_1814# a_14091_9376# vdd sky130_fd_pr__pfet_01v8_lvt ad=0.261 pd=2.38 as=0.261 ps=2.38 w=0.9 l=0.35
X519 a_12367_4276# a_13181_1968# a_8035_6240# vdd sky130_fd_pr__pfet_01v8_lvt ad=0.3045 pd=2.39 as=0.609 ps=4.78 w=2.1 l=0.35
X520 vdd a_18631_1650# vdd vdd sky130_fd_pr__pfet_01v8 ad=0.667 pd=5.18 as=0 ps=0 w=2.3 l=0.15
X521 a_27011_7210# a_25055_7950# vdd vdd sky130_fd_pr__pfet_01v8 ad=0.667 pd=5.18 as=0.667 ps=5.18 w=2.3 l=0.15
X522 a_14091_1984# a_12367_2844# vss vss sky130_fd_pr__nfet_01v8_lvt ad=0.165 pd=1.33 as=0.31 ps=2.62 w=1 l=0.15
X523 a_8035_6840# a0 a_12367_4276# vss sky130_fd_pr__nfet_01v8_lvt ad=0.248 pd=2.22 as=0.132 ps=1.13 w=0.8 l=0.15
X524 a_25471_3430# a_25013_3298# a_14091_1984# vdd sky130_fd_pr__pfet_01v8_lvt ad=0.261 pd=2.38 as=0.261 ps=2.38 w=0.9 l=0.35
X525 a_16702_11162# rst_n vdd vdd sky130_fd_pr__pfet_01v8 ad=0.522 pd=4.18 as=0.522 ps=4.18 w=1.8 l=0.18
X526 a_13621_1968# a6 vss vss sky130_fd_pr__nfet_01v8 ad=0.1305 pd=1.48 as=0.1305 ps=1.48 w=0.45 l=0.18
X527 a_10451_12720# a_22449_11686# a_22479_11933# vdd sky130_fd_pr__pfet_01v8 ad=0.37455 pd=2.6 as=0.37455 ps=2.6 w=2.27 l=0.15
X528 a_26135_12811# a_26627_11933# vdd vdd sky130_fd_pr__pfet_01v8 ad=0.651 pd=4.82 as=0.3465 ps=2.43 w=2.1 l=0.15
X529 a_18215_1650# f1 a_14091_1984# vdd sky130_fd_pr__pfet_01v8_lvt ad=0.261 pd=2.38 as=0.261 ps=2.38 w=0.9 l=0.35
X530 vss a_30888_4424# ep vss sky130_fd_pr__nfet_01v8_lvt ad=0.403 pd=3.22 as=0.2145 ps=1.63 w=1.3 l=0.15
X531 vdd a_6063_2135# a_8035_2120# vdd sky130_fd_pr__pfet_01v8 ad=0.297 pd=2.13 as=0.297 ps=2.13 w=1.8 l=0.15
X532 a_22449_11686# a_21781_11939# vss vss sky130_fd_pr__nfet_01v8_lvt ad=0.1305 pd=1.48 as=0.1305 ps=1.48 w=0.45 l=0.15
X533 a_12367_7364# a6 a_8035_6840# vss sky130_fd_pr__nfet_01v8_lvt ad=0.132 pd=1.13 as=0.248 ps=2.22 w=0.8 l=0.15
X534 vdd a_15527_4276# a_17251_4856# vdd sky130_fd_pr__pfet_01v8 ad=0.363 pd=2.53 as=0.363 ps=2.53 w=2.2 l=0.15
X535 a_18631_6170# f1 a_14091_6504# vss sky130_fd_pr__nfet_01v8_lvt ad=0.145 pd=1.58 as=0.145 ps=1.58 w=0.5 l=0.15
X536 vdd a_29262_11162# a_30771_12720# vdd sky130_fd_pr__pfet_01v8 ad=0.33495 pd=2.36 as=0.33495 ps=2.36 w=2.03 l=0.15
X537 a_15527_8796# a_15901_1968# a_8035_9200# vdd sky130_fd_pr__pfet_01v8_lvt ad=0.3045 pd=2.39 as=0.609 ps=4.78 w=2.1 l=0.35
X538 a_15527_8796# a_16781_1968# a_8035_8600# vdd sky130_fd_pr__pfet_01v8_lvt ad=0.3045 pd=2.39 as=0.609 ps=4.78 w=2.1 l=0.35
X539 a_20495_8270# f2 a_17251_9376# vss sky130_fd_pr__nfet_01v8_lvt ad=0.145 pd=1.58 as=0.145 ps=1.58 w=0.5 l=0.15
X540 a_20495_10050# f3 a_14091_9376# vdd sky130_fd_pr__pfet_01v8_lvt ad=0.261 pd=2.38 as=0.261 ps=2.38 w=0.9 l=0.35
X541 vss a_12367_8796# a_14091_9376# vss sky130_fd_pr__nfet_01v8_lvt ad=0.31 pd=2.62 as=0.165 ps=1.33 w=1 l=0.15
X542 a_8035_4480# b7 a_15527_4276# vss sky130_fd_pr__nfet_01v8_lvt ad=0.248 pd=2.22 as=0.132 ps=1.13 w=0.8 l=0.15
X543 a_2903_6910# a_323_4520# vss vss sky130_fd_pr__nfet_01v8_lvt ad=0.319 pd=2.78 as=0.319 ps=2.78 w=1.1 l=0.15
X544 a_22451_4790# a_20495_5530# vss vss sky130_fd_pr__nfet_01v8_lvt ad=0.1595 pd=1.68 as=0.1595 ps=1.68 w=0.55 l=0.15
X545 a_20911_8270# a_20453_3298# a_17251_9376# vss sky130_fd_pr__nfet_01v8_lvt ad=0.145 pd=1.58 as=0.145 ps=1.58 w=0.5 l=0.15
X546 vdd a_15527_7364# a_17251_6504# vdd sky130_fd_pr__pfet_01v8 ad=0.682 pd=5.02 as=0.363 ps=2.53 w=2.2 l=0.15
X547 a_20495_1650# a_20453_1814# a_17251_1984# vdd sky130_fd_pr__pfet_01v8_lvt ad=0.261 pd=2.38 as=0.261 ps=2.38 w=0.9 l=0.35
X548 a_23191_3430# f4 a_14091_1984# vss sky130_fd_pr__nfet_01v8_lvt ad=0.145 pd=1.58 as=0.145 ps=1.58 w=0.5 l=0.15
X549 a_6063_9215# a_5993_9189# vdd vdd sky130_fd_pr__pfet_01v8_lvt ad=0.23925 pd=1.94 as=0.4785 ps=3.88 w=1.65 l=0.35
X550 dn a_30722_6944# vdd vdd sky130_fd_pr__pfet_01v8_lvt ad=0.377 pd=2.89 as=0.377 ps=2.89 w=2.6 l=0.35
X551 a_22733_3298# f4 vss vss sky130_fd_pr__nfet_01v8 ad=0.1305 pd=1.48 as=0.1305 ps=1.48 w=0.45 l=0.18
X552 a_12367_2844# a_12741_1968# a_8035_2120# vdd sky130_fd_pr__pfet_01v8_lvt ad=0.3045 pd=2.39 as=0.609 ps=4.78 w=2.1 l=0.35
X553 a_27011_2690# a_25055_3430# vss vss sky130_fd_pr__nfet_01v8_lvt ad=0.1595 pd=1.68 as=0.1595 ps=1.68 w=0.55 l=0.15
X554 a_8035_1520# a_6063_1535# vdd vdd sky130_fd_pr__pfet_01v8 ad=0.297 pd=2.13 as=0.297 ps=2.13 w=1.8 l=0.15
X555 a_20171_1645# a_29784_1816# vss sky130_fd_pr__res_high_po_0p69 l=6.4
X556 vdd a_323_4520# a_3663_6910# vdd sky130_fd_pr__pfet_01v8_lvt ad=0.319 pd=2.78 as=0.1595 ps=1.39 w=1.1 l=0.35
X557 a_20911_1650# f3 a_17251_1984# vdd sky130_fd_pr__pfet_01v8_lvt ad=0.261 pd=2.38 as=0.261 ps=2.38 w=0.9 l=0.35
X558 a_22775_8270# a_22733_3298# a_17251_9376# vdd sky130_fd_pr__pfet_01v8_lvt ad=0.261 pd=2.38 as=0.261 ps=2.38 w=0.9 l=0.35
X559 ckd3 ckd1 vss vss sky130_fd_pr__nfet_01v8_lvt ad=0.1305 pd=1.48 as=0.1305 ps=1.48 w=0.45 l=0.15
X560 a_8701_12720# a_9221_11939# a_16702_11162# vdd sky130_fd_pr__pfet_01v8 ad=0.7037 pd=5.16 as=0.37455 ps=2.6 w=2.27 l=0.15
X561 a_18631_10050# a_18173_1814# a_17251_9376# vss sky130_fd_pr__nfet_01v8_lvt ad=0.145 pd=1.58 as=0.145 ps=1.58 w=0.5 l=0.15
X562 vss a_23191_6170# vss vss sky130_fd_pr__nfet_01v8_lvt ad=0.1595 pd=1.68 as=0 ps=0 w=0.55 l=0.15
X563 vdd a_323_2160# a_2903_4550# vdd sky130_fd_pr__pfet_01v8_lvt ad=0.1595 pd=1.39 as=0.1595 ps=1.39 w=1.1 l=0.35
X564 ckd1 a_9827_11933# vss vss sky130_fd_pr__nfet_01v8_lvt ad=0.198 pd=1.53 as=0.372 ps=3.02 w=1.2 l=0.15
X565 a_10422_11162# rst_n vdd vdd sky130_fd_pr__pfet_01v8 ad=0.522 pd=4.18 as=0.522 ps=4.18 w=1.8 l=0.18
X566 vdd a_23191_10050# vdd vdd sky130_fd_pr__pfet_01v8 ad=0.667 pd=5.18 as=0 ps=0 w=2.3 l=0.15
X567 a_20911_7950# f2 a_14091_6504# vss sky130_fd_pr__nfet_01v8_lvt ad=0.145 pd=1.58 as=0.145 ps=1.58 w=0.5 l=0.15
X568 a_3663_9270# a_5214_9128# vss sky130_fd_pr__res_high_po_0p69 l=1.5
X569 a_8035_9200# a_8035_8600# vdd vdd sky130_fd_pr__pfet_01v8 ad=0.2108 pd=1.98 as=0.1122 ps=1.01 w=0.68 l=0.15
X570 a_8035_6240# a_8035_6840# vss vss sky130_fd_pr__nfet_01v8_lvt ad=0.1305 pd=1.48 as=0.1305 ps=1.48 w=0.45 l=0.15
X571 a_8035_6240# a2 a_12367_7364# vss sky130_fd_pr__nfet_01v8_lvt ad=0.248 pd=2.22 as=0.132 ps=1.13 w=0.8 l=0.15
X572 a_8035_1520# a6 a_12367_2844# vss sky130_fd_pr__nfet_01v8_lvt ad=0.248 pd=2.22 as=0.132 ps=1.13 w=0.8 l=0.15
X573 a_23021_12720# a_24771_12720# vdd vdd sky130_fd_pr__pfet_01v8 ad=0.5104 pd=4.1 as=0.5104 ps=4.1 w=1.76 l=0.15
X574 a_18631_5530# f1 a_14091_4856# vss sky130_fd_pr__nfet_01v8_lvt ad=0.145 pd=1.58 as=0.145 ps=1.58 w=0.5 l=0.15
X575 a_8709_11950# a_7787_11933# vdd vdd sky130_fd_pr__pfet_01v8 ad=0.3465 pd=2.43 as=0.651 ps=4.82 w=2.1 l=0.15
X576 vss a_8709_11950# a_9221_11939# vss sky130_fd_pr__nfet_01v8_lvt ad=0.3255 pd=2.72 as=0.17325 ps=1.38 w=1.05 l=0.15
X577 vdd a_323_2160# a_3663_8670# vdd sky130_fd_pr__pfet_01v8_lvt ad=0.319 pd=2.78 as=0.1595 ps=1.39 w=1.1 l=0.35
X578 a_22775_3430# a_22733_3298# a_14091_1984# vss sky130_fd_pr__nfet_01v8_lvt ad=0.145 pd=1.58 as=0.145 ps=1.58 w=0.5 l=0.15
X579 a_29021_12720# a_28759_11933# vdd vdd sky130_fd_pr__pfet_01v8 ad=0.6293 pd=4.68 as=0.33495 ps=2.36 w=2.03 l=0.15
X580 a_23191_8270# a_22733_3298# a_17251_9376# vss sky130_fd_pr__nfet_01v8_lvt ad=0.145 pd=1.58 as=0.145 ps=1.58 w=0.5 l=0.15
X581 a_27011_8265# a_29784_8208# vss sky130_fd_pr__res_high_po_0p69 l=6.4
X582 a_12367_4276# a2 a_8035_1520# vss sky130_fd_pr__nfet_01v8_lvt ad=0.132 pd=1.13 as=0.248 ps=2.22 w=0.8 l=0.15
X583 a_15018_205# b0 vdd vdd sky130_fd_pr__pfet_01v8 ad=0.261 pd=2.38 as=0.261 ps=2.38 w=0.9 l=0.18
X584 a_14091_4856# a_12367_4276# vdd vdd sky130_fd_pr__pfet_01v8 ad=0.363 pd=2.53 as=0.682 ps=5.02 w=2.2 l=0.15
X585 a_9221_11939# a_8709_11950# vdd vdd sky130_fd_pr__pfet_01v8 ad=0.36465 pd=2.54 as=0.6851 ps=5.04 w=2.21 l=0.15
X586 a_6063_6855# a_5993_6829# vdd vdd sky130_fd_pr__pfet_01v8_lvt ad=0.23925 pd=1.94 as=0.4785 ps=3.88 w=1.65 l=0.35
X587 vss a_18631_8270# vss vss sky130_fd_pr__nfet_01v8_lvt ad=0.1595 pd=1.68 as=0 ps=0 w=0.55 l=0.15
X588 a_8035_6840# a_13181_1968# a_12367_2844# vdd sky130_fd_pr__pfet_01v8_lvt ad=0.609 pd=4.78 as=0.3045 ps=2.39 w=2.1 l=0.35
X589 a_7787_11933# rst_n dp vss sky130_fd_pr__nfet_01v8_lvt ad=0.2145 pd=1.63 as=0.403 ps=3.22 w=1.3 l=0.15
X590 a_23191_1650# f5 a_17251_1984# vdd sky130_fd_pr__pfet_01v8_lvt ad=0.261 pd=2.38 as=0.261 ps=2.38 w=0.9 l=0.35
X591 a_20495_7950# a_20453_3298# a_14091_6504# vss sky130_fd_pr__nfet_01v8_lvt ad=0.145 pd=1.58 as=0.145 ps=1.58 w=0.5 l=0.15
X592 a_25055_8270# a_25013_3298# a_17251_9376# vdd sky130_fd_pr__pfet_01v8_lvt ad=0.261 pd=2.38 as=0.261 ps=2.38 w=0.9 l=0.35
X593 a_24731_7210# a_22775_7950# vdd vdd sky130_fd_pr__pfet_01v8 ad=0.667 pd=5.18 as=0.667 ps=5.18 w=2.3 l=0.15
X594 dp a_30888_8944# vdd vdd sky130_fd_pr__pfet_01v8_lvt ad=0.377 pd=2.89 as=0.377 ps=2.89 w=2.6 l=0.35
X595 vdd a_6063_9215# a_8035_9200# vdd sky130_fd_pr__pfet_01v8 ad=0.297 pd=2.13 as=0.297 ps=2.13 w=1.8 l=0.15
X596 a_23191_7950# a_22733_3298# a_14091_6504# vdd sky130_fd_pr__pfet_01v8_lvt ad=0.261 pd=2.38 as=0.261 ps=2.38 w=0.9 l=0.35
X597 a_9919_11933# a_10422_11162# vdd vdd sky130_fd_pr__pfet_01v8 ad=0.1218 pd=1.42 as=0.1218 ps=1.42 w=0.42 l=0.28
X598 vdd a_15527_8796# a_17251_9376# vdd sky130_fd_pr__pfet_01v8 ad=0.682 pd=5.02 as=0.363 ps=2.53 w=2.2 l=0.15
X599 a_14091_6504# a_12367_7364# vdd vdd sky130_fd_pr__pfet_01v8 ad=0.363 pd=2.53 as=0.363 ps=2.53 w=2.2 l=0.15
X600 vss a_23191_5530# vss vss sky130_fd_pr__nfet_01v8_lvt ad=0.1595 pd=1.68 as=0 ps=0 w=0.55 l=0.15
X601 vdd a_30722_4424# a_30722_2424# vdd sky130_fd_pr__pfet_01v8_lvt ad=0.23925 pd=1.94 as=0.23925 ps=1.94 w=1.65 l=0.35
X602 a_15901_1968# b3 vdd vdd sky130_fd_pr__pfet_01v8 ad=0.261 pd=2.38 as=0.261 ps=2.38 w=0.9 l=0.18
X603 vdd a_9919_11933# a_8701_12720# vdd sky130_fd_pr__pfet_01v8 ad=0.58905 pd=3.9 as=0.58905 ps=3.9 w=3.57 l=0.15
X604 a_25471_8270# f6 a_17251_9376# vdd sky130_fd_pr__pfet_01v8_lvt ad=0.261 pd=2.38 as=0.261 ps=2.38 w=0.9 l=0.35
X605 a_8035_4480# b3 a_15527_2844# vss sky130_fd_pr__nfet_01v8_lvt ad=0.248 pd=2.22 as=0.132 ps=1.13 w=0.8 l=0.15
X606 a_8035_1520# a_6063_1535# vss vss sky130_fd_pr__nfet_01v8_lvt ad=0.198 pd=1.53 as=0.372 ps=3.02 w=1.2 l=0.15
X607 a_18215_1650# f1 a_17251_1984# vss sky130_fd_pr__nfet_01v8_lvt ad=0.145 pd=1.58 as=0.145 ps=1.58 w=0.5 l=0.15
X608 cke3 a_30771_12720# vss vss sky130_fd_pr__nfet_01v8_lvt ad=0.198 pd=1.53 as=0.372 ps=3.02 w=1.2 l=0.15
X609 a_323_2160# ip vdd vdd sky130_fd_pr__pfet_01v8_lvt ad=0.203 pd=1.69 as=0.406 ps=3.38 w=1.4 l=0.35
X610 a_5993_1385# a_5214_1580# sky130_fd_pr__cap_mim_m3_1 l=4.2 w=4.2
X611 a_18215_3430# f0 a_14091_1984# vdd sky130_fd_pr__pfet_01v8_lvt ad=0.261 pd=2.38 as=0.261 ps=2.38 w=0.9 l=0.35
X612 a_25055_3430# a_25013_3298# a_14091_1984# vss sky130_fd_pr__nfet_01v8_lvt ad=0.145 pd=1.58 as=0.145 ps=1.58 w=0.5 l=0.15
X613 a_18215_3750# a_18173_3298# a_17251_4856# vdd sky130_fd_pr__pfet_01v8_lvt ad=0.261 pd=2.38 as=0.261 ps=2.38 w=0.9 l=0.35
X614 a_26627_11933# a_6858_11170# en vdd sky130_fd_pr__pfet_01v8_lvt ad=0.32915 pd=2.56 as=0.6583 ps=5.12 w=2.27 l=0.35
X615 a_27011_9310# a_25055_10050# vss vss sky130_fd_pr__nfet_01v8_lvt ad=0.1595 pd=1.68 as=0.1595 ps=1.68 w=0.55 l=0.15
X616 a_24771_12720# a_23021_12720# vss vss sky130_fd_pr__nfet_01v8_lvt ad=0.1218 pd=1.42 as=0.1218 ps=1.42 w=0.42 l=0.15
X617 a_22451_9310# a_20495_10050# vss vss sky130_fd_pr__nfet_01v8_lvt ad=0.1595 pd=1.68 as=0.1595 ps=1.68 w=0.55 l=0.15
X618 a_30888_8944# a_30888_6944# vss vss sky130_fd_pr__nfet_01v8_lvt ad=0.4785 pd=3.88 as=0.4785 ps=3.88 w=1.65 l=0.15
X619 vss a_5993_4469# a_6063_4495# vss sky130_fd_pr__nfet_01v8_lvt ad=0.2573 pd=2.28 as=0.13695 ps=1.16 w=0.83 l=0.15
X620 vdd a_5993_4469# a_6063_4495# vdd sky130_fd_pr__pfet_01v8_lvt ad=0.4785 pd=3.88 as=0.23925 ps=1.94 w=1.65 l=0.35
X621 vdd a_12367_2844# a_14091_1984# vdd sky130_fd_pr__pfet_01v8 ad=0.682 pd=5.02 as=0.363 ps=2.53 w=2.2 l=0.15
X622 a_16998_205# b6 vdd vdd sky130_fd_pr__pfet_01v8 ad=0.261 pd=2.38 as=0.261 ps=2.38 w=0.9 l=0.18
X623 a_18631_3750# f0 a_17251_4856# vdd sky130_fd_pr__pfet_01v8_lvt ad=0.261 pd=2.38 as=0.261 ps=2.38 w=0.9 l=0.35
X624 a_11519_11933# a_21781_11939# a_28759_11933# vdd sky130_fd_pr__pfet_01v8 ad=0.37455 pd=2.6 as=0.37455 ps=2.6 w=2.27 l=0.15
X625 a_18631_10050# a_18173_1814# a_14091_9376# vdd sky130_fd_pr__pfet_01v8_lvt ad=0.261 pd=2.38 as=0.261 ps=2.38 w=0.9 l=0.35
X626 a_22775_6170# f5 a_17251_6504# vss sky130_fd_pr__nfet_01v8_lvt ad=0.145 pd=1.58 as=0.145 ps=1.58 w=0.5 l=0.15
X627 a_8035_8600# a_6063_8615# vdd vdd sky130_fd_pr__pfet_01v8 ad=0.297 pd=2.13 as=0.297 ps=2.13 w=1.8 l=0.15
X628 a_22775_7950# f4 a_14091_6504# vdd sky130_fd_pr__pfet_01v8_lvt ad=0.261 pd=2.38 as=0.261 ps=2.38 w=0.9 l=0.35
X629 a_6063_2135# a_5993_2109# vss sky130_fd_pr__res_high_po_0p35 l=9.5
X630 en a_30722_2424# vss vss sky130_fd_pr__nfet_01v8_lvt ad=0.2145 pd=1.63 as=0.403 ps=3.22 w=1.3 l=0.15
X631 a_24731_2690# a_22775_3430# vss vss sky130_fd_pr__nfet_01v8_lvt ad=0.1595 pd=1.68 as=0.1595 ps=1.68 w=0.55 l=0.15
X632 a_18173_3298# f0 vdd vdd sky130_fd_pr__pfet_01v8 ad=0.261 pd=2.38 as=0.261 ps=2.38 w=0.9 l=0.18
X633 cke0 a_23021_12720# vdd vdd sky130_fd_pr__pfet_01v8 ad=0.4158 pd=2.85 as=0.7812 ps=5.66 w=2.52 l=0.15
X634 vdd a_6063_6855# a_8035_6840# vdd sky130_fd_pr__pfet_01v8 ad=0.297 pd=2.13 as=0.297 ps=2.13 w=1.8 l=0.15
X635 a_20495_3430# a_20453_3298# a_17251_1984# vdd sky130_fd_pr__pfet_01v8_lvt ad=0.261 pd=2.38 as=0.261 ps=2.38 w=0.9 l=0.35
X636 a_21269_11950# a_26135_12811# vdd vdd sky130_fd_pr__pfet_01v8 ad=0.5481 pd=4.36 as=0.5481 ps=4.36 w=1.89 l=0.15
X637 a_15018_205# b0 vss vss sky130_fd_pr__nfet_01v8 ad=0.1305 pd=1.48 as=0.1305 ps=1.48 w=0.45 l=0.18
X638 a_2903_4550# a_323_2160# vss vss sky130_fd_pr__nfet_01v8_lvt ad=0.319 pd=2.78 as=0.319 ps=2.78 w=1.1 l=0.15
X639 a_20911_3430# f2 a_17251_1984# vdd sky130_fd_pr__pfet_01v8_lvt ad=0.261 pd=2.38 as=0.261 ps=2.38 w=0.9 l=0.35
X640 a_22451_7210# a_20495_7950# vss vss sky130_fd_pr__nfet_01v8_lvt ad=0.1595 pd=1.68 as=0.1595 ps=1.68 w=0.55 l=0.15
X641 vss a_5993_2109# a_6063_2135# vss sky130_fd_pr__nfet_01v8_lvt ad=0.2573 pd=2.28 as=0.13695 ps=1.16 w=0.83 l=0.15
X642 vdd a_25471_7950# vdd vdd sky130_fd_pr__pfet_01v8 ad=0.667 pd=5.18 as=0 ps=0 w=2.3 l=0.15
X643 a_22775_10050# f5 a_17251_9376# vss sky130_fd_pr__nfet_01v8_lvt ad=0.145 pd=1.58 as=0.145 ps=1.58 w=0.5 l=0.15
X644 a_14091_9376# a_12367_8796# vdd vdd sky130_fd_pr__pfet_01v8 ad=0.363 pd=2.53 as=0.363 ps=2.53 w=2.2 l=0.15
X645 a_8035_6840# a_12218_205# a_12367_4276# vdd sky130_fd_pr__pfet_01v8_lvt ad=0.609 pd=4.78 as=0.3045 ps=2.39 w=2.1 l=0.35
X646 a_27011_4790# a_25055_5530# vdd vdd sky130_fd_pr__pfet_01v8 ad=0.667 pd=5.18 as=0.667 ps=5.18 w=2.3 l=0.15
X647 a_22479_11933# a_22449_11686# a_10451_12720# vdd sky130_fd_pr__pfet_01v8 ad=0.7037 pd=5.16 as=0.37455 ps=2.6 w=2.27 l=0.15
X648 vss a_20911_10050# vss vss sky130_fd_pr__nfet_01v8_lvt ad=0.1595 pd=1.68 as=0 ps=0 w=0.55 l=0.15
X649 a_25055_6170# f7 a_17251_6504# vss sky130_fd_pr__nfet_01v8_lvt ad=0.145 pd=1.58 as=0.145 ps=1.58 w=0.5 l=0.15
X650 vdd a_323_4520# a_3663_4550# vdd sky130_fd_pr__pfet_01v8_lvt ad=0.319 pd=2.78 as=0.1595 ps=1.39 w=1.1 l=0.35
X651 a_15901_1968# b3 vss vss sky130_fd_pr__nfet_01v8 ad=0.1305 pd=1.48 as=0.1305 ps=1.48 w=0.45 l=0.18
X652 vdd a_6063_1535# a_8035_1520# vdd sky130_fd_pr__pfet_01v8 ad=0.558 pd=4.22 as=0.297 ps=2.13 w=1.8 l=0.15
X653 ep a_6858_11170# a_20347_11933# vdd sky130_fd_pr__pfet_01v8_lvt ad=0.32915 pd=2.56 as=0.32915 ps=2.56 w=2.27 l=0.35
X654 a_25055_7950# f6 a_14091_6504# vdd sky130_fd_pr__pfet_01v8_lvt ad=0.261 pd=2.38 as=0.261 ps=2.38 w=0.9 l=0.35
X655 a_22775_5530# f5 a_17251_4856# vss sky130_fd_pr__nfet_01v8_lvt ad=0.145 pd=1.58 as=0.145 ps=1.58 w=0.5 l=0.15
X656 a_22775_10050# a_22733_1814# a_14091_9376# vss sky130_fd_pr__nfet_01v8_lvt ad=0.145 pd=1.58 as=0.145 ps=1.58 w=0.5 l=0.15
X657 vdd a_323_2160# a_2903_2190# vdd sky130_fd_pr__pfet_01v8_lvt ad=0.1595 pd=1.39 as=0.1595 ps=1.39 w=1.1 l=0.35
X658 a_8035_6840# a_8035_6240# vdd vdd sky130_fd_pr__pfet_01v8 ad=0.2108 pd=1.98 as=0.1122 ps=1.01 w=0.68 l=0.15
X659 a_25471_6170# a_25013_1814# a_17251_6504# vss sky130_fd_pr__nfet_01v8_lvt ad=0.145 pd=1.58 as=0.145 ps=1.58 w=0.5 l=0.15
X660 a_8035_3880# a_8035_4480# vss vss sky130_fd_pr__nfet_01v8_lvt ad=0.1305 pd=1.48 as=0.1305 ps=1.48 w=0.45 l=0.15
X661 a_15527_2844# b5 a_8035_9200# vss sky130_fd_pr__nfet_01v8_lvt ad=0.132 pd=1.13 as=0.248 ps=2.22 w=0.8 l=0.15
X662 a_8709_11950# a_7787_11933# vss vss sky130_fd_pr__nfet_01v8_lvt ad=0.435 pd=3.58 as=0.435 ps=3.58 w=1.5 l=0.15
X663 a_15527_7364# b1 a_8035_3880# vss sky130_fd_pr__nfet_01v8_lvt ad=0.132 pd=1.13 as=0.248 ps=2.22 w=0.8 l=0.15
X664 a_30771_12720# a_29262_11162# vdd vdd sky130_fd_pr__pfet_01v8 ad=0.6293 pd=4.68 as=0.33495 ps=2.36 w=2.03 l=0.15
X665 a_16998_205# b6 vss vss sky130_fd_pr__nfet_01v8 ad=0.1305 pd=1.48 as=0.1305 ps=1.48 w=0.45 l=0.18
X666 a_18631_7950# f0 a_14091_6504# vss sky130_fd_pr__nfet_01v8_lvt ad=0.145 pd=1.58 as=0.145 ps=1.58 w=0.5 l=0.15
X667 a_8035_8600# a_6063_8615# vss vss sky130_fd_pr__nfet_01v8_lvt ad=0.198 pd=1.53 as=0.372 ps=3.02 w=1.2 l=0.15
X668 a_23191_3430# f4 a_17251_1984# vdd sky130_fd_pr__pfet_01v8_lvt ad=0.261 pd=2.38 as=0.261 ps=2.38 w=0.9 l=0.35
X669 a_21781_11939# a_22449_11686# vdd vdd sky130_fd_pr__pfet_01v8 ad=0.5481 pd=4.36 as=0.5481 ps=4.36 w=1.89 l=0.15
X670 a_323_9240# qn vdd vdd sky130_fd_pr__pfet_01v8_lvt ad=0.203 pd=1.69 as=0.406 ps=3.38 w=1.4 l=0.35
X671 a_8035_4480# a_16781_1968# a_15527_4276# vdd sky130_fd_pr__pfet_01v8_lvt ad=0.609 pd=4.78 as=0.3045 ps=2.39 w=2.1 l=0.35
X672 a_2903_6310# a_5214_6300# vss sky130_fd_pr__res_high_po_0p69 l=1.5
X673 vss a_25471_3430# vss vss sky130_fd_pr__nfet_01v8_lvt ad=0.1595 pd=1.68 as=0 ps=0 w=0.55 l=0.15
X674 a_6063_4495# a_5993_4469# vdd vdd sky130_fd_pr__pfet_01v8_lvt ad=0.23925 pd=1.94 as=0.4785 ps=3.88 w=1.65 l=0.35
X675 a_18173_3298# f0 vss vss sky130_fd_pr__nfet_01v8 ad=0.1305 pd=1.48 as=0.1305 ps=1.48 w=0.45 l=0.18
X676 a_9889_11686# a_9221_11939# vss vss sky130_fd_pr__nfet_01v8_lvt ad=0.1305 pd=1.48 as=0.1305 ps=1.48 w=0.45 l=0.15
X677 vdd a_8701_12720# ckd0 vdd sky130_fd_pr__pfet_01v8 ad=0.7812 pd=5.66 as=0.4158 ps=2.85 w=2.52 l=0.15
X678 a_9827_11933# a_22449_11686# a_29262_11162# vss sky130_fd_pr__nfet_01v8_lvt ad=0.231 pd=1.73 as=0.434 ps=3.42 w=1.4 l=0.15
X679 a_6063_1535# a_5993_1385# vss sky130_fd_pr__res_high_po_0p35 l=9.5
X680 a_24771_12720# a_23021_12720# vdd vdd sky130_fd_pr__pfet_01v8 ad=0.5104 pd=4.1 as=0.5104 ps=4.1 w=1.76 l=0.15
X681 a_25055_5530# f7 a_17251_4856# vss sky130_fd_pr__nfet_01v8_lvt ad=0.145 pd=1.58 as=0.145 ps=1.58 w=0.5 l=0.15
X682 a_8035_2120# a_12741_1968# a_12367_2844# vdd sky130_fd_pr__pfet_01v8_lvt ad=0.609 pd=4.78 as=0.3045 ps=2.39 w=2.1 l=0.35
X683 a_18215_5530# a_18173_1814# a_17251_4856# vdd sky130_fd_pr__pfet_01v8_lvt ad=0.261 pd=2.38 as=0.261 ps=2.38 w=0.9 l=0.35
X684 vdd a_10422_11162# a_10451_12720# vdd sky130_fd_pr__pfet_01v8 ad=0.58905 pd=3.9 as=0.58905 ps=3.9 w=3.57 l=0.15
X685 a_8035_3880# b5 a_15527_8796# vss sky130_fd_pr__nfet_01v8_lvt ad=0.248 pd=2.22 as=0.132 ps=1.13 w=0.8 l=0.15
X686 a_3663_2190# a_323_2160# vss vss sky130_fd_pr__nfet_01v8_lvt ad=0.319 pd=2.78 as=0.319 ps=2.78 w=1.1 l=0.15
X687 a_5993_2109# a_5214_2048# sky130_fd_pr__cap_mim_m3_1 l=4.2 w=4.2
X688 a_9221_11939# a_9889_11686# vdd vdd sky130_fd_pr__pfet_01v8 ad=0.5481 pd=4.36 as=0.5481 ps=4.36 w=1.89 l=0.15
X689 vss a_9827_11933# ckd1 vss sky130_fd_pr__nfet_01v8_lvt ad=0.372 pd=3.02 as=0.198 ps=1.53 w=1.2 l=0.15
X690 a_16199_11933# a_16702_11162# vdd vdd sky130_fd_pr__pfet_01v8 ad=0.1218 pd=1.42 as=0.1218 ps=1.42 w=0.42 l=0.28
X691 a_16199_11933# a_9889_11686# a_10451_12720# vss sky130_fd_pr__nfet_01v8_lvt ad=0.231 pd=1.73 as=0.434 ps=3.42 w=1.4 l=0.15
X692 a_30888_6944# a_29784_6336# sky130_fd_pr__cap_mim_m3_1 l=3.7 w=3.7
X693 vdd a_16199_11933# a_9827_11933# vdd sky130_fd_pr__pfet_01v8 ad=0.58905 pd=3.9 as=0.58905 ps=3.9 w=3.57 l=0.15
X694 vss a_23191_7950# vss vss sky130_fd_pr__nfet_01v8_lvt ad=0.1595 pd=1.68 as=0 ps=0 w=0.55 l=0.15
X695 a_15527_7364# a_16341_1968# a_8035_4480# vdd sky130_fd_pr__pfet_01v8_lvt ad=0.3045 pd=2.39 as=0.609 ps=4.78 w=2.1 l=0.35
X696 vdd a_30722_6944# dn vdd sky130_fd_pr__pfet_01v8_lvt ad=0.754 pd=5.78 as=0.377 ps=2.89 w=2.6 l=0.35
X697 a_25471_5530# a_25013_1814# a_17251_4856# vss sky130_fd_pr__nfet_01v8_lvt ad=0.145 pd=1.58 as=0.145 ps=1.58 w=0.5 l=0.15
X698 a_8035_4480# a_8035_3880# vdd vdd sky130_fd_pr__pfet_01v8 ad=0.2108 pd=1.98 as=0.1122 ps=1.01 w=0.68 l=0.15
X699 a_18631_5530# f1 a_17251_4856# vdd sky130_fd_pr__pfet_01v8_lvt ad=0.261 pd=2.38 as=0.261 ps=2.38 w=0.9 l=0.35
X700 a_9919_11933# a_10422_11162# vss vss sky130_fd_pr__nfet_01v8 ad=0.1218 pd=1.42 as=0.1218 ps=1.42 w=0.42 l=0.28
X701 a_8035_1520# a_8035_2120# vss vss sky130_fd_pr__nfet_01v8_lvt ad=0.1305 pd=1.48 as=0.1305 ps=1.48 w=0.45 l=0.15
X702 vdd a_11855_12811# a_9889_11686# vdd sky130_fd_pr__pfet_01v8 ad=0.6851 pd=5.04 as=0.36465 ps=2.54 w=2.21 l=0.15
X703 a_20171_2690# a_29784_1816# vss sky130_fd_pr__res_high_po_0p69 l=6.4
X704 a_8035_8600# b1 a_15527_2844# vss sky130_fd_pr__nfet_01v8_lvt ad=0.248 pd=2.22 as=0.132 ps=1.13 w=0.8 l=0.15
X705 vdd a_7787_11933# a_8709_11950# vdd sky130_fd_pr__pfet_01v8 ad=0.3465 pd=2.43 as=0.3465 ps=2.43 w=2.1 l=0.15
X706 a_22775_10050# a_22733_1814# a_17251_9376# vdd sky130_fd_pr__pfet_01v8_lvt ad=0.261 pd=2.38 as=0.261 ps=2.38 w=0.9 l=0.35
X707 a_18215_6170# a_18173_1814# a_17251_6504# vdd sky130_fd_pr__pfet_01v8_lvt ad=0.261 pd=2.38 as=0.261 ps=2.38 w=0.9 l=0.35
X708 ckd0 ckd2 vss vss sky130_fd_pr__nfet_01v8_lvt ad=0.1305 pd=1.48 as=0.1305 ps=1.48 w=0.45 l=0.15
X709 a_8035_6240# a_6063_6255# vss vss sky130_fd_pr__nfet_01v8_lvt ad=0.198 pd=1.53 as=0.372 ps=3.02 w=1.2 l=0.15
X710 a_323_6880# in vdd vdd sky130_fd_pr__pfet_01v8_lvt ad=0.203 pd=1.69 as=0.406 ps=3.38 w=1.4 l=0.35
X711 vdd a_26135_12811# a_22449_11686# vdd sky130_fd_pr__pfet_01v8 ad=0.36465 pd=2.54 as=0.36465 ps=2.54 w=2.21 l=0.15
X712 vss a_5993_9189# a_6063_9215# vss sky130_fd_pr__nfet_01v8_lvt ad=0.2573 pd=2.28 as=0.13695 ps=1.16 w=0.83 l=0.15
X713 a_18631_6170# f1 a_17251_6504# vdd sky130_fd_pr__pfet_01v8_lvt ad=0.261 pd=2.38 as=0.261 ps=2.38 w=0.9 l=0.35
X714 a_16781_1968# b7 vdd vdd sky130_fd_pr__pfet_01v8 ad=0.261 pd=2.38 as=0.261 ps=2.38 w=0.9 l=0.18
X715 dp rst_n a_7787_11933# vss sky130_fd_pr__nfet_01v8_lvt ad=0.403 pd=3.22 as=0.2145 ps=1.63 w=1.3 l=0.15
X716 a_25055_10050# f7 a_17251_9376# vss sky130_fd_pr__nfet_01v8_lvt ad=0.145 pd=1.58 as=0.145 ps=1.58 w=0.5 l=0.15
X717 a_8035_6240# a_6063_6255# vdd vdd sky130_fd_pr__pfet_01v8 ad=0.297 pd=2.13 as=0.297 ps=2.13 w=1.8 l=0.15
X718 vdd a_6063_8615# a_8035_8600# vdd sky130_fd_pr__pfet_01v8 ad=0.558 pd=4.22 as=0.297 ps=2.13 w=1.8 l=0.15
X719 a_24731_8265# a_29784_8208# vss sky130_fd_pr__res_high_po_0p69 l=6.4
X720 a_30888_4424# a_30888_2424# vss sky130_fd_pr__res_high_po_0p35 l=8
X721 a_6063_6855# a_5993_6829# vss sky130_fd_pr__res_high_po_0p35 l=9.5
X722 a_9827_11933# a_9221_11939# a_9919_11933# vss sky130_fd_pr__nfet_01v8_lvt ad=0.434 pd=3.42 as=0.231 ps=1.73 w=1.4 l=0.15
X723 a_25055_10050# a_25013_1814# a_14091_9376# vss sky130_fd_pr__nfet_01v8_lvt ad=0.145 pd=1.58 as=0.145 ps=1.58 w=0.5 l=0.15
X724 vdd a_323_4520# a_2903_9270# vdd sky130_fd_pr__pfet_01v8_lvt ad=0.1595 pd=1.39 as=0.1595 ps=1.39 w=1.1 l=0.35
X725 vdd a_6063_4495# a_8035_4480# vdd sky130_fd_pr__pfet_01v8 ad=0.297 pd=2.13 as=0.297 ps=2.13 w=1.8 l=0.15
X726 a_24731_4790# a_22775_5530# vdd vdd sky130_fd_pr__pfet_01v8 ad=0.667 pd=5.18 as=0.667 ps=5.18 w=2.3 l=0.15
X727 a_8701_12720# a_9919_11933# vdd vdd sky130_fd_pr__pfet_01v8 ad=0.58905 pd=3.9 as=0.58905 ps=3.9 w=3.57 l=0.15
X728 a_30888_4424# a_30888_2424# vdd vdd sky130_fd_pr__pfet_01v8_lvt ad=0.23925 pd=1.94 as=0.4785 ps=3.88 w=1.65 l=0.35
X729 a_25471_3750# f6 a_14091_4856# vss sky130_fd_pr__nfet_01v8_lvt ad=0.145 pd=1.58 as=0.145 ps=1.58 w=0.5 l=0.15
X730 a_20171_3745# a_18215_3750# vss vss sky130_fd_pr__nfet_01v8_lvt ad=0.1595 pd=1.68 as=0.1595 ps=1.68 w=0.55 l=0.15
X731 a_20171_2690# a_18215_3430# vdd vdd sky130_fd_pr__pfet_01v8 ad=0.667 pd=5.18 as=0.667 ps=5.18 w=2.3 l=0.15
X732 a_22451_3745# a_20495_3750# vdd vdd sky130_fd_pr__pfet_01v8 ad=0.667 pd=5.18 as=0.667 ps=5.18 w=2.3 l=0.15
X733 cke3 cke1 vss vss sky130_fd_pr__nfet_01v8_lvt ad=0.1305 pd=1.48 as=0.1305 ps=1.48 w=0.45 l=0.15
X734 a_30722_2424# a_30722_4424# vdd vdd sky130_fd_pr__pfet_01v8_lvt ad=0.23925 pd=1.94 as=0.23925 ps=1.94 w=1.65 l=0.35
X735 a_20911_1650# f3 a_14091_1984# vss sky130_fd_pr__nfet_01v8_lvt ad=0.145 pd=1.58 as=0.145 ps=1.58 w=0.5 l=0.15
X736 vss a_30771_12720# cke3 vss sky130_fd_pr__nfet_01v8_lvt ad=0.372 pd=3.02 as=0.198 ps=1.53 w=1.2 l=0.15
X737 a_25055_10050# a_25013_1814# a_17251_9376# vdd sky130_fd_pr__pfet_01v8_lvt ad=0.261 pd=2.38 as=0.261 ps=2.38 w=0.9 l=0.35
X738 a_20911_3750# a_20453_3298# a_14091_4856# vdd sky130_fd_pr__pfet_01v8_lvt ad=0.261 pd=2.38 as=0.261 ps=2.38 w=0.9 l=0.35
X739 a_12367_7364# a4 a_8035_2120# vss sky130_fd_pr__nfet_01v8_lvt ad=0.132 pd=1.13 as=0.248 ps=2.22 w=0.8 l=0.15
X740 a_27011_1645# a_25055_1650# vdd vdd sky130_fd_pr__pfet_01v8 ad=0.667 pd=5.18 as=0.667 ps=5.18 w=2.3 l=0.15
X741 vdd a_30888_8944# dp vdd sky130_fd_pr__pfet_01v8_lvt ad=0.754 pd=5.78 as=0.377 ps=2.89 w=2.6 l=0.35
X742 a_8035_1520# a_8035_2120# vdd vdd sky130_fd_pr__pfet_01v8 ad=0.2108 pd=1.98 as=0.1122 ps=1.01 w=0.68 l=0.15
X743 a_25471_10050# f7 a_17251_9376# vdd sky130_fd_pr__pfet_01v8_lvt ad=0.261 pd=2.38 as=0.261 ps=2.38 w=0.9 l=0.35
X744 a_15527_8796# a_16341_1968# a_8035_3880# vdd sky130_fd_pr__pfet_01v8_lvt ad=0.3045 pd=2.39 as=0.609 ps=4.78 w=2.1 l=0.35
X745 a_15527_8796# b3 a_8035_9200# vss sky130_fd_pr__nfet_01v8_lvt ad=0.132 pd=1.13 as=0.248 ps=2.22 w=0.8 l=0.15
X746 a_20171_8265# a_18215_8270# vdd vdd sky130_fd_pr__pfet_01v8 ad=0.667 pd=5.18 as=0.667 ps=5.18 w=2.3 l=0.15
X747 a_17251_6504# a_15527_7364# vss vss sky130_fd_pr__nfet_01v8_lvt ad=0.165 pd=1.33 as=0.31 ps=2.62 w=1 l=0.15
X748 vdd a_323_2160# a_3663_2190# vdd sky130_fd_pr__pfet_01v8_lvt ad=0.319 pd=2.78 as=0.1595 ps=1.39 w=1.1 l=0.35
X749 a_28759_11933# a_21781_11939# a_11519_11933# vdd sky130_fd_pr__pfet_01v8 ad=0.7037 pd=5.16 as=0.37455 ps=2.6 w=2.27 l=0.15
X750 a_8035_3880# a_6063_3895# vdd vdd sky130_fd_pr__pfet_01v8 ad=0.297 pd=2.13 as=0.297 ps=2.13 w=1.8 l=0.15
X751 a_26627_11933# rst_n vdd vdd sky130_fd_pr__pfet_01v8 ad=0.464 pd=3.78 as=0.464 ps=3.78 w=1.6 l=0.18
X752 a_22775_7950# f4 a_17251_6504# vss sky130_fd_pr__nfet_01v8_lvt ad=0.145 pd=1.58 as=0.145 ps=1.58 w=0.5 l=0.15
X753 vdd a_21269_11950# a_21781_11939# vdd sky130_fd_pr__pfet_01v8 ad=0.36465 pd=2.54 as=0.36465 ps=2.54 w=2.21 l=0.15
X754 a_3663_9270# a_323_6880# vss vss sky130_fd_pr__nfet_01v8_lvt ad=0.319 pd=2.78 as=0.319 ps=2.78 w=1.1 l=0.15
X755 a_12367_2844# a_12218_205# a_8035_6240# vdd sky130_fd_pr__pfet_01v8_lvt ad=0.3045 pd=2.39 as=0.609 ps=4.78 w=2.1 l=0.35
X756 a_18631_8270# a_18173_3298# a_17251_9376# vss sky130_fd_pr__nfet_01v8_lvt ad=0.145 pd=1.58 as=0.145 ps=1.58 w=0.5 l=0.15
X757 a_12367_2844# a_13181_1968# a_8035_6840# vdd sky130_fd_pr__pfet_01v8_lvt ad=0.3045 pd=2.39 as=0.609 ps=4.78 w=2.1 l=0.35
X758 vdd a_30888_4424# ep vdd sky130_fd_pr__pfet_01v8_lvt ad=0.377 pd=2.89 as=0.377 ps=2.89 w=2.6 l=0.35
X759 a_20495_1650# a_20453_1814# a_14091_1984# vss sky130_fd_pr__nfet_01v8_lvt ad=0.145 pd=1.58 as=0.145 ps=1.58 w=0.5 l=0.15
X760 a_20495_3750# f2 a_14091_4856# vdd sky130_fd_pr__pfet_01v8_lvt ad=0.261 pd=2.38 as=0.261 ps=2.38 w=0.9 l=0.35
X761 a_16199_11933# a_6858_11170# vss vss sky130_fd_pr__nfet_01v8 ad=0.29 pd=2.58 as=0.29 ps=2.58 w=1 l=0.18
X762 a_8035_8600# a_8035_9200# vss vss sky130_fd_pr__nfet_01v8_lvt ad=0.1305 pd=1.48 as=0.1305 ps=1.48 w=0.45 l=0.15
X763 a_17251_6504# a_15527_7364# vdd vdd sky130_fd_pr__pfet_01v8 ad=0.363 pd=2.53 as=0.682 ps=5.02 w=2.2 l=0.15
X764 vdd a_8035_1520# a_8035_2120# vdd sky130_fd_pr__pfet_01v8 ad=0.1122 pd=1.01 as=0.1122 ps=1.01 w=0.68 l=0.15
X765 a_16781_1968# b7 vss vss sky130_fd_pr__nfet_01v8 ad=0.1305 pd=1.48 as=0.1305 ps=1.48 w=0.45 l=0.18
X766 a_2903_3950# a_5214_3940# vss sky130_fd_pr__res_high_po_0p69 l=1.5
X767 a_8035_6840# a4 a_12367_2844# vss sky130_fd_pr__nfet_01v8_lvt ad=0.248 pd=2.22 as=0.132 ps=1.13 w=0.8 l=0.15
X768 a_8035_1520# a0 a_12367_7364# vss sky130_fd_pr__nfet_01v8_lvt ad=0.248 pd=2.22 as=0.132 ps=1.13 w=0.8 l=0.15
X769 a_27011_6165# a_29784_6336# vss sky130_fd_pr__res_high_po_0p69 l=6.4
X770 vdd a_30722_2424# en vdd sky130_fd_pr__pfet_01v8_lvt ad=0.377 pd=2.89 as=0.377 ps=2.89 w=2.6 l=0.35
X771 vdd a_15527_2844# a_17251_1984# vdd sky130_fd_pr__pfet_01v8 ad=0.363 pd=2.53 as=0.363 ps=2.53 w=2.2 l=0.15
X772 vdd a_25471_5530# vdd vdd sky130_fd_pr__pfet_01v8 ad=0.667 pd=5.18 as=0 ps=0 w=2.3 l=0.15
X773 a_9889_11686# a_11855_12811# vss vss sky130_fd_pr__nfet_01v8_lvt ad=0.17325 pd=1.38 as=0.3255 ps=2.72 w=1.05 l=0.15
X774 cke2 a_24771_12720# vdd vdd sky130_fd_pr__pfet_01v8 ad=0.4158 pd=2.85 as=0.7812 ps=5.66 w=2.52 l=0.15
X775 vdd a_30771_12720# cke3 vdd sky130_fd_pr__pfet_01v8 ad=0.7812 pd=5.66 as=0.4158 ps=2.85 w=2.52 l=0.15
X776 a_8701_12720# a_22449_11686# a_22982_11162# vdd sky130_fd_pr__pfet_01v8 ad=0.37455 pd=2.6 as=0.7037 ps=5.16 w=2.27 l=0.15
X777 vss a_15527_2844# a_17251_1984# vss sky130_fd_pr__nfet_01v8_lvt ad=0.31 pd=2.62 as=0.165 ps=1.33 w=1 l=0.15
X778 vss a_20911_3750# vss vss sky130_fd_pr__nfet_01v8_lvt ad=0.1595 pd=1.68 as=0 ps=0 w=0.55 l=0.15
X779 a_12367_4276# a0 a_8035_6840# vss sky130_fd_pr__nfet_01v8_lvt ad=0.132 pd=1.13 as=0.248 ps=2.22 w=0.8 l=0.15
X780 vdd a_10451_12720# ckd2 vdd sky130_fd_pr__pfet_01v8 ad=0.4158 pd=2.85 as=0.4158 ps=2.85 w=2.52 l=0.15
X781 a_6063_6255# a_5993_6105# vss sky130_fd_pr__res_high_po_0p35 l=9.5
X782 a_25055_7950# f6 a_17251_6504# vss sky130_fd_pr__nfet_01v8_lvt ad=0.145 pd=1.58 as=0.145 ps=1.58 w=0.5 l=0.15
X783 vdd a_20911_3430# vdd vdd sky130_fd_pr__pfet_01v8 ad=0.667 pd=5.18 as=0 ps=0 w=2.3 l=0.15
X784 vdd a_23191_3750# vdd vdd sky130_fd_pr__pfet_01v8 ad=0.667 pd=5.18 as=0 ps=0 w=2.3 l=0.15
X785 cke1 cke3 vss vss sky130_fd_pr__nfet_01v8_lvt ad=0.1305 pd=1.48 as=0.1305 ps=1.48 w=0.45 l=0.15
X786 a_7787_11933# a_6858_11170# dp vdd sky130_fd_pr__pfet_01v8_lvt ad=0.6583 pd=5.12 as=0.32915 ps=2.56 w=2.27 l=0.35
X787 a_16199_11933# a_16702_11162# vss vss sky130_fd_pr__nfet_01v8 ad=0.1218 pd=1.42 as=0.1218 ps=1.42 w=0.42 l=0.28
X788 a_25471_7950# a_25013_3298# a_17251_6504# vss sky130_fd_pr__nfet_01v8_lvt ad=0.145 pd=1.58 as=0.145 ps=1.58 w=0.5 l=0.15
X789 a_323_4520# qp vdd vdd sky130_fd_pr__pfet_01v8_lvt ad=0.203 pd=1.69 as=0.203 ps=1.69 w=1.4 l=0.35
X790 ep a_30888_4424# vss vss sky130_fd_pr__nfet_01v8_lvt ad=0.2145 pd=1.63 as=0.403 ps=3.22 w=1.3 l=0.15
X791 a_30888_2424# a_29784_1816# sky130_fd_pr__cap_mim_m3_1 l=3.7 w=3.7
X792 a_8035_2120# a_6063_2135# vdd vdd sky130_fd_pr__pfet_01v8 ad=0.297 pd=2.13 as=0.297 ps=2.13 w=1.8 l=0.15
X793 a_18215_3430# f0 a_17251_1984# vss sky130_fd_pr__nfet_01v8_lvt ad=0.145 pd=1.58 as=0.145 ps=1.58 w=0.5 l=0.15
X794 a_9919_11933# a_9889_11686# a_9827_11933# vdd sky130_fd_pr__pfet_01v8 ad=0.37455 pd=2.6 as=0.7037 ps=5.16 w=2.27 l=0.15
X795 a_8035_9200# b7 a_15527_7364# vss sky130_fd_pr__nfet_01v8_lvt ad=0.248 pd=2.22 as=0.132 ps=1.13 w=0.8 l=0.15
X796 vdd a_5993_1385# a_6063_1535# vdd sky130_fd_pr__pfet_01v8_lvt ad=0.23925 pd=1.94 as=0.23925 ps=1.94 w=1.65 l=0.35
X797 a_9919_11933# a_6858_11170# vss vss sky130_fd_pr__nfet_01v8 ad=0.29 pd=2.58 as=0.29 ps=2.58 w=1 l=0.18
X798 a_29021_12720# a_28759_11933# vss vss sky130_fd_pr__nfet_01v8_lvt ad=0.4205 pd=3.48 as=0.4205 ps=3.48 w=1.45 l=0.15
X799 vdd a_20911_8270# vdd vdd sky130_fd_pr__pfet_01v8 ad=0.667 pd=5.18 as=0 ps=0 w=2.3 l=0.15
X800 a_23191_8270# f4 a_14091_9376# vss sky130_fd_pr__nfet_01v8_lvt ad=0.145 pd=1.58 as=0.145 ps=1.58 w=0.5 l=0.15
X801 vss a_5993_6829# a_6063_6855# vss sky130_fd_pr__nfet_01v8_lvt ad=0.2573 pd=2.28 as=0.13695 ps=1.16 w=0.83 l=0.15
X802 a_8035_8600# a_8035_9200# vdd vdd sky130_fd_pr__pfet_01v8 ad=0.2108 pd=1.98 as=0.1122 ps=1.01 w=0.68 l=0.15
X803 a_27011_8265# a_25055_8270# vss vss sky130_fd_pr__nfet_01v8_lvt ad=0.1595 pd=1.68 as=0.1595 ps=1.68 w=0.55 l=0.15
X804 a_15527_4276# b7 a_8035_4480# vss sky130_fd_pr__nfet_01v8_lvt ad=0.132 pd=1.13 as=0.248 ps=2.22 w=0.8 l=0.15
X805 a_14091_9376# a_12367_8796# vss vss sky130_fd_pr__nfet_01v8_lvt ad=0.165 pd=1.33 as=0.31 ps=2.62 w=1 l=0.15
X806 a_22451_1645# a_20495_1650# vss vss sky130_fd_pr__nfet_01v8_lvt ad=0.1595 pd=1.68 as=0.1595 ps=1.68 w=0.55 l=0.15
X807 a_24731_1645# a_22775_1650# vdd vdd sky130_fd_pr__pfet_01v8 ad=0.667 pd=5.18 as=0.667 ps=5.18 w=2.3 l=0.15
X808 ckd2 ckd0 vdd vdd sky130_fd_pr__pfet_01v8 ad=0.5481 pd=4.36 as=0.5481 ps=4.36 w=1.89 l=0.15
X809 a_29262_11162# a_22449_11686# a_9827_11933# vss sky130_fd_pr__nfet_01v8_lvt ad=0.434 pd=3.42 as=0.231 ps=1.73 w=1.4 l=0.15
X810 a_24731_9310# a_22775_10050# vss vss sky130_fd_pr__nfet_01v8_lvt ad=0.1595 pd=1.68 as=0.1595 ps=1.68 w=0.55 l=0.15
X811 a_17251_9376# a_15527_8796# vdd vdd sky130_fd_pr__pfet_01v8 ad=0.363 pd=2.53 as=0.682 ps=5.02 w=2.2 l=0.15
X812 a_18215_3750# a_18173_3298# a_14091_4856# vss sky130_fd_pr__nfet_01v8_lvt ad=0.145 pd=1.58 as=0.145 ps=1.58 w=0.5 l=0.15
X813 a_11855_12811# a_8709_11950# vdd vdd sky130_fd_pr__pfet_01v8 ad=0.5481 pd=4.36 as=0.5481 ps=4.36 w=1.89 l=0.15
X814 a_10451_12720# a_10422_11162# vdd vdd sky130_fd_pr__pfet_01v8 ad=0.58905 pd=3.9 as=0.58905 ps=3.9 w=3.57 l=0.15
X815 vdd a_323_6880# a_3663_9270# vdd sky130_fd_pr__pfet_01v8_lvt ad=0.319 pd=2.78 as=0.1595 ps=1.39 w=1.1 l=0.35
X816 vdd a_6063_6255# a_8035_6240# vdd sky130_fd_pr__pfet_01v8 ad=0.558 pd=4.22 as=0.297 ps=2.13 w=1.8 l=0.15
X817 a_5993_8465# a_5214_8660# sky130_fd_pr__cap_mim_m3_1 l=4.2 w=4.2
X818 a_23191_1650# a_22733_1814# a_14091_1984# vdd sky130_fd_pr__pfet_01v8_lvt ad=0.261 pd=2.38 as=0.261 ps=2.38 w=0.9 l=0.35
X819 a_20911_5530# a_20453_1814# a_14091_4856# vdd sky130_fd_pr__pfet_01v8_lvt ad=0.261 pd=2.38 as=0.261 ps=2.38 w=0.9 l=0.35
X820 a_10451_12720# a_9889_11686# a_16199_11933# vss sky130_fd_pr__nfet_01v8_lvt ad=0.434 pd=3.42 as=0.231 ps=1.73 w=1.4 l=0.15
X821 vdd a_30722_8944# a_30722_6944# vdd sky130_fd_pr__pfet_01v8_lvt ad=0.4785 pd=3.88 as=0.23925 ps=1.94 w=1.65 l=0.35
X822 a_9827_11933# a_16199_11933# vdd vdd sky130_fd_pr__pfet_01v8 ad=0.58905 pd=3.9 as=0.58905 ps=3.9 w=3.57 l=0.15
X823 a_14091_1984# a_12367_2844# vdd vdd sky130_fd_pr__pfet_01v8 ad=0.363 pd=2.53 as=0.682 ps=5.02 w=2.2 l=0.15
X824 a_25471_8270# a_25013_3298# a_14091_9376# vdd sky130_fd_pr__pfet_01v8_lvt ad=0.261 pd=2.38 as=0.261 ps=2.38 w=0.9 l=0.35
X825 a_22451_6165# a_20495_6170# vdd vdd sky130_fd_pr__pfet_01v8 ad=0.667 pd=5.18 as=0.667 ps=5.18 w=2.3 l=0.15
X826 a_22775_8270# a_22733_3298# a_14091_9376# vss sky130_fd_pr__nfet_01v8_lvt ad=0.145 pd=1.58 as=0.145 ps=1.58 w=0.5 l=0.15
X827 a_8035_4480# a_16341_1968# a_15527_7364# vdd sky130_fd_pr__pfet_01v8_lvt ad=0.609 pd=4.78 as=0.3045 ps=2.39 w=2.1 l=0.35
X828 a_27011_9310# a_29784_8208# vss sky130_fd_pr__res_high_po_0p69 l=6.4
X829 vdd a_6063_1535# a_8035_1520# vdd sky130_fd_pr__pfet_01v8 ad=0.297 pd=2.13 as=0.297 ps=2.13 w=1.8 l=0.15
X830 a_8709_11950# a_7787_11933# vdd vdd sky130_fd_pr__pfet_01v8 ad=0.651 pd=4.82 as=0.3465 ps=2.43 w=2.1 l=0.15
X831 vdd a_8035_8600# a_8035_9200# vdd sky130_fd_pr__pfet_01v8 ad=0.1122 pd=1.01 as=0.1122 ps=1.01 w=0.68 l=0.15
X832 a_20911_6170# a_20453_1814# a_14091_6504# vdd sky130_fd_pr__pfet_01v8_lvt ad=0.261 pd=2.38 as=0.261 ps=2.38 w=0.9 l=0.35
X833 a_2903_6310# a_323_9240# vdd vdd sky130_fd_pr__pfet_01v8_lvt ad=0.1595 pd=1.39 as=0.1595 ps=1.39 w=1.1 l=0.35
X834 a_12367_2844# a6 a_8035_1520# vss sky130_fd_pr__nfet_01v8_lvt ad=0.132 pd=1.13 as=0.248 ps=2.22 w=0.8 l=0.15
X835 a_12367_7364# a2 a_8035_6240# vss sky130_fd_pr__nfet_01v8_lvt ad=0.132 pd=1.13 as=0.248 ps=2.22 w=0.8 l=0.15
X836 a_18631_1650# f1 a_14091_1984# vss sky130_fd_pr__nfet_01v8_lvt ad=0.145 pd=1.58 as=0.145 ps=1.58 w=0.5 l=0.15
X837 a_22449_11686# a_26135_12811# vdd vdd sky130_fd_pr__pfet_01v8 ad=0.36465 pd=2.54 as=0.36465 ps=2.54 w=2.21 l=0.15
X838 a_15527_4276# a_15901_1968# a_8035_3880# vdd sky130_fd_pr__pfet_01v8_lvt ad=0.3045 pd=2.39 as=0.609 ps=4.78 w=2.1 l=0.35
X839 a_20495_3750# f2 a_17251_4856# vss sky130_fd_pr__nfet_01v8_lvt ad=0.145 pd=1.58 as=0.145 ps=1.58 w=0.5 l=0.15
X840 a_18631_3750# a_18173_3298# a_14091_4856# vdd sky130_fd_pr__pfet_01v8_lvt ad=0.261 pd=2.38 as=0.261 ps=2.38 w=0.9 l=0.35
X841 a_6858_11170# rst_n vdd vdd sky130_fd_pr__pfet_01v8 ad=0.348 pd=2.98 as=0.348 ps=2.98 w=1.2 l=0.18
X842 a_6858_11170# rst_n vss vss sky130_fd_pr__nfet_01v8 ad=0.174 pd=1.78 as=0.174 ps=1.78 w=0.6 l=0.18
X843 a_8035_6240# a_8035_6840# vdd vdd sky130_fd_pr__pfet_01v8 ad=0.2108 pd=1.98 as=0.1122 ps=1.01 w=0.68 l=0.15
X844 a_15527_4276# a_16781_1968# a_8035_4480# vdd sky130_fd_pr__pfet_01v8_lvt ad=0.3045 pd=2.39 as=0.609 ps=4.78 w=2.1 l=0.35
X845 a_22775_1650# f5 a_14091_1984# vdd sky130_fd_pr__pfet_01v8_lvt ad=0.261 pd=2.38 as=0.261 ps=2.38 w=0.9 l=0.35
X846 a_20495_5530# f3 a_14091_4856# vdd sky130_fd_pr__pfet_01v8_lvt ad=0.261 pd=2.38 as=0.261 ps=2.38 w=0.9 l=0.35
X847 a_18215_7950# a_18173_3298# a_17251_6504# vdd sky130_fd_pr__pfet_01v8_lvt ad=0.261 pd=2.38 as=0.261 ps=2.38 w=0.9 l=0.35
X848 vss a_6063_2135# a_8035_2120# vss sky130_fd_pr__nfet_01v8_lvt ad=0.372 pd=3.02 as=0.198 ps=1.53 w=1.2 l=0.15
X849 a_20911_3750# a_20453_3298# a_17251_4856# vss sky130_fd_pr__nfet_01v8_lvt ad=0.145 pd=1.58 as=0.145 ps=1.58 w=0.5 l=0.15
X850 a_3663_6910# a_323_4520# vss vss sky130_fd_pr__nfet_01v8_lvt ad=0.319 pd=2.78 as=0.319 ps=2.78 w=1.1 l=0.15
X851 vdd a_6063_3895# a_8035_3880# vdd sky130_fd_pr__pfet_01v8 ad=0.558 pd=4.22 as=0.297 ps=2.13 w=1.8 l=0.15
X852 a_28759_11933# a_29262_11162# vdd vdd sky130_fd_pr__pfet_01v8 ad=0.1218 pd=1.42 as=0.1218 ps=1.42 w=0.42 l=0.28
X853 a_18631_7950# f0 a_17251_6504# vdd sky130_fd_pr__pfet_01v8_lvt ad=0.261 pd=2.38 as=0.261 ps=2.38 w=0.9 l=0.35
X854 vss a_23191_10050# vss vss sky130_fd_pr__nfet_01v8_lvt ad=0.1595 pd=1.68 as=0 ps=0 w=0.55 l=0.15
X855 a_20495_6170# f3 a_14091_6504# vdd sky130_fd_pr__pfet_01v8_lvt ad=0.261 pd=2.38 as=0.261 ps=2.38 w=0.9 l=0.35
X856 a_323_4520# vss sky130_fd_pr__cap_mim_m3_1 l=1.75 w=1.75
X857 a_11855_12811# a_14067_11933# vss vss sky130_fd_pr__nfet_01v8_lvt ad=0.435 pd=3.58 as=0.435 ps=3.58 w=1.5 l=0.15
X858 a_3663_6310# a_323_9240# vdd vdd sky130_fd_pr__pfet_01v8_lvt ad=0.1595 pd=1.39 as=0.319 ps=2.78 w=1.1 l=0.35
X859 a_8035_6240# a6 a_12367_8796# vss sky130_fd_pr__nfet_01v8_lvt ad=0.248 pd=2.22 as=0.132 ps=1.13 w=0.8 l=0.15
X860 a_8035_9200# a_6063_9215# vdd vdd sky130_fd_pr__pfet_01v8 ad=0.297 pd=2.13 as=0.297 ps=2.13 w=1.8 l=0.15
X861 a_25055_8270# a_25013_3298# a_14091_9376# vss sky130_fd_pr__nfet_01v8_lvt ad=0.145 pd=1.58 as=0.145 ps=1.58 w=0.5 l=0.15
X862 vdd a_12367_7364# a_14091_6504# vdd sky130_fd_pr__pfet_01v8 ad=0.363 pd=2.53 as=0.363 ps=2.53 w=2.2 l=0.15
X863 vss a_23191_1650# vss vss sky130_fd_pr__nfet_01v8_lvt ad=0.1595 pd=1.68 as=0 ps=0 w=0.55 l=0.15
X864 a_8709_11950# a_11855_12811# vss vss sky130_fd_pr__nfet_01v8_lvt ad=0.1305 pd=1.48 as=0.1305 ps=1.48 w=0.45 l=0.15
X865 a_12367_7364# a_13621_1968# a_8035_6840# vdd sky130_fd_pr__pfet_01v8_lvt ad=0.3045 pd=2.39 as=0.609 ps=4.78 w=2.1 l=0.35
X866 vdd a_30888_6944# a_30888_8944# vdd sky130_fd_pr__pfet_01v8_lvt ad=0.4785 pd=3.88 as=0.23925 ps=1.94 w=1.65 l=0.35
X867 a_22451_3745# a_29784_3688# vss sky130_fd_pr__res_high_po_0p69 l=6.4
X868 vdd a_25471_1650# vdd vdd sky130_fd_pr__pfet_01v8 ad=0.667 pd=5.18 as=0 ps=0 w=2.3 l=0.15
X869 vdd a_5993_8465# a_6063_8615# vdd sky130_fd_pr__pfet_01v8_lvt ad=0.23925 pd=1.94 as=0.23925 ps=1.94 w=1.65 l=0.35
X870 a_2903_3950# a_323_6880# vdd vdd sky130_fd_pr__pfet_01v8_lvt ad=0.1595 pd=1.39 as=0.1595 ps=1.39 w=1.1 l=0.35
X871 a_2903_8670# a_5214_8660# vss sky130_fd_pr__res_high_po_0p69 l=1.5
X872 vdd a_30888_2424# a_30888_4424# vdd sky130_fd_pr__pfet_01v8_lvt ad=0.23925 pd=1.94 as=0.23925 ps=1.94 w=1.65 l=0.35
X873 a_14528_205# a7 vdd vdd sky130_fd_pr__pfet_01v8 ad=0.261 pd=2.38 as=0.261 ps=2.38 w=0.9 l=0.18
X874 a_25055_1650# f7 a_14091_1984# vdd sky130_fd_pr__pfet_01v8_lvt ad=0.261 pd=2.38 as=0.261 ps=2.38 w=0.9 l=0.35
X875 a_8035_2120# a2 a_12367_2844# vss sky130_fd_pr__nfet_01v8_lvt ad=0.248 pd=2.22 as=0.132 ps=1.13 w=0.8 l=0.15
X876 a_20911_10050# a_20453_1814# a_17251_9376# vss sky130_fd_pr__nfet_01v8_lvt ad=0.145 pd=1.58 as=0.145 ps=1.58 w=0.5 l=0.15
X877 a_6063_4495# a_5993_4469# vss vss sky130_fd_pr__nfet_01v8_lvt ad=0.13695 pd=1.16 as=0.2573 ps=2.28 w=0.83 l=0.15
X878 vdd a_9827_11933# ckd1 vdd sky130_fd_pr__pfet_01v8 ad=0.7812 pd=5.66 as=0.4158 ps=2.85 w=2.52 l=0.15
X879 a_8035_3880# a_16341_1968# a_15527_8796# vdd sky130_fd_pr__pfet_01v8_lvt ad=0.609 pd=4.78 as=0.3045 ps=2.39 w=2.1 l=0.35
X880 a_23191_3750# a_22733_3298# a_17251_4856# vss sky130_fd_pr__nfet_01v8_lvt ad=0.145 pd=1.58 as=0.145 ps=1.58 w=0.5 l=0.15
X881 vdd a_11519_11933# ckd3 vdd sky130_fd_pr__pfet_01v8 ad=0.4158 pd=2.85 as=0.4158 ps=2.85 w=2.52 l=0.15
X882 a_21781_11939# a_21269_11950# vdd vdd sky130_fd_pr__pfet_01v8 ad=0.36465 pd=2.54 as=0.36465 ps=2.54 w=2.21 l=0.15
X883 a_24731_8265# a_22775_8270# vss vss sky130_fd_pr__nfet_01v8_lvt ad=0.1595 pd=1.68 as=0.1595 ps=1.68 w=0.55 l=0.15
X884 vdd a_23191_6170# vdd vdd sky130_fd_pr__pfet_01v8 ad=0.667 pd=5.18 as=0 ps=0 w=2.3 l=0.15
X885 a_30771_12720# a_29262_11162# vss vss sky130_fd_pr__nfet_01v8_lvt ad=0.4205 pd=3.48 as=0.4205 ps=3.48 w=1.45 l=0.15
X886 a_20171_6165# a_18215_6170# vss vss sky130_fd_pr__nfet_01v8_lvt ad=0.1595 pd=1.68 as=0.1595 ps=1.68 w=0.55 l=0.15
X887 a_25471_6170# f7 a_14091_6504# vss sky130_fd_pr__nfet_01v8_lvt ad=0.145 pd=1.58 as=0.145 ps=1.58 w=0.5 l=0.15
X888 a_323_2160# ip vdd vdd sky130_fd_pr__pfet_01v8_lvt ad=0.203 pd=1.69 as=0.203 ps=1.69 w=1.4 l=0.35
X889 vss a_18631_3750# vss vss sky130_fd_pr__nfet_01v8_lvt ad=0.1595 pd=1.68 as=0 ps=0 w=0.55 l=0.15
X890 a_20171_9310# a_18215_10050# vdd vdd sky130_fd_pr__pfet_01v8 ad=0.667 pd=5.18 as=0.667 ps=5.18 w=2.3 l=0.15
X891 a_8035_6240# a_12218_205# a_12367_2844# vdd sky130_fd_pr__pfet_01v8_lvt ad=0.609 pd=4.78 as=0.3045 ps=2.39 w=2.1 l=0.35
X892 vdd a_18631_3430# vdd vdd sky130_fd_pr__pfet_01v8 ad=0.667 pd=5.18 as=0 ps=0 w=2.3 l=0.15
X893 a_8035_9200# b3 a_15527_8796# vss sky130_fd_pr__nfet_01v8_lvt ad=0.248 pd=2.22 as=0.132 ps=1.13 w=0.8 l=0.15
X894 a_3663_6310# a_5214_6300# vss sky130_fd_pr__res_high_po_0p69 l=1.5
X895 a_3663_3950# a_323_9240# vdd vdd sky130_fd_pr__pfet_01v8_lvt ad=0.1595 pd=1.39 as=0.319 ps=2.78 w=1.1 l=0.35
X896 vdd a_6063_2135# a_8035_2120# vdd sky130_fd_pr__pfet_01v8 ad=0.558 pd=4.22 as=0.297 ps=2.13 w=1.8 l=0.15
X897 cke2 cke0 vss vss sky130_fd_pr__nfet_01v8_lvt ad=0.1305 pd=1.48 as=0.1305 ps=1.48 w=0.45 l=0.15
X898 a_22479_11933# a_22982_11162# vdd vdd sky130_fd_pr__pfet_01v8 ad=0.1218 pd=1.42 as=0.1218 ps=1.42 w=0.42 l=0.28
X899 a_22479_11933# a_21781_11939# a_10451_12720# vss sky130_fd_pr__nfet_01v8_lvt ad=0.231 pd=1.73 as=0.434 ps=3.42 w=1.4 l=0.15
X900 a_8035_6840# a_6063_6855# vdd vdd sky130_fd_pr__pfet_01v8 ad=0.297 pd=2.13 as=0.297 ps=2.13 w=1.8 l=0.15
X901 ep a_30888_4424# vdd vdd sky130_fd_pr__pfet_01v8_lvt ad=0.377 pd=2.89 as=0.377 ps=2.89 w=2.6 l=0.35
X902 a_5993_6105# a_5214_6300# sky130_fd_pr__cap_mim_m3_1 l=4.2 w=4.2
X903 vdd a_14067_11933# a_11855_12811# vdd sky130_fd_pr__pfet_01v8 ad=0.3465 pd=2.43 as=0.3465 ps=2.43 w=2.1 l=0.15
X904 vdd a_6063_8615# a_8035_8600# vdd sky130_fd_pr__pfet_01v8 ad=0.297 pd=2.13 as=0.297 ps=2.13 w=1.8 l=0.15
X905 a_23191_3430# a_22733_3298# a_14091_1984# vdd sky130_fd_pr__pfet_01v8_lvt ad=0.261 pd=2.38 as=0.261 ps=2.38 w=0.9 l=0.35
X906 ckd1 ckd3 vss vss sky130_fd_pr__nfet_01v8_lvt ad=0.1305 pd=1.48 as=0.1305 ps=1.48 w=0.45 l=0.15
X907 vdd a_29021_12720# cke1 vdd sky130_fd_pr__pfet_01v8 ad=0.4158 pd=2.85 as=0.4158 ps=2.85 w=2.52 l=0.15
X908 a_10422_11162# a_9919_11933# vdd vdd sky130_fd_pr__pfet_01v8 ad=0.1218 pd=1.42 as=0.1218 ps=1.42 w=0.42 l=0.28
X909 vdd a_15527_4276# a_17251_4856# vdd sky130_fd_pr__pfet_01v8 ad=0.682 pd=5.02 as=0.363 ps=2.53 w=2.2 l=0.15
X910 vss a_12367_4276# a_14091_4856# vss sky130_fd_pr__nfet_01v8_lvt ad=0.31 pd=2.62 as=0.165 ps=1.33 w=1 l=0.15
X911 vdd a_18631_8270# vdd vdd sky130_fd_pr__pfet_01v8 ad=0.667 pd=5.18 as=0 ps=0 w=2.3 l=0.15
X912 a_11855_12811# a_14067_11933# vdd vdd sky130_fd_pr__pfet_01v8 ad=0.3465 pd=2.43 as=0.651 ps=4.82 w=2.1 l=0.15
X913 vss a_11855_12811# a_9889_11686# vss sky130_fd_pr__nfet_01v8_lvt ad=0.3255 pd=2.72 as=0.17325 ps=1.38 w=1.05 l=0.15
X914 a_22982_11162# a_22449_11686# a_8701_12720# vdd sky130_fd_pr__pfet_01v8 ad=0.37455 pd=2.6 as=0.37455 ps=2.6 w=2.27 l=0.15
X915 vss a_6063_9215# a_8035_9200# vss sky130_fd_pr__nfet_01v8_lvt ad=0.372 pd=3.02 as=0.198 ps=1.53 w=1.2 l=0.15
X916 a_6063_2135# a_5993_2109# vss vss sky130_fd_pr__nfet_01v8_lvt ad=0.13695 pd=1.16 as=0.2573 ps=2.28 w=0.83 l=0.15
X917 a_30888_4424# a_30888_2424# vss vss sky130_fd_pr__nfet_01v8_lvt ad=0.4785 pd=3.88 as=0.4785 ps=3.88 w=1.65 l=0.15
X918 a_18215_8270# f0 a_14091_9376# vdd sky130_fd_pr__pfet_01v8_lvt ad=0.261 pd=2.38 as=0.261 ps=2.38 w=0.9 l=0.35
X919 en a_30722_2424# vdd vdd sky130_fd_pr__pfet_01v8_lvt ad=0.377 pd=2.89 as=0.377 ps=2.89 w=2.6 l=0.35
X920 a_8035_3880# a_16781_1968# a_15527_2844# vdd sky130_fd_pr__pfet_01v8_lvt ad=0.609 pd=4.78 as=0.3045 ps=2.39 w=2.1 l=0.35
X921 ckd2 a_10451_12720# vdd vdd sky130_fd_pr__pfet_01v8 ad=0.4158 pd=2.85 as=0.4158 ps=2.85 w=2.52 l=0.15
X922 vdd a_12367_8796# a_14091_9376# vdd sky130_fd_pr__pfet_01v8 ad=0.363 pd=2.53 as=0.363 ps=2.53 w=2.2 l=0.15
X923 a_12367_8796# a_13621_1968# a_8035_6240# vdd sky130_fd_pr__pfet_01v8_lvt ad=0.3045 pd=2.39 as=0.609 ps=4.78 w=2.1 l=0.35
X924 a_9889_11686# a_11855_12811# vdd vdd sky130_fd_pr__pfet_01v8 ad=0.36465 pd=2.54 as=0.6851 ps=5.04 w=2.21 l=0.15
X925 a_24731_6165# a_29784_6336# vss sky130_fd_pr__res_high_po_0p69 l=6.4
X926 a_25471_5530# f7 a_14091_4856# vss sky130_fd_pr__nfet_01v8_lvt ad=0.145 pd=1.58 as=0.145 ps=1.58 w=0.5 l=0.15
X927 a_22775_1650# f5 a_17251_1984# vss sky130_fd_pr__nfet_01v8_lvt ad=0.145 pd=1.58 as=0.145 ps=1.58 w=0.5 l=0.15
X928 a_8035_1520# a_6063_1535# vdd vdd sky130_fd_pr__pfet_01v8 ad=0.297 pd=2.13 as=0.297 ps=2.13 w=1.8 l=0.15
X929 a_20171_4790# a_18215_5530# vss vss sky130_fd_pr__nfet_01v8_lvt ad=0.1595 pd=1.68 as=0.1595 ps=1.68 w=0.55 l=0.15
X930 a_22775_3430# f4 a_14091_1984# vdd sky130_fd_pr__pfet_01v8_lvt ad=0.261 pd=2.38 as=0.261 ps=2.38 w=0.9 l=0.35
X931 a_22775_3750# a_22733_3298# a_17251_4856# vdd sky130_fd_pr__pfet_01v8_lvt ad=0.261 pd=2.38 as=0.261 ps=2.38 w=0.9 l=0.35
X932 a_18631_5530# a_18173_1814# a_14091_4856# vdd sky130_fd_pr__pfet_01v8_lvt ad=0.261 pd=2.38 as=0.261 ps=2.38 w=0.9 l=0.35
X933 a_9827_11933# a_9889_11686# a_9919_11933# vdd sky130_fd_pr__pfet_01v8 ad=0.37455 pd=2.6 as=0.37455 ps=2.6 w=2.27 l=0.15
X934 vdd a_8035_6240# a_8035_6840# vdd sky130_fd_pr__pfet_01v8 ad=0.1122 pd=1.01 as=0.1122 ps=1.01 w=0.68 l=0.15
X935 a_3663_3950# a_5214_3940# vss sky130_fd_pr__res_high_po_0p69 l=1.5
X936 a_14528_205# a7 vss vss sky130_fd_pr__nfet_01v8 ad=0.1305 pd=1.48 as=0.1305 ps=1.48 w=0.45 l=0.18
X937 a_20911_3430# f2 a_14091_1984# vss sky130_fd_pr__nfet_01v8_lvt ad=0.145 pd=1.58 as=0.145 ps=1.58 w=0.5 l=0.15
X938 vdd a_16702_11162# a_11519_11933# vdd sky130_fd_pr__pfet_01v8 ad=1.1067 pd=7.76 as=0.58905 ps=3.9 w=3.57 l=0.15
X939 a_18215_10050# f1 a_17251_9376# vss sky130_fd_pr__nfet_01v8_lvt ad=0.145 pd=1.58 as=0.145 ps=1.58 w=0.5 l=0.15
X940 a_6063_1535# a_5993_1385# vdd vdd sky130_fd_pr__pfet_01v8_lvt ad=0.23925 pd=1.94 as=0.23925 ps=1.94 w=1.65 l=0.35
X941 vss a_25471_8270# vss vss sky130_fd_pr__nfet_01v8_lvt ad=0.1595 pd=1.68 as=0 ps=0 w=0.55 l=0.15
X942 a_18631_6170# a_18173_1814# a_14091_6504# vdd sky130_fd_pr__pfet_01v8_lvt ad=0.261 pd=2.38 as=0.261 ps=2.38 w=0.9 l=0.35
X943 a_8035_3880# a_8035_4480# vdd vdd sky130_fd_pr__pfet_01v8 ad=0.2108 pd=1.98 as=0.1122 ps=1.01 w=0.68 l=0.15
X944 a_20495_8270# a_20453_3298# a_17251_9376# vdd sky130_fd_pr__pfet_01v8_lvt ad=0.261 pd=2.38 as=0.261 ps=2.38 w=0.9 l=0.35
X945 a_23191_10050# a_22733_1814# a_17251_9376# vss sky130_fd_pr__nfet_01v8_lvt ad=0.145 pd=1.58 as=0.145 ps=1.58 w=0.5 l=0.15
X946 vss a_20911_6170# vss vss sky130_fd_pr__nfet_01v8_lvt ad=0.1595 pd=1.68 as=0 ps=0 w=0.55 l=0.15
X947 a_18215_10050# a_18173_1814# a_14091_9376# vss sky130_fd_pr__nfet_01v8_lvt ad=0.145 pd=1.58 as=0.145 ps=1.58 w=0.5 l=0.15
X948 vdd a_20911_10050# vdd vdd sky130_fd_pr__pfet_01v8 ad=0.667 pd=5.18 as=0 ps=0 w=2.3 l=0.15
X949 a_3663_4550# a_323_4520# vss vss sky130_fd_pr__nfet_01v8_lvt ad=0.319 pd=2.78 as=0.319 ps=2.78 w=1.1 l=0.15
X950 a_20911_8270# f2 a_17251_9376# vdd sky130_fd_pr__pfet_01v8_lvt ad=0.261 pd=2.38 as=0.261 ps=2.38 w=0.9 l=0.35
X951 a_14091_4856# a_12367_4276# vdd vdd sky130_fd_pr__pfet_01v8 ad=0.363 pd=2.53 as=0.363 ps=2.53 w=2.2 l=0.15
X952 a_20453_1814# f3 vdd vdd sky130_fd_pr__pfet_01v8 ad=0.261 pd=2.38 as=0.261 ps=2.38 w=0.9 l=0.18
X953 a_28759_11933# a_29262_11162# vss vss sky130_fd_pr__nfet_01v8 ad=0.1218 pd=1.42 as=0.1218 ps=1.42 w=0.42 l=0.28
X954 a_15527_8796# b5 a_8035_3880# vss sky130_fd_pr__nfet_01v8_lvt ad=0.132 pd=1.13 as=0.248 ps=2.22 w=0.8 l=0.15
X955 a_25055_1650# f7 a_17251_1984# vss sky130_fd_pr__nfet_01v8_lvt ad=0.145 pd=1.58 as=0.145 ps=1.58 w=0.5 l=0.15
X956 a_20495_3430# a_20453_3298# a_14091_1984# vss sky130_fd_pr__nfet_01v8_lvt ad=0.145 pd=1.58 as=0.145 ps=1.58 w=0.5 l=0.15
X957 a_323_9240# qn vdd vdd sky130_fd_pr__pfet_01v8_lvt ad=0.203 pd=1.69 as=0.203 ps=1.69 w=1.4 l=0.35
X958 a_25055_3430# f6 a_14091_1984# vdd sky130_fd_pr__pfet_01v8_lvt ad=0.261 pd=2.38 as=0.261 ps=2.38 w=0.9 l=0.35
X959 a_25055_3750# a_25013_3298# a_17251_4856# vdd sky130_fd_pr__pfet_01v8_lvt ad=0.261 pd=2.38 as=0.261 ps=2.38 w=0.9 l=0.35
X960 vdd qp a_323_4520# vdd sky130_fd_pr__pfet_01v8_lvt ad=0.203 pd=1.69 as=0.203 ps=1.69 w=1.4 l=0.35
X961 a_25471_1650# a_25013_1814# a_17251_1984# vss sky130_fd_pr__nfet_01v8_lvt ad=0.145 pd=1.58 as=0.145 ps=1.58 w=0.5 l=0.15
X962 vdd a_8035_3880# a_8035_4480# vdd sky130_fd_pr__pfet_01v8 ad=0.1122 pd=1.01 as=0.1122 ps=1.01 w=0.68 l=0.15
X963 vdd a_5993_6105# a_6063_6255# vdd sky130_fd_pr__pfet_01v8_lvt ad=0.23925 pd=1.94 as=0.23925 ps=1.94 w=1.65 l=0.35
X964 vdd a_6063_9215# a_8035_9200# vdd sky130_fd_pr__pfet_01v8 ad=0.558 pd=4.22 as=0.297 ps=2.13 w=1.8 l=0.15
X965 a_2903_1590# a_323_6880# vdd vdd sky130_fd_pr__pfet_01v8_lvt ad=0.1595 pd=1.39 as=0.1595 ps=1.39 w=1.1 l=0.35
X966 a_25471_3750# f6 a_17251_4856# vdd sky130_fd_pr__pfet_01v8_lvt ad=0.261 pd=2.38 as=0.261 ps=2.38 w=0.9 l=0.35
X967 a_15527_2844# b1 a_8035_8600# vss sky130_fd_pr__nfet_01v8_lvt ad=0.132 pd=1.13 as=0.248 ps=2.22 w=0.8 l=0.15
X968 a_25471_10050# a_25013_1814# a_14091_9376# vdd sky130_fd_pr__pfet_01v8_lvt ad=0.261 pd=2.38 as=0.261 ps=2.38 w=0.9 l=0.35
X969 a_22451_7210# a_20495_7950# vdd vdd sky130_fd_pr__pfet_01v8 ad=0.667 pd=5.18 as=0.667 ps=5.18 w=2.3 l=0.15
X970 a_18215_6170# a_18173_1814# a_14091_6504# vss sky130_fd_pr__nfet_01v8_lvt ad=0.145 pd=1.58 as=0.145 ps=1.58 w=0.5 l=0.15
X971 a_20911_7950# a_20453_3298# a_14091_6504# vdd sky130_fd_pr__pfet_01v8_lvt ad=0.261 pd=2.38 as=0.261 ps=2.38 w=0.9 l=0.35
X972 a_6063_9215# a_5993_9189# vss vss sky130_fd_pr__nfet_01v8_lvt ad=0.13695 pd=1.16 as=0.2573 ps=2.28 w=0.83 l=0.15
X973 vss a_20911_5530# vss vss sky130_fd_pr__nfet_01v8_lvt ad=0.1595 pd=1.68 as=0 ps=0 w=0.55 l=0.15
X974 vdd a_323_9240# a_2903_6310# vdd sky130_fd_pr__pfet_01v8_lvt ad=0.319 pd=2.78 as=0.1595 ps=1.39 w=1.1 l=0.35
X975 a_23191_8270# f4 a_17251_9376# vdd sky130_fd_pr__pfet_01v8_lvt ad=0.261 pd=2.38 as=0.261 ps=2.38 w=0.9 l=0.35
X976 a_14067_11933# a_6858_11170# dn vdd sky130_fd_pr__pfet_01v8_lvt ad=0.6583 pd=5.12 as=0.32915 ps=2.56 w=2.27 l=0.35
X977 a_20347_11933# rst_n ep vss sky130_fd_pr__nfet_01v8_lvt ad=0.2145 pd=1.63 as=0.403 ps=3.22 w=1.3 l=0.15
X978 a_8035_8600# a_6063_8615# vdd vdd sky130_fd_pr__pfet_01v8 ad=0.297 pd=2.13 as=0.297 ps=2.13 w=1.8 l=0.15
X979 a_323_6880# in vdd vdd sky130_fd_pr__pfet_01v8_lvt ad=0.203 pd=1.69 as=0.203 ps=1.69 w=1.4 l=0.35
X980 a_3663_1590# a_323_6880# vdd vdd sky130_fd_pr__pfet_01v8_lvt ad=0.1595 pd=1.39 as=0.319 ps=2.78 w=1.1 l=0.35
X981 a_28759_11933# a_22449_11686# a_11519_11933# vss sky130_fd_pr__nfet_01v8_lvt ad=0.231 pd=1.73 as=0.434 ps=3.42 w=1.4 l=0.15
X982 a_8035_4480# b1 a_15527_8796# vss sky130_fd_pr__nfet_01v8_lvt ad=0.248 pd=2.22 as=0.132 ps=1.13 w=0.8 l=0.15
X983 a_2903_3950# a_323_6880# vss vss sky130_fd_pr__nfet_01v8_lvt ad=0.319 pd=2.78 as=0.319 ps=2.78 w=1.1 l=0.15
X984 a_8035_4480# a_6063_4495# vdd vdd sky130_fd_pr__pfet_01v8 ad=0.297 pd=2.13 as=0.297 ps=2.13 w=1.8 l=0.15
X985 vdd a_6063_6255# a_8035_6240# vdd sky130_fd_pr__pfet_01v8 ad=0.297 pd=2.13 as=0.297 ps=2.13 w=1.8 l=0.15
X986 a_16199_11933# a_9221_11939# a_10451_12720# vdd sky130_fd_pr__pfet_01v8 ad=0.37455 pd=2.6 as=0.7037 ps=5.16 w=2.27 l=0.15
X987 a_16702_11162# a_16199_11933# vdd vdd sky130_fd_pr__pfet_01v8 ad=0.1218 pd=1.42 as=0.1218 ps=1.42 w=0.42 l=0.28
X988 a_22479_11933# a_22982_11162# vss vss sky130_fd_pr__nfet_01v8 ad=0.1218 pd=1.42 as=0.1218 ps=1.42 w=0.42 l=0.28
X989 vdd a_6063_6855# a_8035_6840# vdd sky130_fd_pr__pfet_01v8 ad=0.558 pd=4.22 as=0.297 ps=2.13 w=1.8 l=0.15
X990 a_15527_7364# a_15348_205# a_8035_3880# vdd sky130_fd_pr__pfet_01v8_lvt ad=0.3045 pd=2.39 as=0.609 ps=4.78 w=2.1 l=0.35
X991 vdd a_5993_3745# a_6063_3895# vdd sky130_fd_pr__pfet_01v8_lvt ad=0.23925 pd=1.94 as=0.23925 ps=1.94 w=1.65 l=0.35
X992 a_20495_6170# f3 a_17251_6504# vss sky130_fd_pr__nfet_01v8_lvt ad=0.145 pd=1.58 as=0.145 ps=1.58 w=0.5 l=0.15
X993 a_15348_205# b1 vdd vdd sky130_fd_pr__pfet_01v8 ad=0.261 pd=2.38 as=0.261 ps=2.38 w=0.9 l=0.18
X994 a_10422_11162# a_9919_11933# vss vss sky130_fd_pr__nfet_01v8 ad=0.1218 pd=1.42 as=0.1218 ps=1.42 w=0.42 l=0.28
X995 a_20495_7950# f2 a_14091_6504# vdd sky130_fd_pr__pfet_01v8_lvt ad=0.261 pd=2.38 as=0.261 ps=2.38 w=0.9 l=0.35
X996 a_6063_8615# a_5993_8465# vdd vdd sky130_fd_pr__pfet_01v8_lvt ad=0.23925 pd=1.94 as=0.23925 ps=1.94 w=1.65 l=0.35
X997 a_8035_6840# a_13621_1968# a_12367_7364# vdd sky130_fd_pr__pfet_01v8_lvt ad=0.609 pd=4.78 as=0.3045 ps=2.39 w=2.1 l=0.35
X998 a_20453_1814# f3 vss vss sky130_fd_pr__nfet_01v8 ad=0.1305 pd=1.48 as=0.1305 ps=1.48 w=0.45 l=0.18
X999 a_22451_2690# a_20495_3430# vss vss sky130_fd_pr__nfet_01v8_lvt ad=0.1595 pd=1.68 as=0.1595 ps=1.68 w=0.55 l=0.15
X1000 vdd a_323_9240# a_3663_6310# vdd sky130_fd_pr__pfet_01v8_lvt ad=0.1595 pd=1.39 as=0.1595 ps=1.39 w=1.1 l=0.35
X1001 vss a_6063_6855# a_8035_6840# vss sky130_fd_pr__nfet_01v8_lvt ad=0.372 pd=3.02 as=0.198 ps=1.53 w=1.2 l=0.15
X1002 a_20911_6170# a_20453_1814# a_17251_6504# vss sky130_fd_pr__nfet_01v8_lvt ad=0.145 pd=1.58 as=0.145 ps=1.58 w=0.5 l=0.15
X1003 vdd a_8035_2120# a_8035_1520# vdd sky130_fd_pr__pfet_01v8 ad=0.1122 pd=1.01 as=0.1122 ps=1.01 w=0.68 l=0.15
X1004 a_22775_5530# a_22733_1814# a_17251_4856# vdd sky130_fd_pr__pfet_01v8_lvt ad=0.261 pd=2.38 as=0.261 ps=2.38 w=0.9 l=0.35
X1005 a_24771_12720# a_22982_11162# vdd vdd sky130_fd_pr__pfet_01v8 ad=0.33495 pd=2.36 as=0.6293 ps=4.68 w=2.03 l=0.15
X1006 a_18215_5530# a_18173_1814# a_14091_4856# vss sky130_fd_pr__nfet_01v8_lvt ad=0.145 pd=1.58 as=0.145 ps=1.58 w=0.5 l=0.15
X1007 ckd3 a_11519_11933# vdd vdd sky130_fd_pr__pfet_01v8 ad=0.4158 pd=2.85 as=0.4158 ps=2.85 w=2.52 l=0.15
X1008 a_30888_4424# a_30888_2424# vdd vdd sky130_fd_pr__pfet_01v8_lvt ad=0.23925 pd=1.94 as=0.23925 ps=1.94 w=1.65 l=0.35
X1009 a_20171_3745# a_29784_3688# vss sky130_fd_pr__res_high_po_0p69 l=6.4
X1010 a_2903_6910# a_323_4520# vdd vdd sky130_fd_pr__pfet_01v8_lvt ad=0.1595 pd=1.39 as=0.1595 ps=1.39 w=1.1 l=0.35
X1011 vdd a_323_6880# a_2903_3950# vdd sky130_fd_pr__pfet_01v8_lvt ad=0.319 pd=2.78 as=0.1595 ps=1.39 w=1.1 l=0.35
X1012 a_16338_205# b4 vdd vdd sky130_fd_pr__pfet_01v8 ad=0.261 pd=2.38 as=0.261 ps=2.38 w=0.9 l=0.18
X1013 cke0 cke2 vdd vdd sky130_fd_pr__pfet_01v8 ad=0.5481 pd=4.36 as=0.5481 ps=4.36 w=1.89 l=0.15
X1014 vdd a_8709_11950# a_9221_11939# vdd sky130_fd_pr__pfet_01v8 ad=0.36465 pd=2.54 as=0.36465 ps=2.54 w=2.21 l=0.15
X1015 a_20171_7210# a_18215_7950# vss vss sky130_fd_pr__nfet_01v8_lvt ad=0.1595 pd=1.68 as=0.1595 ps=1.68 w=0.55 l=0.15
X1016 a_25471_7950# f6 a_14091_6504# vss sky130_fd_pr__nfet_01v8_lvt ad=0.145 pd=1.58 as=0.145 ps=1.58 w=0.5 l=0.15
X1017 a_22775_6170# a_22733_1814# a_17251_6504# vdd sky130_fd_pr__pfet_01v8_lvt ad=0.261 pd=2.38 as=0.261 ps=2.38 w=0.9 l=0.35
X1018 a_3663_1590# a_5214_1580# vss sky130_fd_pr__res_high_po_0p69 l=1.5
X1019 a_10451_12720# a_21781_11939# a_22479_11933# vss sky130_fd_pr__nfet_01v8_lvt ad=0.434 pd=3.42 as=0.231 ps=1.73 w=1.4 l=0.15
X1020 vdd a_23191_7950# vdd vdd sky130_fd_pr__pfet_01v8 ad=0.667 pd=5.18 as=0 ps=0 w=2.3 l=0.15
X1021 a_24731_3745# a_29784_3688# vss sky130_fd_pr__res_high_po_0p69 l=6.4
X1022 a_11855_12811# a_14067_11933# vdd vdd sky130_fd_pr__pfet_01v8 ad=0.651 pd=4.82 as=0.3465 ps=2.43 w=2.1 l=0.15
X1023 a_27011_7210# a_29784_6336# vss sky130_fd_pr__res_high_po_0p69 l=6.4
X1024 vdd a_6063_3895# a_8035_3880# vdd sky130_fd_pr__pfet_01v8 ad=0.297 pd=2.13 as=0.297 ps=2.13 w=1.8 l=0.15
X1025 cke1 a_29021_12720# vdd vdd sky130_fd_pr__pfet_01v8 ad=0.4158 pd=2.85 as=0.4158 ps=2.85 w=2.52 l=0.15
X1026 a_2903_8670# a_323_9240# vdd vdd sky130_fd_pr__pfet_01v8_lvt ad=0.1595 pd=1.39 as=0.1595 ps=1.39 w=1.1 l=0.35
X1027 a_30722_2424# a_30722_4424# vss vss sky130_fd_pr__nfet_01v8_lvt ad=0.4785 pd=3.88 as=0.4785 ps=3.88 w=1.65 l=0.15
X1028 a_8035_2120# a_8035_1520# vdd vdd sky130_fd_pr__pfet_01v8 ad=0.1122 pd=1.01 as=0.2108 ps=1.98 w=0.68 l=0.15
X1029 a_18631_3430# f0 a_14091_1984# vss sky130_fd_pr__nfet_01v8_lvt ad=0.145 pd=1.58 as=0.145 ps=1.58 w=0.5 l=0.15
X1030 ckd2 a_10451_12720# vss vss sky130_fd_pr__nfet_01v8_lvt ad=0.198 pd=1.53 as=0.372 ps=3.02 w=1.2 l=0.15
X1031 a_20911_10050# f3 a_14091_9376# vss sky130_fd_pr__nfet_01v8_lvt ad=0.145 pd=1.58 as=0.145 ps=1.58 w=0.5 l=0.15
X1032 a_8035_8600# a_15901_1968# a_15527_7364# vdd sky130_fd_pr__pfet_01v8_lvt ad=0.609 pd=4.78 as=0.3045 ps=2.39 w=2.1 l=0.35
X1033 a_20495_5530# f3 a_17251_4856# vss sky130_fd_pr__nfet_01v8_lvt ad=0.145 pd=1.58 as=0.145 ps=1.58 w=0.5 l=0.15
X1034 a_25055_5530# a_25013_1814# a_17251_4856# vdd sky130_fd_pr__pfet_01v8_lvt ad=0.261 pd=2.38 as=0.261 ps=2.38 w=0.9 l=0.35
X1035 a_23191_6170# a_22733_1814# a_17251_6504# vss sky130_fd_pr__nfet_01v8_lvt ad=0.145 pd=1.58 as=0.145 ps=1.58 w=0.5 l=0.15
X1036 vdd a_323_9240# a_3663_3950# vdd sky130_fd_pr__pfet_01v8_lvt ad=0.1595 pd=1.39 as=0.1595 ps=1.39 w=1.1 l=0.35
X1037 a_8701_12720# a_22449_11686# a_22982_11162# vdd sky130_fd_pr__pfet_01v8 ad=0.7037 pd=5.16 as=0.37455 ps=2.6 w=2.27 l=0.15
X1038 a_3663_6910# a_323_4520# vdd vdd sky130_fd_pr__pfet_01v8_lvt ad=0.1595 pd=1.39 as=0.319 ps=2.78 w=1.1 l=0.35
X1039 a_12367_7364# a0 a_8035_1520# vss sky130_fd_pr__nfet_01v8_lvt ad=0.132 pd=1.13 as=0.248 ps=2.22 w=0.8 l=0.15
X1040 a_20911_5530# a_20453_1814# a_17251_4856# vss sky130_fd_pr__nfet_01v8_lvt ad=0.145 pd=1.58 as=0.145 ps=1.58 w=0.5 l=0.15
X1041 vdd a_5993_2109# a_6063_2135# vdd sky130_fd_pr__pfet_01v8_lvt ad=0.23925 pd=1.94 as=0.23925 ps=1.94 w=1.65 l=0.35
X1042 vdd a_30888_4424# ep vdd sky130_fd_pr__pfet_01v8_lvt ad=0.754 pd=5.78 as=0.377 ps=2.89 w=2.6 l=0.35
X1043 a_12367_2844# a4 a_8035_6840# vss sky130_fd_pr__nfet_01v8_lvt ad=0.132 pd=1.13 as=0.248 ps=2.22 w=0.8 l=0.15
X1044 vss a_18631_6170# vss vss sky130_fd_pr__nfet_01v8_lvt ad=0.1595 pd=1.68 as=0 ps=0 w=0.55 l=0.15
X1045 a_24731_9310# a_29784_8208# vss sky130_fd_pr__res_high_po_0p69 l=6.4
X1046 a_15527_4276# a_16341_1968# a_8035_8600# vdd sky130_fd_pr__pfet_01v8_lvt ad=0.3045 pd=2.39 as=0.609 ps=4.78 w=2.1 l=0.35
X1047 a_25471_5530# f7 a_17251_4856# vdd sky130_fd_pr__pfet_01v8_lvt ad=0.261 pd=2.38 as=0.261 ps=2.38 w=0.9 l=0.35
X1048 a_15527_8796# a_15348_205# a_8035_4480# vdd sky130_fd_pr__pfet_01v8_lvt ad=0.3045 pd=2.39 as=0.609 ps=4.78 w=2.1 l=0.35
X1049 vdd a_18631_10050# vdd vdd sky130_fd_pr__pfet_01v8 ad=0.667 pd=5.18 as=0 ps=0 w=2.3 l=0.15
X1050 a_17251_1984# a_15527_2844# vss vss sky130_fd_pr__nfet_01v8_lvt ad=0.165 pd=1.33 as=0.31 ps=2.62 w=1 l=0.15
X1051 a_2903_6310# a_323_9240# vdd vdd sky130_fd_pr__pfet_01v8_lvt ad=0.1595 pd=1.39 as=0.319 ps=2.78 w=1.1 l=0.35
X1052 a_8035_8600# b5 a_15527_4276# vss sky130_fd_pr__nfet_01v8_lvt ad=0.248 pd=2.22 as=0.132 ps=1.13 w=0.8 l=0.15
X1053 a_8035_6240# a_13621_1968# a_12367_8796# vdd sky130_fd_pr__pfet_01v8_lvt ad=0.609 pd=4.78 as=0.3045 ps=2.39 w=2.1 l=0.35
X1054 a_18215_8270# f0 a_17251_9376# vss sky130_fd_pr__nfet_01v8_lvt ad=0.145 pd=1.58 as=0.145 ps=1.58 w=0.5 l=0.15
X1055 a_25055_6170# a_25013_1814# a_17251_6504# vdd sky130_fd_pr__pfet_01v8_lvt ad=0.261 pd=2.38 as=0.261 ps=2.38 w=0.9 l=0.35
X1056 a_15348_205# b1 vss vss sky130_fd_pr__nfet_01v8 ad=0.1305 pd=1.48 as=0.1305 ps=1.48 w=0.45 l=0.18
X1057 a_18215_10050# f1 a_14091_9376# vdd sky130_fd_pr__pfet_01v8_lvt ad=0.261 pd=2.38 as=0.261 ps=2.38 w=0.9 l=0.35
X1058 vdd ip a_323_2160# vdd sky130_fd_pr__pfet_01v8_lvt ad=0.203 pd=1.69 as=0.203 ps=1.69 w=1.4 l=0.35
X1059 dp a_6858_11170# a_7787_11933# vdd sky130_fd_pr__pfet_01v8_lvt ad=0.32915 pd=2.56 as=0.32915 ps=2.56 w=2.27 l=0.35
X1060 a_23021_12720# a_22479_11933# vdd vdd sky130_fd_pr__pfet_01v8 ad=0.33495 pd=2.36 as=0.6293 ps=4.68 w=2.03 l=0.15
X1061 a_3663_8670# a_323_2160# vdd vdd sky130_fd_pr__pfet_01v8_lvt ad=0.1595 pd=1.39 as=0.319 ps=2.78 w=1.1 l=0.35
X1062 vdd a_30722_2424# en vdd sky130_fd_pr__pfet_01v8_lvt ad=0.754 pd=5.78 as=0.377 ps=2.89 w=2.6 l=0.35
X1063 vss a_23191_3430# vss vss sky130_fd_pr__nfet_01v8_lvt ad=0.1595 pd=1.68 as=0 ps=0 w=0.55 l=0.15
X1064 vss a_25471_10050# vss vss sky130_fd_pr__nfet_01v8_lvt ad=0.1595 pd=1.68 as=0 ps=0 w=0.55 l=0.15
X1065 a_25471_6170# f7 a_17251_6504# vdd sky130_fd_pr__pfet_01v8_lvt ad=0.261 pd=2.38 as=0.261 ps=2.38 w=0.9 l=0.35
X1066 a_18631_3750# a_18173_3298# a_17251_4856# vss sky130_fd_pr__nfet_01v8_lvt ad=0.145 pd=1.58 as=0.145 ps=1.58 w=0.5 l=0.15
X1067 vdd a_23021_12720# cke0 vdd sky130_fd_pr__pfet_01v8 ad=0.4158 pd=2.85 as=0.4158 ps=2.85 w=2.52 l=0.15
X1068 a_8035_1520# a4 a_12367_8796# vss sky130_fd_pr__nfet_01v8_lvt ad=0.248 pd=2.22 as=0.132 ps=1.13 w=0.8 l=0.15
X1069 a_15527_7364# b7 a_8035_9200# vss sky130_fd_pr__nfet_01v8_lvt ad=0.132 pd=1.13 as=0.248 ps=2.22 w=0.8 l=0.15
X1070 a_22451_1645# a_29784_1816# vss sky130_fd_pr__res_high_po_0p69 l=6.4
X1071 a_18215_1650# a_18173_1814# a_17251_1984# vdd sky130_fd_pr__pfet_01v8_lvt ad=0.261 pd=2.38 as=0.261 ps=2.38 w=0.9 l=0.35
X1072 a_16338_205# b4 vss vss sky130_fd_pr__nfet_01v8 ad=0.1305 pd=1.48 as=0.1305 ps=1.48 w=0.45 l=0.18
X1073 a_6063_6855# a_5993_6829# vss vss sky130_fd_pr__nfet_01v8_lvt ad=0.13695 pd=1.16 as=0.2573 ps=2.28 w=0.83 l=0.15
X1074 vdd a_6063_2135# a_8035_2120# vdd sky130_fd_pr__pfet_01v8 ad=0.297 pd=2.13 as=0.297 ps=2.13 w=1.8 l=0.15
X1075 a_26135_12811# a_21269_11950# vdd vdd sky130_fd_pr__pfet_01v8 ad=0.5481 pd=4.36 as=0.5481 ps=4.36 w=1.89 l=0.15
X1076 vdd a_8035_9200# a_8035_8600# vdd sky130_fd_pr__pfet_01v8 ad=0.1122 pd=1.01 as=0.1122 ps=1.01 w=0.68 l=0.15
X1077 vss a_15527_8796# a_17251_9376# vss sky130_fd_pr__nfet_01v8_lvt ad=0.31 pd=2.62 as=0.165 ps=1.33 w=1 l=0.15
X1078 vss a_20911_7950# vss vss sky130_fd_pr__nfet_01v8_lvt ad=0.1595 pd=1.68 as=0 ps=0 w=0.55 l=0.15
X1079 a_23191_5530# a_22733_1814# a_17251_4856# vss sky130_fd_pr__nfet_01v8_lvt ad=0.145 pd=1.58 as=0.145 ps=1.58 w=0.5 l=0.15
X1080 a_18631_1650# f1 a_17251_1984# vdd sky130_fd_pr__pfet_01v8_lvt ad=0.261 pd=2.38 as=0.261 ps=2.38 w=0.9 l=0.35
X1081 a_8035_6240# a0 a_12367_2844# vss sky130_fd_pr__nfet_01v8_lvt ad=0.248 pd=2.22 as=0.132 ps=1.13 w=0.8 l=0.15
X1082 a_27011_1645# a_29784_1816# vss sky130_fd_pr__res_high_po_0p69 l=6.4
X1083 a_26627_11933# rst_n en vss sky130_fd_pr__nfet_01v8_lvt ad=0.2145 pd=1.63 as=0.403 ps=3.22 w=1.3 l=0.15
X1084 a_20495_10050# a_20453_1814# a_17251_9376# vdd sky130_fd_pr__pfet_01v8_lvt ad=0.261 pd=2.38 as=0.261 ps=2.38 w=0.9 l=0.35
X1085 a_18631_7950# a_18173_3298# a_14091_6504# vdd sky130_fd_pr__pfet_01v8_lvt ad=0.261 pd=2.38 as=0.261 ps=2.38 w=0.9 l=0.35
X1086 a_8035_6240# a_6063_6255# vdd vdd sky130_fd_pr__pfet_01v8 ad=0.297 pd=2.13 as=0.297 ps=2.13 w=1.8 l=0.15
X1087 vss a_18631_5530# vss vss sky130_fd_pr__nfet_01v8_lvt ad=0.1595 pd=1.68 as=0 ps=0 w=0.55 l=0.15
X1088 vss qp a_323_4520# vss sky130_fd_pr__nfet_01v8_lvt ad=0.217 pd=2.02 as=0.1155 ps=1.03 w=0.7 l=0.15
X1089 a_15527_2844# a_16781_1968# a_8035_3880# vdd sky130_fd_pr__pfet_01v8_lvt ad=0.3045 pd=2.39 as=0.609 ps=4.78 w=2.1 l=0.35
X1090 a_15527_2844# a_15901_1968# a_8035_4480# vdd sky130_fd_pr__pfet_01v8_lvt ad=0.3045 pd=2.39 as=0.609 ps=4.78 w=2.1 l=0.35
X1091 a_8035_9200# a_15901_1968# a_15527_8796# vdd sky130_fd_pr__pfet_01v8_lvt ad=0.609 pd=4.78 as=0.3045 ps=2.39 w=2.1 l=0.35
X1092 a_2903_3950# a_323_6880# vdd vdd sky130_fd_pr__pfet_01v8_lvt ad=0.1595 pd=1.39 as=0.319 ps=2.78 w=1.1 l=0.35
X1093 a_30722_8944# a_29784_8208# sky130_fd_pr__cap_mim_m3_1 l=3.7 w=3.7
X1094 a_2903_1590# a_323_6880# vss vss sky130_fd_pr__nfet_01v8_lvt ad=0.319 pd=2.78 as=0.319 ps=2.78 w=1.1 l=0.15
X1095 a_3663_8670# a_5214_8660# vss sky130_fd_pr__res_high_po_0p69 l=1.5
X1096 a_20911_10050# f3 a_17251_9376# vdd sky130_fd_pr__pfet_01v8_lvt ad=0.261 pd=2.38 as=0.261 ps=2.38 w=0.9 l=0.35
X1097 vdd a_6063_4495# a_8035_4480# vdd sky130_fd_pr__pfet_01v8 ad=0.558 pd=4.22 as=0.297 ps=2.13 w=1.8 l=0.15
X1098 a_16702_11162# a_16199_11933# vss vss sky130_fd_pr__nfet_01v8 ad=0.1218 pd=1.42 as=0.1218 ps=1.42 w=0.42 l=0.28
X1099 a_6063_6255# a_5993_6105# vdd vdd sky130_fd_pr__pfet_01v8_lvt ad=0.23925 pd=1.94 as=0.23925 ps=1.94 w=1.65 l=0.35
X1100 a_8035_9200# a_8035_8600# vdd vdd sky130_fd_pr__pfet_01v8 ad=0.1122 pd=1.01 as=0.2108 ps=1.98 w=0.68 l=0.15
X1101 a_8035_1520# a_6063_1535# vdd vdd sky130_fd_pr__pfet_01v8 ad=0.297 pd=2.13 as=0.558 ps=4.22 w=1.8 l=0.15
X1102 a_22451_7210# a_29784_6336# vss sky130_fd_pr__res_high_po_0p69 l=6.4
X1103 vss a_6063_4495# a_8035_4480# vss sky130_fd_pr__nfet_01v8_lvt ad=0.372 pd=3.02 as=0.198 ps=1.53 w=1.2 l=0.15
X1104 a_8035_3880# b7 a_15527_2844# vss sky130_fd_pr__nfet_01v8_lvt ad=0.248 pd=2.22 as=0.132 ps=1.13 w=0.8 l=0.15
X1105 a_18215_7950# a_18173_3298# a_14091_6504# vss sky130_fd_pr__nfet_01v8_lvt ad=0.145 pd=1.58 as=0.145 ps=1.58 w=0.5 l=0.15
X1106 a_22451_4790# a_20495_5530# vdd vdd sky130_fd_pr__pfet_01v8 ad=0.667 pd=5.18 as=0.667 ps=5.18 w=2.3 l=0.15
X1107 vdd a_5993_9189# a_6063_9215# vdd sky130_fd_pr__pfet_01v8_lvt ad=0.23925 pd=1.94 as=0.23925 ps=1.94 w=1.65 l=0.35
X1108 vdd a_8035_6840# a_8035_6240# vdd sky130_fd_pr__pfet_01v8 ad=0.1122 pd=1.01 as=0.1122 ps=1.01 w=0.68 l=0.15
X1109 a_23191_3750# f4 a_14091_4856# vss sky130_fd_pr__nfet_01v8_lvt ad=0.145 pd=1.58 as=0.145 ps=1.58 w=0.5 l=0.15
X1110 a_29021_12720# a_30771_12720# vss vss sky130_fd_pr__nfet_01v8_lvt ad=0.1218 pd=1.42 as=0.1218 ps=1.42 w=0.42 l=0.15
X1111 a_2903_4550# a_323_2160# vdd vdd sky130_fd_pr__pfet_01v8_lvt ad=0.1595 pd=1.39 as=0.1595 ps=1.39 w=1.1 l=0.35
X1112 vdd a_323_6880# a_2903_1590# vdd sky130_fd_pr__pfet_01v8_lvt ad=0.319 pd=2.78 as=0.1595 ps=1.39 w=1.1 l=0.35
X1113 a_8035_2120# a_6063_2135# vss vss sky130_fd_pr__nfet_01v8_lvt ad=0.198 pd=1.53 as=0.372 ps=3.02 w=1.2 l=0.15
X1114 a_27011_3745# a_25055_3750# vss vss sky130_fd_pr__nfet_01v8_lvt ad=0.1595 pd=1.68 as=0.1595 ps=1.68 w=0.55 l=0.15
X1115 a_20171_3745# a_18215_3750# vdd vdd sky130_fd_pr__pfet_01v8 ad=0.667 pd=5.18 as=0.667 ps=5.18 w=2.3 l=0.15
X1116 a_15527_4276# b3 a_8035_3880# vss sky130_fd_pr__nfet_01v8_lvt ad=0.132 pd=1.13 as=0.248 ps=2.22 w=0.8 l=0.15
X1117 a_8035_2120# a_8035_1520# vss vss sky130_fd_pr__nfet_01v8_lvt ad=0.1305 pd=1.48 as=0.1305 ps=1.48 w=0.45 l=0.15
X1118 a_27011_2690# a_25055_3430# vdd vdd sky130_fd_pr__pfet_01v8 ad=0.667 pd=5.18 as=0.667 ps=5.18 w=2.3 l=0.15
X1119 a_10451_12720# a_8701_12720# vss vss sky130_fd_pr__nfet_01v8_lvt ad=0.1218 pd=1.42 as=0.1218 ps=1.42 w=0.42 l=0.15
X1120 ep rst_n a_20347_11933# vss sky130_fd_pr__nfet_01v8_lvt ad=0.403 pd=3.22 as=0.2145 ps=1.63 w=1.3 l=0.15
X1121 a_30722_8944# a_30722_6944# vss sky130_fd_pr__res_high_po_0p35 l=8
X1122 vss ip a_323_2160# vss sky130_fd_pr__nfet_01v8_lvt ad=0.217 pd=2.02 as=0.1155 ps=1.03 w=0.7 l=0.15
X1123 a_22775_3430# f4 a_17251_1984# vss sky130_fd_pr__nfet_01v8_lvt ad=0.145 pd=1.58 as=0.145 ps=1.58 w=0.5 l=0.15
X1124 a_22449_11686# a_21781_11939# vdd vdd sky130_fd_pr__pfet_01v8 ad=0.5481 pd=4.36 as=0.5481 ps=4.36 w=1.89 l=0.15
X1125 a_8035_3880# a_6063_3895# vdd vdd sky130_fd_pr__pfet_01v8 ad=0.297 pd=2.13 as=0.297 ps=2.13 w=1.8 l=0.15
X1126 a_17251_4856# a_15527_4276# vdd vdd sky130_fd_pr__pfet_01v8 ad=0.363 pd=2.53 as=0.682 ps=5.02 w=2.2 l=0.15
X1127 a_11519_11933# a_22449_11686# a_28759_11933# vss sky130_fd_pr__nfet_01v8_lvt ad=0.434 pd=3.42 as=0.231 ps=1.73 w=1.4 l=0.15
X1128 a_11519_11933# a_9221_11939# a_10422_11162# vss sky130_fd_pr__nfet_01v8_lvt ad=0.231 pd=1.73 as=0.434 ps=3.42 w=1.4 l=0.15
X1129 a_23191_10050# f5 a_17251_9376# vdd sky130_fd_pr__pfet_01v8_lvt ad=0.261 pd=2.38 as=0.261 ps=2.38 w=0.9 l=0.35
X1130 a_10451_12720# a_9221_11939# a_16199_11933# vdd sky130_fd_pr__pfet_01v8 ad=0.37455 pd=2.6 as=0.37455 ps=2.6 w=2.27 l=0.15
X1131 vdd qn a_323_9240# vdd sky130_fd_pr__pfet_01v8_lvt ad=0.203 pd=1.69 as=0.203 ps=1.69 w=1.4 l=0.35
X1132 a_12367_8796# a6 a_8035_6240# vss sky130_fd_pr__nfet_01v8_lvt ad=0.132 pd=1.13 as=0.248 ps=2.22 w=0.8 l=0.15
X1133 ckd3 a_11519_11933# vss vss sky130_fd_pr__nfet_01v8_lvt ad=0.198 pd=1.53 as=0.372 ps=3.02 w=1.2 l=0.15
X1134 a_27011_8265# a_25055_8270# vdd vdd sky130_fd_pr__pfet_01v8 ad=0.667 pd=5.18 as=0.667 ps=5.18 w=2.3 l=0.15
X1135 a_17251_6504# a_15527_7364# vdd vdd sky130_fd_pr__pfet_01v8 ad=0.363 pd=2.53 as=0.363 ps=2.53 w=2.2 l=0.15
X1136 a_22733_1814# f5 vdd vdd sky130_fd_pr__pfet_01v8 ad=0.261 pd=2.38 as=0.261 ps=2.38 w=0.9 l=0.18
X1137 a_20495_7950# f2 a_17251_6504# vss sky130_fd_pr__nfet_01v8_lvt ad=0.145 pd=1.58 as=0.145 ps=1.58 w=0.5 l=0.15
X1138 a_6063_3895# a_5993_3745# vdd vdd sky130_fd_pr__pfet_01v8_lvt ad=0.23925 pd=1.94 as=0.23925 ps=1.94 w=1.65 l=0.35
X1139 a_22775_3750# a_22733_3298# a_14091_4856# vss sky130_fd_pr__nfet_01v8_lvt ad=0.145 pd=1.58 as=0.145 ps=1.58 w=0.5 l=0.15
X1140 a_8035_3880# a_15348_205# a_15527_7364# vdd sky130_fd_pr__pfet_01v8_lvt ad=0.609 pd=4.78 as=0.3045 ps=2.39 w=2.1 l=0.35
X1141 vdd a_323_6880# a_3663_1590# vdd sky130_fd_pr__pfet_01v8_lvt ad=0.1595 pd=1.39 as=0.1595 ps=1.39 w=1.1 l=0.35
X1142 a_22982_11162# rst_n vdd vdd sky130_fd_pr__pfet_01v8 ad=0.522 pd=4.18 as=0.522 ps=4.18 w=1.8 l=0.18
X1143 a_3663_4550# a_323_4520# vdd vdd sky130_fd_pr__pfet_01v8_lvt ad=0.1595 pd=1.39 as=0.319 ps=2.78 w=1.1 l=0.35
X1144 vdd a_22982_11162# a_24771_12720# vdd sky130_fd_pr__pfet_01v8 ad=0.33495 pd=2.36 as=0.33495 ps=2.36 w=2.03 l=0.15
X1145 vdd a_6063_9215# a_8035_9200# vdd sky130_fd_pr__pfet_01v8 ad=0.297 pd=2.13 as=0.297 ps=2.13 w=1.8 l=0.15
X1146 a_12367_2844# a2 a_8035_2120# vss sky130_fd_pr__nfet_01v8_lvt ad=0.132 pd=1.13 as=0.248 ps=2.22 w=0.8 l=0.15
X1147 cke3 a_30771_12720# vdd vdd sky130_fd_pr__pfet_01v8 ad=0.4158 pd=2.85 as=0.7812 ps=5.66 w=2.52 l=0.15
X1148 a_3663_6310# a_323_9240# vdd vdd sky130_fd_pr__pfet_01v8_lvt ad=0.1595 pd=1.39 as=0.1595 ps=1.39 w=1.1 l=0.35
X1149 a_20911_7950# a_20453_3298# a_17251_6504# vss sky130_fd_pr__nfet_01v8_lvt ad=0.145 pd=1.58 as=0.145 ps=1.58 w=0.5 l=0.15
X1150 vdd a_15527_2844# a_17251_1984# vdd sky130_fd_pr__pfet_01v8 ad=0.682 pd=5.02 as=0.363 ps=2.53 w=2.2 l=0.15
X1151 vdd a_5993_6829# a_6063_6855# vdd sky130_fd_pr__pfet_01v8_lvt ad=0.23925 pd=1.94 as=0.23925 ps=1.94 w=1.65 l=0.35
X1152 ckd3 ckd1 vdd vdd sky130_fd_pr__pfet_01v8 ad=0.5481 pd=4.36 as=0.5481 ps=4.36 w=1.89 l=0.15
X1153 a_25471_10050# a_25013_1814# a_17251_9376# vss sky130_fd_pr__nfet_01v8_lvt ad=0.145 pd=1.58 as=0.145 ps=1.58 w=0.5 l=0.15
X1154 vss a_30888_8944# dp vss sky130_fd_pr__nfet_01v8_lvt ad=0.403 pd=3.22 as=0.2145 ps=1.63 w=1.3 l=0.15
X1155 cke1 a_29021_12720# vss vss sky130_fd_pr__nfet_01v8_lvt ad=0.198 pd=1.53 as=0.372 ps=3.02 w=1.2 l=0.15
X1156 a_9221_11939# a_8709_11950# vdd vdd sky130_fd_pr__pfet_01v8 ad=0.36465 pd=2.54 as=0.36465 ps=2.54 w=2.21 l=0.15
X1157 a_18215_3430# a_18173_3298# a_17251_1984# vdd sky130_fd_pr__pfet_01v8_lvt ad=0.261 pd=2.38 as=0.261 ps=2.38 w=0.9 l=0.35
X1158 a_25055_3430# f6 a_17251_1984# vss sky130_fd_pr__nfet_01v8_lvt ad=0.145 pd=1.58 as=0.145 ps=1.58 w=0.5 l=0.15
X1159 a_2903_8670# a_323_9240# vss vss sky130_fd_pr__nfet_01v8_lvt ad=0.319 pd=2.78 as=0.319 ps=2.78 w=1.1 l=0.15
X1160 a_18631_3430# f0 a_17251_1984# vdd sky130_fd_pr__pfet_01v8_lvt ad=0.261 pd=2.38 as=0.261 ps=2.38 w=0.9 l=0.35
X1161 a_25471_3430# a_25013_3298# a_17251_1984# vss sky130_fd_pr__nfet_01v8_lvt ad=0.145 pd=1.58 as=0.145 ps=1.58 w=0.5 l=0.15
X1162 a_9919_11933# a_9889_11686# a_9827_11933# vdd sky130_fd_pr__pfet_01v8 ad=0.7037 pd=5.16 as=0.37455 ps=2.6 w=2.27 l=0.15
X1163 vdd in a_323_6880# vdd sky130_fd_pr__pfet_01v8_lvt ad=0.203 pd=1.69 as=0.203 ps=1.69 w=1.4 l=0.35
X1164 a_12548_205# a1 vdd vdd sky130_fd_pr__pfet_01v8 ad=0.261 pd=2.38 as=0.261 ps=2.38 w=0.9 l=0.18
X1165 vdd a_23191_5530# vdd vdd sky130_fd_pr__pfet_01v8 ad=0.667 pd=5.18 as=0 ps=0 w=2.3 l=0.15
X1166 vdd a_323_4520# a_2903_6910# vdd sky130_fd_pr__pfet_01v8_lvt ad=0.319 pd=2.78 as=0.1595 ps=1.39 w=1.1 l=0.35
X1167 a_8035_2120# a_6063_2135# vdd vdd sky130_fd_pr__pfet_01v8 ad=0.297 pd=2.13 as=0.297 ps=2.13 w=1.8 l=0.15
X1168 vss a_10451_12720# ckd2 vss sky130_fd_pr__nfet_01v8_lvt ad=0.372 pd=3.02 as=0.198 ps=1.53 w=1.2 l=0.15
X1169 vdd a_9919_11933# a_8701_12720# vdd sky130_fd_pr__pfet_01v8 ad=1.1067 pd=7.76 as=0.58905 ps=3.9 w=3.57 l=0.15
X1170 a_8035_6840# a2 a_12367_8796# vss sky130_fd_pr__nfet_01v8_lvt ad=0.248 pd=2.22 as=0.132 ps=1.13 w=0.8 l=0.15
X1171 vss a_12367_7364# a_14091_6504# vss sky130_fd_pr__nfet_01v8_lvt ad=0.31 pd=2.62 as=0.165 ps=1.33 w=1 l=0.15
X1172 a_8035_8600# a_6063_8615# vdd vdd sky130_fd_pr__pfet_01v8 ad=0.297 pd=2.13 as=0.558 ps=4.22 w=1.8 l=0.15
X1173 a_22775_7950# a_22733_3298# a_17251_6504# vdd sky130_fd_pr__pfet_01v8_lvt ad=0.261 pd=2.38 as=0.261 ps=2.38 w=0.9 l=0.35
X1174 a_25055_3750# a_25013_3298# a_14091_4856# vss sky130_fd_pr__nfet_01v8_lvt ad=0.145 pd=1.58 as=0.145 ps=1.58 w=0.5 l=0.15
X1175 vdd a_20911_3750# vdd vdd sky130_fd_pr__pfet_01v8 ad=0.667 pd=5.18 as=0 ps=0 w=2.3 l=0.15
X1176 a_12367_7364# a_12741_1968# a_8035_6240# vdd sky130_fd_pr__pfet_01v8_lvt ad=0.3045 pd=2.39 as=0.609 ps=4.78 w=2.1 l=0.35
X1177 a_23191_7950# a_22733_3298# a_17251_6504# vss sky130_fd_pr__nfet_01v8_lvt ad=0.145 pd=1.58 as=0.145 ps=1.58 w=0.5 l=0.15
X1178 a_13181_1968# a4 vdd vdd sky130_fd_pr__pfet_01v8 ad=0.261 pd=2.38 as=0.261 ps=2.38 w=0.9 l=0.18
X1179 a_27011_3745# a_29784_3688# vss sky130_fd_pr__res_high_po_0p69 l=6.4
X1180 a_14091_4856# a_12367_4276# vss vss sky130_fd_pr__nfet_01v8_lvt ad=0.165 pd=1.33 as=0.31 ps=2.62 w=1 l=0.15
X1181 vdd a_6063_6855# a_8035_6840# vdd sky130_fd_pr__pfet_01v8 ad=0.297 pd=2.13 as=0.297 ps=2.13 w=1.8 l=0.15
X1182 vdd a_323_9240# a_2903_8670# vdd sky130_fd_pr__pfet_01v8_lvt ad=0.319 pd=2.78 as=0.1595 ps=1.39 w=1.1 l=0.35
X1183 dn a_30722_6944# vdd vdd sky130_fd_pr__pfet_01v8_lvt ad=0.377 pd=2.89 as=0.754 ps=5.78 w=2.6 l=0.35
X1184 a_3663_3950# a_323_9240# vdd vdd sky130_fd_pr__pfet_01v8_lvt ad=0.1595 pd=1.39 as=0.1595 ps=1.39 w=1.1 l=0.35
X1185 a_6063_2135# a_5993_2109# vdd vdd sky130_fd_pr__pfet_01v8_lvt ad=0.23925 pd=1.94 as=0.23925 ps=1.94 w=1.65 l=0.35
X1186 a_29784_6336# vss sky130_fd_pr__cap_mim_m3_1 l=2.8 w=2.8
X1187 vdd a_21269_11950# a_21781_11939# vdd sky130_fd_pr__pfet_01v8 ad=0.6851 pd=5.04 as=0.36465 ps=2.54 w=2.21 l=0.15
X1188 a_8035_9200# a_6063_9215# vss vss sky130_fd_pr__nfet_01v8_lvt ad=0.198 pd=1.53 as=0.372 ps=3.02 w=1.2 l=0.15
X1189 a_17251_9376# a_15527_8796# vdd vdd sky130_fd_pr__pfet_01v8 ad=0.363 pd=2.53 as=0.363 ps=2.53 w=2.2 l=0.15
X1190 vss a_18631_7950# vss vss sky130_fd_pr__nfet_01v8_lvt ad=0.1595 pd=1.68 as=0 ps=0 w=0.55 l=0.15
X1191 a_2903_1590# a_323_6880# vdd vdd sky130_fd_pr__pfet_01v8_lvt ad=0.1595 pd=1.39 as=0.319 ps=2.78 w=1.1 l=0.35
X1192 a_8035_8600# a_16341_1968# a_15527_4276# vdd sky130_fd_pr__pfet_01v8_lvt ad=0.609 pd=4.78 as=0.3045 ps=2.39 w=2.1 l=0.35
X1193 a_30722_4424# a_29784_3688# sky130_fd_pr__cap_mim_m3_1 l=3.7 w=3.7
X1194 vss qn a_323_9240# vss sky130_fd_pr__nfet_01v8_lvt ad=0.217 pd=2.02 as=0.1155 ps=1.03 w=0.7 l=0.15
X1195 a_8035_4480# a_15348_205# a_15527_8796# vdd sky130_fd_pr__pfet_01v8_lvt ad=0.609 pd=4.78 as=0.3045 ps=2.39 w=2.1 l=0.35
X1196 a_20911_8270# f2 a_14091_9376# vss sky130_fd_pr__nfet_01v8_lvt ad=0.145 pd=1.58 as=0.145 ps=1.58 w=0.5 l=0.15
X1197 vdd a_30722_4424# a_30722_2424# vdd sky130_fd_pr__pfet_01v8_lvt ad=0.4785 pd=3.88 as=0.23925 ps=1.94 w=1.65 l=0.35
X1198 a_22733_1814# f5 vss vss sky130_fd_pr__nfet_01v8 ad=0.1305 pd=1.48 as=0.1305 ps=1.48 w=0.45 l=0.18
X1199 a_24731_3745# a_22775_3750# vss vss sky130_fd_pr__nfet_01v8_lvt ad=0.1595 pd=1.68 as=0.1595 ps=1.68 w=0.55 l=0.15
X1200 a_29021_12720# a_30771_12720# vdd vdd sky130_fd_pr__pfet_01v8 ad=0.5104 pd=4.1 as=0.5104 ps=4.1 w=1.76 l=0.15
X1201 vdd a_323_4520# a_3663_6910# vdd sky130_fd_pr__pfet_01v8_lvt ad=0.1595 pd=1.39 as=0.1595 ps=1.39 w=1.1 l=0.35
X1202 a_24731_2690# a_22775_3430# vdd vdd sky130_fd_pr__pfet_01v8 ad=0.667 pd=5.18 as=0.667 ps=5.18 w=2.3 l=0.15
X1203 vdd a_22479_11933# a_23021_12720# vdd sky130_fd_pr__pfet_01v8 ad=0.33495 pd=2.36 as=0.33495 ps=2.36 w=2.03 l=0.15
X1204 a_2903_6310# a_323_9240# vss vss sky130_fd_pr__nfet_01v8_lvt ad=0.319 pd=2.78 as=0.319 ps=2.78 w=1.1 l=0.15
X1205 a_25471_1650# f7 a_14091_1984# vss sky130_fd_pr__nfet_01v8_lvt ad=0.145 pd=1.58 as=0.145 ps=1.58 w=0.5 l=0.15
X1206 a_10451_12720# a_8701_12720# vdd vdd sky130_fd_pr__pfet_01v8 ad=0.5104 pd=4.1 as=0.5104 ps=4.1 w=1.76 l=0.15
X1207 a_20171_1645# a_18215_1650# vss vss sky130_fd_pr__nfet_01v8_lvt ad=0.1595 pd=1.68 as=0.1595 ps=1.68 w=0.55 l=0.15
X1208 a_22451_1645# a_20495_1650# vdd vdd sky130_fd_pr__pfet_01v8 ad=0.667 pd=5.18 as=0.667 ps=5.18 w=2.3 l=0.15
X1209 a_14091_1984# a_12367_2844# vdd vdd sky130_fd_pr__pfet_01v8 ad=0.363 pd=2.53 as=0.363 ps=2.53 w=2.2 l=0.15
X1210 a_25471_3750# a_25013_3298# a_14091_4856# vdd sky130_fd_pr__pfet_01v8_lvt ad=0.261 pd=2.38 as=0.261 ps=2.38 w=0.9 l=0.35
X1211 cke0 a_23021_12720# vdd vdd sky130_fd_pr__pfet_01v8 ad=0.4158 pd=2.85 as=0.4158 ps=2.85 w=2.52 l=0.15
X1212 a_8035_6840# a_8035_6240# vdd vdd sky130_fd_pr__pfet_01v8 ad=0.1122 pd=1.01 as=0.2108 ps=1.98 w=0.68 l=0.15
X1213 a_27011_4790# a_29784_3688# vss sky130_fd_pr__res_high_po_0p69 l=6.4
X1214 a_25055_7950# a_25013_3298# a_17251_6504# vdd sky130_fd_pr__pfet_01v8_lvt ad=0.261 pd=2.38 as=0.261 ps=2.38 w=0.9 l=0.35
X1215 a_22451_9310# a_29784_8208# vss sky130_fd_pr__res_high_po_0p69 l=6.4
X1216 a_20911_1650# a_20453_1814# a_14091_1984# vdd sky130_fd_pr__pfet_01v8_lvt ad=0.261 pd=2.38 as=0.261 ps=2.38 w=0.9 l=0.35
X1217 a_22982_11162# a_22479_11933# vdd vdd sky130_fd_pr__pfet_01v8 ad=0.1218 pd=1.42 as=0.1218 ps=1.42 w=0.42 l=0.28
X1218 vdd a_323_2160# a_3663_8670# vdd sky130_fd_pr__pfet_01v8_lvt ad=0.1595 pd=1.39 as=0.1595 ps=1.39 w=1.1 l=0.35
X1219 a_24731_8265# a_22775_8270# vdd vdd sky130_fd_pr__pfet_01v8 ad=0.667 pd=5.18 as=0.667 ps=5.18 w=2.3 l=0.15
X1220 vdd a_8035_4480# a_8035_3880# vdd sky130_fd_pr__pfet_01v8 ad=0.1122 pd=1.01 as=0.1122 ps=1.01 w=0.68 l=0.15
X1221 a_25471_7950# f6 a_17251_6504# vdd sky130_fd_pr__pfet_01v8_lvt ad=0.261 pd=2.38 as=0.261 ps=2.38 w=0.9 l=0.35
X1222 vss a_30722_6944# dn vss sky130_fd_pr__nfet_01v8_lvt ad=0.403 pd=3.22 as=0.2145 ps=1.63 w=1.3 l=0.15
X1223 a_2903_2190# a_323_2160# vdd vdd sky130_fd_pr__pfet_01v8_lvt ad=0.1595 pd=1.39 as=0.1595 ps=1.39 w=1.1 l=0.35
X1224 a_23191_8270# a_22733_3298# a_14091_9376# vdd sky130_fd_pr__pfet_01v8_lvt ad=0.261 pd=2.38 as=0.261 ps=2.38 w=0.9 l=0.35
X1225 a_8035_2120# a_13181_1968# a_12367_7364# vdd sky130_fd_pr__pfet_01v8_lvt ad=0.609 pd=4.78 as=0.3045 ps=2.39 w=2.1 l=0.35
X1226 a_20171_6165# a_18215_6170# vdd vdd sky130_fd_pr__pfet_01v8 ad=0.667 pd=5.18 as=0.667 ps=5.18 w=2.3 l=0.15
X1227 a_11519_11933# a_9827_11933# vss vss sky130_fd_pr__nfet_01v8_lvt ad=0.1218 pd=1.42 as=0.1218 ps=1.42 w=0.42 l=0.15
X1228 en rst_n a_26627_11933# vss sky130_fd_pr__nfet_01v8_lvt ad=0.403 pd=3.22 as=0.2145 ps=1.63 w=1.3 l=0.15
X1229 a_20495_8270# a_20453_3298# a_14091_9376# vss sky130_fd_pr__nfet_01v8_lvt ad=0.145 pd=1.58 as=0.145 ps=1.58 w=0.5 l=0.15
X1230 a_12548_205# a1 vss vss sky130_fd_pr__nfet_01v8 ad=0.1305 pd=1.48 as=0.1305 ps=1.48 w=0.45 l=0.18
X1231 a_8035_6840# a_8035_6240# vss vss sky130_fd_pr__nfet_01v8_lvt ad=0.1305 pd=1.48 as=0.1305 ps=1.48 w=0.45 l=0.15
X1232 vdd a_24771_12720# cke2 vdd sky130_fd_pr__pfet_01v8 ad=0.4158 pd=2.85 as=0.4158 ps=2.85 w=2.52 l=0.15
X1233 a_8701_12720# a_9889_11686# a_16702_11162# vss sky130_fd_pr__nfet_01v8_lvt ad=0.231 pd=1.73 as=0.434 ps=3.42 w=1.4 l=0.15
X1234 vdd a_12367_4276# a_14091_4856# vdd sky130_fd_pr__pfet_01v8 ad=0.363 pd=2.53 as=0.363 ps=2.53 w=2.2 l=0.15
X1235 a_20453_3298# f2 vdd vdd sky130_fd_pr__pfet_01v8 ad=0.261 pd=2.38 as=0.261 ps=2.38 w=0.9 l=0.18
X1236 a_12367_8796# a_12741_1968# a_8035_6840# vdd sky130_fd_pr__pfet_01v8_lvt ad=0.3045 pd=2.39 as=0.609 ps=4.78 w=2.1 l=0.35
X1237 a_18631_6170# a_18173_1814# a_17251_6504# vss sky130_fd_pr__nfet_01v8_lvt ad=0.145 pd=1.58 as=0.145 ps=1.58 w=0.5 l=0.15
X1238 a_12367_4276# a_13621_1968# a_8035_2120# vdd sky130_fd_pr__pfet_01v8_lvt ad=0.3045 pd=2.39 as=0.609 ps=4.78 w=2.1 l=0.35
X1239 dp a_30888_8944# vdd vdd sky130_fd_pr__pfet_01v8_lvt ad=0.377 pd=2.89 as=0.754 ps=5.78 w=2.6 l=0.35
X1240 a_20495_1650# f3 a_14091_1984# vdd sky130_fd_pr__pfet_01v8_lvt ad=0.261 pd=2.38 as=0.261 ps=2.38 w=0.9 l=0.35
X1241 a_8035_2120# a6 a_12367_4276# vss sky130_fd_pr__nfet_01v8_lvt ad=0.248 pd=2.22 as=0.132 ps=1.13 w=0.8 l=0.15
X1242 a_30771_12720# a_29021_12720# vss vss sky130_fd_pr__nfet_01v8_lvt ad=0.1218 pd=1.42 as=0.1218 ps=1.42 w=0.42 l=0.15
X1243 a_13181_1968# a4 vss vss sky130_fd_pr__nfet_01v8 ad=0.1305 pd=1.48 as=0.1305 ps=1.48 w=0.45 l=0.18
X1244 a_8035_9200# a_6063_9215# vdd vdd sky130_fd_pr__pfet_01v8 ad=0.297 pd=2.13 as=0.297 ps=2.13 w=1.8 l=0.15
X1245 a_8035_4480# a_8035_3880# vdd vdd sky130_fd_pr__pfet_01v8 ad=0.1122 pd=1.01 as=0.2108 ps=1.98 w=0.68 l=0.15
.ends
