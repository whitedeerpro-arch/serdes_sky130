* Exact flattened LVS reference netlist for serdes_rx_pi_4ph_5g_pdk
* Source subckt: serdes_rx_pi_4ph_iq_8ph (analog/rx/cmos_rx/spice/rx_pi_4ph_iq_5g_cand.spice)
.subckt serdes_rx_pi_4ph_5g_pdk ip qp in qn a0 a1 a2 a3 a4 a5 a6 a7 b0 b1 b2 b3 b4 b5 b6 b7 f0 f1 f2 f3 f4 f5 f6 f7 rst_n dp dn ep en ckd0 ckd1 ckd2 ckd3 cke0 cke1 cke2 cke3 vdd vss
X1 t_Xpi_ab0 a0 vss vss sky130_fd_pr__nfet_01v8 w=0.45 l=0.18
X2 t_Xpi_ab0 a0 vdd vdd sky130_fd_pr__pfet_01v8 w=0.9 l=0.18
X3 t_Xpi_ab1 a1 vss vss sky130_fd_pr__nfet_01v8 w=0.45 l=0.18
X4 t_Xpi_ab1 a1 vdd vdd sky130_fd_pr__pfet_01v8 w=0.9 l=0.18
X5 t_Xpi_ab2 a2 vss vss sky130_fd_pr__nfet_01v8 w=0.45 l=0.18
X6 t_Xpi_ab2 a2 vdd vdd sky130_fd_pr__pfet_01v8 w=0.9 l=0.18
X7 t_Xpi_ab3 a3 vss vss sky130_fd_pr__nfet_01v8 w=0.45 l=0.18
X8 t_Xpi_ab3 a3 vdd vdd sky130_fd_pr__pfet_01v8 w=0.9 l=0.18
X9 t_Xpi_ab4 a4 vss vss sky130_fd_pr__nfet_01v8 w=0.45 l=0.18
X10 t_Xpi_ab4 a4 vdd vdd sky130_fd_pr__pfet_01v8 w=0.9 l=0.18
X11 t_Xpi_ab5 a5 vss vss sky130_fd_pr__nfet_01v8 w=0.45 l=0.18
X12 t_Xpi_ab5 a5 vdd vdd sky130_fd_pr__pfet_01v8 w=0.9 l=0.18
X13 t_Xpi_ab6 a6 vss vss sky130_fd_pr__nfet_01v8 w=0.45 l=0.18
X14 t_Xpi_ab6 a6 vdd vdd sky130_fd_pr__pfet_01v8 w=0.9 l=0.18
X15 t_Xpi_ab7 a7 vss vss sky130_fd_pr__nfet_01v8 w=0.45 l=0.18
X16 t_Xpi_ab7 a7 vdd vdd sky130_fd_pr__pfet_01v8 w=0.9 l=0.18
X17 t_Xpi_bb0 b0 vss vss sky130_fd_pr__nfet_01v8 w=0.45 l=0.18
X18 t_Xpi_bb0 b0 vdd vdd sky130_fd_pr__pfet_01v8 w=0.9 l=0.18
X19 t_Xpi_bb1 b1 vss vss sky130_fd_pr__nfet_01v8 w=0.45 l=0.18
X20 t_Xpi_bb1 b1 vdd vdd sky130_fd_pr__pfet_01v8 w=0.9 l=0.18
X21 t_Xpi_bb2 b2 vss vss sky130_fd_pr__nfet_01v8 w=0.45 l=0.18
X22 t_Xpi_bb2 b2 vdd vdd sky130_fd_pr__pfet_01v8 w=0.9 l=0.18
X23 t_Xpi_bb3 b3 vss vss sky130_fd_pr__nfet_01v8 w=0.45 l=0.18
X24 t_Xpi_bb3 b3 vdd vdd sky130_fd_pr__pfet_01v8 w=0.9 l=0.18
X25 t_Xpi_bb4 b4 vss vss sky130_fd_pr__nfet_01v8 w=0.45 l=0.18
X26 t_Xpi_bb4 b4 vdd vdd sky130_fd_pr__pfet_01v8 w=0.9 l=0.18
X27 t_Xpi_bb5 b5 vss vss sky130_fd_pr__nfet_01v8 w=0.45 l=0.18
X28 t_Xpi_bb5 b5 vdd vdd sky130_fd_pr__pfet_01v8 w=0.9 l=0.18
X29 t_Xpi_bb6 b6 vss vss sky130_fd_pr__nfet_01v8 w=0.45 l=0.18
X30 t_Xpi_bb6 b6 vdd vdd sky130_fd_pr__pfet_01v8 w=0.9 l=0.18
X31 t_Xpi_bb7 b7 vss vss sky130_fd_pr__nfet_01v8 w=0.45 l=0.18
X32 t_Xpi_bb7 b7 vdd vdd sky130_fd_pr__pfet_01v8 w=0.9 l=0.18
X33 t_Xpi_fb0 f0 vss vss sky130_fd_pr__nfet_01v8 w=0.45 l=0.18
X34 t_Xpi_fb0 f0 vdd vdd sky130_fd_pr__pfet_01v8 w=0.9 l=0.18
X35 t_Xpi_fb1 f1 vss vss sky130_fd_pr__nfet_01v8 w=0.45 l=0.18
X36 t_Xpi_fb1 f1 vdd vdd sky130_fd_pr__pfet_01v8 w=0.9 l=0.18
X37 t_Xpi_fb2 f2 vss vss sky130_fd_pr__nfet_01v8 w=0.45 l=0.18
X38 t_Xpi_fb2 f2 vdd vdd sky130_fd_pr__pfet_01v8 w=0.9 l=0.18
X39 t_Xpi_fb3 f3 vss vss sky130_fd_pr__nfet_01v8 w=0.45 l=0.18
X40 t_Xpi_fb3 f3 vdd vdd sky130_fd_pr__pfet_01v8 w=0.9 l=0.18
X41 t_Xpi_fb4 f4 vss vss sky130_fd_pr__nfet_01v8 w=0.45 l=0.18
X42 t_Xpi_fb4 f4 vdd vdd sky130_fd_pr__pfet_01v8 w=0.9 l=0.18
X43 t_Xpi_fb5 f5 vss vss sky130_fd_pr__nfet_01v8 w=0.45 l=0.18
X44 t_Xpi_fb5 f5 vdd vdd sky130_fd_pr__pfet_01v8 w=0.9 l=0.18
X45 t_Xpi_fb6 f6 vss vss sky130_fd_pr__nfet_01v8 w=0.45 l=0.18
X46 t_Xpi_fb6 f6 vdd vdd sky130_fd_pr__pfet_01v8 w=0.9 l=0.18
X47 t_Xpi_fb7 f7 vss vss sky130_fd_pr__nfet_01v8 w=0.45 l=0.18
X48 t_Xpi_fb7 f7 vdd vdd sky130_fd_pr__pfet_01v8 w=0.9 l=0.18
X49 t_Xpi_Xoct_ips ip vss vss sky130_fd_pr__nfet_01v8_lvt w=1.4 l=0.15
X50 t_Xpi_Xoct_ips ip vdd vdd sky130_fd_pr__pfet_01v8_lvt w=5.6 l=0.35
X51 t_Xpi_Xoct_qps qp vss vss sky130_fd_pr__nfet_01v8_lvt w=1.4 l=0.15
X52 t_Xpi_Xoct_qps qp vdd vdd sky130_fd_pr__pfet_01v8_lvt w=5.6 l=0.35
X53 t_Xpi_Xoct_ins in vss vss sky130_fd_pr__nfet_01v8_lvt w=1.4 l=0.15
X54 t_Xpi_Xoct_ins in vdd vdd sky130_fd_pr__pfet_01v8_lvt w=5.6 l=0.35
X55 t_Xpi_Xoct_qns qn vss vss sky130_fd_pr__nfet_01v8_lvt w=1.4 l=0.15
X56 t_Xpi_Xoct_qns qn vdd vdd sky130_fd_pr__pfet_01v8_lvt w=5.6 l=0.35
X57 t_Xpi_Xoct_ips vss sky130_fd_pr__cap_mim_m3_1 w=1.75 l=1.75
X58 t_Xpi_Xoct_qps vss sky130_fd_pr__cap_mim_m3_1 w=1.75 l=1.75
X59 t_Xpi_Xoct_ins vss sky130_fd_pr__cap_mim_m3_1 w=1.75 l=1.75
X60 t_Xpi_Xoct_qns vss sky130_fd_pr__cap_mim_m3_1 w=1.75 l=1.75
X61 t_Xpi_Xoct_Xo0_da t_Xpi_Xoct_ips vss vss sky130_fd_pr__nfet_01v8_lvt w=1.1 l=0.15
X62 t_Xpi_Xoct_Xo0_da t_Xpi_Xoct_ips vdd vdd sky130_fd_pr__pfet_01v8_lvt w=4.4 l=0.35
X63 t_Xpi_Xoct_Xo0_db t_Xpi_Xoct_ips vss vss sky130_fd_pr__nfet_01v8_lvt w=1.1 l=0.15
X64 t_Xpi_Xoct_Xo0_db t_Xpi_Xoct_ips vdd vdd sky130_fd_pr__pfet_01v8_lvt w=4.4 l=0.35
X65 t_Xpi_Xoct_Xo0_da t_Xpi_Xoct_m0 vss sky130_fd_pr__res_high_po_0p69 l=1.5
X66 t_Xpi_Xoct_Xo0_db t_Xpi_Xoct_m0 vss sky130_fd_pr__res_high_po_0p69 l=1.5
X67 t_Xpi_Xoct_Xo1_da t_Xpi_Xoct_ips vss vss sky130_fd_pr__nfet_01v8_lvt w=1.1 l=0.15
X68 t_Xpi_Xoct_Xo1_da t_Xpi_Xoct_ips vdd vdd sky130_fd_pr__pfet_01v8_lvt w=4.4 l=0.35
X69 t_Xpi_Xoct_Xo1_db t_Xpi_Xoct_qps vss vss sky130_fd_pr__nfet_01v8_lvt w=1.1 l=0.15
X70 t_Xpi_Xoct_Xo1_db t_Xpi_Xoct_qps vdd vdd sky130_fd_pr__pfet_01v8_lvt w=4.4 l=0.35
X71 t_Xpi_Xoct_Xo1_da t_Xpi_Xoct_m1 vss sky130_fd_pr__res_high_po_0p69 l=1.5
X72 t_Xpi_Xoct_Xo1_db t_Xpi_Xoct_m1 vss sky130_fd_pr__res_high_po_0p69 l=1.5
X73 t_Xpi_Xoct_Xo2_da t_Xpi_Xoct_qps vss vss sky130_fd_pr__nfet_01v8_lvt w=1.1 l=0.15
X74 t_Xpi_Xoct_Xo2_da t_Xpi_Xoct_qps vdd vdd sky130_fd_pr__pfet_01v8_lvt w=4.4 l=0.35
X75 t_Xpi_Xoct_Xo2_db t_Xpi_Xoct_qps vss vss sky130_fd_pr__nfet_01v8_lvt w=1.1 l=0.15
X76 t_Xpi_Xoct_Xo2_db t_Xpi_Xoct_qps vdd vdd sky130_fd_pr__pfet_01v8_lvt w=4.4 l=0.35
X77 t_Xpi_Xoct_Xo2_da t_Xpi_Xoct_m2 vss sky130_fd_pr__res_high_po_0p69 l=1.5
X78 t_Xpi_Xoct_Xo2_db t_Xpi_Xoct_m2 vss sky130_fd_pr__res_high_po_0p69 l=1.5
X79 t_Xpi_Xoct_Xo3_da t_Xpi_Xoct_qps vss vss sky130_fd_pr__nfet_01v8_lvt w=1.1 l=0.15
X80 t_Xpi_Xoct_Xo3_da t_Xpi_Xoct_qps vdd vdd sky130_fd_pr__pfet_01v8_lvt w=4.4 l=0.35
X81 t_Xpi_Xoct_Xo3_db t_Xpi_Xoct_ins vss vss sky130_fd_pr__nfet_01v8_lvt w=1.1 l=0.15
X82 t_Xpi_Xoct_Xo3_db t_Xpi_Xoct_ins vdd vdd sky130_fd_pr__pfet_01v8_lvt w=4.4 l=0.35
X83 t_Xpi_Xoct_Xo3_da t_Xpi_Xoct_m3 vss sky130_fd_pr__res_high_po_0p69 l=1.5
X84 t_Xpi_Xoct_Xo3_db t_Xpi_Xoct_m3 vss sky130_fd_pr__res_high_po_0p69 l=1.5
X85 t_Xpi_Xoct_Xo4_da t_Xpi_Xoct_ins vss vss sky130_fd_pr__nfet_01v8_lvt w=1.1 l=0.15
X86 t_Xpi_Xoct_Xo4_da t_Xpi_Xoct_ins vdd vdd sky130_fd_pr__pfet_01v8_lvt w=4.4 l=0.35
X87 t_Xpi_Xoct_Xo4_db t_Xpi_Xoct_ins vss vss sky130_fd_pr__nfet_01v8_lvt w=1.1 l=0.15
X88 t_Xpi_Xoct_Xo4_db t_Xpi_Xoct_ins vdd vdd sky130_fd_pr__pfet_01v8_lvt w=4.4 l=0.35
X89 t_Xpi_Xoct_Xo4_da t_Xpi_Xoct_m4 vss sky130_fd_pr__res_high_po_0p69 l=1.5
X90 t_Xpi_Xoct_Xo4_db t_Xpi_Xoct_m4 vss sky130_fd_pr__res_high_po_0p69 l=1.5
X91 t_Xpi_Xoct_Xo5_da t_Xpi_Xoct_ins vss vss sky130_fd_pr__nfet_01v8_lvt w=1.1 l=0.15
X92 t_Xpi_Xoct_Xo5_da t_Xpi_Xoct_ins vdd vdd sky130_fd_pr__pfet_01v8_lvt w=4.4 l=0.35
X93 t_Xpi_Xoct_Xo5_db t_Xpi_Xoct_qns vss vss sky130_fd_pr__nfet_01v8_lvt w=1.1 l=0.15
X94 t_Xpi_Xoct_Xo5_db t_Xpi_Xoct_qns vdd vdd sky130_fd_pr__pfet_01v8_lvt w=4.4 l=0.35
X95 t_Xpi_Xoct_Xo5_da t_Xpi_Xoct_m5 vss sky130_fd_pr__res_high_po_0p69 l=1.5
X96 t_Xpi_Xoct_Xo5_db t_Xpi_Xoct_m5 vss sky130_fd_pr__res_high_po_0p69 l=1.5
X97 t_Xpi_Xoct_Xo6_da t_Xpi_Xoct_qns vss vss sky130_fd_pr__nfet_01v8_lvt w=1.1 l=0.15
X98 t_Xpi_Xoct_Xo6_da t_Xpi_Xoct_qns vdd vdd sky130_fd_pr__pfet_01v8_lvt w=4.4 l=0.35
X99 t_Xpi_Xoct_Xo6_db t_Xpi_Xoct_qns vss vss sky130_fd_pr__nfet_01v8_lvt w=1.1 l=0.15
X100 t_Xpi_Xoct_Xo6_db t_Xpi_Xoct_qns vdd vdd sky130_fd_pr__pfet_01v8_lvt w=4.4 l=0.35
X101 t_Xpi_Xoct_Xo6_da t_Xpi_Xoct_m6 vss sky130_fd_pr__res_high_po_0p69 l=1.5
X102 t_Xpi_Xoct_Xo6_db t_Xpi_Xoct_m6 vss sky130_fd_pr__res_high_po_0p69 l=1.5
X103 t_Xpi_Xoct_Xo7_da t_Xpi_Xoct_qns vss vss sky130_fd_pr__nfet_01v8_lvt w=1.1 l=0.15
X104 t_Xpi_Xoct_Xo7_da t_Xpi_Xoct_qns vdd vdd sky130_fd_pr__pfet_01v8_lvt w=4.4 l=0.35
X105 t_Xpi_Xoct_Xo7_db t_Xpi_Xoct_ips vss vss sky130_fd_pr__nfet_01v8_lvt w=1.1 l=0.15
X106 t_Xpi_Xoct_Xo7_db t_Xpi_Xoct_ips vdd vdd sky130_fd_pr__pfet_01v8_lvt w=4.4 l=0.35
X107 t_Xpi_Xoct_Xo7_da t_Xpi_Xoct_m7 vss sky130_fd_pr__res_high_po_0p69 l=1.5
X108 t_Xpi_Xoct_Xo7_db t_Xpi_Xoct_m7 vss sky130_fd_pr__res_high_po_0p69 l=1.5
X109 t_Xpi_Xoct_Xrec04_acp t_Xpi_Xoct_m0 sky130_fd_pr__cap_mim_m3_1 w=4.2 l=4.2
X110 t_Xpi_Xoct_Xrec04_acn t_Xpi_Xoct_m4 sky130_fd_pr__cap_mim_m3_1 w=4.2 l=4.2
X111 t_Xpi_Xoct_Xrec04_acp t_Xpi_Xoct_o0 vss sky130_fd_pr__res_high_po_0p35 l=9.5
X112 t_Xpi_Xoct_Xrec04_acn t_Xpi_Xoct_o4 vss sky130_fd_pr__res_high_po_0p35 l=9.5
X113 t_Xpi_Xoct_o0 t_Xpi_Xoct_Xrec04_acp vss vss sky130_fd_pr__nfet_01v8_lvt w=1.65 l=0.15
X114 t_Xpi_Xoct_o0 t_Xpi_Xoct_Xrec04_acp vdd vdd sky130_fd_pr__pfet_01v8_lvt w=6.6 l=0.35
X115 t_Xpi_Xoct_o4 t_Xpi_Xoct_Xrec04_acn vss vss sky130_fd_pr__nfet_01v8_lvt w=1.65 l=0.15
X116 t_Xpi_Xoct_o4 t_Xpi_Xoct_Xrec04_acn vdd vdd sky130_fd_pr__pfet_01v8_lvt w=6.6 l=0.35
X117 t_Xpi_Xoct_Xrec15_acp t_Xpi_Xoct_m1 sky130_fd_pr__cap_mim_m3_1 w=4.2 l=4.2
X118 t_Xpi_Xoct_Xrec15_acn t_Xpi_Xoct_m5 sky130_fd_pr__cap_mim_m3_1 w=4.2 l=4.2
X119 t_Xpi_Xoct_Xrec15_acp t_Xpi_Xoct_o1 vss sky130_fd_pr__res_high_po_0p35 l=9.5
X120 t_Xpi_Xoct_Xrec15_acn t_Xpi_Xoct_o5 vss sky130_fd_pr__res_high_po_0p35 l=9.5
X121 t_Xpi_Xoct_o1 t_Xpi_Xoct_Xrec15_acp vss vss sky130_fd_pr__nfet_01v8_lvt w=1.65 l=0.15
X122 t_Xpi_Xoct_o1 t_Xpi_Xoct_Xrec15_acp vdd vdd sky130_fd_pr__pfet_01v8_lvt w=6.6 l=0.35
X123 t_Xpi_Xoct_o5 t_Xpi_Xoct_Xrec15_acn vss vss sky130_fd_pr__nfet_01v8_lvt w=1.65 l=0.15
X124 t_Xpi_Xoct_o5 t_Xpi_Xoct_Xrec15_acn vdd vdd sky130_fd_pr__pfet_01v8_lvt w=6.6 l=0.35
X125 t_Xpi_Xoct_Xrec26_acp t_Xpi_Xoct_m2 sky130_fd_pr__cap_mim_m3_1 w=4.2 l=4.2
X126 t_Xpi_Xoct_Xrec26_acn t_Xpi_Xoct_m6 sky130_fd_pr__cap_mim_m3_1 w=4.2 l=4.2
X127 t_Xpi_Xoct_Xrec26_acp t_Xpi_Xoct_o2 vss sky130_fd_pr__res_high_po_0p35 l=9.5
X128 t_Xpi_Xoct_Xrec26_acn t_Xpi_Xoct_o6 vss sky130_fd_pr__res_high_po_0p35 l=9.5
X129 t_Xpi_Xoct_o2 t_Xpi_Xoct_Xrec26_acp vss vss sky130_fd_pr__nfet_01v8_lvt w=1.65 l=0.15
X130 t_Xpi_Xoct_o2 t_Xpi_Xoct_Xrec26_acp vdd vdd sky130_fd_pr__pfet_01v8_lvt w=6.6 l=0.35
X131 t_Xpi_Xoct_o6 t_Xpi_Xoct_Xrec26_acn vss vss sky130_fd_pr__nfet_01v8_lvt w=1.65 l=0.15
X132 t_Xpi_Xoct_o6 t_Xpi_Xoct_Xrec26_acn vdd vdd sky130_fd_pr__pfet_01v8_lvt w=6.6 l=0.35
X133 t_Xpi_Xoct_Xrec37_acp t_Xpi_Xoct_m3 sky130_fd_pr__cap_mim_m3_1 w=4.2 l=4.2
X134 t_Xpi_Xoct_Xrec37_acn t_Xpi_Xoct_m7 sky130_fd_pr__cap_mim_m3_1 w=4.2 l=4.2
X135 t_Xpi_Xoct_Xrec37_acp t_Xpi_Xoct_o3 vss sky130_fd_pr__res_high_po_0p35 l=9.5
X136 t_Xpi_Xoct_Xrec37_acn t_Xpi_Xoct_o7 vss sky130_fd_pr__res_high_po_0p35 l=9.5
X137 t_Xpi_Xoct_o3 t_Xpi_Xoct_Xrec37_acp vss vss sky130_fd_pr__nfet_01v8_lvt w=1.65 l=0.15
X138 t_Xpi_Xoct_o3 t_Xpi_Xoct_Xrec37_acp vdd vdd sky130_fd_pr__pfet_01v8_lvt w=6.6 l=0.35
X139 t_Xpi_Xoct_o7 t_Xpi_Xoct_Xrec37_acn vss vss sky130_fd_pr__nfet_01v8_lvt w=1.65 l=0.15
X140 t_Xpi_Xoct_o7 t_Xpi_Xoct_Xrec37_acn vdd vdd sky130_fd_pr__pfet_01v8_lvt w=6.6 l=0.35
X141 t_Xpi_cb0 t_Xpi_Xoct_o0 vss vss sky130_fd_pr__nfet_01v8_lvt w=2.4 l=0.15
X142 t_Xpi_cb0 t_Xpi_Xoct_o0 vdd vdd sky130_fd_pr__pfet_01v8 w=10.8 l=0.15
X143 t_Xpi_cb1 t_Xpi_Xoct_o1 vss vss sky130_fd_pr__nfet_01v8_lvt w=2.4 l=0.15
X144 t_Xpi_cb1 t_Xpi_Xoct_o1 vdd vdd sky130_fd_pr__pfet_01v8 w=10.8 l=0.15
X145 t_Xpi_cb2 t_Xpi_Xoct_o2 vss vss sky130_fd_pr__nfet_01v8_lvt w=2.4 l=0.15
X146 t_Xpi_cb2 t_Xpi_Xoct_o2 vdd vdd sky130_fd_pr__pfet_01v8 w=10.8 l=0.15
X147 t_Xpi_cb3 t_Xpi_Xoct_o3 vss vss sky130_fd_pr__nfet_01v8_lvt w=2.4 l=0.15
X148 t_Xpi_cb3 t_Xpi_Xoct_o3 vdd vdd sky130_fd_pr__pfet_01v8 w=10.8 l=0.15
X149 t_Xpi_cb4 t_Xpi_Xoct_o4 vss vss sky130_fd_pr__nfet_01v8_lvt w=2.4 l=0.15
X150 t_Xpi_cb4 t_Xpi_Xoct_o4 vdd vdd sky130_fd_pr__pfet_01v8 w=10.8 l=0.15
X151 t_Xpi_cb5 t_Xpi_Xoct_o5 vss vss sky130_fd_pr__nfet_01v8_lvt w=2.4 l=0.15
X152 t_Xpi_cb5 t_Xpi_Xoct_o5 vdd vdd sky130_fd_pr__pfet_01v8 w=10.8 l=0.15
X153 t_Xpi_cb6 t_Xpi_Xoct_o6 vss vss sky130_fd_pr__nfet_01v8_lvt w=2.4 l=0.15
X154 t_Xpi_cb6 t_Xpi_Xoct_o6 vdd vdd sky130_fd_pr__pfet_01v8 w=10.8 l=0.15
X155 t_Xpi_cb7 t_Xpi_Xoct_o7 vss vss sky130_fd_pr__nfet_01v8_lvt w=2.4 l=0.15
X156 t_Xpi_cb7 t_Xpi_Xoct_o7 vdd vdd sky130_fd_pr__pfet_01v8 w=10.8 l=0.15
X157 t_Xpi_cb4 t_Xpi_cb0 vss vss sky130_fd_pr__nfet_01v8_lvt w=0.45 l=0.15
X158 t_Xpi_cb4 t_Xpi_cb0 vdd vdd sky130_fd_pr__pfet_01v8 w=2.025 l=0.15
X159 t_Xpi_cb0 t_Xpi_cb4 vss vss sky130_fd_pr__nfet_01v8_lvt w=0.45 l=0.15
X160 t_Xpi_cb0 t_Xpi_cb4 vdd vdd sky130_fd_pr__pfet_01v8 w=2.025 l=0.15
X161 t_Xpi_cb5 t_Xpi_cb1 vss vss sky130_fd_pr__nfet_01v8_lvt w=0.45 l=0.15
X162 t_Xpi_cb5 t_Xpi_cb1 vdd vdd sky130_fd_pr__pfet_01v8 w=2.025 l=0.15
X163 t_Xpi_cb1 t_Xpi_cb5 vss vss sky130_fd_pr__nfet_01v8_lvt w=0.45 l=0.15
X164 t_Xpi_cb1 t_Xpi_cb5 vdd vdd sky130_fd_pr__pfet_01v8 w=2.025 l=0.15
X165 t_Xpi_cb6 t_Xpi_cb2 vss vss sky130_fd_pr__nfet_01v8_lvt w=0.45 l=0.15
X166 t_Xpi_cb6 t_Xpi_cb2 vdd vdd sky130_fd_pr__pfet_01v8 w=2.025 l=0.15
X167 t_Xpi_cb2 t_Xpi_cb6 vss vss sky130_fd_pr__nfet_01v8_lvt w=0.45 l=0.15
X168 t_Xpi_cb2 t_Xpi_cb6 vdd vdd sky130_fd_pr__pfet_01v8 w=2.025 l=0.15
X169 t_Xpi_cb7 t_Xpi_cb3 vss vss sky130_fd_pr__nfet_01v8_lvt w=0.45 l=0.15
X170 t_Xpi_cb7 t_Xpi_cb3 vdd vdd sky130_fd_pr__pfet_01v8 w=2.025 l=0.15
X171 t_Xpi_cb3 t_Xpi_cb7 vss vss sky130_fd_pr__nfet_01v8_lvt w=0.45 l=0.15
X172 t_Xpi_cb3 t_Xpi_cb7 vdd vdd sky130_fd_pr__pfet_01v8 w=2.025 l=0.15
X173 t_Xpi_cb0 a0 t_Xpi_Xch_d_Xmap_m vss sky130_fd_pr__nfet_01v8_lvt w=1.6 l=0.15
X174 t_Xpi_cb0 t_Xpi_ab0 t_Xpi_Xch_d_Xmap_m vdd sky130_fd_pr__pfet_01v8_lvt w=4.2 l=0.35
X175 t_Xpi_cb2 a2 t_Xpi_Xch_d_Xmap_m vss sky130_fd_pr__nfet_01v8_lvt w=1.6 l=0.15
X176 t_Xpi_cb2 t_Xpi_ab2 t_Xpi_Xch_d_Xmap_m vdd sky130_fd_pr__pfet_01v8_lvt w=4.2 l=0.35
X177 t_Xpi_cb4 a4 t_Xpi_Xch_d_Xmap_m vss sky130_fd_pr__nfet_01v8_lvt w=1.6 l=0.15
X178 t_Xpi_cb4 t_Xpi_ab4 t_Xpi_Xch_d_Xmap_m vdd sky130_fd_pr__pfet_01v8_lvt w=4.2 l=0.35
X179 t_Xpi_cb6 a6 t_Xpi_Xch_d_Xmap_m vss sky130_fd_pr__nfet_01v8_lvt w=1.6 l=0.15
X180 t_Xpi_cb6 t_Xpi_ab6 t_Xpi_Xch_d_Xmap_m vdd sky130_fd_pr__pfet_01v8_lvt w=4.2 l=0.35
X181 t_Xpi_Xch_d_cap t_Xpi_Xch_d_Xmap_m vss vss sky130_fd_pr__nfet_01v8_lvt w=2 l=0.15
X182 t_Xpi_Xch_d_cap t_Xpi_Xch_d_Xmap_m vdd vdd sky130_fd_pr__pfet_01v8 w=8.8 l=0.15
X183 t_Xpi_cb4 a0 t_Xpi_Xch_d_Xman_m vss sky130_fd_pr__nfet_01v8_lvt w=1.6 l=0.15
X184 t_Xpi_cb4 t_Xpi_ab0 t_Xpi_Xch_d_Xman_m vdd sky130_fd_pr__pfet_01v8_lvt w=4.2 l=0.35
X185 t_Xpi_cb6 a2 t_Xpi_Xch_d_Xman_m vss sky130_fd_pr__nfet_01v8_lvt w=1.6 l=0.15
X186 t_Xpi_cb6 t_Xpi_ab2 t_Xpi_Xch_d_Xman_m vdd sky130_fd_pr__pfet_01v8_lvt w=4.2 l=0.35
X187 t_Xpi_cb0 a4 t_Xpi_Xch_d_Xman_m vss sky130_fd_pr__nfet_01v8_lvt w=1.6 l=0.15
X188 t_Xpi_cb0 t_Xpi_ab4 t_Xpi_Xch_d_Xman_m vdd sky130_fd_pr__pfet_01v8_lvt w=4.2 l=0.35
X189 t_Xpi_cb2 a6 t_Xpi_Xch_d_Xman_m vss sky130_fd_pr__nfet_01v8_lvt w=1.6 l=0.15
X190 t_Xpi_cb2 t_Xpi_ab6 t_Xpi_Xch_d_Xman_m vdd sky130_fd_pr__pfet_01v8_lvt w=4.2 l=0.35
X191 t_Xpi_Xch_d_can t_Xpi_Xch_d_Xman_m vss vss sky130_fd_pr__nfet_01v8_lvt w=2 l=0.15
X192 t_Xpi_Xch_d_can t_Xpi_Xch_d_Xman_m vdd vdd sky130_fd_pr__pfet_01v8 w=8.8 l=0.15
X193 t_Xpi_cb1 b1 t_Xpi_Xch_d_Xmbp_m vss sky130_fd_pr__nfet_01v8_lvt w=1.6 l=0.15
X194 t_Xpi_cb1 t_Xpi_bb1 t_Xpi_Xch_d_Xmbp_m vdd sky130_fd_pr__pfet_01v8_lvt w=4.2 l=0.35
X195 t_Xpi_cb3 b3 t_Xpi_Xch_d_Xmbp_m vss sky130_fd_pr__nfet_01v8_lvt w=1.6 l=0.15
X196 t_Xpi_cb3 t_Xpi_bb3 t_Xpi_Xch_d_Xmbp_m vdd sky130_fd_pr__pfet_01v8_lvt w=4.2 l=0.35
X197 t_Xpi_cb5 b5 t_Xpi_Xch_d_Xmbp_m vss sky130_fd_pr__nfet_01v8_lvt w=1.6 l=0.15
X198 t_Xpi_cb5 t_Xpi_bb5 t_Xpi_Xch_d_Xmbp_m vdd sky130_fd_pr__pfet_01v8_lvt w=4.2 l=0.35
X199 t_Xpi_cb7 b7 t_Xpi_Xch_d_Xmbp_m vss sky130_fd_pr__nfet_01v8_lvt w=1.6 l=0.15
X200 t_Xpi_cb7 t_Xpi_bb7 t_Xpi_Xch_d_Xmbp_m vdd sky130_fd_pr__pfet_01v8_lvt w=4.2 l=0.35
X201 t_Xpi_Xch_d_cbp t_Xpi_Xch_d_Xmbp_m vss vss sky130_fd_pr__nfet_01v8_lvt w=2 l=0.15
X202 t_Xpi_Xch_d_cbp t_Xpi_Xch_d_Xmbp_m vdd vdd sky130_fd_pr__pfet_01v8 w=8.8 l=0.15
X203 t_Xpi_cb5 b1 t_Xpi_Xch_d_Xmbn_m vss sky130_fd_pr__nfet_01v8_lvt w=1.6 l=0.15
X204 t_Xpi_cb5 t_Xpi_bb1 t_Xpi_Xch_d_Xmbn_m vdd sky130_fd_pr__pfet_01v8_lvt w=4.2 l=0.35
X205 t_Xpi_cb7 b3 t_Xpi_Xch_d_Xmbn_m vss sky130_fd_pr__nfet_01v8_lvt w=1.6 l=0.15
X206 t_Xpi_cb7 t_Xpi_bb3 t_Xpi_Xch_d_Xmbn_m vdd sky130_fd_pr__pfet_01v8_lvt w=4.2 l=0.35
X207 t_Xpi_cb1 b5 t_Xpi_Xch_d_Xmbn_m vss sky130_fd_pr__nfet_01v8_lvt w=1.6 l=0.15
X208 t_Xpi_cb1 t_Xpi_bb5 t_Xpi_Xch_d_Xmbn_m vdd sky130_fd_pr__pfet_01v8_lvt w=4.2 l=0.35
X209 t_Xpi_cb3 b7 t_Xpi_Xch_d_Xmbn_m vss sky130_fd_pr__nfet_01v8_lvt w=1.6 l=0.15
X210 t_Xpi_cb3 t_Xpi_bb7 t_Xpi_Xch_d_Xmbn_m vdd sky130_fd_pr__pfet_01v8_lvt w=4.2 l=0.35
X211 t_Xpi_Xch_d_cbn t_Xpi_Xch_d_Xmbn_m vss vss sky130_fd_pr__nfet_01v8_lvt w=2 l=0.15
X212 t_Xpi_Xch_d_cbn t_Xpi_Xch_d_Xmbn_m vdd vdd sky130_fd_pr__pfet_01v8 w=8.8 l=0.15
X213 t_Xpi_Xch_d_cap t_Xpi_fb0 t_Xpi_Xch_d_Xmixp_Xs0_sel vss sky130_fd_pr__nfet_01v8_lvt w=0.5 l=0.15
X214 t_Xpi_Xch_d_cap f0 t_Xpi_Xch_d_Xmixp_Xs0_sel vdd sky130_fd_pr__pfet_01v8_lvt w=0.9 l=0.35
X215 t_Xpi_Xch_d_cbp f0 t_Xpi_Xch_d_Xmixp_Xs0_sel vss sky130_fd_pr__nfet_01v8_lvt w=0.5 l=0.15
X216 t_Xpi_Xch_d_cbp t_Xpi_fb0 t_Xpi_Xch_d_Xmixp_Xs0_sel vdd sky130_fd_pr__pfet_01v8_lvt w=0.9 l=0.35
X217 t_Xpi_Xch_d_Xmixp_Xs0_drv t_Xpi_Xch_d_Xmixp_Xs0_sel vss vss sky130_fd_pr__nfet_01v8_lvt w=0.55 l=0.15
X218 t_Xpi_Xch_d_Xmixp_Xs0_drv t_Xpi_Xch_d_Xmixp_Xs0_sel vdd vdd sky130_fd_pr__pfet_01v8 w=2.3 l=0.15
X219 t_Xpi_Xch_d_Xmixp_Xs0_drv t_Xpi_Xch_d_mixp vss sky130_fd_pr__res_high_po_0p69 l=6.4
X220 t_Xpi_Xch_d_cap f0 t_Xpi_Xch_d_Xmixp_Xs0_dum vss sky130_fd_pr__nfet_01v8_lvt w=0.5 l=0.15
X221 t_Xpi_Xch_d_cap t_Xpi_fb0 t_Xpi_Xch_d_Xmixp_Xs0_dum vdd sky130_fd_pr__pfet_01v8_lvt w=0.9 l=0.35
X222 t_Xpi_Xch_d_cbp t_Xpi_fb0 t_Xpi_Xch_d_Xmixp_Xs0_dum vss sky130_fd_pr__nfet_01v8_lvt w=0.5 l=0.15
X223 t_Xpi_Xch_d_cbp f0 t_Xpi_Xch_d_Xmixp_Xs0_dum vdd sky130_fd_pr__pfet_01v8_lvt w=0.9 l=0.35
X224 vss t_Xpi_Xch_d_Xmixp_Xs0_dum vss vss sky130_fd_pr__nfet_01v8_lvt w=0.55 l=0.15
X225 vdd t_Xpi_Xch_d_Xmixp_Xs0_dum vdd vdd sky130_fd_pr__pfet_01v8 w=2.3 l=0.15
X226 t_Xpi_Xch_d_cap t_Xpi_fb1 t_Xpi_Xch_d_Xmixp_Xs1_sel vss sky130_fd_pr__nfet_01v8_lvt w=0.5 l=0.15
X227 t_Xpi_Xch_d_cap f1 t_Xpi_Xch_d_Xmixp_Xs1_sel vdd sky130_fd_pr__pfet_01v8_lvt w=0.9 l=0.35
X228 t_Xpi_Xch_d_cbp f1 t_Xpi_Xch_d_Xmixp_Xs1_sel vss sky130_fd_pr__nfet_01v8_lvt w=0.5 l=0.15
X229 t_Xpi_Xch_d_cbp t_Xpi_fb1 t_Xpi_Xch_d_Xmixp_Xs1_sel vdd sky130_fd_pr__pfet_01v8_lvt w=0.9 l=0.35
X230 t_Xpi_Xch_d_Xmixp_Xs1_drv t_Xpi_Xch_d_Xmixp_Xs1_sel vss vss sky130_fd_pr__nfet_01v8_lvt w=0.55 l=0.15
X231 t_Xpi_Xch_d_Xmixp_Xs1_drv t_Xpi_Xch_d_Xmixp_Xs1_sel vdd vdd sky130_fd_pr__pfet_01v8 w=2.3 l=0.15
X232 t_Xpi_Xch_d_Xmixp_Xs1_drv t_Xpi_Xch_d_mixp vss sky130_fd_pr__res_high_po_0p69 l=6.4
X233 t_Xpi_Xch_d_cap f1 t_Xpi_Xch_d_Xmixp_Xs1_dum vss sky130_fd_pr__nfet_01v8_lvt w=0.5 l=0.15
X234 t_Xpi_Xch_d_cap t_Xpi_fb1 t_Xpi_Xch_d_Xmixp_Xs1_dum vdd sky130_fd_pr__pfet_01v8_lvt w=0.9 l=0.35
X235 t_Xpi_Xch_d_cbp t_Xpi_fb1 t_Xpi_Xch_d_Xmixp_Xs1_dum vss sky130_fd_pr__nfet_01v8_lvt w=0.5 l=0.15
X236 t_Xpi_Xch_d_cbp f1 t_Xpi_Xch_d_Xmixp_Xs1_dum vdd sky130_fd_pr__pfet_01v8_lvt w=0.9 l=0.35
X237 vss t_Xpi_Xch_d_Xmixp_Xs1_dum vss vss sky130_fd_pr__nfet_01v8_lvt w=0.55 l=0.15
X238 vdd t_Xpi_Xch_d_Xmixp_Xs1_dum vdd vdd sky130_fd_pr__pfet_01v8 w=2.3 l=0.15
X239 t_Xpi_Xch_d_cap t_Xpi_fb2 t_Xpi_Xch_d_Xmixp_Xs2_sel vss sky130_fd_pr__nfet_01v8_lvt w=0.5 l=0.15
X240 t_Xpi_Xch_d_cap f2 t_Xpi_Xch_d_Xmixp_Xs2_sel vdd sky130_fd_pr__pfet_01v8_lvt w=0.9 l=0.35
X241 t_Xpi_Xch_d_cbp f2 t_Xpi_Xch_d_Xmixp_Xs2_sel vss sky130_fd_pr__nfet_01v8_lvt w=0.5 l=0.15
X242 t_Xpi_Xch_d_cbp t_Xpi_fb2 t_Xpi_Xch_d_Xmixp_Xs2_sel vdd sky130_fd_pr__pfet_01v8_lvt w=0.9 l=0.35
X243 t_Xpi_Xch_d_Xmixp_Xs2_drv t_Xpi_Xch_d_Xmixp_Xs2_sel vss vss sky130_fd_pr__nfet_01v8_lvt w=0.55 l=0.15
X244 t_Xpi_Xch_d_Xmixp_Xs2_drv t_Xpi_Xch_d_Xmixp_Xs2_sel vdd vdd sky130_fd_pr__pfet_01v8 w=2.3 l=0.15
X245 t_Xpi_Xch_d_Xmixp_Xs2_drv t_Xpi_Xch_d_mixp vss sky130_fd_pr__res_high_po_0p69 l=6.4
X246 t_Xpi_Xch_d_cap f2 t_Xpi_Xch_d_Xmixp_Xs2_dum vss sky130_fd_pr__nfet_01v8_lvt w=0.5 l=0.15
X247 t_Xpi_Xch_d_cap t_Xpi_fb2 t_Xpi_Xch_d_Xmixp_Xs2_dum vdd sky130_fd_pr__pfet_01v8_lvt w=0.9 l=0.35
X248 t_Xpi_Xch_d_cbp t_Xpi_fb2 t_Xpi_Xch_d_Xmixp_Xs2_dum vss sky130_fd_pr__nfet_01v8_lvt w=0.5 l=0.15
X249 t_Xpi_Xch_d_cbp f2 t_Xpi_Xch_d_Xmixp_Xs2_dum vdd sky130_fd_pr__pfet_01v8_lvt w=0.9 l=0.35
X250 vss t_Xpi_Xch_d_Xmixp_Xs2_dum vss vss sky130_fd_pr__nfet_01v8_lvt w=0.55 l=0.15
X251 vdd t_Xpi_Xch_d_Xmixp_Xs2_dum vdd vdd sky130_fd_pr__pfet_01v8 w=2.3 l=0.15
X252 t_Xpi_Xch_d_cap t_Xpi_fb3 t_Xpi_Xch_d_Xmixp_Xs3_sel vss sky130_fd_pr__nfet_01v8_lvt w=0.5 l=0.15
X253 t_Xpi_Xch_d_cap f3 t_Xpi_Xch_d_Xmixp_Xs3_sel vdd sky130_fd_pr__pfet_01v8_lvt w=0.9 l=0.35
X254 t_Xpi_Xch_d_cbp f3 t_Xpi_Xch_d_Xmixp_Xs3_sel vss sky130_fd_pr__nfet_01v8_lvt w=0.5 l=0.15
X255 t_Xpi_Xch_d_cbp t_Xpi_fb3 t_Xpi_Xch_d_Xmixp_Xs3_sel vdd sky130_fd_pr__pfet_01v8_lvt w=0.9 l=0.35
X256 t_Xpi_Xch_d_Xmixp_Xs3_drv t_Xpi_Xch_d_Xmixp_Xs3_sel vss vss sky130_fd_pr__nfet_01v8_lvt w=0.55 l=0.15
X257 t_Xpi_Xch_d_Xmixp_Xs3_drv t_Xpi_Xch_d_Xmixp_Xs3_sel vdd vdd sky130_fd_pr__pfet_01v8 w=2.3 l=0.15
X258 t_Xpi_Xch_d_Xmixp_Xs3_drv t_Xpi_Xch_d_mixp vss sky130_fd_pr__res_high_po_0p69 l=6.4
X259 t_Xpi_Xch_d_cap f3 t_Xpi_Xch_d_Xmixp_Xs3_dum vss sky130_fd_pr__nfet_01v8_lvt w=0.5 l=0.15
X260 t_Xpi_Xch_d_cap t_Xpi_fb3 t_Xpi_Xch_d_Xmixp_Xs3_dum vdd sky130_fd_pr__pfet_01v8_lvt w=0.9 l=0.35
X261 t_Xpi_Xch_d_cbp t_Xpi_fb3 t_Xpi_Xch_d_Xmixp_Xs3_dum vss sky130_fd_pr__nfet_01v8_lvt w=0.5 l=0.15
X262 t_Xpi_Xch_d_cbp f3 t_Xpi_Xch_d_Xmixp_Xs3_dum vdd sky130_fd_pr__pfet_01v8_lvt w=0.9 l=0.35
X263 vss t_Xpi_Xch_d_Xmixp_Xs3_dum vss vss sky130_fd_pr__nfet_01v8_lvt w=0.55 l=0.15
X264 vdd t_Xpi_Xch_d_Xmixp_Xs3_dum vdd vdd sky130_fd_pr__pfet_01v8 w=2.3 l=0.15
X265 t_Xpi_Xch_d_cap t_Xpi_fb4 t_Xpi_Xch_d_Xmixp_Xs4_sel vss sky130_fd_pr__nfet_01v8_lvt w=0.5 l=0.15
X266 t_Xpi_Xch_d_cap f4 t_Xpi_Xch_d_Xmixp_Xs4_sel vdd sky130_fd_pr__pfet_01v8_lvt w=0.9 l=0.35
X267 t_Xpi_Xch_d_cbp f4 t_Xpi_Xch_d_Xmixp_Xs4_sel vss sky130_fd_pr__nfet_01v8_lvt w=0.5 l=0.15
X268 t_Xpi_Xch_d_cbp t_Xpi_fb4 t_Xpi_Xch_d_Xmixp_Xs4_sel vdd sky130_fd_pr__pfet_01v8_lvt w=0.9 l=0.35
X269 t_Xpi_Xch_d_Xmixp_Xs4_drv t_Xpi_Xch_d_Xmixp_Xs4_sel vss vss sky130_fd_pr__nfet_01v8_lvt w=0.55 l=0.15
X270 t_Xpi_Xch_d_Xmixp_Xs4_drv t_Xpi_Xch_d_Xmixp_Xs4_sel vdd vdd sky130_fd_pr__pfet_01v8 w=2.3 l=0.15
X271 t_Xpi_Xch_d_Xmixp_Xs4_drv t_Xpi_Xch_d_mixp vss sky130_fd_pr__res_high_po_0p69 l=6.4
X272 t_Xpi_Xch_d_cap f4 t_Xpi_Xch_d_Xmixp_Xs4_dum vss sky130_fd_pr__nfet_01v8_lvt w=0.5 l=0.15
X273 t_Xpi_Xch_d_cap t_Xpi_fb4 t_Xpi_Xch_d_Xmixp_Xs4_dum vdd sky130_fd_pr__pfet_01v8_lvt w=0.9 l=0.35
X274 t_Xpi_Xch_d_cbp t_Xpi_fb4 t_Xpi_Xch_d_Xmixp_Xs4_dum vss sky130_fd_pr__nfet_01v8_lvt w=0.5 l=0.15
X275 t_Xpi_Xch_d_cbp f4 t_Xpi_Xch_d_Xmixp_Xs4_dum vdd sky130_fd_pr__pfet_01v8_lvt w=0.9 l=0.35
X276 vss t_Xpi_Xch_d_Xmixp_Xs4_dum vss vss sky130_fd_pr__nfet_01v8_lvt w=0.55 l=0.15
X277 vdd t_Xpi_Xch_d_Xmixp_Xs4_dum vdd vdd sky130_fd_pr__pfet_01v8 w=2.3 l=0.15
X278 t_Xpi_Xch_d_cap t_Xpi_fb5 t_Xpi_Xch_d_Xmixp_Xs5_sel vss sky130_fd_pr__nfet_01v8_lvt w=0.5 l=0.15
X279 t_Xpi_Xch_d_cap f5 t_Xpi_Xch_d_Xmixp_Xs5_sel vdd sky130_fd_pr__pfet_01v8_lvt w=0.9 l=0.35
X280 t_Xpi_Xch_d_cbp f5 t_Xpi_Xch_d_Xmixp_Xs5_sel vss sky130_fd_pr__nfet_01v8_lvt w=0.5 l=0.15
X281 t_Xpi_Xch_d_cbp t_Xpi_fb5 t_Xpi_Xch_d_Xmixp_Xs5_sel vdd sky130_fd_pr__pfet_01v8_lvt w=0.9 l=0.35
X282 t_Xpi_Xch_d_Xmixp_Xs5_drv t_Xpi_Xch_d_Xmixp_Xs5_sel vss vss sky130_fd_pr__nfet_01v8_lvt w=0.55 l=0.15
X283 t_Xpi_Xch_d_Xmixp_Xs5_drv t_Xpi_Xch_d_Xmixp_Xs5_sel vdd vdd sky130_fd_pr__pfet_01v8 w=2.3 l=0.15
X284 t_Xpi_Xch_d_Xmixp_Xs5_drv t_Xpi_Xch_d_mixp vss sky130_fd_pr__res_high_po_0p69 l=6.4
X285 t_Xpi_Xch_d_cap f5 t_Xpi_Xch_d_Xmixp_Xs5_dum vss sky130_fd_pr__nfet_01v8_lvt w=0.5 l=0.15
X286 t_Xpi_Xch_d_cap t_Xpi_fb5 t_Xpi_Xch_d_Xmixp_Xs5_dum vdd sky130_fd_pr__pfet_01v8_lvt w=0.9 l=0.35
X287 t_Xpi_Xch_d_cbp t_Xpi_fb5 t_Xpi_Xch_d_Xmixp_Xs5_dum vss sky130_fd_pr__nfet_01v8_lvt w=0.5 l=0.15
X288 t_Xpi_Xch_d_cbp f5 t_Xpi_Xch_d_Xmixp_Xs5_dum vdd sky130_fd_pr__pfet_01v8_lvt w=0.9 l=0.35
X289 vss t_Xpi_Xch_d_Xmixp_Xs5_dum vss vss sky130_fd_pr__nfet_01v8_lvt w=0.55 l=0.15
X290 vdd t_Xpi_Xch_d_Xmixp_Xs5_dum vdd vdd sky130_fd_pr__pfet_01v8 w=2.3 l=0.15
X291 t_Xpi_Xch_d_cap t_Xpi_fb6 t_Xpi_Xch_d_Xmixp_Xs6_sel vss sky130_fd_pr__nfet_01v8_lvt w=0.5 l=0.15
X292 t_Xpi_Xch_d_cap f6 t_Xpi_Xch_d_Xmixp_Xs6_sel vdd sky130_fd_pr__pfet_01v8_lvt w=0.9 l=0.35
X293 t_Xpi_Xch_d_cbp f6 t_Xpi_Xch_d_Xmixp_Xs6_sel vss sky130_fd_pr__nfet_01v8_lvt w=0.5 l=0.15
X294 t_Xpi_Xch_d_cbp t_Xpi_fb6 t_Xpi_Xch_d_Xmixp_Xs6_sel vdd sky130_fd_pr__pfet_01v8_lvt w=0.9 l=0.35
X295 t_Xpi_Xch_d_Xmixp_Xs6_drv t_Xpi_Xch_d_Xmixp_Xs6_sel vss vss sky130_fd_pr__nfet_01v8_lvt w=0.55 l=0.15
X296 t_Xpi_Xch_d_Xmixp_Xs6_drv t_Xpi_Xch_d_Xmixp_Xs6_sel vdd vdd sky130_fd_pr__pfet_01v8 w=2.3 l=0.15
X297 t_Xpi_Xch_d_Xmixp_Xs6_drv t_Xpi_Xch_d_mixp vss sky130_fd_pr__res_high_po_0p69 l=6.4
X298 t_Xpi_Xch_d_cap f6 t_Xpi_Xch_d_Xmixp_Xs6_dum vss sky130_fd_pr__nfet_01v8_lvt w=0.5 l=0.15
X299 t_Xpi_Xch_d_cap t_Xpi_fb6 t_Xpi_Xch_d_Xmixp_Xs6_dum vdd sky130_fd_pr__pfet_01v8_lvt w=0.9 l=0.35
X300 t_Xpi_Xch_d_cbp t_Xpi_fb6 t_Xpi_Xch_d_Xmixp_Xs6_dum vss sky130_fd_pr__nfet_01v8_lvt w=0.5 l=0.15
X301 t_Xpi_Xch_d_cbp f6 t_Xpi_Xch_d_Xmixp_Xs6_dum vdd sky130_fd_pr__pfet_01v8_lvt w=0.9 l=0.35
X302 vss t_Xpi_Xch_d_Xmixp_Xs6_dum vss vss sky130_fd_pr__nfet_01v8_lvt w=0.55 l=0.15
X303 vdd t_Xpi_Xch_d_Xmixp_Xs6_dum vdd vdd sky130_fd_pr__pfet_01v8 w=2.3 l=0.15
X304 t_Xpi_Xch_d_cap t_Xpi_fb7 t_Xpi_Xch_d_Xmixp_Xs7_sel vss sky130_fd_pr__nfet_01v8_lvt w=0.5 l=0.15
X305 t_Xpi_Xch_d_cap f7 t_Xpi_Xch_d_Xmixp_Xs7_sel vdd sky130_fd_pr__pfet_01v8_lvt w=0.9 l=0.35
X306 t_Xpi_Xch_d_cbp f7 t_Xpi_Xch_d_Xmixp_Xs7_sel vss sky130_fd_pr__nfet_01v8_lvt w=0.5 l=0.15
X307 t_Xpi_Xch_d_cbp t_Xpi_fb7 t_Xpi_Xch_d_Xmixp_Xs7_sel vdd sky130_fd_pr__pfet_01v8_lvt w=0.9 l=0.35
X308 t_Xpi_Xch_d_Xmixp_Xs7_drv t_Xpi_Xch_d_Xmixp_Xs7_sel vss vss sky130_fd_pr__nfet_01v8_lvt w=0.55 l=0.15
X309 t_Xpi_Xch_d_Xmixp_Xs7_drv t_Xpi_Xch_d_Xmixp_Xs7_sel vdd vdd sky130_fd_pr__pfet_01v8 w=2.3 l=0.15
X310 t_Xpi_Xch_d_Xmixp_Xs7_drv t_Xpi_Xch_d_mixp vss sky130_fd_pr__res_high_po_0p69 l=6.4
X311 t_Xpi_Xch_d_cap f7 t_Xpi_Xch_d_Xmixp_Xs7_dum vss sky130_fd_pr__nfet_01v8_lvt w=0.5 l=0.15
X312 t_Xpi_Xch_d_cap t_Xpi_fb7 t_Xpi_Xch_d_Xmixp_Xs7_dum vdd sky130_fd_pr__pfet_01v8_lvt w=0.9 l=0.35
X313 t_Xpi_Xch_d_cbp t_Xpi_fb7 t_Xpi_Xch_d_Xmixp_Xs7_dum vss sky130_fd_pr__nfet_01v8_lvt w=0.5 l=0.15
X314 t_Xpi_Xch_d_cbp f7 t_Xpi_Xch_d_Xmixp_Xs7_dum vdd sky130_fd_pr__pfet_01v8_lvt w=0.9 l=0.35
X315 vss t_Xpi_Xch_d_Xmixp_Xs7_dum vss vss sky130_fd_pr__nfet_01v8_lvt w=0.55 l=0.15
X316 vdd t_Xpi_Xch_d_Xmixp_Xs7_dum vdd vdd sky130_fd_pr__pfet_01v8 w=2.3 l=0.15
X317 t_Xpi_Xch_d_mixp vss sky130_fd_pr__cap_mim_m3_1 w=2.8 l=2.8
X318 t_Xpi_Xch_d_can t_Xpi_fb0 t_Xpi_Xch_d_Xmixn_Xs0_sel vss sky130_fd_pr__nfet_01v8_lvt w=0.5 l=0.15
X319 t_Xpi_Xch_d_can f0 t_Xpi_Xch_d_Xmixn_Xs0_sel vdd sky130_fd_pr__pfet_01v8_lvt w=0.9 l=0.35
X320 t_Xpi_Xch_d_cbn f0 t_Xpi_Xch_d_Xmixn_Xs0_sel vss sky130_fd_pr__nfet_01v8_lvt w=0.5 l=0.15
X321 t_Xpi_Xch_d_cbn t_Xpi_fb0 t_Xpi_Xch_d_Xmixn_Xs0_sel vdd sky130_fd_pr__pfet_01v8_lvt w=0.9 l=0.35
X322 t_Xpi_Xch_d_Xmixn_Xs0_drv t_Xpi_Xch_d_Xmixn_Xs0_sel vss vss sky130_fd_pr__nfet_01v8_lvt w=0.55 l=0.15
X323 t_Xpi_Xch_d_Xmixn_Xs0_drv t_Xpi_Xch_d_Xmixn_Xs0_sel vdd vdd sky130_fd_pr__pfet_01v8 w=2.3 l=0.15
X324 t_Xpi_Xch_d_Xmixn_Xs0_drv t_Xpi_Xch_d_mixn vss sky130_fd_pr__res_high_po_0p69 l=6.4
X325 t_Xpi_Xch_d_can f0 t_Xpi_Xch_d_Xmixn_Xs0_dum vss sky130_fd_pr__nfet_01v8_lvt w=0.5 l=0.15
X326 t_Xpi_Xch_d_can t_Xpi_fb0 t_Xpi_Xch_d_Xmixn_Xs0_dum vdd sky130_fd_pr__pfet_01v8_lvt w=0.9 l=0.35
X327 t_Xpi_Xch_d_cbn t_Xpi_fb0 t_Xpi_Xch_d_Xmixn_Xs0_dum vss sky130_fd_pr__nfet_01v8_lvt w=0.5 l=0.15
X328 t_Xpi_Xch_d_cbn f0 t_Xpi_Xch_d_Xmixn_Xs0_dum vdd sky130_fd_pr__pfet_01v8_lvt w=0.9 l=0.35
X329 vss t_Xpi_Xch_d_Xmixn_Xs0_dum vss vss sky130_fd_pr__nfet_01v8_lvt w=0.55 l=0.15
X330 vdd t_Xpi_Xch_d_Xmixn_Xs0_dum vdd vdd sky130_fd_pr__pfet_01v8 w=2.3 l=0.15
X331 t_Xpi_Xch_d_can t_Xpi_fb1 t_Xpi_Xch_d_Xmixn_Xs1_sel vss sky130_fd_pr__nfet_01v8_lvt w=0.5 l=0.15
X332 t_Xpi_Xch_d_can f1 t_Xpi_Xch_d_Xmixn_Xs1_sel vdd sky130_fd_pr__pfet_01v8_lvt w=0.9 l=0.35
X333 t_Xpi_Xch_d_cbn f1 t_Xpi_Xch_d_Xmixn_Xs1_sel vss sky130_fd_pr__nfet_01v8_lvt w=0.5 l=0.15
X334 t_Xpi_Xch_d_cbn t_Xpi_fb1 t_Xpi_Xch_d_Xmixn_Xs1_sel vdd sky130_fd_pr__pfet_01v8_lvt w=0.9 l=0.35
X335 t_Xpi_Xch_d_Xmixn_Xs1_drv t_Xpi_Xch_d_Xmixn_Xs1_sel vss vss sky130_fd_pr__nfet_01v8_lvt w=0.55 l=0.15
X336 t_Xpi_Xch_d_Xmixn_Xs1_drv t_Xpi_Xch_d_Xmixn_Xs1_sel vdd vdd sky130_fd_pr__pfet_01v8 w=2.3 l=0.15
X337 t_Xpi_Xch_d_Xmixn_Xs1_drv t_Xpi_Xch_d_mixn vss sky130_fd_pr__res_high_po_0p69 l=6.4
X338 t_Xpi_Xch_d_can f1 t_Xpi_Xch_d_Xmixn_Xs1_dum vss sky130_fd_pr__nfet_01v8_lvt w=0.5 l=0.15
X339 t_Xpi_Xch_d_can t_Xpi_fb1 t_Xpi_Xch_d_Xmixn_Xs1_dum vdd sky130_fd_pr__pfet_01v8_lvt w=0.9 l=0.35
X340 t_Xpi_Xch_d_cbn t_Xpi_fb1 t_Xpi_Xch_d_Xmixn_Xs1_dum vss sky130_fd_pr__nfet_01v8_lvt w=0.5 l=0.15
X341 t_Xpi_Xch_d_cbn f1 t_Xpi_Xch_d_Xmixn_Xs1_dum vdd sky130_fd_pr__pfet_01v8_lvt w=0.9 l=0.35
X342 vss t_Xpi_Xch_d_Xmixn_Xs1_dum vss vss sky130_fd_pr__nfet_01v8_lvt w=0.55 l=0.15
X343 vdd t_Xpi_Xch_d_Xmixn_Xs1_dum vdd vdd sky130_fd_pr__pfet_01v8 w=2.3 l=0.15
X344 t_Xpi_Xch_d_can t_Xpi_fb2 t_Xpi_Xch_d_Xmixn_Xs2_sel vss sky130_fd_pr__nfet_01v8_lvt w=0.5 l=0.15
X345 t_Xpi_Xch_d_can f2 t_Xpi_Xch_d_Xmixn_Xs2_sel vdd sky130_fd_pr__pfet_01v8_lvt w=0.9 l=0.35
X346 t_Xpi_Xch_d_cbn f2 t_Xpi_Xch_d_Xmixn_Xs2_sel vss sky130_fd_pr__nfet_01v8_lvt w=0.5 l=0.15
X347 t_Xpi_Xch_d_cbn t_Xpi_fb2 t_Xpi_Xch_d_Xmixn_Xs2_sel vdd sky130_fd_pr__pfet_01v8_lvt w=0.9 l=0.35
X348 t_Xpi_Xch_d_Xmixn_Xs2_drv t_Xpi_Xch_d_Xmixn_Xs2_sel vss vss sky130_fd_pr__nfet_01v8_lvt w=0.55 l=0.15
X349 t_Xpi_Xch_d_Xmixn_Xs2_drv t_Xpi_Xch_d_Xmixn_Xs2_sel vdd vdd sky130_fd_pr__pfet_01v8 w=2.3 l=0.15
X350 t_Xpi_Xch_d_Xmixn_Xs2_drv t_Xpi_Xch_d_mixn vss sky130_fd_pr__res_high_po_0p69 l=6.4
X351 t_Xpi_Xch_d_can f2 t_Xpi_Xch_d_Xmixn_Xs2_dum vss sky130_fd_pr__nfet_01v8_lvt w=0.5 l=0.15
X352 t_Xpi_Xch_d_can t_Xpi_fb2 t_Xpi_Xch_d_Xmixn_Xs2_dum vdd sky130_fd_pr__pfet_01v8_lvt w=0.9 l=0.35
X353 t_Xpi_Xch_d_cbn t_Xpi_fb2 t_Xpi_Xch_d_Xmixn_Xs2_dum vss sky130_fd_pr__nfet_01v8_lvt w=0.5 l=0.15
X354 t_Xpi_Xch_d_cbn f2 t_Xpi_Xch_d_Xmixn_Xs2_dum vdd sky130_fd_pr__pfet_01v8_lvt w=0.9 l=0.35
X355 vss t_Xpi_Xch_d_Xmixn_Xs2_dum vss vss sky130_fd_pr__nfet_01v8_lvt w=0.55 l=0.15
X356 vdd t_Xpi_Xch_d_Xmixn_Xs2_dum vdd vdd sky130_fd_pr__pfet_01v8 w=2.3 l=0.15
X357 t_Xpi_Xch_d_can t_Xpi_fb3 t_Xpi_Xch_d_Xmixn_Xs3_sel vss sky130_fd_pr__nfet_01v8_lvt w=0.5 l=0.15
X358 t_Xpi_Xch_d_can f3 t_Xpi_Xch_d_Xmixn_Xs3_sel vdd sky130_fd_pr__pfet_01v8_lvt w=0.9 l=0.35
X359 t_Xpi_Xch_d_cbn f3 t_Xpi_Xch_d_Xmixn_Xs3_sel vss sky130_fd_pr__nfet_01v8_lvt w=0.5 l=0.15
X360 t_Xpi_Xch_d_cbn t_Xpi_fb3 t_Xpi_Xch_d_Xmixn_Xs3_sel vdd sky130_fd_pr__pfet_01v8_lvt w=0.9 l=0.35
X361 t_Xpi_Xch_d_Xmixn_Xs3_drv t_Xpi_Xch_d_Xmixn_Xs3_sel vss vss sky130_fd_pr__nfet_01v8_lvt w=0.55 l=0.15
X362 t_Xpi_Xch_d_Xmixn_Xs3_drv t_Xpi_Xch_d_Xmixn_Xs3_sel vdd vdd sky130_fd_pr__pfet_01v8 w=2.3 l=0.15
X363 t_Xpi_Xch_d_Xmixn_Xs3_drv t_Xpi_Xch_d_mixn vss sky130_fd_pr__res_high_po_0p69 l=6.4
X364 t_Xpi_Xch_d_can f3 t_Xpi_Xch_d_Xmixn_Xs3_dum vss sky130_fd_pr__nfet_01v8_lvt w=0.5 l=0.15
X365 t_Xpi_Xch_d_can t_Xpi_fb3 t_Xpi_Xch_d_Xmixn_Xs3_dum vdd sky130_fd_pr__pfet_01v8_lvt w=0.9 l=0.35
X366 t_Xpi_Xch_d_cbn t_Xpi_fb3 t_Xpi_Xch_d_Xmixn_Xs3_dum vss sky130_fd_pr__nfet_01v8_lvt w=0.5 l=0.15
X367 t_Xpi_Xch_d_cbn f3 t_Xpi_Xch_d_Xmixn_Xs3_dum vdd sky130_fd_pr__pfet_01v8_lvt w=0.9 l=0.35
X368 vss t_Xpi_Xch_d_Xmixn_Xs3_dum vss vss sky130_fd_pr__nfet_01v8_lvt w=0.55 l=0.15
X369 vdd t_Xpi_Xch_d_Xmixn_Xs3_dum vdd vdd sky130_fd_pr__pfet_01v8 w=2.3 l=0.15
X370 t_Xpi_Xch_d_can t_Xpi_fb4 t_Xpi_Xch_d_Xmixn_Xs4_sel vss sky130_fd_pr__nfet_01v8_lvt w=0.5 l=0.15
X371 t_Xpi_Xch_d_can f4 t_Xpi_Xch_d_Xmixn_Xs4_sel vdd sky130_fd_pr__pfet_01v8_lvt w=0.9 l=0.35
X372 t_Xpi_Xch_d_cbn f4 t_Xpi_Xch_d_Xmixn_Xs4_sel vss sky130_fd_pr__nfet_01v8_lvt w=0.5 l=0.15
X373 t_Xpi_Xch_d_cbn t_Xpi_fb4 t_Xpi_Xch_d_Xmixn_Xs4_sel vdd sky130_fd_pr__pfet_01v8_lvt w=0.9 l=0.35
X374 t_Xpi_Xch_d_Xmixn_Xs4_drv t_Xpi_Xch_d_Xmixn_Xs4_sel vss vss sky130_fd_pr__nfet_01v8_lvt w=0.55 l=0.15
X375 t_Xpi_Xch_d_Xmixn_Xs4_drv t_Xpi_Xch_d_Xmixn_Xs4_sel vdd vdd sky130_fd_pr__pfet_01v8 w=2.3 l=0.15
X376 t_Xpi_Xch_d_Xmixn_Xs4_drv t_Xpi_Xch_d_mixn vss sky130_fd_pr__res_high_po_0p69 l=6.4
X377 t_Xpi_Xch_d_can f4 t_Xpi_Xch_d_Xmixn_Xs4_dum vss sky130_fd_pr__nfet_01v8_lvt w=0.5 l=0.15
X378 t_Xpi_Xch_d_can t_Xpi_fb4 t_Xpi_Xch_d_Xmixn_Xs4_dum vdd sky130_fd_pr__pfet_01v8_lvt w=0.9 l=0.35
X379 t_Xpi_Xch_d_cbn t_Xpi_fb4 t_Xpi_Xch_d_Xmixn_Xs4_dum vss sky130_fd_pr__nfet_01v8_lvt w=0.5 l=0.15
X380 t_Xpi_Xch_d_cbn f4 t_Xpi_Xch_d_Xmixn_Xs4_dum vdd sky130_fd_pr__pfet_01v8_lvt w=0.9 l=0.35
X381 vss t_Xpi_Xch_d_Xmixn_Xs4_dum vss vss sky130_fd_pr__nfet_01v8_lvt w=0.55 l=0.15
X382 vdd t_Xpi_Xch_d_Xmixn_Xs4_dum vdd vdd sky130_fd_pr__pfet_01v8 w=2.3 l=0.15
X383 t_Xpi_Xch_d_can t_Xpi_fb5 t_Xpi_Xch_d_Xmixn_Xs5_sel vss sky130_fd_pr__nfet_01v8_lvt w=0.5 l=0.15
X384 t_Xpi_Xch_d_can f5 t_Xpi_Xch_d_Xmixn_Xs5_sel vdd sky130_fd_pr__pfet_01v8_lvt w=0.9 l=0.35
X385 t_Xpi_Xch_d_cbn f5 t_Xpi_Xch_d_Xmixn_Xs5_sel vss sky130_fd_pr__nfet_01v8_lvt w=0.5 l=0.15
X386 t_Xpi_Xch_d_cbn t_Xpi_fb5 t_Xpi_Xch_d_Xmixn_Xs5_sel vdd sky130_fd_pr__pfet_01v8_lvt w=0.9 l=0.35
X387 t_Xpi_Xch_d_Xmixn_Xs5_drv t_Xpi_Xch_d_Xmixn_Xs5_sel vss vss sky130_fd_pr__nfet_01v8_lvt w=0.55 l=0.15
X388 t_Xpi_Xch_d_Xmixn_Xs5_drv t_Xpi_Xch_d_Xmixn_Xs5_sel vdd vdd sky130_fd_pr__pfet_01v8 w=2.3 l=0.15
X389 t_Xpi_Xch_d_Xmixn_Xs5_drv t_Xpi_Xch_d_mixn vss sky130_fd_pr__res_high_po_0p69 l=6.4
X390 t_Xpi_Xch_d_can f5 t_Xpi_Xch_d_Xmixn_Xs5_dum vss sky130_fd_pr__nfet_01v8_lvt w=0.5 l=0.15
X391 t_Xpi_Xch_d_can t_Xpi_fb5 t_Xpi_Xch_d_Xmixn_Xs5_dum vdd sky130_fd_pr__pfet_01v8_lvt w=0.9 l=0.35
X392 t_Xpi_Xch_d_cbn t_Xpi_fb5 t_Xpi_Xch_d_Xmixn_Xs5_dum vss sky130_fd_pr__nfet_01v8_lvt w=0.5 l=0.15
X393 t_Xpi_Xch_d_cbn f5 t_Xpi_Xch_d_Xmixn_Xs5_dum vdd sky130_fd_pr__pfet_01v8_lvt w=0.9 l=0.35
X394 vss t_Xpi_Xch_d_Xmixn_Xs5_dum vss vss sky130_fd_pr__nfet_01v8_lvt w=0.55 l=0.15
X395 vdd t_Xpi_Xch_d_Xmixn_Xs5_dum vdd vdd sky130_fd_pr__pfet_01v8 w=2.3 l=0.15
X396 t_Xpi_Xch_d_can t_Xpi_fb6 t_Xpi_Xch_d_Xmixn_Xs6_sel vss sky130_fd_pr__nfet_01v8_lvt w=0.5 l=0.15
X397 t_Xpi_Xch_d_can f6 t_Xpi_Xch_d_Xmixn_Xs6_sel vdd sky130_fd_pr__pfet_01v8_lvt w=0.9 l=0.35
X398 t_Xpi_Xch_d_cbn f6 t_Xpi_Xch_d_Xmixn_Xs6_sel vss sky130_fd_pr__nfet_01v8_lvt w=0.5 l=0.15
X399 t_Xpi_Xch_d_cbn t_Xpi_fb6 t_Xpi_Xch_d_Xmixn_Xs6_sel vdd sky130_fd_pr__pfet_01v8_lvt w=0.9 l=0.35
X400 t_Xpi_Xch_d_Xmixn_Xs6_drv t_Xpi_Xch_d_Xmixn_Xs6_sel vss vss sky130_fd_pr__nfet_01v8_lvt w=0.55 l=0.15
X401 t_Xpi_Xch_d_Xmixn_Xs6_drv t_Xpi_Xch_d_Xmixn_Xs6_sel vdd vdd sky130_fd_pr__pfet_01v8 w=2.3 l=0.15
X402 t_Xpi_Xch_d_Xmixn_Xs6_drv t_Xpi_Xch_d_mixn vss sky130_fd_pr__res_high_po_0p69 l=6.4
X403 t_Xpi_Xch_d_can f6 t_Xpi_Xch_d_Xmixn_Xs6_dum vss sky130_fd_pr__nfet_01v8_lvt w=0.5 l=0.15
X404 t_Xpi_Xch_d_can t_Xpi_fb6 t_Xpi_Xch_d_Xmixn_Xs6_dum vdd sky130_fd_pr__pfet_01v8_lvt w=0.9 l=0.35
X405 t_Xpi_Xch_d_cbn t_Xpi_fb6 t_Xpi_Xch_d_Xmixn_Xs6_dum vss sky130_fd_pr__nfet_01v8_lvt w=0.5 l=0.15
X406 t_Xpi_Xch_d_cbn f6 t_Xpi_Xch_d_Xmixn_Xs6_dum vdd sky130_fd_pr__pfet_01v8_lvt w=0.9 l=0.35
X407 vss t_Xpi_Xch_d_Xmixn_Xs6_dum vss vss sky130_fd_pr__nfet_01v8_lvt w=0.55 l=0.15
X408 vdd t_Xpi_Xch_d_Xmixn_Xs6_dum vdd vdd sky130_fd_pr__pfet_01v8 w=2.3 l=0.15
X409 t_Xpi_Xch_d_can t_Xpi_fb7 t_Xpi_Xch_d_Xmixn_Xs7_sel vss sky130_fd_pr__nfet_01v8_lvt w=0.5 l=0.15
X410 t_Xpi_Xch_d_can f7 t_Xpi_Xch_d_Xmixn_Xs7_sel vdd sky130_fd_pr__pfet_01v8_lvt w=0.9 l=0.35
X411 t_Xpi_Xch_d_cbn f7 t_Xpi_Xch_d_Xmixn_Xs7_sel vss sky130_fd_pr__nfet_01v8_lvt w=0.5 l=0.15
X412 t_Xpi_Xch_d_cbn t_Xpi_fb7 t_Xpi_Xch_d_Xmixn_Xs7_sel vdd sky130_fd_pr__pfet_01v8_lvt w=0.9 l=0.35
X413 t_Xpi_Xch_d_Xmixn_Xs7_drv t_Xpi_Xch_d_Xmixn_Xs7_sel vss vss sky130_fd_pr__nfet_01v8_lvt w=0.55 l=0.15
X414 t_Xpi_Xch_d_Xmixn_Xs7_drv t_Xpi_Xch_d_Xmixn_Xs7_sel vdd vdd sky130_fd_pr__pfet_01v8 w=2.3 l=0.15
X415 t_Xpi_Xch_d_Xmixn_Xs7_drv t_Xpi_Xch_d_mixn vss sky130_fd_pr__res_high_po_0p69 l=6.4
X416 t_Xpi_Xch_d_can f7 t_Xpi_Xch_d_Xmixn_Xs7_dum vss sky130_fd_pr__nfet_01v8_lvt w=0.5 l=0.15
X417 t_Xpi_Xch_d_can t_Xpi_fb7 t_Xpi_Xch_d_Xmixn_Xs7_dum vdd sky130_fd_pr__pfet_01v8_lvt w=0.9 l=0.35
X418 t_Xpi_Xch_d_cbn t_Xpi_fb7 t_Xpi_Xch_d_Xmixn_Xs7_dum vss sky130_fd_pr__nfet_01v8_lvt w=0.5 l=0.15
X419 t_Xpi_Xch_d_cbn f7 t_Xpi_Xch_d_Xmixn_Xs7_dum vdd sky130_fd_pr__pfet_01v8_lvt w=0.9 l=0.35
X420 vss t_Xpi_Xch_d_Xmixn_Xs7_dum vss vss sky130_fd_pr__nfet_01v8_lvt w=0.55 l=0.15
X421 vdd t_Xpi_Xch_d_Xmixn_Xs7_dum vdd vdd sky130_fd_pr__pfet_01v8 w=2.3 l=0.15
X422 t_Xpi_Xch_d_mixn vss sky130_fd_pr__cap_mim_m3_1 w=2.8 l=2.8
X423 t_Xpi_Xch_d_Xrec_acp t_Xpi_Xch_d_mixp sky130_fd_pr__cap_mim_m3_1 w=3.7 l=3.7
X424 t_Xpi_Xch_d_Xrec_acn t_Xpi_Xch_d_mixn sky130_fd_pr__cap_mim_m3_1 w=3.7 l=3.7
X425 t_Xpi_Xch_d_Xrec_acp t_Xpi_Xch_d_r1p vss sky130_fd_pr__res_high_po_0p35 l=8
X426 t_Xpi_Xch_d_Xrec_acn t_Xpi_Xch_d_r1n vss sky130_fd_pr__res_high_po_0p35 l=8
X427 t_Xpi_Xch_d_r1p t_Xpi_Xch_d_Xrec_acp vss vss sky130_fd_pr__nfet_01v8_lvt w=1.65 l=0.15
X428 t_Xpi_Xch_d_r1p t_Xpi_Xch_d_Xrec_acp vdd vdd sky130_fd_pr__pfet_01v8_lvt w=6.6 l=0.35
X429 t_Xpi_Xch_d_r1n t_Xpi_Xch_d_Xrec_acn vss vss sky130_fd_pr__nfet_01v8_lvt w=1.65 l=0.15
X430 t_Xpi_Xch_d_r1n t_Xpi_Xch_d_Xrec_acn vdd vdd sky130_fd_pr__pfet_01v8_lvt w=6.6 l=0.35
X431 dp t_Xpi_Xch_d_r1n vss vss sky130_fd_pr__nfet_01v8_lvt w=2.6 l=0.15
X432 dp t_Xpi_Xch_d_r1n vdd vdd sky130_fd_pr__pfet_01v8_lvt w=10.4 l=0.35
X433 dn t_Xpi_Xch_d_r1p vss vss sky130_fd_pr__nfet_01v8_lvt w=2.6 l=0.15
X434 dn t_Xpi_Xch_d_r1p vdd vdd sky130_fd_pr__pfet_01v8_lvt w=10.4 l=0.35
X435 t_Xpi_cb2 a0 t_Xpi_Xch_e_Xmap_m vss sky130_fd_pr__nfet_01v8_lvt w=1.6 l=0.15
X436 t_Xpi_cb2 t_Xpi_ab0 t_Xpi_Xch_e_Xmap_m vdd sky130_fd_pr__pfet_01v8_lvt w=4.2 l=0.35
X437 t_Xpi_cb4 a2 t_Xpi_Xch_e_Xmap_m vss sky130_fd_pr__nfet_01v8_lvt w=1.6 l=0.15
X438 t_Xpi_cb4 t_Xpi_ab2 t_Xpi_Xch_e_Xmap_m vdd sky130_fd_pr__pfet_01v8_lvt w=4.2 l=0.35
X439 t_Xpi_cb6 a4 t_Xpi_Xch_e_Xmap_m vss sky130_fd_pr__nfet_01v8_lvt w=1.6 l=0.15
X440 t_Xpi_cb6 t_Xpi_ab4 t_Xpi_Xch_e_Xmap_m vdd sky130_fd_pr__pfet_01v8_lvt w=4.2 l=0.35
X441 t_Xpi_cb0 a6 t_Xpi_Xch_e_Xmap_m vss sky130_fd_pr__nfet_01v8_lvt w=1.6 l=0.15
X442 t_Xpi_cb0 t_Xpi_ab6 t_Xpi_Xch_e_Xmap_m vdd sky130_fd_pr__pfet_01v8_lvt w=4.2 l=0.35
X443 t_Xpi_Xch_e_cap t_Xpi_Xch_e_Xmap_m vss vss sky130_fd_pr__nfet_01v8_lvt w=2 l=0.15
X444 t_Xpi_Xch_e_cap t_Xpi_Xch_e_Xmap_m vdd vdd sky130_fd_pr__pfet_01v8 w=8.8 l=0.15
X445 t_Xpi_cb6 a0 t_Xpi_Xch_e_Xman_m vss sky130_fd_pr__nfet_01v8_lvt w=1.6 l=0.15
X446 t_Xpi_cb6 t_Xpi_ab0 t_Xpi_Xch_e_Xman_m vdd sky130_fd_pr__pfet_01v8_lvt w=4.2 l=0.35
X447 t_Xpi_cb0 a2 t_Xpi_Xch_e_Xman_m vss sky130_fd_pr__nfet_01v8_lvt w=1.6 l=0.15
X448 t_Xpi_cb0 t_Xpi_ab2 t_Xpi_Xch_e_Xman_m vdd sky130_fd_pr__pfet_01v8_lvt w=4.2 l=0.35
X449 t_Xpi_cb2 a4 t_Xpi_Xch_e_Xman_m vss sky130_fd_pr__nfet_01v8_lvt w=1.6 l=0.15
X450 t_Xpi_cb2 t_Xpi_ab4 t_Xpi_Xch_e_Xman_m vdd sky130_fd_pr__pfet_01v8_lvt w=4.2 l=0.35
X451 t_Xpi_cb4 a6 t_Xpi_Xch_e_Xman_m vss sky130_fd_pr__nfet_01v8_lvt w=1.6 l=0.15
X452 t_Xpi_cb4 t_Xpi_ab6 t_Xpi_Xch_e_Xman_m vdd sky130_fd_pr__pfet_01v8_lvt w=4.2 l=0.35
X453 t_Xpi_Xch_e_can t_Xpi_Xch_e_Xman_m vss vss sky130_fd_pr__nfet_01v8_lvt w=2 l=0.15
X454 t_Xpi_Xch_e_can t_Xpi_Xch_e_Xman_m vdd vdd sky130_fd_pr__pfet_01v8 w=8.8 l=0.15
X455 t_Xpi_cb3 b1 t_Xpi_Xch_e_Xmbp_m vss sky130_fd_pr__nfet_01v8_lvt w=1.6 l=0.15
X456 t_Xpi_cb3 t_Xpi_bb1 t_Xpi_Xch_e_Xmbp_m vdd sky130_fd_pr__pfet_01v8_lvt w=4.2 l=0.35
X457 t_Xpi_cb5 b3 t_Xpi_Xch_e_Xmbp_m vss sky130_fd_pr__nfet_01v8_lvt w=1.6 l=0.15
X458 t_Xpi_cb5 t_Xpi_bb3 t_Xpi_Xch_e_Xmbp_m vdd sky130_fd_pr__pfet_01v8_lvt w=4.2 l=0.35
X459 t_Xpi_cb7 b5 t_Xpi_Xch_e_Xmbp_m vss sky130_fd_pr__nfet_01v8_lvt w=1.6 l=0.15
X460 t_Xpi_cb7 t_Xpi_bb5 t_Xpi_Xch_e_Xmbp_m vdd sky130_fd_pr__pfet_01v8_lvt w=4.2 l=0.35
X461 t_Xpi_cb1 b7 t_Xpi_Xch_e_Xmbp_m vss sky130_fd_pr__nfet_01v8_lvt w=1.6 l=0.15
X462 t_Xpi_cb1 t_Xpi_bb7 t_Xpi_Xch_e_Xmbp_m vdd sky130_fd_pr__pfet_01v8_lvt w=4.2 l=0.35
X463 t_Xpi_Xch_e_cbp t_Xpi_Xch_e_Xmbp_m vss vss sky130_fd_pr__nfet_01v8_lvt w=2 l=0.15
X464 t_Xpi_Xch_e_cbp t_Xpi_Xch_e_Xmbp_m vdd vdd sky130_fd_pr__pfet_01v8 w=8.8 l=0.15
X465 t_Xpi_cb7 b1 t_Xpi_Xch_e_Xmbn_m vss sky130_fd_pr__nfet_01v8_lvt w=1.6 l=0.15
X466 t_Xpi_cb7 t_Xpi_bb1 t_Xpi_Xch_e_Xmbn_m vdd sky130_fd_pr__pfet_01v8_lvt w=4.2 l=0.35
X467 t_Xpi_cb1 b3 t_Xpi_Xch_e_Xmbn_m vss sky130_fd_pr__nfet_01v8_lvt w=1.6 l=0.15
X468 t_Xpi_cb1 t_Xpi_bb3 t_Xpi_Xch_e_Xmbn_m vdd sky130_fd_pr__pfet_01v8_lvt w=4.2 l=0.35
X469 t_Xpi_cb3 b5 t_Xpi_Xch_e_Xmbn_m vss sky130_fd_pr__nfet_01v8_lvt w=1.6 l=0.15
X470 t_Xpi_cb3 t_Xpi_bb5 t_Xpi_Xch_e_Xmbn_m vdd sky130_fd_pr__pfet_01v8_lvt w=4.2 l=0.35
X471 t_Xpi_cb5 b7 t_Xpi_Xch_e_Xmbn_m vss sky130_fd_pr__nfet_01v8_lvt w=1.6 l=0.15
X472 t_Xpi_cb5 t_Xpi_bb7 t_Xpi_Xch_e_Xmbn_m vdd sky130_fd_pr__pfet_01v8_lvt w=4.2 l=0.35
X473 t_Xpi_Xch_e_cbn t_Xpi_Xch_e_Xmbn_m vss vss sky130_fd_pr__nfet_01v8_lvt w=2 l=0.15
X474 t_Xpi_Xch_e_cbn t_Xpi_Xch_e_Xmbn_m vdd vdd sky130_fd_pr__pfet_01v8 w=8.8 l=0.15
X475 t_Xpi_Xch_e_cap t_Xpi_fb0 t_Xpi_Xch_e_Xmixp_Xs0_sel vss sky130_fd_pr__nfet_01v8_lvt w=0.5 l=0.15
X476 t_Xpi_Xch_e_cap f0 t_Xpi_Xch_e_Xmixp_Xs0_sel vdd sky130_fd_pr__pfet_01v8_lvt w=0.9 l=0.35
X477 t_Xpi_Xch_e_cbp f0 t_Xpi_Xch_e_Xmixp_Xs0_sel vss sky130_fd_pr__nfet_01v8_lvt w=0.5 l=0.15
X478 t_Xpi_Xch_e_cbp t_Xpi_fb0 t_Xpi_Xch_e_Xmixp_Xs0_sel vdd sky130_fd_pr__pfet_01v8_lvt w=0.9 l=0.35
X479 t_Xpi_Xch_e_Xmixp_Xs0_drv t_Xpi_Xch_e_Xmixp_Xs0_sel vss vss sky130_fd_pr__nfet_01v8_lvt w=0.55 l=0.15
X480 t_Xpi_Xch_e_Xmixp_Xs0_drv t_Xpi_Xch_e_Xmixp_Xs0_sel vdd vdd sky130_fd_pr__pfet_01v8 w=2.3 l=0.15
X481 t_Xpi_Xch_e_Xmixp_Xs0_drv t_Xpi_Xch_e_mixp vss sky130_fd_pr__res_high_po_0p69 l=6.4
X482 t_Xpi_Xch_e_cap f0 t_Xpi_Xch_e_Xmixp_Xs0_dum vss sky130_fd_pr__nfet_01v8_lvt w=0.5 l=0.15
X483 t_Xpi_Xch_e_cap t_Xpi_fb0 t_Xpi_Xch_e_Xmixp_Xs0_dum vdd sky130_fd_pr__pfet_01v8_lvt w=0.9 l=0.35
X484 t_Xpi_Xch_e_cbp t_Xpi_fb0 t_Xpi_Xch_e_Xmixp_Xs0_dum vss sky130_fd_pr__nfet_01v8_lvt w=0.5 l=0.15
X485 t_Xpi_Xch_e_cbp f0 t_Xpi_Xch_e_Xmixp_Xs0_dum vdd sky130_fd_pr__pfet_01v8_lvt w=0.9 l=0.35
X486 vss t_Xpi_Xch_e_Xmixp_Xs0_dum vss vss sky130_fd_pr__nfet_01v8_lvt w=0.55 l=0.15
X487 vdd t_Xpi_Xch_e_Xmixp_Xs0_dum vdd vdd sky130_fd_pr__pfet_01v8 w=2.3 l=0.15
X488 t_Xpi_Xch_e_cap t_Xpi_fb1 t_Xpi_Xch_e_Xmixp_Xs1_sel vss sky130_fd_pr__nfet_01v8_lvt w=0.5 l=0.15
X489 t_Xpi_Xch_e_cap f1 t_Xpi_Xch_e_Xmixp_Xs1_sel vdd sky130_fd_pr__pfet_01v8_lvt w=0.9 l=0.35
X490 t_Xpi_Xch_e_cbp f1 t_Xpi_Xch_e_Xmixp_Xs1_sel vss sky130_fd_pr__nfet_01v8_lvt w=0.5 l=0.15
X491 t_Xpi_Xch_e_cbp t_Xpi_fb1 t_Xpi_Xch_e_Xmixp_Xs1_sel vdd sky130_fd_pr__pfet_01v8_lvt w=0.9 l=0.35
X492 t_Xpi_Xch_e_Xmixp_Xs1_drv t_Xpi_Xch_e_Xmixp_Xs1_sel vss vss sky130_fd_pr__nfet_01v8_lvt w=0.55 l=0.15
X493 t_Xpi_Xch_e_Xmixp_Xs1_drv t_Xpi_Xch_e_Xmixp_Xs1_sel vdd vdd sky130_fd_pr__pfet_01v8 w=2.3 l=0.15
X494 t_Xpi_Xch_e_Xmixp_Xs1_drv t_Xpi_Xch_e_mixp vss sky130_fd_pr__res_high_po_0p69 l=6.4
X495 t_Xpi_Xch_e_cap f1 t_Xpi_Xch_e_Xmixp_Xs1_dum vss sky130_fd_pr__nfet_01v8_lvt w=0.5 l=0.15
X496 t_Xpi_Xch_e_cap t_Xpi_fb1 t_Xpi_Xch_e_Xmixp_Xs1_dum vdd sky130_fd_pr__pfet_01v8_lvt w=0.9 l=0.35
X497 t_Xpi_Xch_e_cbp t_Xpi_fb1 t_Xpi_Xch_e_Xmixp_Xs1_dum vss sky130_fd_pr__nfet_01v8_lvt w=0.5 l=0.15
X498 t_Xpi_Xch_e_cbp f1 t_Xpi_Xch_e_Xmixp_Xs1_dum vdd sky130_fd_pr__pfet_01v8_lvt w=0.9 l=0.35
X499 vss t_Xpi_Xch_e_Xmixp_Xs1_dum vss vss sky130_fd_pr__nfet_01v8_lvt w=0.55 l=0.15
X500 vdd t_Xpi_Xch_e_Xmixp_Xs1_dum vdd vdd sky130_fd_pr__pfet_01v8 w=2.3 l=0.15
X501 t_Xpi_Xch_e_cap t_Xpi_fb2 t_Xpi_Xch_e_Xmixp_Xs2_sel vss sky130_fd_pr__nfet_01v8_lvt w=0.5 l=0.15
X502 t_Xpi_Xch_e_cap f2 t_Xpi_Xch_e_Xmixp_Xs2_sel vdd sky130_fd_pr__pfet_01v8_lvt w=0.9 l=0.35
X503 t_Xpi_Xch_e_cbp f2 t_Xpi_Xch_e_Xmixp_Xs2_sel vss sky130_fd_pr__nfet_01v8_lvt w=0.5 l=0.15
X504 t_Xpi_Xch_e_cbp t_Xpi_fb2 t_Xpi_Xch_e_Xmixp_Xs2_sel vdd sky130_fd_pr__pfet_01v8_lvt w=0.9 l=0.35
X505 t_Xpi_Xch_e_Xmixp_Xs2_drv t_Xpi_Xch_e_Xmixp_Xs2_sel vss vss sky130_fd_pr__nfet_01v8_lvt w=0.55 l=0.15
X506 t_Xpi_Xch_e_Xmixp_Xs2_drv t_Xpi_Xch_e_Xmixp_Xs2_sel vdd vdd sky130_fd_pr__pfet_01v8 w=2.3 l=0.15
X507 t_Xpi_Xch_e_Xmixp_Xs2_drv t_Xpi_Xch_e_mixp vss sky130_fd_pr__res_high_po_0p69 l=6.4
X508 t_Xpi_Xch_e_cap f2 t_Xpi_Xch_e_Xmixp_Xs2_dum vss sky130_fd_pr__nfet_01v8_lvt w=0.5 l=0.15
X509 t_Xpi_Xch_e_cap t_Xpi_fb2 t_Xpi_Xch_e_Xmixp_Xs2_dum vdd sky130_fd_pr__pfet_01v8_lvt w=0.9 l=0.35
X510 t_Xpi_Xch_e_cbp t_Xpi_fb2 t_Xpi_Xch_e_Xmixp_Xs2_dum vss sky130_fd_pr__nfet_01v8_lvt w=0.5 l=0.15
X511 t_Xpi_Xch_e_cbp f2 t_Xpi_Xch_e_Xmixp_Xs2_dum vdd sky130_fd_pr__pfet_01v8_lvt w=0.9 l=0.35
X512 vss t_Xpi_Xch_e_Xmixp_Xs2_dum vss vss sky130_fd_pr__nfet_01v8_lvt w=0.55 l=0.15
X513 vdd t_Xpi_Xch_e_Xmixp_Xs2_dum vdd vdd sky130_fd_pr__pfet_01v8 w=2.3 l=0.15
X514 t_Xpi_Xch_e_cap t_Xpi_fb3 t_Xpi_Xch_e_Xmixp_Xs3_sel vss sky130_fd_pr__nfet_01v8_lvt w=0.5 l=0.15
X515 t_Xpi_Xch_e_cap f3 t_Xpi_Xch_e_Xmixp_Xs3_sel vdd sky130_fd_pr__pfet_01v8_lvt w=0.9 l=0.35
X516 t_Xpi_Xch_e_cbp f3 t_Xpi_Xch_e_Xmixp_Xs3_sel vss sky130_fd_pr__nfet_01v8_lvt w=0.5 l=0.15
X517 t_Xpi_Xch_e_cbp t_Xpi_fb3 t_Xpi_Xch_e_Xmixp_Xs3_sel vdd sky130_fd_pr__pfet_01v8_lvt w=0.9 l=0.35
X518 t_Xpi_Xch_e_Xmixp_Xs3_drv t_Xpi_Xch_e_Xmixp_Xs3_sel vss vss sky130_fd_pr__nfet_01v8_lvt w=0.55 l=0.15
X519 t_Xpi_Xch_e_Xmixp_Xs3_drv t_Xpi_Xch_e_Xmixp_Xs3_sel vdd vdd sky130_fd_pr__pfet_01v8 w=2.3 l=0.15
X520 t_Xpi_Xch_e_Xmixp_Xs3_drv t_Xpi_Xch_e_mixp vss sky130_fd_pr__res_high_po_0p69 l=6.4
X521 t_Xpi_Xch_e_cap f3 t_Xpi_Xch_e_Xmixp_Xs3_dum vss sky130_fd_pr__nfet_01v8_lvt w=0.5 l=0.15
X522 t_Xpi_Xch_e_cap t_Xpi_fb3 t_Xpi_Xch_e_Xmixp_Xs3_dum vdd sky130_fd_pr__pfet_01v8_lvt w=0.9 l=0.35
X523 t_Xpi_Xch_e_cbp t_Xpi_fb3 t_Xpi_Xch_e_Xmixp_Xs3_dum vss sky130_fd_pr__nfet_01v8_lvt w=0.5 l=0.15
X524 t_Xpi_Xch_e_cbp f3 t_Xpi_Xch_e_Xmixp_Xs3_dum vdd sky130_fd_pr__pfet_01v8_lvt w=0.9 l=0.35
X525 vss t_Xpi_Xch_e_Xmixp_Xs3_dum vss vss sky130_fd_pr__nfet_01v8_lvt w=0.55 l=0.15
X526 vdd t_Xpi_Xch_e_Xmixp_Xs3_dum vdd vdd sky130_fd_pr__pfet_01v8 w=2.3 l=0.15
X527 t_Xpi_Xch_e_cap t_Xpi_fb4 t_Xpi_Xch_e_Xmixp_Xs4_sel vss sky130_fd_pr__nfet_01v8_lvt w=0.5 l=0.15
X528 t_Xpi_Xch_e_cap f4 t_Xpi_Xch_e_Xmixp_Xs4_sel vdd sky130_fd_pr__pfet_01v8_lvt w=0.9 l=0.35
X529 t_Xpi_Xch_e_cbp f4 t_Xpi_Xch_e_Xmixp_Xs4_sel vss sky130_fd_pr__nfet_01v8_lvt w=0.5 l=0.15
X530 t_Xpi_Xch_e_cbp t_Xpi_fb4 t_Xpi_Xch_e_Xmixp_Xs4_sel vdd sky130_fd_pr__pfet_01v8_lvt w=0.9 l=0.35
X531 t_Xpi_Xch_e_Xmixp_Xs4_drv t_Xpi_Xch_e_Xmixp_Xs4_sel vss vss sky130_fd_pr__nfet_01v8_lvt w=0.55 l=0.15
X532 t_Xpi_Xch_e_Xmixp_Xs4_drv t_Xpi_Xch_e_Xmixp_Xs4_sel vdd vdd sky130_fd_pr__pfet_01v8 w=2.3 l=0.15
X533 t_Xpi_Xch_e_Xmixp_Xs4_drv t_Xpi_Xch_e_mixp vss sky130_fd_pr__res_high_po_0p69 l=6.4
X534 t_Xpi_Xch_e_cap f4 t_Xpi_Xch_e_Xmixp_Xs4_dum vss sky130_fd_pr__nfet_01v8_lvt w=0.5 l=0.15
X535 t_Xpi_Xch_e_cap t_Xpi_fb4 t_Xpi_Xch_e_Xmixp_Xs4_dum vdd sky130_fd_pr__pfet_01v8_lvt w=0.9 l=0.35
X536 t_Xpi_Xch_e_cbp t_Xpi_fb4 t_Xpi_Xch_e_Xmixp_Xs4_dum vss sky130_fd_pr__nfet_01v8_lvt w=0.5 l=0.15
X537 t_Xpi_Xch_e_cbp f4 t_Xpi_Xch_e_Xmixp_Xs4_dum vdd sky130_fd_pr__pfet_01v8_lvt w=0.9 l=0.35
X538 vss t_Xpi_Xch_e_Xmixp_Xs4_dum vss vss sky130_fd_pr__nfet_01v8_lvt w=0.55 l=0.15
X539 vdd t_Xpi_Xch_e_Xmixp_Xs4_dum vdd vdd sky130_fd_pr__pfet_01v8 w=2.3 l=0.15
X540 t_Xpi_Xch_e_cap t_Xpi_fb5 t_Xpi_Xch_e_Xmixp_Xs5_sel vss sky130_fd_pr__nfet_01v8_lvt w=0.5 l=0.15
X541 t_Xpi_Xch_e_cap f5 t_Xpi_Xch_e_Xmixp_Xs5_sel vdd sky130_fd_pr__pfet_01v8_lvt w=0.9 l=0.35
X542 t_Xpi_Xch_e_cbp f5 t_Xpi_Xch_e_Xmixp_Xs5_sel vss sky130_fd_pr__nfet_01v8_lvt w=0.5 l=0.15
X543 t_Xpi_Xch_e_cbp t_Xpi_fb5 t_Xpi_Xch_e_Xmixp_Xs5_sel vdd sky130_fd_pr__pfet_01v8_lvt w=0.9 l=0.35
X544 t_Xpi_Xch_e_Xmixp_Xs5_drv t_Xpi_Xch_e_Xmixp_Xs5_sel vss vss sky130_fd_pr__nfet_01v8_lvt w=0.55 l=0.15
X545 t_Xpi_Xch_e_Xmixp_Xs5_drv t_Xpi_Xch_e_Xmixp_Xs5_sel vdd vdd sky130_fd_pr__pfet_01v8 w=2.3 l=0.15
X546 t_Xpi_Xch_e_Xmixp_Xs5_drv t_Xpi_Xch_e_mixp vss sky130_fd_pr__res_high_po_0p69 l=6.4
X547 t_Xpi_Xch_e_cap f5 t_Xpi_Xch_e_Xmixp_Xs5_dum vss sky130_fd_pr__nfet_01v8_lvt w=0.5 l=0.15
X548 t_Xpi_Xch_e_cap t_Xpi_fb5 t_Xpi_Xch_e_Xmixp_Xs5_dum vdd sky130_fd_pr__pfet_01v8_lvt w=0.9 l=0.35
X549 t_Xpi_Xch_e_cbp t_Xpi_fb5 t_Xpi_Xch_e_Xmixp_Xs5_dum vss sky130_fd_pr__nfet_01v8_lvt w=0.5 l=0.15
X550 t_Xpi_Xch_e_cbp f5 t_Xpi_Xch_e_Xmixp_Xs5_dum vdd sky130_fd_pr__pfet_01v8_lvt w=0.9 l=0.35
X551 vss t_Xpi_Xch_e_Xmixp_Xs5_dum vss vss sky130_fd_pr__nfet_01v8_lvt w=0.55 l=0.15
X552 vdd t_Xpi_Xch_e_Xmixp_Xs5_dum vdd vdd sky130_fd_pr__pfet_01v8 w=2.3 l=0.15
X553 t_Xpi_Xch_e_cap t_Xpi_fb6 t_Xpi_Xch_e_Xmixp_Xs6_sel vss sky130_fd_pr__nfet_01v8_lvt w=0.5 l=0.15
X554 t_Xpi_Xch_e_cap f6 t_Xpi_Xch_e_Xmixp_Xs6_sel vdd sky130_fd_pr__pfet_01v8_lvt w=0.9 l=0.35
X555 t_Xpi_Xch_e_cbp f6 t_Xpi_Xch_e_Xmixp_Xs6_sel vss sky130_fd_pr__nfet_01v8_lvt w=0.5 l=0.15
X556 t_Xpi_Xch_e_cbp t_Xpi_fb6 t_Xpi_Xch_e_Xmixp_Xs6_sel vdd sky130_fd_pr__pfet_01v8_lvt w=0.9 l=0.35
X557 t_Xpi_Xch_e_Xmixp_Xs6_drv t_Xpi_Xch_e_Xmixp_Xs6_sel vss vss sky130_fd_pr__nfet_01v8_lvt w=0.55 l=0.15
X558 t_Xpi_Xch_e_Xmixp_Xs6_drv t_Xpi_Xch_e_Xmixp_Xs6_sel vdd vdd sky130_fd_pr__pfet_01v8 w=2.3 l=0.15
X559 t_Xpi_Xch_e_Xmixp_Xs6_drv t_Xpi_Xch_e_mixp vss sky130_fd_pr__res_high_po_0p69 l=6.4
X560 t_Xpi_Xch_e_cap f6 t_Xpi_Xch_e_Xmixp_Xs6_dum vss sky130_fd_pr__nfet_01v8_lvt w=0.5 l=0.15
X561 t_Xpi_Xch_e_cap t_Xpi_fb6 t_Xpi_Xch_e_Xmixp_Xs6_dum vdd sky130_fd_pr__pfet_01v8_lvt w=0.9 l=0.35
X562 t_Xpi_Xch_e_cbp t_Xpi_fb6 t_Xpi_Xch_e_Xmixp_Xs6_dum vss sky130_fd_pr__nfet_01v8_lvt w=0.5 l=0.15
X563 t_Xpi_Xch_e_cbp f6 t_Xpi_Xch_e_Xmixp_Xs6_dum vdd sky130_fd_pr__pfet_01v8_lvt w=0.9 l=0.35
X564 vss t_Xpi_Xch_e_Xmixp_Xs6_dum vss vss sky130_fd_pr__nfet_01v8_lvt w=0.55 l=0.15
X565 vdd t_Xpi_Xch_e_Xmixp_Xs6_dum vdd vdd sky130_fd_pr__pfet_01v8 w=2.3 l=0.15
X566 t_Xpi_Xch_e_cap t_Xpi_fb7 t_Xpi_Xch_e_Xmixp_Xs7_sel vss sky130_fd_pr__nfet_01v8_lvt w=0.5 l=0.15
X567 t_Xpi_Xch_e_cap f7 t_Xpi_Xch_e_Xmixp_Xs7_sel vdd sky130_fd_pr__pfet_01v8_lvt w=0.9 l=0.35
X568 t_Xpi_Xch_e_cbp f7 t_Xpi_Xch_e_Xmixp_Xs7_sel vss sky130_fd_pr__nfet_01v8_lvt w=0.5 l=0.15
X569 t_Xpi_Xch_e_cbp t_Xpi_fb7 t_Xpi_Xch_e_Xmixp_Xs7_sel vdd sky130_fd_pr__pfet_01v8_lvt w=0.9 l=0.35
X570 t_Xpi_Xch_e_Xmixp_Xs7_drv t_Xpi_Xch_e_Xmixp_Xs7_sel vss vss sky130_fd_pr__nfet_01v8_lvt w=0.55 l=0.15
X571 t_Xpi_Xch_e_Xmixp_Xs7_drv t_Xpi_Xch_e_Xmixp_Xs7_sel vdd vdd sky130_fd_pr__pfet_01v8 w=2.3 l=0.15
X572 t_Xpi_Xch_e_Xmixp_Xs7_drv t_Xpi_Xch_e_mixp vss sky130_fd_pr__res_high_po_0p69 l=6.4
X573 t_Xpi_Xch_e_cap f7 t_Xpi_Xch_e_Xmixp_Xs7_dum vss sky130_fd_pr__nfet_01v8_lvt w=0.5 l=0.15
X574 t_Xpi_Xch_e_cap t_Xpi_fb7 t_Xpi_Xch_e_Xmixp_Xs7_dum vdd sky130_fd_pr__pfet_01v8_lvt w=0.9 l=0.35
X575 t_Xpi_Xch_e_cbp t_Xpi_fb7 t_Xpi_Xch_e_Xmixp_Xs7_dum vss sky130_fd_pr__nfet_01v8_lvt w=0.5 l=0.15
X576 t_Xpi_Xch_e_cbp f7 t_Xpi_Xch_e_Xmixp_Xs7_dum vdd sky130_fd_pr__pfet_01v8_lvt w=0.9 l=0.35
X577 vss t_Xpi_Xch_e_Xmixp_Xs7_dum vss vss sky130_fd_pr__nfet_01v8_lvt w=0.55 l=0.15
X578 vdd t_Xpi_Xch_e_Xmixp_Xs7_dum vdd vdd sky130_fd_pr__pfet_01v8 w=2.3 l=0.15
X579 t_Xpi_Xch_e_mixp vss sky130_fd_pr__cap_mim_m3_1 w=2.8 l=2.8
X580 t_Xpi_Xch_e_can t_Xpi_fb0 t_Xpi_Xch_e_Xmixn_Xs0_sel vss sky130_fd_pr__nfet_01v8_lvt w=0.5 l=0.15
X581 t_Xpi_Xch_e_can f0 t_Xpi_Xch_e_Xmixn_Xs0_sel vdd sky130_fd_pr__pfet_01v8_lvt w=0.9 l=0.35
X582 t_Xpi_Xch_e_cbn f0 t_Xpi_Xch_e_Xmixn_Xs0_sel vss sky130_fd_pr__nfet_01v8_lvt w=0.5 l=0.15
X583 t_Xpi_Xch_e_cbn t_Xpi_fb0 t_Xpi_Xch_e_Xmixn_Xs0_sel vdd sky130_fd_pr__pfet_01v8_lvt w=0.9 l=0.35
X584 t_Xpi_Xch_e_Xmixn_Xs0_drv t_Xpi_Xch_e_Xmixn_Xs0_sel vss vss sky130_fd_pr__nfet_01v8_lvt w=0.55 l=0.15
X585 t_Xpi_Xch_e_Xmixn_Xs0_drv t_Xpi_Xch_e_Xmixn_Xs0_sel vdd vdd sky130_fd_pr__pfet_01v8 w=2.3 l=0.15
X586 t_Xpi_Xch_e_Xmixn_Xs0_drv t_Xpi_Xch_e_mixn vss sky130_fd_pr__res_high_po_0p69 l=6.4
X587 t_Xpi_Xch_e_can f0 t_Xpi_Xch_e_Xmixn_Xs0_dum vss sky130_fd_pr__nfet_01v8_lvt w=0.5 l=0.15
X588 t_Xpi_Xch_e_can t_Xpi_fb0 t_Xpi_Xch_e_Xmixn_Xs0_dum vdd sky130_fd_pr__pfet_01v8_lvt w=0.9 l=0.35
X589 t_Xpi_Xch_e_cbn t_Xpi_fb0 t_Xpi_Xch_e_Xmixn_Xs0_dum vss sky130_fd_pr__nfet_01v8_lvt w=0.5 l=0.15
X590 t_Xpi_Xch_e_cbn f0 t_Xpi_Xch_e_Xmixn_Xs0_dum vdd sky130_fd_pr__pfet_01v8_lvt w=0.9 l=0.35
X591 vss t_Xpi_Xch_e_Xmixn_Xs0_dum vss vss sky130_fd_pr__nfet_01v8_lvt w=0.55 l=0.15
X592 vdd t_Xpi_Xch_e_Xmixn_Xs0_dum vdd vdd sky130_fd_pr__pfet_01v8 w=2.3 l=0.15
X593 t_Xpi_Xch_e_can t_Xpi_fb1 t_Xpi_Xch_e_Xmixn_Xs1_sel vss sky130_fd_pr__nfet_01v8_lvt w=0.5 l=0.15
X594 t_Xpi_Xch_e_can f1 t_Xpi_Xch_e_Xmixn_Xs1_sel vdd sky130_fd_pr__pfet_01v8_lvt w=0.9 l=0.35
X595 t_Xpi_Xch_e_cbn f1 t_Xpi_Xch_e_Xmixn_Xs1_sel vss sky130_fd_pr__nfet_01v8_lvt w=0.5 l=0.15
X596 t_Xpi_Xch_e_cbn t_Xpi_fb1 t_Xpi_Xch_e_Xmixn_Xs1_sel vdd sky130_fd_pr__pfet_01v8_lvt w=0.9 l=0.35
X597 t_Xpi_Xch_e_Xmixn_Xs1_drv t_Xpi_Xch_e_Xmixn_Xs1_sel vss vss sky130_fd_pr__nfet_01v8_lvt w=0.55 l=0.15
X598 t_Xpi_Xch_e_Xmixn_Xs1_drv t_Xpi_Xch_e_Xmixn_Xs1_sel vdd vdd sky130_fd_pr__pfet_01v8 w=2.3 l=0.15
X599 t_Xpi_Xch_e_Xmixn_Xs1_drv t_Xpi_Xch_e_mixn vss sky130_fd_pr__res_high_po_0p69 l=6.4
X600 t_Xpi_Xch_e_can f1 t_Xpi_Xch_e_Xmixn_Xs1_dum vss sky130_fd_pr__nfet_01v8_lvt w=0.5 l=0.15
X601 t_Xpi_Xch_e_can t_Xpi_fb1 t_Xpi_Xch_e_Xmixn_Xs1_dum vdd sky130_fd_pr__pfet_01v8_lvt w=0.9 l=0.35
X602 t_Xpi_Xch_e_cbn t_Xpi_fb1 t_Xpi_Xch_e_Xmixn_Xs1_dum vss sky130_fd_pr__nfet_01v8_lvt w=0.5 l=0.15
X603 t_Xpi_Xch_e_cbn f1 t_Xpi_Xch_e_Xmixn_Xs1_dum vdd sky130_fd_pr__pfet_01v8_lvt w=0.9 l=0.35
X604 vss t_Xpi_Xch_e_Xmixn_Xs1_dum vss vss sky130_fd_pr__nfet_01v8_lvt w=0.55 l=0.15
X605 vdd t_Xpi_Xch_e_Xmixn_Xs1_dum vdd vdd sky130_fd_pr__pfet_01v8 w=2.3 l=0.15
X606 t_Xpi_Xch_e_can t_Xpi_fb2 t_Xpi_Xch_e_Xmixn_Xs2_sel vss sky130_fd_pr__nfet_01v8_lvt w=0.5 l=0.15
X607 t_Xpi_Xch_e_can f2 t_Xpi_Xch_e_Xmixn_Xs2_sel vdd sky130_fd_pr__pfet_01v8_lvt w=0.9 l=0.35
X608 t_Xpi_Xch_e_cbn f2 t_Xpi_Xch_e_Xmixn_Xs2_sel vss sky130_fd_pr__nfet_01v8_lvt w=0.5 l=0.15
X609 t_Xpi_Xch_e_cbn t_Xpi_fb2 t_Xpi_Xch_e_Xmixn_Xs2_sel vdd sky130_fd_pr__pfet_01v8_lvt w=0.9 l=0.35
X610 t_Xpi_Xch_e_Xmixn_Xs2_drv t_Xpi_Xch_e_Xmixn_Xs2_sel vss vss sky130_fd_pr__nfet_01v8_lvt w=0.55 l=0.15
X611 t_Xpi_Xch_e_Xmixn_Xs2_drv t_Xpi_Xch_e_Xmixn_Xs2_sel vdd vdd sky130_fd_pr__pfet_01v8 w=2.3 l=0.15
X612 t_Xpi_Xch_e_Xmixn_Xs2_drv t_Xpi_Xch_e_mixn vss sky130_fd_pr__res_high_po_0p69 l=6.4
X613 t_Xpi_Xch_e_can f2 t_Xpi_Xch_e_Xmixn_Xs2_dum vss sky130_fd_pr__nfet_01v8_lvt w=0.5 l=0.15
X614 t_Xpi_Xch_e_can t_Xpi_fb2 t_Xpi_Xch_e_Xmixn_Xs2_dum vdd sky130_fd_pr__pfet_01v8_lvt w=0.9 l=0.35
X615 t_Xpi_Xch_e_cbn t_Xpi_fb2 t_Xpi_Xch_e_Xmixn_Xs2_dum vss sky130_fd_pr__nfet_01v8_lvt w=0.5 l=0.15
X616 t_Xpi_Xch_e_cbn f2 t_Xpi_Xch_e_Xmixn_Xs2_dum vdd sky130_fd_pr__pfet_01v8_lvt w=0.9 l=0.35
X617 vss t_Xpi_Xch_e_Xmixn_Xs2_dum vss vss sky130_fd_pr__nfet_01v8_lvt w=0.55 l=0.15
X618 vdd t_Xpi_Xch_e_Xmixn_Xs2_dum vdd vdd sky130_fd_pr__pfet_01v8 w=2.3 l=0.15
X619 t_Xpi_Xch_e_can t_Xpi_fb3 t_Xpi_Xch_e_Xmixn_Xs3_sel vss sky130_fd_pr__nfet_01v8_lvt w=0.5 l=0.15
X620 t_Xpi_Xch_e_can f3 t_Xpi_Xch_e_Xmixn_Xs3_sel vdd sky130_fd_pr__pfet_01v8_lvt w=0.9 l=0.35
X621 t_Xpi_Xch_e_cbn f3 t_Xpi_Xch_e_Xmixn_Xs3_sel vss sky130_fd_pr__nfet_01v8_lvt w=0.5 l=0.15
X622 t_Xpi_Xch_e_cbn t_Xpi_fb3 t_Xpi_Xch_e_Xmixn_Xs3_sel vdd sky130_fd_pr__pfet_01v8_lvt w=0.9 l=0.35
X623 t_Xpi_Xch_e_Xmixn_Xs3_drv t_Xpi_Xch_e_Xmixn_Xs3_sel vss vss sky130_fd_pr__nfet_01v8_lvt w=0.55 l=0.15
X624 t_Xpi_Xch_e_Xmixn_Xs3_drv t_Xpi_Xch_e_Xmixn_Xs3_sel vdd vdd sky130_fd_pr__pfet_01v8 w=2.3 l=0.15
X625 t_Xpi_Xch_e_Xmixn_Xs3_drv t_Xpi_Xch_e_mixn vss sky130_fd_pr__res_high_po_0p69 l=6.4
X626 t_Xpi_Xch_e_can f3 t_Xpi_Xch_e_Xmixn_Xs3_dum vss sky130_fd_pr__nfet_01v8_lvt w=0.5 l=0.15
X627 t_Xpi_Xch_e_can t_Xpi_fb3 t_Xpi_Xch_e_Xmixn_Xs3_dum vdd sky130_fd_pr__pfet_01v8_lvt w=0.9 l=0.35
X628 t_Xpi_Xch_e_cbn t_Xpi_fb3 t_Xpi_Xch_e_Xmixn_Xs3_dum vss sky130_fd_pr__nfet_01v8_lvt w=0.5 l=0.15
X629 t_Xpi_Xch_e_cbn f3 t_Xpi_Xch_e_Xmixn_Xs3_dum vdd sky130_fd_pr__pfet_01v8_lvt w=0.9 l=0.35
X630 vss t_Xpi_Xch_e_Xmixn_Xs3_dum vss vss sky130_fd_pr__nfet_01v8_lvt w=0.55 l=0.15
X631 vdd t_Xpi_Xch_e_Xmixn_Xs3_dum vdd vdd sky130_fd_pr__pfet_01v8 w=2.3 l=0.15
X632 t_Xpi_Xch_e_can t_Xpi_fb4 t_Xpi_Xch_e_Xmixn_Xs4_sel vss sky130_fd_pr__nfet_01v8_lvt w=0.5 l=0.15
X633 t_Xpi_Xch_e_can f4 t_Xpi_Xch_e_Xmixn_Xs4_sel vdd sky130_fd_pr__pfet_01v8_lvt w=0.9 l=0.35
X634 t_Xpi_Xch_e_cbn f4 t_Xpi_Xch_e_Xmixn_Xs4_sel vss sky130_fd_pr__nfet_01v8_lvt w=0.5 l=0.15
X635 t_Xpi_Xch_e_cbn t_Xpi_fb4 t_Xpi_Xch_e_Xmixn_Xs4_sel vdd sky130_fd_pr__pfet_01v8_lvt w=0.9 l=0.35
X636 t_Xpi_Xch_e_Xmixn_Xs4_drv t_Xpi_Xch_e_Xmixn_Xs4_sel vss vss sky130_fd_pr__nfet_01v8_lvt w=0.55 l=0.15
X637 t_Xpi_Xch_e_Xmixn_Xs4_drv t_Xpi_Xch_e_Xmixn_Xs4_sel vdd vdd sky130_fd_pr__pfet_01v8 w=2.3 l=0.15
X638 t_Xpi_Xch_e_Xmixn_Xs4_drv t_Xpi_Xch_e_mixn vss sky130_fd_pr__res_high_po_0p69 l=6.4
X639 t_Xpi_Xch_e_can f4 t_Xpi_Xch_e_Xmixn_Xs4_dum vss sky130_fd_pr__nfet_01v8_lvt w=0.5 l=0.15
X640 t_Xpi_Xch_e_can t_Xpi_fb4 t_Xpi_Xch_e_Xmixn_Xs4_dum vdd sky130_fd_pr__pfet_01v8_lvt w=0.9 l=0.35
X641 t_Xpi_Xch_e_cbn t_Xpi_fb4 t_Xpi_Xch_e_Xmixn_Xs4_dum vss sky130_fd_pr__nfet_01v8_lvt w=0.5 l=0.15
X642 t_Xpi_Xch_e_cbn f4 t_Xpi_Xch_e_Xmixn_Xs4_dum vdd sky130_fd_pr__pfet_01v8_lvt w=0.9 l=0.35
X643 vss t_Xpi_Xch_e_Xmixn_Xs4_dum vss vss sky130_fd_pr__nfet_01v8_lvt w=0.55 l=0.15
X644 vdd t_Xpi_Xch_e_Xmixn_Xs4_dum vdd vdd sky130_fd_pr__pfet_01v8 w=2.3 l=0.15
X645 t_Xpi_Xch_e_can t_Xpi_fb5 t_Xpi_Xch_e_Xmixn_Xs5_sel vss sky130_fd_pr__nfet_01v8_lvt w=0.5 l=0.15
X646 t_Xpi_Xch_e_can f5 t_Xpi_Xch_e_Xmixn_Xs5_sel vdd sky130_fd_pr__pfet_01v8_lvt w=0.9 l=0.35
X647 t_Xpi_Xch_e_cbn f5 t_Xpi_Xch_e_Xmixn_Xs5_sel vss sky130_fd_pr__nfet_01v8_lvt w=0.5 l=0.15
X648 t_Xpi_Xch_e_cbn t_Xpi_fb5 t_Xpi_Xch_e_Xmixn_Xs5_sel vdd sky130_fd_pr__pfet_01v8_lvt w=0.9 l=0.35
X649 t_Xpi_Xch_e_Xmixn_Xs5_drv t_Xpi_Xch_e_Xmixn_Xs5_sel vss vss sky130_fd_pr__nfet_01v8_lvt w=0.55 l=0.15
X650 t_Xpi_Xch_e_Xmixn_Xs5_drv t_Xpi_Xch_e_Xmixn_Xs5_sel vdd vdd sky130_fd_pr__pfet_01v8 w=2.3 l=0.15
X651 t_Xpi_Xch_e_Xmixn_Xs5_drv t_Xpi_Xch_e_mixn vss sky130_fd_pr__res_high_po_0p69 l=6.4
X652 t_Xpi_Xch_e_can f5 t_Xpi_Xch_e_Xmixn_Xs5_dum vss sky130_fd_pr__nfet_01v8_lvt w=0.5 l=0.15
X653 t_Xpi_Xch_e_can t_Xpi_fb5 t_Xpi_Xch_e_Xmixn_Xs5_dum vdd sky130_fd_pr__pfet_01v8_lvt w=0.9 l=0.35
X654 t_Xpi_Xch_e_cbn t_Xpi_fb5 t_Xpi_Xch_e_Xmixn_Xs5_dum vss sky130_fd_pr__nfet_01v8_lvt w=0.5 l=0.15
X655 t_Xpi_Xch_e_cbn f5 t_Xpi_Xch_e_Xmixn_Xs5_dum vdd sky130_fd_pr__pfet_01v8_lvt w=0.9 l=0.35
X656 vss t_Xpi_Xch_e_Xmixn_Xs5_dum vss vss sky130_fd_pr__nfet_01v8_lvt w=0.55 l=0.15
X657 vdd t_Xpi_Xch_e_Xmixn_Xs5_dum vdd vdd sky130_fd_pr__pfet_01v8 w=2.3 l=0.15
X658 t_Xpi_Xch_e_can t_Xpi_fb6 t_Xpi_Xch_e_Xmixn_Xs6_sel vss sky130_fd_pr__nfet_01v8_lvt w=0.5 l=0.15
X659 t_Xpi_Xch_e_can f6 t_Xpi_Xch_e_Xmixn_Xs6_sel vdd sky130_fd_pr__pfet_01v8_lvt w=0.9 l=0.35
X660 t_Xpi_Xch_e_cbn f6 t_Xpi_Xch_e_Xmixn_Xs6_sel vss sky130_fd_pr__nfet_01v8_lvt w=0.5 l=0.15
X661 t_Xpi_Xch_e_cbn t_Xpi_fb6 t_Xpi_Xch_e_Xmixn_Xs6_sel vdd sky130_fd_pr__pfet_01v8_lvt w=0.9 l=0.35
X662 t_Xpi_Xch_e_Xmixn_Xs6_drv t_Xpi_Xch_e_Xmixn_Xs6_sel vss vss sky130_fd_pr__nfet_01v8_lvt w=0.55 l=0.15
X663 t_Xpi_Xch_e_Xmixn_Xs6_drv t_Xpi_Xch_e_Xmixn_Xs6_sel vdd vdd sky130_fd_pr__pfet_01v8 w=2.3 l=0.15
X664 t_Xpi_Xch_e_Xmixn_Xs6_drv t_Xpi_Xch_e_mixn vss sky130_fd_pr__res_high_po_0p69 l=6.4
X665 t_Xpi_Xch_e_can f6 t_Xpi_Xch_e_Xmixn_Xs6_dum vss sky130_fd_pr__nfet_01v8_lvt w=0.5 l=0.15
X666 t_Xpi_Xch_e_can t_Xpi_fb6 t_Xpi_Xch_e_Xmixn_Xs6_dum vdd sky130_fd_pr__pfet_01v8_lvt w=0.9 l=0.35
X667 t_Xpi_Xch_e_cbn t_Xpi_fb6 t_Xpi_Xch_e_Xmixn_Xs6_dum vss sky130_fd_pr__nfet_01v8_lvt w=0.5 l=0.15
X668 t_Xpi_Xch_e_cbn f6 t_Xpi_Xch_e_Xmixn_Xs6_dum vdd sky130_fd_pr__pfet_01v8_lvt w=0.9 l=0.35
X669 vss t_Xpi_Xch_e_Xmixn_Xs6_dum vss vss sky130_fd_pr__nfet_01v8_lvt w=0.55 l=0.15
X670 vdd t_Xpi_Xch_e_Xmixn_Xs6_dum vdd vdd sky130_fd_pr__pfet_01v8 w=2.3 l=0.15
X671 t_Xpi_Xch_e_can t_Xpi_fb7 t_Xpi_Xch_e_Xmixn_Xs7_sel vss sky130_fd_pr__nfet_01v8_lvt w=0.5 l=0.15
X672 t_Xpi_Xch_e_can f7 t_Xpi_Xch_e_Xmixn_Xs7_sel vdd sky130_fd_pr__pfet_01v8_lvt w=0.9 l=0.35
X673 t_Xpi_Xch_e_cbn f7 t_Xpi_Xch_e_Xmixn_Xs7_sel vss sky130_fd_pr__nfet_01v8_lvt w=0.5 l=0.15
X674 t_Xpi_Xch_e_cbn t_Xpi_fb7 t_Xpi_Xch_e_Xmixn_Xs7_sel vdd sky130_fd_pr__pfet_01v8_lvt w=0.9 l=0.35
X675 t_Xpi_Xch_e_Xmixn_Xs7_drv t_Xpi_Xch_e_Xmixn_Xs7_sel vss vss sky130_fd_pr__nfet_01v8_lvt w=0.55 l=0.15
X676 t_Xpi_Xch_e_Xmixn_Xs7_drv t_Xpi_Xch_e_Xmixn_Xs7_sel vdd vdd sky130_fd_pr__pfet_01v8 w=2.3 l=0.15
X677 t_Xpi_Xch_e_Xmixn_Xs7_drv t_Xpi_Xch_e_mixn vss sky130_fd_pr__res_high_po_0p69 l=6.4
X678 t_Xpi_Xch_e_can f7 t_Xpi_Xch_e_Xmixn_Xs7_dum vss sky130_fd_pr__nfet_01v8_lvt w=0.5 l=0.15
X679 t_Xpi_Xch_e_can t_Xpi_fb7 t_Xpi_Xch_e_Xmixn_Xs7_dum vdd sky130_fd_pr__pfet_01v8_lvt w=0.9 l=0.35
X680 t_Xpi_Xch_e_cbn t_Xpi_fb7 t_Xpi_Xch_e_Xmixn_Xs7_dum vss sky130_fd_pr__nfet_01v8_lvt w=0.5 l=0.15
X681 t_Xpi_Xch_e_cbn f7 t_Xpi_Xch_e_Xmixn_Xs7_dum vdd sky130_fd_pr__pfet_01v8_lvt w=0.9 l=0.35
X682 vss t_Xpi_Xch_e_Xmixn_Xs7_dum vss vss sky130_fd_pr__nfet_01v8_lvt w=0.55 l=0.15
X683 vdd t_Xpi_Xch_e_Xmixn_Xs7_dum vdd vdd sky130_fd_pr__pfet_01v8 w=2.3 l=0.15
X684 t_Xpi_Xch_e_mixn vss sky130_fd_pr__cap_mim_m3_1 w=2.8 l=2.8
X685 t_Xpi_Xch_e_Xrec_acp t_Xpi_Xch_e_mixp sky130_fd_pr__cap_mim_m3_1 w=3.7 l=3.7
X686 t_Xpi_Xch_e_Xrec_acn t_Xpi_Xch_e_mixn sky130_fd_pr__cap_mim_m3_1 w=3.7 l=3.7
X687 t_Xpi_Xch_e_Xrec_acp t_Xpi_Xch_e_r1p vss sky130_fd_pr__res_high_po_0p35 l=8
X688 t_Xpi_Xch_e_Xrec_acn t_Xpi_Xch_e_r1n vss sky130_fd_pr__res_high_po_0p35 l=8
X689 t_Xpi_Xch_e_r1p t_Xpi_Xch_e_Xrec_acp vss vss sky130_fd_pr__nfet_01v8_lvt w=1.65 l=0.15
X690 t_Xpi_Xch_e_r1p t_Xpi_Xch_e_Xrec_acp vdd vdd sky130_fd_pr__pfet_01v8_lvt w=6.6 l=0.35
X691 t_Xpi_Xch_e_r1n t_Xpi_Xch_e_Xrec_acn vss vss sky130_fd_pr__nfet_01v8_lvt w=1.65 l=0.15
X692 t_Xpi_Xch_e_r1n t_Xpi_Xch_e_Xrec_acn vdd vdd sky130_fd_pr__pfet_01v8_lvt w=6.6 l=0.35
X693 ep t_Xpi_Xch_e_r1n vss vss sky130_fd_pr__nfet_01v8_lvt w=2.6 l=0.15
X694 ep t_Xpi_Xch_e_r1n vdd vdd sky130_fd_pr__pfet_01v8_lvt w=10.4 l=0.35
X695 en t_Xpi_Xch_e_r1p vss vss sky130_fd_pr__nfet_01v8_lvt w=2.6 l=0.15
X696 en t_Xpi_Xch_e_r1p vdd vdd sky130_fd_pr__pfet_01v8_lvt w=10.4 l=0.35
X697 t_Xdiv_rst rst_n vss vss sky130_fd_pr__nfet_01v8 w=0.6 l=0.18
X698 t_Xdiv_rst rst_n vdd vdd sky130_fd_pr__pfet_01v8 w=1.2 l=0.18
X699 dp rst_n t_Xdiv_Xg_dpb_ck_g vss sky130_fd_pr__nfet_01v8_lvt w=2.6 l=0.15
X700 dp t_Xdiv_rst t_Xdiv_Xg_dpb_ck_g vdd sky130_fd_pr__pfet_01v8_lvt w=6.8 l=0.35
X701 t_Xdiv_Xg_dpb_ck_g t_Xdiv_rst vss vss sky130_fd_pr__nfet_01v8 w=0.8 l=0.18
X702 t_Xdiv_dp_ckb t_Xdiv_Xg_dpb_ck_g vss vss sky130_fd_pr__nfet_01v8_lvt w=1.5 l=0.15
X703 t_Xdiv_dp_ckb t_Xdiv_Xg_dpb_ck_g vdd vdd sky130_fd_pr__pfet_01v8 w=6.3 l=0.15
X704 dn rst_n t_Xdiv_Xg_dnb_ck_g vss sky130_fd_pr__nfet_01v8_lvt w=2.6 l=0.15
X705 dn t_Xdiv_rst t_Xdiv_Xg_dnb_ck_g vdd sky130_fd_pr__pfet_01v8_lvt w=6.8 l=0.35
X706 t_Xdiv_Xg_dnb_ck_g rst_n vdd vdd sky130_fd_pr__pfet_01v8 w=1.6 l=0.18
X707 t_Xdiv_dn_ckb t_Xdiv_Xg_dnb_ck_g vss vss sky130_fd_pr__nfet_01v8_lvt w=1.5 l=0.15
X708 t_Xdiv_dn_ckb t_Xdiv_Xg_dnb_ck_g vdd vdd sky130_fd_pr__pfet_01v8 w=6.3 l=0.15
X709 ep rst_n t_Xdiv_Xg_epb_ck_g vss sky130_fd_pr__nfet_01v8_lvt w=2.6 l=0.15
X710 ep t_Xdiv_rst t_Xdiv_Xg_epb_ck_g vdd sky130_fd_pr__pfet_01v8_lvt w=6.8 l=0.35
X711 t_Xdiv_Xg_epb_ck_g t_Xdiv_rst vss vss sky130_fd_pr__nfet_01v8 w=0.8 l=0.18
X712 t_Xdiv_ep_ckb t_Xdiv_Xg_epb_ck_g vss vss sky130_fd_pr__nfet_01v8_lvt w=1.5 l=0.15
X713 t_Xdiv_ep_ckb t_Xdiv_Xg_epb_ck_g vdd vdd sky130_fd_pr__pfet_01v8 w=6.3 l=0.15
X714 en rst_n t_Xdiv_Xg_enb_ck_g vss sky130_fd_pr__nfet_01v8_lvt w=2.6 l=0.15
X715 en t_Xdiv_rst t_Xdiv_Xg_enb_ck_g vdd sky130_fd_pr__pfet_01v8_lvt w=6.8 l=0.35
X716 t_Xdiv_Xg_enb_ck_g rst_n vdd vdd sky130_fd_pr__pfet_01v8 w=1.6 l=0.18
X717 t_Xdiv_en_ckb t_Xdiv_Xg_enb_ck_g vss vss sky130_fd_pr__nfet_01v8_lvt w=1.5 l=0.15
X718 t_Xdiv_en_ckb t_Xdiv_Xg_enb_ck_g vdd vdd sky130_fd_pr__pfet_01v8 w=6.3 l=0.15
X719 t_Xdiv_dn_ckb t_Xdiv_dp_ckb vss vss sky130_fd_pr__nfet_01v8_lvt w=0.45 l=0.15
X720 t_Xdiv_dn_ckb t_Xdiv_dp_ckb vdd vdd sky130_fd_pr__pfet_01v8 w=1.89 l=0.15
X721 t_Xdiv_dp_ckb t_Xdiv_dn_ckb vss vss sky130_fd_pr__nfet_01v8_lvt w=0.45 l=0.15
X722 t_Xdiv_dp_ckb t_Xdiv_dn_ckb vdd vdd sky130_fd_pr__pfet_01v8 w=1.89 l=0.15
X723 t_Xdiv_en_ckb t_Xdiv_ep_ckb vss vss sky130_fd_pr__nfet_01v8_lvt w=0.45 l=0.15
X724 t_Xdiv_en_ckb t_Xdiv_ep_ckb vdd vdd sky130_fd_pr__pfet_01v8 w=1.89 l=0.15
X725 t_Xdiv_ep_ckb t_Xdiv_en_ckb vss vss sky130_fd_pr__nfet_01v8_lvt w=0.45 l=0.15
X726 t_Xdiv_ep_ckb t_Xdiv_en_ckb vdd vdd sky130_fd_pr__pfet_01v8 w=1.89 l=0.15
X727 t_Xdiv_dp_ck t_Xdiv_dp_ckb vss vss sky130_fd_pr__nfet_01v8_lvt w=2.1 l=0.15
X728 t_Xdiv_dp_ck t_Xdiv_dp_ckb vdd vdd sky130_fd_pr__pfet_01v8 w=8.82 l=0.15
X729 t_Xdiv_dn_ck t_Xdiv_dn_ckb vss vss sky130_fd_pr__nfet_01v8_lvt w=2.1 l=0.15
X730 t_Xdiv_dn_ck t_Xdiv_dn_ckb vdd vdd sky130_fd_pr__pfet_01v8 w=8.82 l=0.15
X731 t_Xdiv_ep_ck t_Xdiv_ep_ckb vss vss sky130_fd_pr__nfet_01v8_lvt w=2.1 l=0.15
X732 t_Xdiv_ep_ck t_Xdiv_ep_ckb vdd vdd sky130_fd_pr__pfet_01v8 w=8.82 l=0.15
X733 t_Xdiv_en_ck t_Xdiv_en_ckb vss vss sky130_fd_pr__nfet_01v8_lvt w=2.1 l=0.15
X734 t_Xdiv_en_ck t_Xdiv_en_ckb vdd vdd sky130_fd_pr__pfet_01v8 w=8.82 l=0.15
X735 t_Xdiv_dn_ck t_Xdiv_dp_ck vss vss sky130_fd_pr__nfet_01v8_lvt w=0.45 l=0.15
X736 t_Xdiv_dn_ck t_Xdiv_dp_ck vdd vdd sky130_fd_pr__pfet_01v8 w=1.89 l=0.15
X737 t_Xdiv_dp_ck t_Xdiv_dn_ck vss vss sky130_fd_pr__nfet_01v8_lvt w=0.45 l=0.15
X738 t_Xdiv_dp_ck t_Xdiv_dn_ck vdd vdd sky130_fd_pr__pfet_01v8 w=1.89 l=0.15
X739 t_Xdiv_en_ck t_Xdiv_ep_ck vss vss sky130_fd_pr__nfet_01v8_lvt w=0.45 l=0.15
X740 t_Xdiv_en_ck t_Xdiv_ep_ck vdd vdd sky130_fd_pr__pfet_01v8 w=1.89 l=0.15
X741 t_Xdiv_ep_ck t_Xdiv_en_ck vss vss sky130_fd_pr__nfet_01v8_lvt w=0.45 l=0.15
X742 t_Xdiv_ep_ck t_Xdiv_en_ck vdd vdd sky130_fd_pr__pfet_01v8 w=1.89 l=0.15
X743 t_Xdiv_d3 t_Xdiv_dp_ck t_Xdiv_Xld0_int_p vss sky130_fd_pr__nfet_01v8_lvt w=2.8 l=0.15
X744 t_Xdiv_d3 t_Xdiv_dn_ck t_Xdiv_Xld0_int_p vdd sky130_fd_pr__pfet_01v8 w=6.8 l=0.15
X745 t_Xdiv_d1 t_Xdiv_dp_ck t_Xdiv_Xld0_int_n vss sky130_fd_pr__nfet_01v8_lvt w=2.8 l=0.15
X746 t_Xdiv_d1 t_Xdiv_dn_ck t_Xdiv_Xld0_int_n vdd sky130_fd_pr__pfet_01v8 w=6.8 l=0.15
X747 t_Xdiv_Xld0_int_p t_Xdiv_Xld0_int_n vdd vdd sky130_fd_pr__pfet_01v8 w=0.42 l=0.28
X748 t_Xdiv_Xld0_int_p t_Xdiv_Xld0_int_n vss vss sky130_fd_pr__nfet_01v8 w=0.42 l=0.28
X749 t_Xdiv_Xld0_int_n t_Xdiv_Xld0_int_p vdd vdd sky130_fd_pr__pfet_01v8 w=0.42 l=0.28
X750 t_Xdiv_Xld0_int_n t_Xdiv_Xld0_int_p vss vss sky130_fd_pr__nfet_01v8 w=0.42 l=0.28
X751 t_Xdiv_Xld0_int_p t_Xdiv_rst vss vss sky130_fd_pr__nfet_01v8 w=1 l=0.18
X752 t_Xdiv_Xld0_int_n rst_n vdd vdd sky130_fd_pr__pfet_01v8 w=1.8 l=0.18
X753 t_Xdiv_d0 t_Xdiv_Xld0_int_n vss vss sky130_fd_pr__nfet_01v8_lvt w=3.4 l=0.15
X754 t_Xdiv_d0 t_Xdiv_Xld0_int_n vdd vdd sky130_fd_pr__pfet_01v8 w=14.28 l=0.15
X755 t_Xdiv_d2 t_Xdiv_Xld0_int_p vss vss sky130_fd_pr__nfet_01v8_lvt w=3.4 l=0.15
X756 t_Xdiv_d2 t_Xdiv_Xld0_int_p vdd vdd sky130_fd_pr__pfet_01v8 w=14.28 l=0.15
X757 t_Xdiv_d2 t_Xdiv_d0 vss vss sky130_fd_pr__nfet_01v8_lvt w=0.42 l=0.15
X758 t_Xdiv_d2 t_Xdiv_d0 vdd vdd sky130_fd_pr__pfet_01v8 w=1.76 l=0.15
X759 t_Xdiv_d0 t_Xdiv_d2 vss vss sky130_fd_pr__nfet_01v8_lvt w=0.42 l=0.15
X760 t_Xdiv_d0 t_Xdiv_d2 vdd vdd sky130_fd_pr__pfet_01v8 w=1.76 l=0.15
X761 t_Xdiv_d0 t_Xdiv_dn_ck t_Xdiv_Xld1_int_p vss sky130_fd_pr__nfet_01v8_lvt w=2.8 l=0.15
X762 t_Xdiv_d0 t_Xdiv_dp_ck t_Xdiv_Xld1_int_p vdd sky130_fd_pr__pfet_01v8 w=6.8 l=0.15
X763 t_Xdiv_d2 t_Xdiv_dn_ck t_Xdiv_Xld1_int_n vss sky130_fd_pr__nfet_01v8_lvt w=2.8 l=0.15
X764 t_Xdiv_d2 t_Xdiv_dp_ck t_Xdiv_Xld1_int_n vdd sky130_fd_pr__pfet_01v8 w=6.8 l=0.15
X765 t_Xdiv_Xld1_int_p t_Xdiv_Xld1_int_n vdd vdd sky130_fd_pr__pfet_01v8 w=0.42 l=0.28
X766 t_Xdiv_Xld1_int_p t_Xdiv_Xld1_int_n vss vss sky130_fd_pr__nfet_01v8 w=0.42 l=0.28
X767 t_Xdiv_Xld1_int_n t_Xdiv_Xld1_int_p vdd vdd sky130_fd_pr__pfet_01v8 w=0.42 l=0.28
X768 t_Xdiv_Xld1_int_n t_Xdiv_Xld1_int_p vss vss sky130_fd_pr__nfet_01v8 w=0.42 l=0.28
X769 t_Xdiv_Xld1_int_p t_Xdiv_rst vss vss sky130_fd_pr__nfet_01v8 w=1 l=0.18
X770 t_Xdiv_Xld1_int_n rst_n vdd vdd sky130_fd_pr__pfet_01v8 w=1.8 l=0.18
X771 t_Xdiv_d1 t_Xdiv_Xld1_int_n vss vss sky130_fd_pr__nfet_01v8_lvt w=3.4 l=0.15
X772 t_Xdiv_d1 t_Xdiv_Xld1_int_n vdd vdd sky130_fd_pr__pfet_01v8 w=14.28 l=0.15
X773 t_Xdiv_d3 t_Xdiv_Xld1_int_p vss vss sky130_fd_pr__nfet_01v8_lvt w=3.4 l=0.15
X774 t_Xdiv_d3 t_Xdiv_Xld1_int_p vdd vdd sky130_fd_pr__pfet_01v8 w=14.28 l=0.15
X775 t_Xdiv_d3 t_Xdiv_d1 vss vss sky130_fd_pr__nfet_01v8_lvt w=0.42 l=0.15
X776 t_Xdiv_d3 t_Xdiv_d1 vdd vdd sky130_fd_pr__pfet_01v8 w=1.76 l=0.15
X777 t_Xdiv_d1 t_Xdiv_d3 vss vss sky130_fd_pr__nfet_01v8_lvt w=0.42 l=0.15
X778 t_Xdiv_d1 t_Xdiv_d3 vdd vdd sky130_fd_pr__pfet_01v8 w=1.76 l=0.15
X779 t_Xdiv_d0 t_Xdiv_ep_ck t_Xdiv_Xle0_int_p vss sky130_fd_pr__nfet_01v8_lvt w=2.8 l=0.15
X780 t_Xdiv_d0 t_Xdiv_en_ck t_Xdiv_Xle0_int_p vdd sky130_fd_pr__pfet_01v8 w=6.8 l=0.15
X781 t_Xdiv_d2 t_Xdiv_ep_ck t_Xdiv_Xle0_int_n vss sky130_fd_pr__nfet_01v8_lvt w=2.8 l=0.15
X782 t_Xdiv_d2 t_Xdiv_en_ck t_Xdiv_Xle0_int_n vdd sky130_fd_pr__pfet_01v8 w=6.8 l=0.15
X783 t_Xdiv_Xle0_int_p t_Xdiv_Xle0_int_n vdd vdd sky130_fd_pr__pfet_01v8 w=0.42 l=0.28
X784 t_Xdiv_Xle0_int_p t_Xdiv_Xle0_int_n vss vss sky130_fd_pr__nfet_01v8 w=0.42 l=0.28
X785 t_Xdiv_Xle0_int_n t_Xdiv_Xle0_int_p vdd vdd sky130_fd_pr__pfet_01v8 w=0.42 l=0.28
X786 t_Xdiv_Xle0_int_n t_Xdiv_Xle0_int_p vss vss sky130_fd_pr__nfet_01v8 w=0.42 l=0.28
X787 t_Xdiv_Xle0_int_p t_Xdiv_rst vss vss sky130_fd_pr__nfet_01v8 w=1 l=0.18
X788 t_Xdiv_Xle0_int_n rst_n vdd vdd sky130_fd_pr__pfet_01v8 w=1.8 l=0.18
X789 t_Xdiv_e0 t_Xdiv_Xle0_int_n vss vss sky130_fd_pr__nfet_01v8_lvt w=1.45 l=0.15
X790 t_Xdiv_e0 t_Xdiv_Xle0_int_n vdd vdd sky130_fd_pr__pfet_01v8 w=6.09 l=0.15
X791 t_Xdiv_e2 t_Xdiv_Xle0_int_p vss vss sky130_fd_pr__nfet_01v8_lvt w=1.45 l=0.15
X792 t_Xdiv_e2 t_Xdiv_Xle0_int_p vdd vdd sky130_fd_pr__pfet_01v8 w=6.09 l=0.15
X793 t_Xdiv_e2 t_Xdiv_e0 vss vss sky130_fd_pr__nfet_01v8_lvt w=0.42 l=0.15
X794 t_Xdiv_e2 t_Xdiv_e0 vdd vdd sky130_fd_pr__pfet_01v8 w=1.76 l=0.15
X795 t_Xdiv_e0 t_Xdiv_e2 vss vss sky130_fd_pr__nfet_01v8_lvt w=0.42 l=0.15
X796 t_Xdiv_e0 t_Xdiv_e2 vdd vdd sky130_fd_pr__pfet_01v8 w=1.76 l=0.15
X797 t_Xdiv_d1 t_Xdiv_en_ck t_Xdiv_Xle1_int_p vss sky130_fd_pr__nfet_01v8_lvt w=2.8 l=0.15
X798 t_Xdiv_d1 t_Xdiv_ep_ck t_Xdiv_Xle1_int_p vdd sky130_fd_pr__pfet_01v8 w=6.8 l=0.15
X799 t_Xdiv_d3 t_Xdiv_en_ck t_Xdiv_Xle1_int_n vss sky130_fd_pr__nfet_01v8_lvt w=2.8 l=0.15
X800 t_Xdiv_d3 t_Xdiv_ep_ck t_Xdiv_Xle1_int_n vdd sky130_fd_pr__pfet_01v8 w=6.8 l=0.15
X801 t_Xdiv_Xle1_int_p t_Xdiv_Xle1_int_n vdd vdd sky130_fd_pr__pfet_01v8 w=0.42 l=0.28
X802 t_Xdiv_Xle1_int_p t_Xdiv_Xle1_int_n vss vss sky130_fd_pr__nfet_01v8 w=0.42 l=0.28
X803 t_Xdiv_Xle1_int_n t_Xdiv_Xle1_int_p vdd vdd sky130_fd_pr__pfet_01v8 w=0.42 l=0.28
X804 t_Xdiv_Xle1_int_n t_Xdiv_Xle1_int_p vss vss sky130_fd_pr__nfet_01v8 w=0.42 l=0.28
X805 t_Xdiv_Xle1_int_p t_Xdiv_rst vss vss sky130_fd_pr__nfet_01v8 w=1 l=0.18
X806 t_Xdiv_Xle1_int_n rst_n vdd vdd sky130_fd_pr__pfet_01v8 w=1.8 l=0.18
X807 t_Xdiv_e1 t_Xdiv_Xle1_int_n vss vss sky130_fd_pr__nfet_01v8_lvt w=1.45 l=0.15
X808 t_Xdiv_e1 t_Xdiv_Xle1_int_n vdd vdd sky130_fd_pr__pfet_01v8 w=6.09 l=0.15
X809 t_Xdiv_e3 t_Xdiv_Xle1_int_p vss vss sky130_fd_pr__nfet_01v8_lvt w=1.45 l=0.15
X810 t_Xdiv_e3 t_Xdiv_Xle1_int_p vdd vdd sky130_fd_pr__pfet_01v8 w=6.09 l=0.15
X811 t_Xdiv_e3 t_Xdiv_e1 vss vss sky130_fd_pr__nfet_01v8_lvt w=0.42 l=0.15
X812 t_Xdiv_e3 t_Xdiv_e1 vdd vdd sky130_fd_pr__pfet_01v8 w=1.76 l=0.15
X813 t_Xdiv_e1 t_Xdiv_e3 vss vss sky130_fd_pr__nfet_01v8_lvt w=0.42 l=0.15
X814 t_Xdiv_e1 t_Xdiv_e3 vdd vdd sky130_fd_pr__pfet_01v8 w=1.76 l=0.15
X815 ckd0 t_Xdiv_d2 vss vss sky130_fd_pr__nfet_01v8_lvt w=2.4 l=0.15
X816 ckd0 t_Xdiv_d2 vdd vdd sky130_fd_pr__pfet_01v8 w=10.08 l=0.15
X817 ckd2 t_Xdiv_d0 vss vss sky130_fd_pr__nfet_01v8_lvt w=2.4 l=0.15
X818 ckd2 t_Xdiv_d0 vdd vdd sky130_fd_pr__pfet_01v8 w=10.08 l=0.15
X819 ckd1 t_Xdiv_d3 vss vss sky130_fd_pr__nfet_01v8_lvt w=2.4 l=0.15
X820 ckd1 t_Xdiv_d3 vdd vdd sky130_fd_pr__pfet_01v8 w=10.08 l=0.15
X821 ckd3 t_Xdiv_d1 vss vss sky130_fd_pr__nfet_01v8_lvt w=2.4 l=0.15
X822 ckd3 t_Xdiv_d1 vdd vdd sky130_fd_pr__pfet_01v8 w=10.08 l=0.15
X823 cke0 t_Xdiv_e2 vss vss sky130_fd_pr__nfet_01v8_lvt w=2.4 l=0.15
X824 cke0 t_Xdiv_e2 vdd vdd sky130_fd_pr__pfet_01v8 w=10.08 l=0.15
X825 cke2 t_Xdiv_e0 vss vss sky130_fd_pr__nfet_01v8_lvt w=2.4 l=0.15
X826 cke2 t_Xdiv_e0 vdd vdd sky130_fd_pr__pfet_01v8 w=10.08 l=0.15
X827 cke1 t_Xdiv_e3 vss vss sky130_fd_pr__nfet_01v8_lvt w=2.4 l=0.15
X828 cke1 t_Xdiv_e3 vdd vdd sky130_fd_pr__pfet_01v8 w=10.08 l=0.15
X829 cke3 t_Xdiv_e1 vss vss sky130_fd_pr__nfet_01v8_lvt w=2.4 l=0.15
X830 cke3 t_Xdiv_e1 vdd vdd sky130_fd_pr__pfet_01v8 w=10.08 l=0.15
X831 ckd2 ckd0 vss vss sky130_fd_pr__nfet_01v8_lvt w=0.45 l=0.15
X832 ckd2 ckd0 vdd vdd sky130_fd_pr__pfet_01v8 w=1.89 l=0.15
X833 ckd0 ckd2 vss vss sky130_fd_pr__nfet_01v8_lvt w=0.45 l=0.15
X834 ckd0 ckd2 vdd vdd sky130_fd_pr__pfet_01v8 w=1.89 l=0.15
X835 ckd3 ckd1 vss vss sky130_fd_pr__nfet_01v8_lvt w=0.45 l=0.15
X836 ckd3 ckd1 vdd vdd sky130_fd_pr__pfet_01v8 w=1.89 l=0.15
X837 ckd1 ckd3 vss vss sky130_fd_pr__nfet_01v8_lvt w=0.45 l=0.15
X838 ckd1 ckd3 vdd vdd sky130_fd_pr__pfet_01v8 w=1.89 l=0.15
X839 cke2 cke0 vss vss sky130_fd_pr__nfet_01v8_lvt w=0.45 l=0.15
X840 cke2 cke0 vdd vdd sky130_fd_pr__pfet_01v8 w=1.89 l=0.15
X841 cke0 cke2 vss vss sky130_fd_pr__nfet_01v8_lvt w=0.45 l=0.15
X842 cke0 cke2 vdd vdd sky130_fd_pr__pfet_01v8 w=1.89 l=0.15
X843 cke3 cke1 vss vss sky130_fd_pr__nfet_01v8_lvt w=0.45 l=0.15
X844 cke3 cke1 vdd vdd sky130_fd_pr__pfet_01v8 w=1.89 l=0.15
X845 cke1 cke3 vss vss sky130_fd_pr__nfet_01v8_lvt w=0.45 l=0.15
X846 cke1 cke3 vdd vdd sky130_fd_pr__pfet_01v8 w=1.89 l=0.15
.ends serdes_rx_pi_4ph_5g_pdk
