* NGSPICE file created from serdes_rx_octature_4to8_2p5g_pdk.ext - technology: sky130A

.subckt serdes_rx_octature_4to8_2p5g_pdk ip qp in qn cb0 cb1 cb2 cb3 cb4 cb5 cb6 cb7
+ vdd vss
X0 cb3 a_6063_8350# vdd vdd sky130_fd_pr__pfet_01v8_lvt ad=0.3045 pd=2.39 as=0.3045 ps=2.39 w=2.1 l=0.35
X1 vdd a_6063_5390# cb6 vdd sky130_fd_pr__pfet_01v8_lvt ad=0.609 pd=4.78 as=0.3045 ps=2.39 w=2.1 l=0.35
X2 vdd a_6063_1270# cb0 vdd sky130_fd_pr__pfet_01v8_lvt ad=0.3045 pd=2.39 as=0.3045 ps=2.39 w=2.1 l=0.35
X3 a_6063_1270# a_5993_1244# vss vss sky130_fd_pr__nfet_01v8_lvt ad=0.1815 pd=1.43 as=0.341 ps=2.82 w=1.1 l=0.15
X4 vdd a_323_1340# a_3663_7850# vdd sky130_fd_pr__pfet_01v8_lvt ad=0.1595 pd=1.39 as=0.1595 ps=1.39 w=1.1 l=0.35
X5 a_323_3700# vss sky130_fd_pr__cap_mim_m3_1 l=1.75 w=1.75
X6 a_2903_1370# a_323_1340# vdd vdd sky130_fd_pr__pfet_01v8_lvt ad=0.1595 pd=1.39 as=0.1595 ps=1.39 w=1.1 l=0.35
X7 vdd in a_323_6060# vdd sky130_fd_pr__pfet_01v8_lvt ad=0.203 pd=1.69 as=0.203 ps=1.69 w=1.4 l=0.35
X8 cb5 cb1 vdd vdd sky130_fd_pr__pfet_01v8_lvt ad=0.609 pd=4.78 as=0.609 ps=4.78 w=2.1 l=0.35
X9 cb2 a_6063_5990# vdd vdd sky130_fd_pr__pfet_01v8_lvt ad=0.3045 pd=2.39 as=0.3045 ps=2.39 w=2.1 l=0.35
X10 cb2 cb6 vdd vdd sky130_fd_pr__pfet_01v8_lvt ad=0.609 pd=4.78 as=0.609 ps=4.78 w=2.1 l=0.35
X11 a_5993_7633# a_5214_7840# sky130_fd_pr__cap_mim_m3_1 l=4.2 w=4.2
X12 cb2 a_6063_5990# vss vss sky130_fd_pr__nfet_01v8_lvt ad=0.2805 pd=2.03 as=0.527 ps=4.02 w=1.7 l=0.15
X13 a_3663_3130# a_323_8420# vdd vdd sky130_fd_pr__pfet_01v8_lvt ad=0.1595 pd=1.39 as=0.1595 ps=1.39 w=1.1 l=0.35
X14 a_3663_1370# a_323_1340# vdd vdd sky130_fd_pr__pfet_01v8_lvt ad=0.1595 pd=1.39 as=0.319 ps=2.78 w=1.1 l=0.35
X15 vss qn a_323_8420# vss sky130_fd_pr__nfet_01v8_lvt ad=0.217 pd=2.02 as=0.1155 ps=1.03 w=0.7 l=0.15
X16 a_6063_7750# a_5993_7633# vdd vdd sky130_fd_pr__pfet_01v8_lvt ad=0.3045 pd=2.39 as=0.609 ps=4.78 w=2.1 l=0.35
X17 vdd qp a_323_3700# vdd sky130_fd_pr__pfet_01v8_lvt ad=0.406 pd=3.38 as=0.203 ps=1.69 w=1.4 l=0.35
X18 a_5993_5273# a_5214_5480# sky130_fd_pr__cap_mim_m3_1 l=4.2 w=4.2
X19 a_2903_7850# a_323_8420# vdd vdd sky130_fd_pr__pfet_01v8_lvt ad=0.1595 pd=1.39 as=0.319 ps=2.78 w=1.1 l=0.35
X20 vdd a_323_1340# a_2903_3730# vdd sky130_fd_pr__pfet_01v8_lvt ad=0.319 pd=2.78 as=0.1595 ps=1.39 w=1.1 l=0.35
X21 vdd a_5993_3604# a_6063_3630# vdd sky130_fd_pr__pfet_01v8_lvt ad=0.609 pd=4.78 as=0.3045 ps=2.39 w=2.1 l=0.35
X22 vdd a_6063_8350# cb3 vdd sky130_fd_pr__pfet_01v8_lvt ad=0.3045 pd=2.39 as=0.3045 ps=2.39 w=2.1 l=0.35
X23 a_2903_8450# a_323_3700# vdd vdd sky130_fd_pr__pfet_01v8_lvt ad=0.1595 pd=1.39 as=0.1595 ps=1.39 w=1.1 l=0.35
X24 vdd a_323_8420# a_2903_5490# vdd sky130_fd_pr__pfet_01v8_lvt ad=0.319 pd=2.78 as=0.1595 ps=1.39 w=1.1 l=0.35
X25 vdd a_5993_5273# a_6063_5390# vdd sky130_fd_pr__pfet_01v8_lvt ad=0.609 pd=4.78 as=0.3045 ps=2.39 w=2.1 l=0.35
X26 vdd a_6063_1270# cb0 vdd sky130_fd_pr__pfet_01v8_lvt ad=0.609 pd=4.78 as=0.3045 ps=2.39 w=2.1 l=0.35
X27 vss in a_323_6060# vss sky130_fd_pr__nfet_01v8_lvt ad=0.217 pd=2.02 as=0.1155 ps=1.03 w=0.7 l=0.15
X28 vdd a_323_3700# a_3663_3730# vdd sky130_fd_pr__pfet_01v8_lvt ad=0.1595 pd=1.39 as=0.1595 ps=1.39 w=1.1 l=0.35
X29 a_2903_3130# a_323_6060# vss vss sky130_fd_pr__nfet_01v8_lvt ad=0.319 pd=2.78 as=0.319 ps=2.78 w=1.1 l=0.15
X30 vss a_5993_8324# a_6063_8350# vss sky130_fd_pr__nfet_01v8_lvt ad=0.341 pd=2.82 as=0.1815 ps=1.43 w=1.1 l=0.15
X31 a_3663_8450# a_323_6060# vdd vdd sky130_fd_pr__pfet_01v8_lvt ad=0.1595 pd=1.39 as=0.319 ps=2.78 w=1.1 l=0.35
X32 vdd a_323_8420# a_3663_5490# vdd sky130_fd_pr__pfet_01v8_lvt ad=0.1595 pd=1.39 as=0.1595 ps=1.39 w=1.1 l=0.35
X33 vdd a_6063_5990# cb2 vdd sky130_fd_pr__pfet_01v8_lvt ad=0.3045 pd=2.39 as=0.3045 ps=2.39 w=2.1 l=0.35
X34 vdd a_6063_670# cb4 vdd sky130_fd_pr__pfet_01v8_lvt ad=0.3045 pd=2.39 as=0.3045 ps=2.39 w=2.1 l=0.35
X35 cb4 cb0 vdd vdd sky130_fd_pr__pfet_01v8_lvt ad=0.609 pd=4.78 as=0.609 ps=4.78 w=2.1 l=0.35
X36 a_6063_3630# a_5993_3604# vdd vdd sky130_fd_pr__pfet_01v8_lvt ad=0.3045 pd=2.39 as=0.609 ps=4.78 w=2.1 l=0.35
X37 a_2903_3730# a_323_1340# vdd vdd sky130_fd_pr__pfet_01v8_lvt ad=0.1595 pd=1.39 as=0.319 ps=2.78 w=1.1 l=0.35
X38 a_3663_7850# a_323_1340# vdd vdd sky130_fd_pr__pfet_01v8_lvt ad=0.1595 pd=1.39 as=0.1595 ps=1.39 w=1.1 l=0.35
X39 a_2903_5490# a_323_8420# vdd vdd sky130_fd_pr__pfet_01v8_lvt ad=0.1595 pd=1.39 as=0.319 ps=2.78 w=1.1 l=0.35
X40 a_6063_5390# a_5993_5273# vdd vdd sky130_fd_pr__pfet_01v8_lvt ad=0.3045 pd=2.39 as=0.609 ps=4.78 w=2.1 l=0.35
X41 vdd a_6063_8350# cb3 vdd sky130_fd_pr__pfet_01v8_lvt ad=0.609 pd=4.78 as=0.3045 ps=2.39 w=2.1 l=0.35
X42 cb5 cb1 vss vss sky130_fd_pr__nfet_01v8_lvt ad=0.1305 pd=1.48 as=0.1305 ps=1.48 w=0.45 l=0.15
X43 vdd ip a_323_1340# vdd sky130_fd_pr__pfet_01v8_lvt ad=0.406 pd=3.38 as=0.203 ps=1.69 w=1.4 l=0.35
X44 a_323_3700# qp vss vss sky130_fd_pr__nfet_01v8_lvt ad=0.1155 pd=1.03 as=0.217 ps=2.02 w=0.7 l=0.15
X45 vdd a_5993_1244# a_6063_1270# vdd sky130_fd_pr__pfet_01v8_lvt ad=0.609 pd=4.78 as=0.3045 ps=2.39 w=2.1 l=0.35
X46 vdd a_323_1340# a_2903_1370# vdd sky130_fd_pr__pfet_01v8_lvt ad=0.319 pd=2.78 as=0.1595 ps=1.39 w=1.1 l=0.35
X47 a_6063_5990# a_5993_5964# vss vss sky130_fd_pr__nfet_01v8_lvt ad=0.1815 pd=1.43 as=0.341 ps=2.82 w=1.1 l=0.15
X48 a_2903_6090# a_323_3700# vdd vdd sky130_fd_pr__pfet_01v8_lvt ad=0.1595 pd=1.39 as=0.1595 ps=1.39 w=1.1 l=0.35
X49 cb4 cb0 vss vss sky130_fd_pr__nfet_01v8_lvt ad=0.1305 pd=1.48 as=0.1305 ps=1.48 w=0.45 l=0.15
X50 cb7 cb3 vdd vdd sky130_fd_pr__pfet_01v8_lvt ad=0.609 pd=4.78 as=0.609 ps=4.78 w=2.1 l=0.35
X51 vdd a_6063_5990# cb2 vdd sky130_fd_pr__pfet_01v8_lvt ad=0.609 pd=4.78 as=0.3045 ps=2.39 w=2.1 l=0.35
X52 vdd a_5993_553# a_6063_670# vdd sky130_fd_pr__pfet_01v8_lvt ad=0.609 pd=4.78 as=0.3045 ps=2.39 w=2.1 l=0.35
X53 vdd a_323_1340# a_3663_1370# vdd sky130_fd_pr__pfet_01v8_lvt ad=0.1595 pd=1.39 as=0.1595 ps=1.39 w=1.1 l=0.35
X54 a_323_1340# ip vss vss sky130_fd_pr__nfet_01v8_lvt ad=0.1155 pd=1.03 as=0.217 ps=2.02 w=0.7 l=0.15
X55 a_3663_6090# a_323_3700# vdd vdd sky130_fd_pr__pfet_01v8_lvt ad=0.1595 pd=1.39 as=0.319 ps=2.78 w=1.1 l=0.35
X56 vdd qn a_323_8420# vdd sky130_fd_pr__pfet_01v8_lvt ad=0.406 pd=3.38 as=0.203 ps=1.69 w=1.4 l=0.35
X57 cb6 cb2 vdd vdd sky130_fd_pr__pfet_01v8_lvt ad=0.609 pd=4.78 as=0.609 ps=4.78 w=2.1 l=0.35
X58 vdd a_5993_8324# a_6063_8350# vdd sky130_fd_pr__pfet_01v8_lvt ad=0.609 pd=4.78 as=0.3045 ps=2.39 w=2.1 l=0.35
X59 a_3663_3730# a_323_3700# vdd vdd sky130_fd_pr__pfet_01v8_lvt ad=0.1595 pd=1.39 as=0.1595 ps=1.39 w=1.1 l=0.35
X60 a_6063_1270# a_5993_1244# vdd vdd sky130_fd_pr__pfet_01v8_lvt ad=0.3045 pd=2.39 as=0.609 ps=4.78 w=2.1 l=0.35
X61 vdd a_323_3700# a_2903_8450# vdd sky130_fd_pr__pfet_01v8_lvt ad=0.319 pd=2.78 as=0.1595 ps=1.39 w=1.1 l=0.35
X62 vss a_6063_3030# cb5 vss sky130_fd_pr__nfet_01v8_lvt ad=0.527 pd=4.02 as=0.2805 ps=2.03 w=1.7 l=0.15
X63 a_2903_1370# a_323_1340# vdd vdd sky130_fd_pr__pfet_01v8_lvt ad=0.1595 pd=1.39 as=0.319 ps=2.78 w=1.1 l=0.35
X64 a_3663_5490# a_323_8420# vdd vdd sky130_fd_pr__pfet_01v8_lvt ad=0.1595 pd=1.39 as=0.1595 ps=1.39 w=1.1 l=0.35
X65 a_323_1340# vss sky130_fd_pr__cap_mim_m3_1 l=1.75 w=1.75
X66 a_3663_770# a_323_6060# vdd vdd sky130_fd_pr__pfet_01v8_lvt ad=0.1595 pd=1.39 as=0.1595 ps=1.39 w=1.1 l=0.35
X67 vdd a_323_6060# a_3663_8450# vdd sky130_fd_pr__pfet_01v8_lvt ad=0.1595 pd=1.39 as=0.1595 ps=1.39 w=1.1 l=0.35
X68 vdd a_323_6060# a_2903_770# vdd sky130_fd_pr__pfet_01v8_lvt ad=0.1595 pd=1.39 as=0.1595 ps=1.39 w=1.1 l=0.35
X69 vdd a_5993_5964# a_6063_5990# vdd sky130_fd_pr__pfet_01v8_lvt ad=0.609 pd=4.78 as=0.3045 ps=2.39 w=2.1 l=0.35
X70 a_6063_3630# a_5993_3604# vss vss sky130_fd_pr__nfet_01v8_lvt ad=0.1815 pd=1.43 as=0.341 ps=2.82 w=1.1 l=0.15
X71 a_5993_3604# a_6063_3630# vss sky130_fd_pr__res_high_po_0p35 l=9.5
X72 a_3663_7850# a_323_1340# vss vss sky130_fd_pr__nfet_01v8_lvt ad=0.319 pd=2.78 as=0.319 ps=2.78 w=1.1 l=0.15
X73 cb0 cb4 vss vss sky130_fd_pr__nfet_01v8_lvt ad=0.1305 pd=1.48 as=0.1305 ps=1.48 w=0.45 l=0.15
X74 cb5 a_6063_3030# vdd vdd sky130_fd_pr__pfet_01v8_lvt ad=0.3045 pd=2.39 as=0.3045 ps=2.39 w=2.1 l=0.35
X75 a_2903_8450# a_323_3700# vdd vdd sky130_fd_pr__pfet_01v8_lvt ad=0.1595 pd=1.39 as=0.319 ps=2.78 w=1.1 l=0.35
X76 a_6063_8350# a_5993_8324# vdd vdd sky130_fd_pr__pfet_01v8_lvt ad=0.3045 pd=2.39 as=0.609 ps=4.78 w=2.1 l=0.35
X77 cb7 cb3 vss vss sky130_fd_pr__nfet_01v8_lvt ad=0.1305 pd=1.48 as=0.1305 ps=1.48 w=0.45 l=0.15
X78 vdd in a_323_6060# vdd sky130_fd_pr__pfet_01v8_lvt ad=0.406 pd=3.38 as=0.203 ps=1.69 w=1.4 l=0.35
X79 a_3663_5490# a_323_8420# vss vss sky130_fd_pr__nfet_01v8_lvt ad=0.319 pd=2.78 as=0.319 ps=2.78 w=1.1 l=0.15
X80 a_323_8420# qn vss vss sky130_fd_pr__nfet_01v8_lvt ad=0.1155 pd=1.03 as=0.217 ps=2.02 w=0.7 l=0.15
X81 vdd a_323_3700# a_2903_6090# vdd sky130_fd_pr__pfet_01v8_lvt ad=0.319 pd=2.78 as=0.1595 ps=1.39 w=1.1 l=0.35
X82 a_3663_1370# a_323_1340# vdd vdd sky130_fd_pr__pfet_01v8_lvt ad=0.1595 pd=1.39 as=0.1595 ps=1.39 w=1.1 l=0.35
X83 a_6063_5990# a_5993_5964# vdd vdd sky130_fd_pr__pfet_01v8_lvt ad=0.3045 pd=2.39 as=0.609 ps=4.78 w=2.1 l=0.35
X84 cb6 cb2 vss vss sky130_fd_pr__nfet_01v8_lvt ad=0.1305 pd=1.48 as=0.1305 ps=1.48 w=0.45 l=0.15
X85 vdd a_323_3700# a_3663_6090# vdd sky130_fd_pr__pfet_01v8_lvt ad=0.1595 pd=1.39 as=0.1595 ps=1.39 w=1.1 l=0.35
X86 a_323_6060# in vss vss sky130_fd_pr__nfet_01v8_lvt ad=0.1155 pd=1.03 as=0.217 ps=2.02 w=0.7 l=0.15
X87 a_6063_8350# a_5993_8324# vss vss sky130_fd_pr__nfet_01v8_lvt ad=0.1815 pd=1.43 as=0.341 ps=2.82 w=1.1 l=0.15
X88 a_5993_5964# a_5214_5948# sky130_fd_pr__cap_mim_m3_1 l=4.2 w=4.2
X89 cb0 cb4 vdd vdd sky130_fd_pr__pfet_01v8_lvt ad=0.609 pd=4.78 as=0.609 ps=4.78 w=2.1 l=0.35
X90 cb4 a_6063_670# vdd vdd sky130_fd_pr__pfet_01v8_lvt ad=0.3045 pd=2.39 as=0.609 ps=4.78 w=2.1 l=0.35
X91 a_2903_770# a_5214_760# vss sky130_fd_pr__res_high_po_0p69 l=1.5
X92 a_3663_8450# a_323_6060# vdd vdd sky130_fd_pr__pfet_01v8_lvt ad=0.1595 pd=1.39 as=0.1595 ps=1.39 w=1.1 l=0.35
X93 a_2903_1370# a_5214_1228# vss sky130_fd_pr__res_high_po_0p69 l=1.5
X94 a_2903_6090# a_323_3700# vdd vdd sky130_fd_pr__pfet_01v8_lvt ad=0.1595 pd=1.39 as=0.319 ps=2.78 w=1.1 l=0.35
X95 cb7 a_6063_7750# vdd vdd sky130_fd_pr__pfet_01v8_lvt ad=0.3045 pd=2.39 as=0.3045 ps=2.39 w=2.1 l=0.35
X96 vss a_6063_7750# cb7 vss sky130_fd_pr__nfet_01v8_lvt ad=0.527 pd=4.02 as=0.2805 ps=2.03 w=1.7 l=0.15
X97 vdd a_323_6060# a_2903_3130# vdd sky130_fd_pr__pfet_01v8_lvt ad=0.1595 pd=1.39 as=0.1595 ps=1.39 w=1.1 l=0.35
X98 a_3663_3130# a_323_8420# vss vss sky130_fd_pr__nfet_01v8_lvt ad=0.319 pd=2.78 as=0.319 ps=2.78 w=1.1 l=0.15
X99 a_2903_1370# a_323_1340# vss vss sky130_fd_pr__nfet_01v8_lvt ad=0.319 pd=2.78 as=0.319 ps=2.78 w=1.1 l=0.15
X100 a_5993_8324# a_6063_8350# vss sky130_fd_pr__res_high_po_0p35 l=9.5
X101 vss a_6063_5390# cb6 vss sky130_fd_pr__nfet_01v8_lvt ad=0.527 pd=4.02 as=0.2805 ps=2.03 w=1.7 l=0.15
X102 vdd a_6063_3030# cb5 vdd sky130_fd_pr__pfet_01v8_lvt ad=0.3045 pd=2.39 as=0.3045 ps=2.39 w=2.1 l=0.35
X103 a_3663_3730# a_5214_3588# vss sky130_fd_pr__res_high_po_0p69 l=1.5
X104 a_5993_2913# a_6063_3030# vss sky130_fd_pr__res_high_po_0p35 l=9.5
X105 a_2903_8450# a_5214_8308# vss sky130_fd_pr__res_high_po_0p69 l=1.5
X106 a_5993_3604# a_5214_3588# sky130_fd_pr__cap_mim_m3_1 l=4.2 w=4.2
X107 a_6063_670# a_5993_553# vdd vdd sky130_fd_pr__pfet_01v8_lvt ad=0.3045 pd=2.39 as=0.609 ps=4.78 w=2.1 l=0.35
X108 a_5993_553# a_5214_760# sky130_fd_pr__cap_mim_m3_1 l=4.2 w=4.2
X109 cb1 a_6063_3630# vdd vdd sky130_fd_pr__pfet_01v8_lvt ad=0.3045 pd=2.39 as=0.3045 ps=2.39 w=2.1 l=0.35
X110 a_3663_6090# a_323_3700# vdd vdd sky130_fd_pr__pfet_01v8_lvt ad=0.1595 pd=1.39 as=0.1595 ps=1.39 w=1.1 l=0.35
X111 a_2903_6090# a_5214_5948# vss sky130_fd_pr__res_high_po_0p69 l=1.5
X112 a_3663_770# a_323_6060# vss vss sky130_fd_pr__nfet_01v8_lvt ad=0.319 pd=2.78 as=0.319 ps=2.78 w=1.1 l=0.15
X113 cb6 a_6063_5390# vdd vdd sky130_fd_pr__pfet_01v8_lvt ad=0.3045 pd=2.39 as=0.3045 ps=2.39 w=2.1 l=0.35
X114 vdd a_323_8420# a_3663_3130# vdd sky130_fd_pr__pfet_01v8_lvt ad=0.319 pd=2.78 as=0.1595 ps=1.39 w=1.1 l=0.35
X115 cb5 a_6063_3030# vss vss sky130_fd_pr__nfet_01v8_lvt ad=0.2805 pd=2.03 as=0.527 ps=4.02 w=1.7 l=0.15
X116 cb5 a_6063_3030# vdd vdd sky130_fd_pr__pfet_01v8_lvt ad=0.3045 pd=2.39 as=0.609 ps=4.78 w=2.1 l=0.35
X117 vdd a_323_6060# a_2903_770# vdd sky130_fd_pr__pfet_01v8_lvt ad=0.319 pd=2.78 as=0.1595 ps=1.39 w=1.1 l=0.35
X118 vdd a_323_8420# a_2903_7850# vdd sky130_fd_pr__pfet_01v8_lvt ad=0.1595 pd=1.39 as=0.1595 ps=1.39 w=1.1 l=0.35
X119 vdd a_5993_2913# a_6063_3030# vdd sky130_fd_pr__pfet_01v8_lvt ad=0.3045 pd=2.39 as=0.3045 ps=2.39 w=2.1 l=0.35
X120 vss a_6063_670# cb4 vss sky130_fd_pr__nfet_01v8_lvt ad=0.527 pd=4.02 as=0.2805 ps=2.03 w=1.7 l=0.15
X121 vss a_5993_7633# a_6063_7750# vss sky130_fd_pr__nfet_01v8_lvt ad=0.341 pd=2.82 as=0.1815 ps=1.43 w=1.1 l=0.15
X122 cb4 a_6063_670# vss vss sky130_fd_pr__nfet_01v8_lvt ad=0.2805 pd=2.03 as=0.527 ps=4.02 w=1.7 l=0.15
X123 vdd a_6063_7750# cb7 vdd sky130_fd_pr__pfet_01v8_lvt ad=0.3045 pd=2.39 as=0.3045 ps=2.39 w=2.1 l=0.35
X124 a_3663_1370# a_5214_1228# vss sky130_fd_pr__res_high_po_0p69 l=1.5
X125 a_323_3700# qp vdd vdd sky130_fd_pr__pfet_01v8_lvt ad=0.203 pd=1.69 as=0.406 ps=3.38 w=1.4 l=0.35
X126 a_323_8420# vss sky130_fd_pr__cap_mim_m3_1 l=1.75 w=1.75
X127 vss a_5993_5273# a_6063_5390# vss sky130_fd_pr__nfet_01v8_lvt ad=0.341 pd=2.82 as=0.1815 ps=1.43 w=1.1 l=0.15
X128 a_2903_6090# a_323_3700# vss vss sky130_fd_pr__nfet_01v8_lvt ad=0.319 pd=2.78 as=0.319 ps=2.78 w=1.1 l=0.15
X129 cb0 a_6063_1270# vdd vdd sky130_fd_pr__pfet_01v8_lvt ad=0.3045 pd=2.39 as=0.3045 ps=2.39 w=2.1 l=0.35
X130 a_2903_3730# a_5214_3588# vss sky130_fd_pr__res_high_po_0p69 l=1.5
X131 cb4 a_6063_670# vdd vdd sky130_fd_pr__pfet_01v8_lvt ad=0.3045 pd=2.39 as=0.3045 ps=2.39 w=2.1 l=0.35
X132 vdd a_323_1340# a_2903_3730# vdd sky130_fd_pr__pfet_01v8_lvt ad=0.1595 pd=1.39 as=0.1595 ps=1.39 w=1.1 l=0.35
X133 a_3663_8450# a_5214_8308# vss sky130_fd_pr__res_high_po_0p69 l=1.5
X134 a_5993_7633# a_6063_7750# vss sky130_fd_pr__res_high_po_0p35 l=9.5
X135 cb7 a_6063_7750# vdd vdd sky130_fd_pr__pfet_01v8_lvt ad=0.3045 pd=2.39 as=0.609 ps=4.78 w=2.1 l=0.35
X136 a_3663_770# a_5214_760# vss sky130_fd_pr__res_high_po_0p69 l=1.5
X137 vdd a_323_1340# a_3663_7850# vdd sky130_fd_pr__pfet_01v8_lvt ad=0.319 pd=2.78 as=0.1595 ps=1.39 w=1.1 l=0.35
X138 vdd a_323_8420# a_2903_5490# vdd sky130_fd_pr__pfet_01v8_lvt ad=0.1595 pd=1.39 as=0.1595 ps=1.39 w=1.1 l=0.35
X139 vdd a_6063_3630# cb1 vdd sky130_fd_pr__pfet_01v8_lvt ad=0.3045 pd=2.39 as=0.3045 ps=2.39 w=2.1 l=0.35
X140 vdd a_5993_7633# a_6063_7750# vdd sky130_fd_pr__pfet_01v8_lvt ad=0.3045 pd=2.39 as=0.3045 ps=2.39 w=2.1 l=0.35
X141 vdd a_6063_670# cb4 vdd sky130_fd_pr__pfet_01v8_lvt ad=0.609 pd=4.78 as=0.3045 ps=2.39 w=2.1 l=0.35
X142 vdd a_6063_5390# cb6 vdd sky130_fd_pr__pfet_01v8_lvt ad=0.3045 pd=2.39 as=0.3045 ps=2.39 w=2.1 l=0.35
X143 cb3 a_6063_8350# vdd vdd sky130_fd_pr__pfet_01v8_lvt ad=0.3045 pd=2.39 as=0.3045 ps=2.39 w=2.1 l=0.35
X144 a_323_1340# ip vdd vdd sky130_fd_pr__pfet_01v8_lvt ad=0.203 pd=1.69 as=0.406 ps=3.38 w=1.4 l=0.35
X145 a_6063_3030# a_5993_2913# vdd vdd sky130_fd_pr__pfet_01v8_lvt ad=0.3045 pd=2.39 as=0.3045 ps=2.39 w=2.1 l=0.35
X146 a_6063_1270# a_5993_1244# vss sky130_fd_pr__res_high_po_0p35 l=9.5
X147 vss a_5993_2913# a_6063_3030# vss sky130_fd_pr__nfet_01v8_lvt ad=0.341 pd=2.82 as=0.1815 ps=1.43 w=1.1 l=0.15
X148 cb7 a_6063_7750# vss vss sky130_fd_pr__nfet_01v8_lvt ad=0.2805 pd=2.03 as=0.527 ps=4.02 w=1.7 l=0.15
X149 a_2903_3730# a_323_1340# vss vss sky130_fd_pr__nfet_01v8_lvt ad=0.319 pd=2.78 as=0.319 ps=2.78 w=1.1 l=0.15
X150 cb2 a_6063_5990# vdd vdd sky130_fd_pr__pfet_01v8_lvt ad=0.3045 pd=2.39 as=0.3045 ps=2.39 w=2.1 l=0.35
X151 vdd a_323_3700# a_3663_3730# vdd sky130_fd_pr__pfet_01v8_lvt ad=0.319 pd=2.78 as=0.1595 ps=1.39 w=1.1 l=0.35
X152 cb1 a_6063_3630# vdd vdd sky130_fd_pr__pfet_01v8_lvt ad=0.3045 pd=2.39 as=0.609 ps=4.78 w=2.1 l=0.35
X153 vdd a_323_1340# a_2903_1370# vdd sky130_fd_pr__pfet_01v8_lvt ad=0.1595 pd=1.39 as=0.1595 ps=1.39 w=1.1 l=0.35
X154 a_3663_6090# a_5214_5948# vss sky130_fd_pr__res_high_po_0p69 l=1.5
X155 cb6 a_6063_5390# vdd vdd sky130_fd_pr__pfet_01v8_lvt ad=0.3045 pd=2.39 as=0.609 ps=4.78 w=2.1 l=0.35
X156 vdd a_5993_3604# a_6063_3630# vdd sky130_fd_pr__pfet_01v8_lvt ad=0.3045 pd=2.39 as=0.3045 ps=2.39 w=2.1 l=0.35
X157 a_323_8420# qn vdd vdd sky130_fd_pr__pfet_01v8_lvt ad=0.203 pd=1.69 as=0.406 ps=3.38 w=1.4 l=0.35
X158 vdd a_323_8420# a_3663_5490# vdd sky130_fd_pr__pfet_01v8_lvt ad=0.319 pd=2.78 as=0.1595 ps=1.39 w=1.1 l=0.35
X159 a_2903_5490# a_5214_5480# vss sky130_fd_pr__res_high_po_0p69 l=1.5
X160 cb6 a_6063_5390# vss vss sky130_fd_pr__nfet_01v8_lvt ad=0.2805 pd=2.03 as=0.527 ps=4.02 w=1.7 l=0.15
X161 vdd a_6063_1270# cb0 vdd sky130_fd_pr__pfet_01v8_lvt ad=0.3045 pd=2.39 as=0.3045 ps=2.39 w=2.1 l=0.35
X162 a_6063_670# a_5993_553# vdd vdd sky130_fd_pr__pfet_01v8_lvt ad=0.3045 pd=2.39 as=0.3045 ps=2.39 w=2.1 l=0.35
X163 a_2903_770# a_323_6060# vdd vdd sky130_fd_pr__pfet_01v8_lvt ad=0.1595 pd=1.39 as=0.1595 ps=1.39 w=1.1 l=0.35
X164 vdd a_5993_5273# a_6063_5390# vdd sky130_fd_pr__pfet_01v8_lvt ad=0.3045 pd=2.39 as=0.3045 ps=2.39 w=2.1 l=0.35
X165 a_6063_670# a_5993_553# vss sky130_fd_pr__res_high_po_0p35 l=9.5
X166 vdd a_323_6060# a_3663_770# vdd sky130_fd_pr__pfet_01v8_lvt ad=0.1595 pd=1.39 as=0.1595 ps=1.39 w=1.1 l=0.35
X167 a_3663_1370# a_323_1340# vss vss sky130_fd_pr__nfet_01v8_lvt ad=0.319 pd=2.78 as=0.319 ps=2.78 w=1.1 l=0.15
X168 vdd a_323_3700# a_2903_8450# vdd sky130_fd_pr__pfet_01v8_lvt ad=0.1595 pd=1.39 as=0.1595 ps=1.39 w=1.1 l=0.35
X169 a_6063_7750# a_5993_7633# vdd vdd sky130_fd_pr__pfet_01v8_lvt ad=0.3045 pd=2.39 as=0.3045 ps=2.39 w=2.1 l=0.35
X170 cb2 cb6 vss vss sky130_fd_pr__nfet_01v8_lvt ad=0.1305 pd=1.48 as=0.1305 ps=1.48 w=0.45 l=0.15
X171 a_2903_8450# a_323_3700# vss vss sky130_fd_pr__nfet_01v8_lvt ad=0.319 pd=2.78 as=0.319 ps=2.78 w=1.1 l=0.15
X172 vdd a_6063_8350# cb3 vdd sky130_fd_pr__pfet_01v8_lvt ad=0.3045 pd=2.39 as=0.3045 ps=2.39 w=2.1 l=0.35
X173 a_2903_770# a_323_6060# vdd vdd sky130_fd_pr__pfet_01v8_lvt ad=0.1595 pd=1.39 as=0.319 ps=2.78 w=1.1 l=0.35
X174 cb0 a_6063_1270# vdd vdd sky130_fd_pr__pfet_01v8_lvt ad=0.3045 pd=2.39 as=0.609 ps=4.78 w=2.1 l=0.35
X175 vdd a_323_1340# a_3663_1370# vdd sky130_fd_pr__pfet_01v8_lvt ad=0.319 pd=2.78 as=0.1595 ps=1.39 w=1.1 l=0.35
X176 a_6063_7750# a_5993_7633# vss vss sky130_fd_pr__nfet_01v8_lvt ad=0.1815 pd=1.43 as=0.341 ps=2.82 w=1.1 l=0.15
X177 a_5993_2913# a_5214_3120# sky130_fd_pr__cap_mim_m3_1 l=4.2 w=4.2
X178 vdd a_5993_1244# a_6063_1270# vdd sky130_fd_pr__pfet_01v8_lvt ad=0.3045 pd=2.39 as=0.3045 ps=2.39 w=2.1 l=0.35
X179 a_323_6060# in vdd vdd sky130_fd_pr__pfet_01v8_lvt ad=0.203 pd=1.69 as=0.406 ps=3.38 w=1.4 l=0.35
X180 a_2903_3130# a_5214_3120# vss sky130_fd_pr__res_high_po_0p69 l=1.5
X181 cb1 cb5 vss vss sky130_fd_pr__nfet_01v8_lvt ad=0.1305 pd=1.48 as=0.1305 ps=1.48 w=0.45 l=0.15
X182 vdd a_6063_5990# cb2 vdd sky130_fd_pr__pfet_01v8_lvt ad=0.3045 pd=2.39 as=0.3045 ps=2.39 w=2.1 l=0.35
X183 vss a_6063_3630# cb1 vss sky130_fd_pr__nfet_01v8_lvt ad=0.527 pd=4.02 as=0.2805 ps=2.03 w=1.7 l=0.15
X184 a_6063_5990# a_5993_5964# vss sky130_fd_pr__res_high_po_0p35 l=9.5
X185 a_6063_5390# a_5993_5273# vss vss sky130_fd_pr__nfet_01v8_lvt ad=0.1815 pd=1.43 as=0.341 ps=2.82 w=1.1 l=0.15
X186 a_323_3700# qp vdd vdd sky130_fd_pr__pfet_01v8_lvt ad=0.203 pd=1.69 as=0.203 ps=1.69 w=1.4 l=0.35
X187 cb4 a_6063_670# vdd vdd sky130_fd_pr__pfet_01v8_lvt ad=0.3045 pd=2.39 as=0.3045 ps=2.39 w=2.1 l=0.35
X188 a_6063_3630# a_5993_3604# vdd vdd sky130_fd_pr__pfet_01v8_lvt ad=0.3045 pd=2.39 as=0.3045 ps=2.39 w=2.1 l=0.35
X189 vss a_6063_1270# cb0 vss sky130_fd_pr__nfet_01v8_lvt ad=0.527 pd=4.02 as=0.2805 ps=2.03 w=1.7 l=0.15
X190 vdd a_323_6060# a_3663_8450# vdd sky130_fd_pr__pfet_01v8_lvt ad=0.319 pd=2.78 as=0.1595 ps=1.39 w=1.1 l=0.35
X191 vdd a_323_3700# a_2903_6090# vdd sky130_fd_pr__pfet_01v8_lvt ad=0.1595 pd=1.39 as=0.1595 ps=1.39 w=1.1 l=0.35
X192 a_6063_5390# a_5993_5273# vdd vdd sky130_fd_pr__pfet_01v8_lvt ad=0.3045 pd=2.39 as=0.3045 ps=2.39 w=2.1 l=0.35
X193 cb3 a_6063_8350# vdd vdd sky130_fd_pr__pfet_01v8_lvt ad=0.3045 pd=2.39 as=0.609 ps=4.78 w=2.1 l=0.35
X194 vdd a_5993_8324# a_6063_8350# vdd sky130_fd_pr__pfet_01v8_lvt ad=0.3045 pd=2.39 as=0.3045 ps=2.39 w=2.1 l=0.35
X195 a_6063_5390# a_5993_5273# vss sky130_fd_pr__res_high_po_0p35 l=9.5
X196 cb2 a_6063_5990# vdd vdd sky130_fd_pr__pfet_01v8_lvt ad=0.3045 pd=2.39 as=0.609 ps=4.78 w=2.1 l=0.35
X197 a_3663_6090# a_323_3700# vss vss sky130_fd_pr__nfet_01v8_lvt ad=0.319 pd=2.78 as=0.319 ps=2.78 w=1.1 l=0.15
X198 cb5 a_6063_3030# vdd vdd sky130_fd_pr__pfet_01v8_lvt ad=0.3045 pd=2.39 as=0.3045 ps=2.39 w=2.1 l=0.35
X199 vdd a_5993_5964# a_6063_5990# vdd sky130_fd_pr__pfet_01v8_lvt ad=0.3045 pd=2.39 as=0.3045 ps=2.39 w=2.1 l=0.35
X200 vss a_6063_8350# cb3 vss sky130_fd_pr__nfet_01v8_lvt ad=0.527 pd=4.02 as=0.2805 ps=2.03 w=1.7 l=0.15
X201 a_6063_3030# a_5993_2913# vss vss sky130_fd_pr__nfet_01v8_lvt ad=0.1815 pd=1.43 as=0.341 ps=2.82 w=1.1 l=0.15
X202 a_3663_770# a_323_6060# vdd vdd sky130_fd_pr__pfet_01v8_lvt ad=0.1595 pd=1.39 as=0.319 ps=2.78 w=1.1 l=0.35
X203 a_323_1340# ip vdd vdd sky130_fd_pr__pfet_01v8_lvt ad=0.203 pd=1.69 as=0.203 ps=1.69 w=1.4 l=0.35
X204 a_5993_8324# a_5214_8308# sky130_fd_pr__cap_mim_m3_1 l=4.2 w=4.2
X205 a_2903_770# a_323_6060# vss vss sky130_fd_pr__nfet_01v8_lvt ad=0.319 pd=2.78 as=0.319 ps=2.78 w=1.1 l=0.15
X206 a_6063_1270# a_5993_1244# vdd vdd sky130_fd_pr__pfet_01v8_lvt ad=0.3045 pd=2.39 as=0.3045 ps=2.39 w=2.1 l=0.35
X207 vdd a_323_3700# a_3663_6090# vdd sky130_fd_pr__pfet_01v8_lvt ad=0.319 pd=2.78 as=0.1595 ps=1.39 w=1.1 l=0.35
X208 vdd a_6063_3030# cb5 vdd sky130_fd_pr__pfet_01v8_lvt ad=0.3045 pd=2.39 as=0.3045 ps=2.39 w=2.1 l=0.35
X209 vdd a_323_6060# a_3663_770# vdd sky130_fd_pr__pfet_01v8_lvt ad=0.319 pd=2.78 as=0.1595 ps=1.39 w=1.1 l=0.35
X210 a_2903_7850# a_5214_7840# vss sky130_fd_pr__res_high_po_0p69 l=1.5
X211 cb3 cb7 vss vss sky130_fd_pr__nfet_01v8_lvt ad=0.1305 pd=1.48 as=0.1305 ps=1.48 w=0.45 l=0.15
X212 a_2903_3130# a_323_6060# vdd vdd sky130_fd_pr__pfet_01v8_lvt ad=0.1595 pd=1.39 as=0.1595 ps=1.39 w=1.1 l=0.35
X213 vss a_5993_1244# a_6063_1270# vss sky130_fd_pr__nfet_01v8_lvt ad=0.341 pd=2.82 as=0.1815 ps=1.43 w=1.1 l=0.15
X214 cb7 a_6063_7750# vdd vdd sky130_fd_pr__pfet_01v8_lvt ad=0.3045 pd=2.39 as=0.3045 ps=2.39 w=2.1 l=0.35
X215 a_3663_3730# a_323_3700# vss vss sky130_fd_pr__nfet_01v8_lvt ad=0.319 pd=2.78 as=0.319 ps=2.78 w=1.1 l=0.15
X216 a_323_8420# qn vdd vdd sky130_fd_pr__pfet_01v8_lvt ad=0.203 pd=1.69 as=0.203 ps=1.69 w=1.4 l=0.35
X217 vdd qp a_323_3700# vdd sky130_fd_pr__pfet_01v8_lvt ad=0.203 pd=1.69 as=0.203 ps=1.69 w=1.4 l=0.35
X218 a_3663_3130# a_323_8420# vdd vdd sky130_fd_pr__pfet_01v8_lvt ad=0.1595 pd=1.39 as=0.319 ps=2.78 w=1.1 l=0.35
X219 a_6063_8350# a_5993_8324# vdd vdd sky130_fd_pr__pfet_01v8_lvt ad=0.3045 pd=2.39 as=0.3045 ps=2.39 w=2.1 l=0.35
X220 vss a_6063_5990# cb2 vss sky130_fd_pr__nfet_01v8_lvt ad=0.527 pd=4.02 as=0.2805 ps=2.03 w=1.7 l=0.15
X221 vss a_5993_553# a_6063_670# vss sky130_fd_pr__nfet_01v8_lvt ad=0.341 pd=2.82 as=0.1815 ps=1.43 w=1.1 l=0.15
X222 a_3663_3130# a_5214_3120# vss sky130_fd_pr__res_high_po_0p69 l=1.5
X223 a_6063_670# a_5993_553# vss vss sky130_fd_pr__nfet_01v8_lvt ad=0.1815 pd=1.43 as=0.341 ps=2.82 w=1.1 l=0.15
X224 a_6063_5990# a_5993_5964# vdd vdd sky130_fd_pr__pfet_01v8_lvt ad=0.3045 pd=2.39 as=0.3045 ps=2.39 w=2.1 l=0.35
X225 vdd a_6063_3030# cb5 vdd sky130_fd_pr__pfet_01v8_lvt ad=0.609 pd=4.78 as=0.3045 ps=2.39 w=2.1 l=0.35
X226 vdd a_6063_7750# cb7 vdd sky130_fd_pr__pfet_01v8_lvt ad=0.3045 pd=2.39 as=0.3045 ps=2.39 w=2.1 l=0.35
X227 a_2903_7850# a_323_8420# vdd vdd sky130_fd_pr__pfet_01v8_lvt ad=0.1595 pd=1.39 as=0.1595 ps=1.39 w=1.1 l=0.35
X228 cb1 cb5 vdd vdd sky130_fd_pr__pfet_01v8_lvt ad=0.609 pd=4.78 as=0.609 ps=4.78 w=2.1 l=0.35
X229 cb1 a_6063_3630# vdd vdd sky130_fd_pr__pfet_01v8_lvt ad=0.3045 pd=2.39 as=0.3045 ps=2.39 w=2.1 l=0.35
X230 a_3663_8450# a_323_6060# vss vss sky130_fd_pr__nfet_01v8_lvt ad=0.319 pd=2.78 as=0.319 ps=2.78 w=1.1 l=0.15
X231 cb6 a_6063_5390# vdd vdd sky130_fd_pr__pfet_01v8_lvt ad=0.3045 pd=2.39 as=0.3045 ps=2.39 w=2.1 l=0.35
X232 cb1 a_6063_3630# vss vss sky130_fd_pr__nfet_01v8_lvt ad=0.2805 pd=2.03 as=0.527 ps=4.02 w=1.7 l=0.15
X233 a_3663_7850# a_323_1340# vdd vdd sky130_fd_pr__pfet_01v8_lvt ad=0.1595 pd=1.39 as=0.319 ps=2.78 w=1.1 l=0.35
X234 a_323_6060# in vdd vdd sky130_fd_pr__pfet_01v8_lvt ad=0.203 pd=1.69 as=0.203 ps=1.69 w=1.4 l=0.35
X235 vdd a_6063_670# cb4 vdd sky130_fd_pr__pfet_01v8_lvt ad=0.3045 pd=2.39 as=0.3045 ps=2.39 w=2.1 l=0.35
X236 vdd ip a_323_1340# vdd sky130_fd_pr__pfet_01v8_lvt ad=0.203 pd=1.69 as=0.203 ps=1.69 w=1.4 l=0.35
X237 vdd a_323_6060# a_2903_3130# vdd sky130_fd_pr__pfet_01v8_lvt ad=0.319 pd=2.78 as=0.1595 ps=1.39 w=1.1 l=0.35
X238 vdd a_5993_2913# a_6063_3030# vdd sky130_fd_pr__pfet_01v8_lvt ad=0.609 pd=4.78 as=0.3045 ps=2.39 w=2.1 l=0.35
X239 cb0 a_6063_1270# vss vss sky130_fd_pr__nfet_01v8_lvt ad=0.2805 pd=2.03 as=0.527 ps=4.02 w=1.7 l=0.15
X240 vss qp a_323_3700# vss sky130_fd_pr__nfet_01v8_lvt ad=0.217 pd=2.02 as=0.1155 ps=1.03 w=0.7 l=0.15
X241 a_3663_7850# a_5214_7840# vss sky130_fd_pr__res_high_po_0p69 l=1.5
X242 vss a_5993_5964# a_6063_5990# vss sky130_fd_pr__nfet_01v8_lvt ad=0.341 pd=2.82 as=0.1815 ps=1.43 w=1.1 l=0.15
X243 a_5993_1244# a_5214_1228# sky130_fd_pr__cap_mim_m3_1 l=4.2 w=4.2
X244 vdd a_6063_7750# cb7 vdd sky130_fd_pr__pfet_01v8_lvt ad=0.609 pd=4.78 as=0.3045 ps=2.39 w=2.1 l=0.35
X245 vdd a_323_8420# a_3663_3130# vdd sky130_fd_pr__pfet_01v8_lvt ad=0.1595 pd=1.39 as=0.1595 ps=1.39 w=1.1 l=0.35
X246 vdd a_6063_3630# cb1 vdd sky130_fd_pr__pfet_01v8_lvt ad=0.3045 pd=2.39 as=0.3045 ps=2.39 w=2.1 l=0.35
X247 a_2903_3730# a_323_1340# vdd vdd sky130_fd_pr__pfet_01v8_lvt ad=0.1595 pd=1.39 as=0.1595 ps=1.39 w=1.1 l=0.35
X248 vdd qn a_323_8420# vdd sky130_fd_pr__pfet_01v8_lvt ad=0.203 pd=1.69 as=0.203 ps=1.69 w=1.4 l=0.35
X249 vdd a_6063_5390# cb6 vdd sky130_fd_pr__pfet_01v8_lvt ad=0.3045 pd=2.39 as=0.3045 ps=2.39 w=2.1 l=0.35
X250 vss ip a_323_1340# vss sky130_fd_pr__nfet_01v8_lvt ad=0.217 pd=2.02 as=0.1155 ps=1.03 w=0.7 l=0.15
X251 a_2903_5490# a_323_8420# vdd vdd sky130_fd_pr__pfet_01v8_lvt ad=0.1595 pd=1.39 as=0.1595 ps=1.39 w=1.1 l=0.35
X252 cb3 cb7 vdd vdd sky130_fd_pr__pfet_01v8_lvt ad=0.609 pd=4.78 as=0.609 ps=4.78 w=2.1 l=0.35
X253 cb0 a_6063_1270# vdd vdd sky130_fd_pr__pfet_01v8_lvt ad=0.3045 pd=2.39 as=0.3045 ps=2.39 w=2.1 l=0.35
X254 cb3 a_6063_8350# vss vss sky130_fd_pr__nfet_01v8_lvt ad=0.2805 pd=2.03 as=0.527 ps=4.02 w=1.7 l=0.15
X255 a_3663_3730# a_323_3700# vdd vdd sky130_fd_pr__pfet_01v8_lvt ad=0.1595 pd=1.39 as=0.319 ps=2.78 w=1.1 l=0.35
X256 a_6063_3030# a_5993_2913# vdd vdd sky130_fd_pr__pfet_01v8_lvt ad=0.3045 pd=2.39 as=0.609 ps=4.78 w=2.1 l=0.35
X257 vdd a_5993_553# a_6063_670# vdd sky130_fd_pr__pfet_01v8_lvt ad=0.3045 pd=2.39 as=0.3045 ps=2.39 w=2.1 l=0.35
X258 a_3663_5490# a_323_8420# vdd vdd sky130_fd_pr__pfet_01v8_lvt ad=0.1595 pd=1.39 as=0.319 ps=2.78 w=1.1 l=0.35
X259 a_2903_3130# a_323_6060# vdd vdd sky130_fd_pr__pfet_01v8_lvt ad=0.1595 pd=1.39 as=0.319 ps=2.78 w=1.1 l=0.35
X260 a_2903_7850# a_323_8420# vss vss sky130_fd_pr__nfet_01v8_lvt ad=0.319 pd=2.78 as=0.319 ps=2.78 w=1.1 l=0.15
X261 vdd a_323_8420# a_2903_7850# vdd sky130_fd_pr__pfet_01v8_lvt ad=0.319 pd=2.78 as=0.1595 ps=1.39 w=1.1 l=0.35
X262 vdd a_5993_7633# a_6063_7750# vdd sky130_fd_pr__pfet_01v8_lvt ad=0.609 pd=4.78 as=0.3045 ps=2.39 w=2.1 l=0.35
X263 vdd a_6063_3630# cb1 vdd sky130_fd_pr__pfet_01v8_lvt ad=0.609 pd=4.78 as=0.3045 ps=2.39 w=2.1 l=0.35
X264 a_3663_5490# a_5214_5480# vss sky130_fd_pr__res_high_po_0p69 l=1.5
X265 a_2903_5490# a_323_8420# vss vss sky130_fd_pr__nfet_01v8_lvt ad=0.319 pd=2.78 as=0.319 ps=2.78 w=1.1 l=0.15
X266 vss a_5993_3604# a_6063_3630# vss sky130_fd_pr__nfet_01v8_lvt ad=0.341 pd=2.82 as=0.1815 ps=1.43 w=1.1 l=0.15
X267 a_323_6060# vss sky130_fd_pr__cap_mim_m3_1 l=1.75 w=1.75
.ends
