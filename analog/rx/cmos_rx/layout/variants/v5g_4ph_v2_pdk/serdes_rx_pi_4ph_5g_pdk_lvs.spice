* NGSPICE file created from serdes_rx_pi_4ph_5g_pdk.ext - technology: sky130A

.subckt serdes_rx_pi_4ph_5g_pdk ip qp in qn a0 a1 a2 a3 a4 a5 a6 a7 b0 b1 b2 b3 b4
+ b5 b6 b7 f0 f1 f2 f3 f4 f5 f6 f7 rst_n dp dn ep en ckd0 ckd1 ckd2 ckd3 cke0 cke1
+ cke2 cke3 vdd vss
X0 a_2903_6910# a_323_4520# vdd vdd sky130_fd_pr__pfet_01v8_lvt ad=0.1595 pd=1.39 as=0.319 ps=2.78 w=1.1 l=0.35
X1 a_30963_8465# vss vdd vdd sky130_fd_pr__pfet_01v8 ad=0.2607 pd=1.91 as=0.2607 ps=1.91 w=1.58 l=0.15
X2 a_30817_8037# a_29868_8794# a_30963_7375# vss sky130_fd_pr__nfet_01v8_lvt ad=0.396 pd=2.73 as=0.396 ps=2.73 w=2.4 l=0.15
X3 a_3663_2190# a_323_2160# vdd vdd sky130_fd_pr__pfet_01v8_lvt ad=0.1595 pd=1.39 as=0.319 ps=2.78 w=1.1 l=0.35
X4 a_30217_2855# vdd vss vss sky130_fd_pr__nfet_01v8 ad=0.16675 pd=1.44 as=0.16675 ps=1.44 w=1.15 l=0.2
X5 en a_30963_3945# vdd vdd sky130_fd_pr__pfet_01v8 ad=0.495 pd=3.33 as=0.495 ps=3.33 w=3 l=0.15
X6 a_26917_2720# a_28514_1816# vss sky130_fd_pr__res_high_po_0p69 l=2.2
X7 a_22437_4220# a_20555_3741# vss vss sky130_fd_pr__nfet_01v8_lvt ad=0.203 pd=1.98 as=0.203 ps=1.98 w=0.7 l=0.15
X8 vdd a_7787_11933# a_8717_11890# vdd sky130_fd_pr__pfet_01v8 ad=0.837 pd=6.02 as=0.4455 ps=3.03 w=2.7 l=0.15
X9 a_26917_6640# a_25035_6161# vdd vdd sky130_fd_pr__pfet_01v8 ad=0.2805 pd=2.03 as=0.527 ps=4.02 w=1.7 l=0.15
X10 a_5993_4424# a_5214_4408# sky130_fd_pr__cap_mim_m3_1 l=4.2 w=4.2
X11 a_24677_7240# a_22795_7929# vss vss sky130_fd_pr__nfet_01v8_lvt ad=0.203 pd=1.98 as=0.203 ps=1.98 w=0.7 l=0.15
X12 dn a_30963_8465# vdd vdd sky130_fd_pr__pfet_01v8 ad=0.495 pd=3.33 as=0.495 ps=3.33 w=3 l=0.15
X13 vdd a_29702_7094# a_29868_8794# vdd sky130_fd_pr__pfet_01v8 ad=0.4464 pd=3.5 as=0.2376 ps=1.77 w=1.44 l=0.15
X14 a_11527_4275# a_11849_1934# a_7935_1490# vdd sky130_fd_pr__pfet_01v8_lvt ad=0.3335 pd=2.59 as=0.667 ps=5.18 w=2.3 l=0.35
X15 a_9381_11896# a_9999_11686# vdd vdd sky130_fd_pr__pfet_01v8 ad=0.3465 pd=2.43 as=0.651 ps=4.82 w=2.1 l=0.15
X16 a_7935_6810# a_6063_6810# vss vss sky130_fd_pr__nfet_01v8_lvt ad=0.2805 pd=2.03 as=0.527 ps=4.02 w=1.7 l=0.15
X17 a_7935_6210# a_7935_6810# vss vss sky130_fd_pr__nfet_01v8_lvt ad=0.1305 pd=1.48 as=0.1305 ps=1.48 w=0.45 l=0.15
X18 a_16768_4274# a_16768_2574# vdd vdd sky130_fd_pr__pfet_01v8 ad=0.462 pd=3.13 as=0.462 ps=3.13 w=2.8 l=0.15
X19 vdd a_30963_2855# ep vdd sky130_fd_pr__pfet_01v8 ad=0.495 pd=3.33 as=0.495 ps=3.33 w=3 l=0.15
X20 a_17675_12870# a_8701_12702# a_17547_12870# vdd sky130_fd_pr__pfet_01v8_lvt ad=0.464 pd=3.78 as=0.464 ps=3.78 w=1.6 l=0.35
X21 vdd a_30963_7375# dp vdd sky130_fd_pr__pfet_01v8 ad=0.93 pd=6.62 as=0.495 ps=3.33 w=3 l=0.15
X22 vdd qp a_323_4520# vdd sky130_fd_pr__pfet_01v8_lvt ad=0.406 pd=3.38 as=0.203 ps=1.69 w=1.4 l=0.35
X23 a_11270_13392# a_16802_11144# vss vss sky130_fd_pr__nfet_01v8_lvt ad=0.2805 pd=2.03 as=0.527 ps=4.02 w=1.7 l=0.15
X24 a_6063_8570# a_5993_8453# vdd vdd sky130_fd_pr__pfet_01v8_lvt ad=0.3045 pd=2.39 as=0.609 ps=4.78 w=2.1 l=0.35
X25 vdd a_18719_7929# vdd vdd sky130_fd_pr__pfet_01v8 ad=0.527 pd=4.02 as=335.98239 ps=2.5368k w=1.7 l=0.15
X26 a_10451_12702# a_8701_12702# vss vss sky130_fd_pr__nfet_01v8_lvt ad=0.1885 pd=1.88 as=0.1885 ps=1.88 w=0.65 l=0.15
X27 a_2903_8670# a_323_9240# vdd vdd sky130_fd_pr__pfet_01v8_lvt ad=0.1595 pd=1.39 as=0.319 ps=2.78 w=1.1 l=0.35
X28 a_27658_12850# a_20458_12920# vss vss sky130_fd_pr__nfet_01v8 ad=0.174 pd=1.78 as=0.174 ps=1.78 w=0.6 l=0.18
X29 a_14067_11933# a_6211_11960# dn vdd sky130_fd_pr__pfet_01v8_lvt ad=0.32915 pd=2.56 as=0.6583 ps=5.12 w=2.27 l=0.35
X30 a_18550_13392# a_21667_12830# vdd vdd sky130_fd_pr__pfet_01v8 ad=0.5445 pd=3.63 as=0.5445 ps=3.63 w=3.3 l=0.15
X31 vss a_29327_12830# a_24149_11800# vss sky130_fd_pr__nfet_01v8_lvt ad=0.527 pd=4.02 as=0.2805 ps=2.03 w=1.7 l=0.15
X32 a_22795_10029# a_22753_1814# a_13102_7094# vss sky130_fd_pr__nfet_01v8_lvt ad=0.1885 pd=1.88 as=0.1885 ps=1.88 w=0.65 l=0.15
X33 a_23199_5509# f5 a_13102_2574# vss sky130_fd_pr__nfet_01v8_lvt ad=0.1885 pd=1.88 as=0.1885 ps=1.88 w=0.65 l=0.15
X34 vdd a_5993_4424# a_6063_4450# vdd sky130_fd_pr__pfet_01v8_lvt ad=0.609 pd=4.78 as=0.3045 ps=2.39 w=2.1 l=0.35
X35 a_11527_2855# a2 a_7935_2090# vss sky130_fd_pr__nfet_01v8_lvt ad=0.12375 pd=1.08 as=0.2325 ps=2.12 w=0.75 l=0.15
X36 dn a_6211_11960# a_14067_11933# vdd sky130_fd_pr__pfet_01v8_lvt ad=0.32915 pd=2.56 as=0.32915 ps=2.56 w=2.27 l=0.35
X37 a_20197_9340# a_28514_8208# vss sky130_fd_pr__res_high_po_0p69 l=2.2
X38 vss vdd a_30217_7375# vss sky130_fd_pr__nfet_01v8 ad=0.3335 pd=2.88 as=0.16675 ps=1.44 w=1.15 l=0.2
X39 vdd a_323_2160# a_2903_4550# vdd sky130_fd_pr__pfet_01v8_lvt ad=0.319 pd=2.78 as=0.1595 ps=1.39 w=1.1 l=0.35
X40 vdd en ep vdd sky130_fd_pr__pfet_01v8 ad=0.589 pd=4.42 as=0.3135 ps=2.23 w=1.9 l=0.15
X41 vss a_20959_3409# vss vss sky130_fd_pr__nfet_01v8_lvt ad=0.203 pd=1.98 as=97.0225 ps=846.06 w=0.7 l=0.15
X42 a_26917_4220# a_25035_3741# vss vss sky130_fd_pr__nfet_01v8_lvt ad=0.203 pd=1.98 as=0.203 ps=1.98 w=0.7 l=0.15
X43 a_18719_3741# a_18273_3298# a_13102_2574# vdd sky130_fd_pr__pfet_01v8_lvt ad=0.609 pd=4.78 as=0.609 ps=4.78 w=2.1 l=0.35
X44 a_11527_4275# a_12625_1934# a_7935_2090# vdd sky130_fd_pr__pfet_01v8_lvt ad=0.3335 pd=2.59 as=0.667 ps=5.18 w=2.3 l=0.35
X45 vss a_11270_13392# vss vss sky130_fd_pr__nfet_01v8 ad=0.1218 pd=1.42 as=0 ps=0 w=0.42 l=0.5
X46 a_25439_6161# f7 a_16768_8794# vdd sky130_fd_pr__pfet_01v8_lvt ad=0.609 pd=4.78 as=0.609 ps=4.78 w=2.1 l=0.35
X47 a_20959_1641# f3 a_13268_4274# vss sky130_fd_pr__nfet_01v8_lvt ad=0.1885 pd=1.88 as=0.1885 ps=1.88 w=0.65 l=0.15
X48 a_7935_4450# a_15349_1934# a_15027_2855# vdd sky130_fd_pr__pfet_01v8_lvt ad=0.667 pd=5.18 as=0.3335 ps=2.59 w=2.3 l=0.35
X49 vdd a_13102_4274# a_13102_2574# vdd sky130_fd_pr__pfet_01v8_lvt ad=0.812 pd=6.18 as=0.406 ps=3.09 w=2.8 l=0.35
X50 a_9999_11686# a_14997_11890# vss vss sky130_fd_pr__nfet_01v8_lvt ad=0.198 pd=1.53 as=0.372 ps=3.02 w=1.2 l=0.15
X51 a_20347_11933# a_6211_11960# vss vss sky130_fd_pr__nfet_01v8 ad=0.232 pd=2.18 as=0.232 ps=2.18 w=0.8 l=0.18
X52 a_6063_9170# a_5993_9144# vss vss sky130_fd_pr__nfet_01v8_lvt ad=0.1815 pd=1.43 as=0.341 ps=2.82 w=1.1 l=0.15
X53 vdd a_6063_9170# a_7935_9170# vdd sky130_fd_pr__pfet_01v8_lvt ad=0.3045 pd=2.39 as=0.3045 ps=2.39 w=2.1 l=0.35
X54 vdd a_16768_2574# a_16768_4274# vdd sky130_fd_pr__pfet_01v8_lvt ad=0.812 pd=6.18 as=0.406 ps=3.09 w=2.8 l=0.35
X55 a_18550_13392# a_22559_11686# a_29327_12830# vss sky130_fd_pr__nfet_01v8_lvt ad=0.33 pd=2.33 as=0.62 ps=4.62 w=2 l=0.15
X56 a_20555_8261# f2 a_13102_7094# vdd sky130_fd_pr__pfet_01v8_lvt ad=0.609 pd=4.78 as=0.609 ps=4.78 w=2.1 l=0.35
X57 a_22437_2120# a_20555_1641# vdd vdd sky130_fd_pr__pfet_01v8 ad=0.2805 pd=2.03 as=0.527 ps=4.02 w=1.7 l=0.15
X58 a_20197_2720# a_18315_3409# vss vss sky130_fd_pr__nfet_01v8_lvt ad=0.203 pd=1.98 as=0.203 ps=1.98 w=0.7 l=0.15
X59 a_20959_8261# f2 a_16602_7094# vdd sky130_fd_pr__pfet_01v8_lvt ad=0.609 pd=4.78 as=0.609 ps=4.78 w=2.1 l=0.35
X60 a_18719_8261# f0 a_13102_7094# vss sky130_fd_pr__nfet_01v8_lvt ad=0.1885 pd=1.88 as=0.1885 ps=1.88 w=0.65 l=0.15
X61 vdd a_20959_7929# vdd vdd sky130_fd_pr__pfet_01v8 ad=0.527 pd=4.02 as=0 ps=0 w=1.7 l=0.15
X62 dn dp vss vss sky130_fd_pr__nfet_01v8_lvt ad=0.261 pd=2.38 as=0.261 ps=2.38 w=0.9 l=0.15
X63 a_3663_1590# a_323_6880# vdd vdd sky130_fd_pr__pfet_01v8_lvt ad=0.1595 pd=1.39 as=0.1595 ps=1.39 w=1.1 l=0.35
X64 a_11527_2855# a6 a_7935_1490# vss sky130_fd_pr__nfet_01v8_lvt ad=0.12375 pd=1.08 as=0.2325 ps=2.12 w=0.75 l=0.15
X65 vdd a_6063_2090# a_7935_2090# vdd sky130_fd_pr__pfet_01v8_lvt ad=0.609 pd=4.78 as=0.3045 ps=2.39 w=2.1 l=0.35
X66 a_20513_3298# f2 vss vss sky130_fd_pr__nfet_01v8 ad=0.1305 pd=1.48 as=0.1305 ps=1.48 w=0.45 l=0.18
X67 vss a_22497_11800# cke3 vss sky130_fd_pr__nfet_01v8_lvt ad=0.372 pd=3.02 as=0.198 ps=1.53 w=1.2 l=0.15
X68 a_20197_9340# a_18315_10029# vss vss sky130_fd_pr__nfet_01v8_lvt ad=0.203 pd=1.98 as=0.203 ps=1.98 w=0.7 l=0.15
X69 a_2903_9270# a_323_4520# vdd vdd sky130_fd_pr__pfet_01v8_lvt ad=0.1595 pd=1.39 as=0.1595 ps=1.39 w=1.1 l=0.35
X70 a_15027_4275# b3 a_7935_3850# vss sky130_fd_pr__nfet_01v8_lvt ad=0.12375 pd=1.08 as=0.2325 ps=2.12 w=0.75 l=0.15
X71 vdd a_16602_4274# a_16602_2574# vdd sky130_fd_pr__pfet_01v8 ad=0.868 pd=6.22 as=0.462 ps=3.13 w=2.8 l=0.15
X72 vdd a_23199_5509# vdd vdd sky130_fd_pr__pfet_01v8 ad=0.527 pd=4.02 as=0 ps=0 w=1.7 l=0.15
X73 a_18315_1641# f1 a_16768_4274# vss sky130_fd_pr__nfet_01v8_lvt ad=0.1885 pd=1.88 as=0.1885 ps=1.88 w=0.65 l=0.15
X74 a_25035_3741# f6 a_16602_2574# vss sky130_fd_pr__nfet_01v8_lvt ad=0.1885 pd=1.88 as=0.1885 ps=1.88 w=0.65 l=0.15
X75 cke1 a_24149_11800# vdd vdd sky130_fd_pr__pfet_01v8 ad=0.495 pd=3.33 as=0.495 ps=3.33 w=3 l=0.15
X76 vss in a_323_6880# vss sky130_fd_pr__nfet_01v8_lvt ad=0.217 pd=2.02 as=0.1155 ps=1.03 w=0.7 l=0.15
X77 cke3 a_22497_11800# vdd vdd sky130_fd_pr__pfet_01v8 ad=0.495 pd=3.33 as=0.93 ps=6.62 w=3 l=0.15
X78 a_20959_10029# a_20513_1814# a_13102_7094# vdd sky130_fd_pr__pfet_01v8_lvt ad=0.609 pd=4.78 as=0.609 ps=4.78 w=2.1 l=0.35
X79 vdd a_323_4520# a_3663_4550# vdd sky130_fd_pr__pfet_01v8_lvt ad=0.1595 pd=1.39 as=0.1595 ps=1.39 w=1.1 l=0.35
X80 a_7935_3850# a_16125_1934# a_15027_2855# vdd sky130_fd_pr__pfet_01v8_lvt ad=0.667 pd=5.18 as=0.3335 ps=2.59 w=2.3 l=0.35
X81 a_22507_12830# a_21667_12830# vss vss sky130_fd_pr__nfet_01v8 ad=0.174 pd=1.78 as=0.174 ps=1.78 w=0.6 l=0.28
X82 a_25439_1641# f7 a_13268_4274# vss sky130_fd_pr__nfet_01v8_lvt ad=0.1885 pd=1.88 as=0.1885 ps=1.88 w=0.65 l=0.15
X83 cke3 cke1 vdd vdd sky130_fd_pr__pfet_01v8 ad=0.6264 pd=4.9 as=0.6264 ps=4.9 w=2.16 l=0.15
X84 a_25035_10029# a_24993_1814# a_13102_7094# vss sky130_fd_pr__nfet_01v8_lvt ad=0.1885 pd=1.88 as=0.1885 ps=1.88 w=0.65 l=0.15
X85 a_11527_8795# a0 a_7935_2090# vss sky130_fd_pr__nfet_01v8_lvt ad=0.12375 pd=1.08 as=0.2325 ps=2.12 w=0.75 l=0.15
X86 a_13268_8794# a_13268_7094# vss vss sky130_fd_pr__nfet_01v8_lvt ad=0.2805 pd=2.03 as=0.527 ps=4.02 w=1.7 l=0.15
X87 a_20197_7240# a_18315_7929# vdd vdd sky130_fd_pr__pfet_01v8 ad=0.2805 pd=2.03 as=0.527 ps=4.02 w=1.7 l=0.15
X88 a_23199_3409# a_22753_3298# a_13268_4274# vdd sky130_fd_pr__pfet_01v8_lvt ad=0.609 pd=4.78 as=0.609 ps=4.78 w=2.1 l=0.35
X89 a_23199_3741# f4 a_16602_2574# vdd sky130_fd_pr__pfet_01v8_lvt ad=0.609 pd=4.78 as=0.609 ps=4.78 w=2.1 l=0.35
X90 a_29868_8794# a_29868_7094# vss sky130_fd_pr__res_high_po_0p35 l=6.5
X91 a_15027_4275# b7 a_7935_4450# vss sky130_fd_pr__nfet_01v8_lvt ad=0.12375 pd=1.08 as=0.2325 ps=2.12 w=0.75 l=0.15
X92 a_18315_10029# a_18273_1814# a_16602_7094# vdd sky130_fd_pr__pfet_01v8_lvt ad=0.609 pd=4.78 as=0.609 ps=4.78 w=2.1 l=0.35
X93 vdd a_25439_7929# vdd vdd sky130_fd_pr__pfet_01v8 ad=0.527 pd=4.02 as=0 ps=0 w=1.7 l=0.15
X94 a_22795_5509# f5 a_16602_2574# vss sky130_fd_pr__nfet_01v8_lvt ad=0.1885 pd=1.88 as=0.1885 ps=1.88 w=0.65 l=0.15
X95 a_3663_9270# a_323_6880# vdd vdd sky130_fd_pr__pfet_01v8_lvt ad=0.1595 pd=1.39 as=0.319 ps=2.78 w=1.1 l=0.35
X96 a_16309_11910# a_16802_11144# vdd vdd sky130_fd_pr__pfet_01v8 ad=0.174 pd=1.78 as=0.174 ps=1.78 w=0.6 l=0.28
X97 a_3663_3950# a_323_9240# vss vss sky130_fd_pr__nfet_01v8_lvt ad=0.319 pd=2.78 as=0.319 ps=2.78 w=1.1 l=0.15
X98 a_29702_2574# a_29868_4274# vdd vdd sky130_fd_pr__pfet_01v8 ad=0.2376 pd=1.77 as=0.4464 ps=3.5 w=1.44 l=0.15
X99 a_18719_7929# a_18273_3298# a_13268_8794# vdd sky130_fd_pr__pfet_01v8_lvt ad=0.609 pd=4.78 as=0.609 ps=4.78 w=2.1 l=0.35
X100 a_20555_1641# f3 a_16768_4274# vss sky130_fd_pr__nfet_01v8_lvt ad=0.1885 pd=1.88 as=0.1885 ps=1.88 w=0.65 l=0.15
X101 a_25035_3409# a_24993_3298# a_13268_4274# vss sky130_fd_pr__nfet_01v8_lvt ad=0.1885 pd=1.88 as=0.1885 ps=1.88 w=0.65 l=0.15
X102 a_10029_11910# a_10522_11144# vss vss sky130_fd_pr__nfet_01v8 ad=0.174 pd=1.78 as=0.174 ps=1.78 w=0.6 l=0.28
X103 a_22497_11800# a_28467_12830# vdd vdd sky130_fd_pr__pfet_01v8 ad=0.5445 pd=3.63 as=1.023 ps=7.22 w=3.3 l=0.15
X104 a_25439_10029# a_24993_1814# a_13102_7094# vdd sky130_fd_pr__pfet_01v8_lvt ad=0.609 pd=4.78 as=0.609 ps=4.78 w=2.1 l=0.35
X105 dn a_30963_8465# vdd vdd sky130_fd_pr__pfet_01v8 ad=0.495 pd=3.33 as=0.93 ps=6.62 w=3 l=0.15
X106 vdd vss a_30963_3945# vdd sky130_fd_pr__pfet_01v8 ad=0.4898 pd=3.78 as=0.2607 ps=1.91 w=1.58 l=0.15
X107 a_18315_3741# a_18273_3298# a_13102_2574# vss sky130_fd_pr__nfet_01v8_lvt ad=0.1885 pd=1.88 as=0.1885 ps=1.88 w=0.65 l=0.15
X108 vss a_11270_13392# ckd3 vss sky130_fd_pr__nfet_01v8_lvt ad=0.372 pd=3.02 as=0.198 ps=1.53 w=1.2 l=0.15
X109 a_11527_8795# a4 a_7935_1490# vss sky130_fd_pr__nfet_01v8_lvt ad=0.12375 pd=1.08 as=0.2325 ps=2.12 w=0.75 l=0.15
X110 a_23199_8261# a_22753_3298# a_16602_7094# vss sky130_fd_pr__nfet_01v8_lvt ad=0.1885 pd=1.88 as=0.1885 ps=1.88 w=0.65 l=0.15
X111 a_7935_1490# a_7935_2090# vdd vdd sky130_fd_pr__pfet_01v8_lvt ad=0.609 pd=4.78 as=0.609 ps=4.78 w=2.1 l=0.35
X112 vdd a_8717_11890# a_9381_11896# vdd sky130_fd_pr__pfet_01v8 ad=0.4356 pd=2.97 as=0.4356 ps=2.97 w=2.64 l=0.15
X113 a_24677_7240# a_22795_7929# vdd vdd sky130_fd_pr__pfet_01v8 ad=0.2805 pd=2.03 as=0.527 ps=4.02 w=1.7 l=0.15
X114 a_20197_6640# a_28514_6336# vss sky130_fd_pr__res_high_po_0p69 l=2.2
X115 a_7935_8570# a_15737_1934# a_15027_4275# vdd sky130_fd_pr__pfet_01v8_lvt ad=0.667 pd=5.18 as=0.3335 ps=2.59 w=2.3 l=0.35
X116 a_25439_3409# a_24993_3298# a_16768_4274# vss sky130_fd_pr__nfet_01v8_lvt ad=0.1885 pd=1.88 as=0.1885 ps=1.88 w=0.65 l=0.15
X117 a_18719_3741# a_18273_3298# a_16602_2574# vss sky130_fd_pr__nfet_01v8_lvt ad=0.1885 pd=1.88 as=0.1885 ps=1.88 w=0.65 l=0.15
X118 a_16309_11910# a_9381_11896# a_10451_12702# vdd sky130_fd_pr__pfet_01v8 ad=0.4125 pd=2.83 as=0.775 ps=5.62 w=2.5 l=0.15
X119 ckd0 ckd2 vdd vdd sky130_fd_pr__pfet_01v8 ad=0.6264 pd=4.9 as=0.6264 ps=4.9 w=2.16 l=0.15
X120 ckd3 a_11270_13392# vdd vdd sky130_fd_pr__pfet_01v8 ad=0.495 pd=3.33 as=0.93 ps=6.62 w=3 l=0.15
X121 cke0 a_17910_13392# vdd vdd sky130_fd_pr__pfet_01v8 ad=0.495 pd=3.33 as=0.495 ps=3.33 w=3 l=0.15
X122 vss a_28467_12830# a_22497_11800# vss sky130_fd_pr__nfet_01v8_lvt ad=0.527 pd=4.02 as=0.2805 ps=2.03 w=1.7 l=0.15
X123 vdd a_30963_7375# dp vdd sky130_fd_pr__pfet_01v8 ad=0.495 pd=3.33 as=0.495 ps=3.33 w=3 l=0.15
X124 a_26917_4820# a_25035_5509# vdd vdd sky130_fd_pr__pfet_01v8 ad=0.2805 pd=2.03 as=0.527 ps=4.02 w=1.7 l=0.15
X125 ckd3 ckd1 vdd vdd sky130_fd_pr__pfet_01v8 ad=0.6264 pd=4.9 as=0.6264 ps=4.9 w=2.16 l=0.15
X126 a_29702_7094# a_29702_8794# a_30217_7375# vss sky130_fd_pr__nfet_01v8_lvt ad=0.744 pd=5.42 as=0.396 ps=2.73 w=2.4 l=0.15
X127 a_24993_1814# f7 vdd vdd sky130_fd_pr__pfet_01v8 ad=0.261 pd=2.38 as=0.261 ps=2.38 w=0.9 l=0.18
X128 vdd a_9937_11910# ckd1 vdd sky130_fd_pr__pfet_01v8 ad=0.495 pd=3.33 as=0.495 ps=3.33 w=3 l=0.15
X129 a_22507_12830# a_6858_11170# vdd vdd sky130_fd_pr__pfet_01v8 ad=0.522 pd=4.18 as=0.522 ps=4.18 w=1.8 l=0.18
X130 a_3663_6910# a_323_4520# vdd vdd sky130_fd_pr__pfet_01v8_lvt ad=0.1595 pd=1.39 as=0.1595 ps=1.39 w=1.1 l=0.35
X131 a_20555_10029# a_20513_1814# a_16602_7094# vdd sky130_fd_pr__pfet_01v8_lvt ad=0.609 pd=4.78 as=0.609 ps=4.78 w=2.1 l=0.35
X132 vss a_13268_2574# a_13268_4274# vss sky130_fd_pr__nfet_01v8_lvt ad=0.527 pd=4.02 as=0.2805 ps=2.03 w=1.7 l=0.15
X133 vdd a_30963_3945# a_30963_2855# vdd sky130_fd_pr__pfet_01v8 ad=0.2079 pd=1.59 as=0.2079 ps=1.59 w=1.26 l=0.15
X134 vdd a_18315_3409# a_20197_2720# vdd sky130_fd_pr__pfet_01v8 ad=0.527 pd=4.02 as=0.2805 ps=2.03 w=1.7 l=0.15
X135 vdd a_10522_11144# a_10451_12702# vdd sky130_fd_pr__pfet_01v8 ad=1.023 pd=7.22 as=0.5445 ps=3.63 w=3.3 l=0.15
X136 a_13268_8794# a_13268_7094# vss sky130_fd_pr__res_high_po_0p35 l=6.5
X137 a_6063_4450# a_5993_4424# vdd vdd sky130_fd_pr__pfet_01v8_lvt ad=0.3045 pd=2.39 as=0.609 ps=4.78 w=2.1 l=0.35
X138 a_323_9240# vss sky130_fd_pr__cap_mim_m3_1 l=1.75 w=1.75
X139 vdd a_30963_8465# a_30963_7375# vdd sky130_fd_pr__pfet_01v8 ad=0.3906 pd=3.14 as=0.2079 ps=1.59 w=1.26 l=0.15
X140 vss a_6063_6210# a_7935_6210# vss sky130_fd_pr__nfet_01v8_lvt ad=0.527 pd=4.02 as=0.2805 ps=2.03 w=1.7 l=0.15
X141 a_2903_4550# a_323_2160# vdd vdd sky130_fd_pr__pfet_01v8_lvt ad=0.1595 pd=1.39 as=0.319 ps=2.78 w=1.1 l=0.35
X142 a_28947_12830# a_27658_12850# a_29327_12830# vdd sky130_fd_pr__pfet_01v8 ad=0.62 pd=4.62 as=0.33 ps=2.33 w=2 l=0.15
X143 a_7787_11933# a_6211_11960# dp vdd sky130_fd_pr__pfet_01v8_lvt ad=0.32915 pd=2.56 as=0.6583 ps=5.12 w=2.27 l=0.35
X144 vdd a_25035_1641# a_26917_2120# vdd sky130_fd_pr__pfet_01v8 ad=0.527 pd=4.02 as=0.2805 ps=2.03 w=1.7 l=0.15
X145 dp dn vss vss sky130_fd_pr__nfet_01v8_lvt ad=0.261 pd=2.38 as=0.261 ps=2.38 w=0.9 l=0.15
X146 vdd a_30963_3945# en vdd sky130_fd_pr__pfet_01v8 ad=0.93 pd=6.62 as=0.495 ps=3.33 w=3 l=0.15
X147 a_22795_1641# f5 a_13268_4274# vdd sky130_fd_pr__pfet_01v8_lvt ad=0.609 pd=4.78 as=0.609 ps=4.78 w=2.1 l=0.35
X148 vss a_18719_3741# vss vss sky130_fd_pr__nfet_01v8_lvt ad=0.203 pd=1.98 as=0 ps=0 w=0.7 l=0.15
X149 a_7935_3850# a_7935_4450# vss vss sky130_fd_pr__nfet_01v8_lvt ad=0.1305 pd=1.48 as=0.1305 ps=1.48 w=0.45 l=0.15
X150 a_7935_1490# a_11461_1934# a_11527_7375# vdd sky130_fd_pr__pfet_01v8_lvt ad=0.667 pd=5.18 as=0.3335 ps=2.59 w=2.3 l=0.35
X151 a_23199_7929# f4 a_16768_8794# vdd sky130_fd_pr__pfet_01v8_lvt ad=0.609 pd=4.78 as=0.609 ps=4.78 w=2.1 l=0.35
X152 en a_30963_3945# vdd vdd sky130_fd_pr__pfet_01v8_lvt ad=0.406 pd=3.09 as=0.812 ps=6.18 w=2.8 l=0.35
X153 a_9999_11686# a_9381_11896# vss vss sky130_fd_pr__nfet_01v8_lvt ad=0.29 pd=2.58 as=0.29 ps=2.58 w=1 l=0.15
X154 a_18719_10029# a_18273_1814# a_16602_7094# vss sky130_fd_pr__nfet_01v8_lvt ad=0.1885 pd=1.88 as=0.1885 ps=1.88 w=0.65 l=0.15
X155 a_3663_8670# a_323_2160# vdd vdd sky130_fd_pr__pfet_01v8_lvt ad=0.1595 pd=1.39 as=0.1595 ps=1.39 w=1.1 l=0.35
X156 vdd ip a_323_2160# vdd sky130_fd_pr__pfet_01v8_lvt ad=0.406 pd=3.38 as=0.203 ps=1.69 w=1.4 l=0.35
X157 a_22437_4820# a_28514_3688# vss sky130_fd_pr__res_high_po_0p69 l=2.2
X158 vdd a_6063_9170# a_7935_9170# vdd sky130_fd_pr__pfet_01v8_lvt ad=0.609 pd=4.78 as=0.3045 ps=2.39 w=2.1 l=0.35
X159 a_11270_13392# a_9937_11910# vss vss sky130_fd_pr__nfet_01v8_lvt ad=0.1885 pd=1.88 as=0.1885 ps=1.88 w=0.65 l=0.15
X160 a_9937_11910# a_9999_11686# a_10029_11910# vdd sky130_fd_pr__pfet_01v8 ad=0.4125 pd=2.83 as=0.4125 ps=2.83 w=2.5 l=0.15
X161 a_9937_11910# a_11270_13392# vss vss sky130_fd_pr__nfet_01v8_lvt ad=0.1885 pd=1.88 as=0.1885 ps=1.88 w=0.65 l=0.15
X162 a_323_6880# vss sky130_fd_pr__cap_mim_m3_1 l=1.75 w=1.75
X163 vdd a_22795_3409# a_24677_2720# vdd sky130_fd_pr__pfet_01v8 ad=0.527 pd=4.02 as=0.2805 ps=2.03 w=1.7 l=0.15
X164 a_7935_3850# b5 a_15027_8795# vss sky130_fd_pr__nfet_01v8_lvt ad=0.2325 pd=2.12 as=0.12375 ps=1.08 w=0.75 l=0.15
X165 a_323_4520# qp vss vss sky130_fd_pr__nfet_01v8_lvt ad=0.1155 pd=1.03 as=0.217 ps=2.02 w=0.7 l=0.15
X166 vdd a_5993_2064# a_6063_2090# vdd sky130_fd_pr__pfet_01v8_lvt ad=0.609 pd=4.78 as=0.3045 ps=2.39 w=2.1 l=0.35
X167 a_20555_3409# f2 a_13268_4274# vdd sky130_fd_pr__pfet_01v8_lvt ad=0.609 pd=4.78 as=0.609 ps=4.78 w=2.1 l=0.35
X168 a_22795_6161# a_22753_1814# a_13268_8794# vss sky130_fd_pr__nfet_01v8_lvt ad=0.1885 pd=1.88 as=0.1885 ps=1.88 w=0.65 l=0.15
X169 vdd a_323_2160# a_2903_2190# vdd sky130_fd_pr__pfet_01v8_lvt ad=0.319 pd=2.78 as=0.1595 ps=1.39 w=1.1 l=0.35
X170 a_21667_12830# a_20458_12920# a_21335_13580# vss sky130_fd_pr__nfet_01v8_lvt ad=0.377 pd=3.18 as=0.377 ps=3.18 w=1.3 l=0.15
X171 vss a_16602_8794# a_16602_7094# vss sky130_fd_pr__nfet_01v8_lvt ad=0.527 pd=4.02 as=0.2805 ps=2.03 w=1.7 l=0.15
X172 a_23199_7929# f4 a_13268_8794# vss sky130_fd_pr__nfet_01v8_lvt ad=0.1885 pd=1.88 as=0.1885 ps=1.88 w=0.65 l=0.15
X173 a_7935_2090# a_12237_1934# a_11527_7375# vdd sky130_fd_pr__pfet_01v8_lvt ad=0.667 pd=5.18 as=0.3335 ps=2.59 w=2.3 l=0.35
X174 a_20959_3409# f2 a_16768_4274# vdd sky130_fd_pr__pfet_01v8_lvt ad=0.609 pd=4.78 as=0.609 ps=4.78 w=2.1 l=0.35
X175 a_24149_11800# a_22497_11800# vss vss sky130_fd_pr__nfet_01v8_lvt ad=0.1885 pd=1.88 as=0.1885 ps=1.88 w=0.65 l=0.15
X176 a_6063_6810# a_5993_6784# vss vss sky130_fd_pr__nfet_01v8_lvt ad=0.1815 pd=1.43 as=0.341 ps=2.82 w=1.1 l=0.15
X177 a_29868_8794# a_29868_7094# a_30217_7375# vss sky130_fd_pr__nfet_01v8_lvt ad=0.744 pd=5.42 as=0.396 ps=2.73 w=2.4 l=0.15
X178 vdd a_9999_11686# a_9381_11896# vdd sky130_fd_pr__pfet_01v8 ad=0.651 pd=4.82 as=0.3465 ps=2.43 w=2.1 l=0.15
X179 a_21667_12830# a_22507_12830# vdd vdd sky130_fd_pr__pfet_01v8 ad=0.174 pd=1.78 as=0.174 ps=1.78 w=0.6 l=0.28
X180 vdd a_23199_8261# vdd vdd sky130_fd_pr__pfet_01v8 ad=0.2805 pd=2.03 as=0 ps=0 w=1.7 l=0.15
X181 vdd a_18719_1641# vdd vdd sky130_fd_pr__pfet_01v8 ad=0.527 pd=4.02 as=0 ps=0 w=1.7 l=0.15
X182 a_7935_1490# a_7935_2090# vss vss sky130_fd_pr__nfet_01v8_lvt ad=0.1305 pd=1.48 as=0.1305 ps=1.48 w=0.45 l=0.15
X183 a_22559_11686# a_27557_11890# vdd vdd sky130_fd_pr__pfet_01v8 ad=0.4356 pd=2.97 as=0.8184 ps=5.9 w=2.64 l=0.15
X184 a_13102_7094# a_13102_8794# vdd vdd sky130_fd_pr__pfet_01v8 ad=0.462 pd=3.13 as=0.868 ps=6.22 w=2.8 l=0.15
X185 vss a_16802_11144# a_11270_13392# vss sky130_fd_pr__nfet_01v8_lvt ad=0.527 pd=4.02 as=0.2805 ps=2.03 w=1.7 l=0.15
X186 a_7935_8570# a_7935_9170# vdd vdd sky130_fd_pr__pfet_01v8_lvt ad=0.609 pd=4.78 as=0.609 ps=4.78 w=2.1 l=0.35
X187 a_24993_1814# f7 vss vss sky130_fd_pr__nfet_01v8 ad=0.1305 pd=1.48 as=0.1305 ps=1.48 w=0.45 l=0.18
X188 vss a_23199_6161# vss vss sky130_fd_pr__nfet_01v8_lvt ad=0.203 pd=1.98 as=0 ps=0 w=0.7 l=0.15
X189 vdd a_323_2160# a_3663_2190# vdd sky130_fd_pr__pfet_01v8_lvt ad=0.1595 pd=1.39 as=0.1595 ps=1.39 w=1.1 l=0.35
X190 vss vdd a_30817_3517# vss sky130_fd_pr__nfet_01v8 ad=0.17835 pd=1.52 as=0.17835 ps=1.52 w=1.23 l=0.2
X191 a_28467_12830# a_20458_12920# a_28135_13580# vss sky130_fd_pr__nfet_01v8_lvt ad=0.377 pd=3.18 as=0.377 ps=3.18 w=1.3 l=0.15
X192 vss a_25439_3741# vss vss sky130_fd_pr__nfet_01v8_lvt ad=0.203 pd=1.98 as=0 ps=0 w=0.7 l=0.15
X193 a_323_2160# ip vss vss sky130_fd_pr__nfet_01v8_lvt ad=0.1155 pd=1.03 as=0.217 ps=2.02 w=0.7 l=0.15
X194 a_7935_6810# a0 a_11527_4275# vss sky130_fd_pr__nfet_01v8_lvt ad=0.2325 pd=2.12 as=0.12375 ps=1.08 w=0.75 l=0.15
X195 en ep vdd vdd sky130_fd_pr__pfet_01v8 ad=0.3135 pd=2.23 as=0.589 ps=4.42 w=1.9 l=0.15
X196 a_21287_12830# a_10451_12702# vdd vdd sky130_fd_pr__pfet_01v8 ad=0.33 pd=2.33 as=0.62 ps=4.62 w=2 l=0.15
X197 vdd a_10029_11910# a_8701_12702# vdd sky130_fd_pr__pfet_01v8 ad=1.023 pd=7.22 as=0.5445 ps=3.63 w=3.3 l=0.15
X198 a_8701_12702# a_10451_12702# vss vss sky130_fd_pr__nfet_01v8_lvt ad=0.1885 pd=1.88 as=0.1885 ps=1.88 w=0.65 l=0.15
X199 a_7935_6810# a_11849_1934# a_11527_8795# vdd sky130_fd_pr__pfet_01v8_lvt ad=0.667 pd=5.18 as=0.3335 ps=2.59 w=2.3 l=0.35
X200 a_7935_6210# a_6063_6210# vdd vdd sky130_fd_pr__pfet_01v8_lvt ad=0.3045 pd=2.39 as=0.3045 ps=2.39 w=2.1 l=0.35
X201 vdd a_13268_7094# a_13268_8794# vdd sky130_fd_pr__pfet_01v8 ad=0.462 pd=3.13 as=0.462 ps=3.13 w=2.8 l=0.15
X202 a_30817_3517# vdd vss vss sky130_fd_pr__nfet_01v8 ad=0.17835 pd=1.52 as=0.17835 ps=1.52 w=1.23 l=0.2
X203 a_10451_12702# a_8701_12702# vdd vdd sky130_fd_pr__pfet_01v8 ad=0.7975 pd=6.08 as=0.7975 ps=6.08 w=2.75 l=0.15
X204 vdd a_20555_8261# a_22437_8740# vdd sky130_fd_pr__pfet_01v8 ad=0.527 pd=4.02 as=0.2805 ps=2.03 w=1.7 l=0.15
X205 a_22437_6640# a_20555_6161# vss vss sky130_fd_pr__nfet_01v8_lvt ad=0.203 pd=1.98 as=0.203 ps=1.98 w=0.7 l=0.15
X206 vss a_14997_11890# a_9999_11686# vss sky130_fd_pr__nfet_01v8_lvt ad=0.372 pd=3.02 as=0.198 ps=1.53 w=1.2 l=0.15
X207 a_22795_7929# f4 a_16768_8794# vss sky130_fd_pr__nfet_01v8_lvt ad=0.1885 pd=1.88 as=0.1885 ps=1.88 w=0.65 l=0.15
X208 a_3663_1590# a_323_6880# vss vss sky130_fd_pr__nfet_01v8_lvt ad=0.319 pd=2.78 as=0.319 ps=2.78 w=1.1 l=0.15
X209 vdd a_20959_1641# vdd vdd sky130_fd_pr__pfet_01v8 ad=0.527 pd=4.02 as=0 ps=0 w=1.7 l=0.15
X210 vss a_22497_11800# vss vss sky130_fd_pr__nfet_01v8 ad=0.1218 pd=1.42 as=0 ps=0 w=0.42 l=0.5
X211 a_14067_11933# rst_n vdd vdd sky130_fd_pr__pfet_01v8 ad=0.464 pd=3.78 as=0.464 ps=3.78 w=1.6 l=0.18
X212 a_29327_12830# a_22559_11686# a_18550_13392# vss sky130_fd_pr__nfet_01v8_lvt ad=0.62 pd=4.62 as=0.33 ps=2.33 w=2 l=0.15
X213 a_20959_5509# f3 a_13102_2574# vss sky130_fd_pr__nfet_01v8_lvt ad=0.1885 pd=1.88 as=0.1885 ps=1.88 w=0.65 l=0.15
X214 a_24677_4220# a_22795_3741# vss vss sky130_fd_pr__nfet_01v8_lvt ad=0.203 pd=1.98 as=0.203 ps=1.98 w=0.7 l=0.15
X215 vdd a_8701_12702# ckd0 vdd sky130_fd_pr__pfet_01v8 ad=0.93 pd=6.62 as=0.495 ps=3.33 w=3 l=0.15
X216 cke2 cke0 vss vss sky130_fd_pr__nfet_01v8_lvt ad=0.1305 pd=1.48 as=0.1305 ps=1.48 w=0.45 l=0.15
X217 a_16309_11910# a_16802_11144# vss vss sky130_fd_pr__nfet_01v8 ad=0.174 pd=1.78 as=0.174 ps=1.78 w=0.6 l=0.28
X218 a_7935_4450# a_14961_1934# a_15027_8795# vdd sky130_fd_pr__pfet_01v8_lvt ad=0.667 pd=5.18 as=0.3335 ps=2.59 w=2.3 l=0.35
X219 a_21277_11890# a_20347_11933# vss vss sky130_fd_pr__nfet_01v8_lvt ad=0.464 pd=3.78 as=0.464 ps=3.78 w=1.6 l=0.15
X220 a_22795_6161# a_22753_1814# a_16768_8794# vdd sky130_fd_pr__pfet_01v8_lvt ad=0.609 pd=4.78 as=0.609 ps=4.78 w=2.1 l=0.35
X221 vdd a_30963_3945# en vdd sky130_fd_pr__pfet_01v8 ad=0.495 pd=3.33 as=0.495 ps=3.33 w=3 l=0.15
X222 a_7935_6210# a_12625_1934# a_11527_8795# vdd sky130_fd_pr__pfet_01v8_lvt ad=0.667 pd=5.18 as=0.3335 ps=2.59 w=2.3 l=0.35
X223 a_13268_4274# a_13268_2574# vdd vdd sky130_fd_pr__pfet_01v8_lvt ad=0.406 pd=3.09 as=0.812 ps=6.18 w=2.8 l=0.35
X224 a_15678_205# b2 vdd vdd sky130_fd_pr__pfet_01v8 ad=0.261 pd=2.38 as=0.261 ps=2.38 w=0.9 l=0.18
X225 vdd qn a_323_9240# vdd sky130_fd_pr__pfet_01v8_lvt ad=0.406 pd=3.38 as=0.203 ps=1.69 w=1.4 l=0.35
X226 a_20197_2120# a_18315_1641# vdd vdd sky130_fd_pr__pfet_01v8 ad=0.2805 pd=2.03 as=0.527 ps=4.02 w=1.7 l=0.15
X227 a_18315_5509# f1 a_16602_2574# vss sky130_fd_pr__nfet_01v8_lvt ad=0.1885 pd=1.88 as=0.1885 ps=1.88 w=0.65 l=0.15
X228 a_16768_4274# a_16768_2574# vss vss sky130_fd_pr__nfet_01v8_lvt ad=0.2805 pd=2.03 as=0.527 ps=4.02 w=1.7 l=0.15
X229 a_10029_11910# a_9381_11896# a_9937_11910# vss sky130_fd_pr__nfet_01v8_lvt ad=0.23925 pd=1.78 as=0.4495 ps=3.52 w=1.45 l=0.15
X230 a_20197_8740# a_28514_8208# vss sky130_fd_pr__res_high_po_0p69 l=2.2
X231 vss vdd a_30817_8037# vss sky130_fd_pr__nfet_01v8 ad=0.17835 pd=1.52 as=0.17835 ps=1.52 w=1.23 l=0.2
X232 cke1 a_24149_11800# vss vss sky130_fd_pr__nfet_01v8_lvt ad=0.198 pd=1.53 as=0.372 ps=3.02 w=1.2 l=0.15
X233 a_26917_6640# a_25035_6161# vss vss sky130_fd_pr__nfet_01v8_lvt ad=0.203 pd=1.98 as=0.203 ps=1.98 w=0.7 l=0.15
X234 a_28087_12830# a_11270_13392# vdd vdd sky130_fd_pr__pfet_01v8 ad=0.33 pd=2.33 as=0.62 ps=4.62 w=2 l=0.15
X235 a_29327_12830# a_6858_11170# vdd vdd sky130_fd_pr__pfet_01v8 ad=0.522 pd=4.18 as=0.522 ps=4.18 w=1.8 l=0.18
X236 vdd a_5993_9144# a_6063_9170# vdd sky130_fd_pr__pfet_01v8_lvt ad=0.609 pd=4.78 as=0.3045 ps=2.39 w=2.1 l=0.35
X237 vdd a_18719_10029# vdd vdd sky130_fd_pr__pfet_01v8 ad=0.2805 pd=2.03 as=0 ps=0 w=1.7 l=0.15
X238 a_3663_4550# a_323_4520# vdd vdd sky130_fd_pr__pfet_01v8_lvt ad=0.1595 pd=1.39 as=0.1595 ps=1.39 w=1.1 l=0.35
X239 vdd a_25439_1641# vdd vdd sky130_fd_pr__pfet_01v8 ad=0.527 pd=4.02 as=0 ps=0 w=1.7 l=0.15
X240 a_18719_3409# f0 a_13268_4274# vss sky130_fd_pr__nfet_01v8_lvt ad=0.1885 pd=1.88 as=0.1885 ps=1.88 w=0.65 l=0.15
X241 a_28995_13580# a_9937_11910# vss vss sky130_fd_pr__nfet_01v8_lvt ad=0.377 pd=3.18 as=0.377 ps=3.18 w=1.3 l=0.15
X242 vdd a_323_4520# a_2903_9270# vdd sky130_fd_pr__pfet_01v8_lvt ad=0.319 pd=2.78 as=0.1595 ps=1.39 w=1.1 l=0.35
X243 a_25439_5509# f7 a_13102_2574# vss sky130_fd_pr__nfet_01v8_lvt ad=0.1885 pd=1.88 as=0.1885 ps=1.88 w=0.65 l=0.15
X244 a_6063_2090# a_5993_2064# vdd vdd sky130_fd_pr__pfet_01v8_lvt ad=0.3045 pd=2.39 as=0.609 ps=4.78 w=2.1 l=0.35
X245 a_7935_3850# a_6063_3850# vdd vdd sky130_fd_pr__pfet_01v8_lvt ad=0.3045 pd=2.39 as=0.3045 ps=2.39 w=2.1 l=0.35
X246 a_13268_4274# a_13268_2574# vdd vdd sky130_fd_pr__pfet_01v8 ad=0.462 pd=3.13 as=0.462 ps=3.13 w=2.8 l=0.15
X247 a_25035_1641# a_24993_1814# a_16768_4274# vdd sky130_fd_pr__pfet_01v8_lvt ad=0.609 pd=4.78 as=0.609 ps=4.78 w=2.1 l=0.35
X248 vss a_23199_3409# vss vss sky130_fd_pr__nfet_01v8_lvt ad=0.203 pd=1.98 as=0 ps=0 w=0.7 l=0.15
X249 a_2903_2190# a_323_2160# vdd vdd sky130_fd_pr__pfet_01v8_lvt ad=0.1595 pd=1.39 as=0.319 ps=2.78 w=1.1 l=0.35
X250 vss a_6063_3850# a_7935_3850# vss sky130_fd_pr__nfet_01v8_lvt ad=0.527 pd=4.02 as=0.2805 ps=2.03 w=1.7 l=0.15
X251 a_15737_1934# b5 vdd vdd sky130_fd_pr__pfet_01v8 ad=0.261 pd=2.38 as=0.261 ps=2.38 w=0.9 l=0.18
X252 a_17532_13668# a_18550_13392# vss vss sky130_fd_pr__nfet_01v8 ad=0.1218 pd=1.42 as=0.1218 ps=1.42 w=0.42 l=0.5
X253 a_7935_9170# b7 a_15027_7375# vss sky130_fd_pr__nfet_01v8_lvt ad=0.2325 pd=2.12 as=0.12375 ps=1.08 w=0.75 l=0.15
X254 vdd a_30963_8465# dn vdd sky130_fd_pr__pfet_01v8_lvt ad=0.812 pd=6.18 as=0.406 ps=3.09 w=2.8 l=0.35
X255 vdd rst_n a_6211_11960# vdd sky130_fd_pr__pfet_01v8 ad=0.33 pd=2.33 as=0.33 ps=2.33 w=2 l=0.15
X256 a_22559_11686# a_27557_11890# vss vss sky130_fd_pr__nfet_01v8_lvt ad=0.198 pd=1.53 as=0.372 ps=3.02 w=1.2 l=0.15
X257 vss a_23199_10029# vss vss sky130_fd_pr__nfet_01v8_lvt ad=0.203 pd=1.98 as=0 ps=0 w=0.7 l=0.15
X258 a_16602_8794# a_16602_7094# vss sky130_fd_pr__res_high_po_0p35 l=6.5
X259 a_29327_12830# a_20458_12920# a_28995_13580# vss sky130_fd_pr__nfet_01v8_lvt ad=0.377 pd=3.18 as=0.377 ps=3.18 w=1.3 l=0.15
X260 vdd a_14067_11933# a_14997_11890# vdd sky130_fd_pr__pfet_01v8 ad=0.837 pd=6.02 as=0.4455 ps=3.03 w=2.7 l=0.15
X261 a_22795_8261# f4 a_13102_7094# vdd sky130_fd_pr__pfet_01v8_lvt ad=0.609 pd=4.78 as=0.609 ps=4.78 w=2.1 l=0.35
X262 a_24677_2120# a_22795_1641# vdd vdd sky130_fd_pr__pfet_01v8 ad=0.2805 pd=2.03 as=0.527 ps=4.02 w=1.7 l=0.15
X263 a_16602_2574# a_16602_4274# vdd vdd sky130_fd_pr__pfet_01v8_lvt ad=0.406 pd=3.09 as=0.812 ps=6.18 w=2.8 l=0.35
X264 a_16602_8794# a_15027_8795# sky130_fd_pr__cap_mim_m3_1 l=4.2 w=4.3
X265 a_22437_2720# a_20555_3409# vss vss sky130_fd_pr__nfet_01v8_lvt ad=0.203 pd=1.98 as=0.203 ps=1.98 w=0.7 l=0.15
X266 a_7935_8570# a_7935_9170# vss vss sky130_fd_pr__nfet_01v8_lvt ad=0.1305 pd=1.48 as=0.1305 ps=1.48 w=0.45 l=0.15
X267 vdd a_23199_7929# vdd vdd sky130_fd_pr__pfet_01v8 ad=0.527 pd=4.02 as=0 ps=0 w=1.7 l=0.15
X268 a_25035_6161# f7 a_16768_8794# vss sky130_fd_pr__nfet_01v8_lvt ad=0.1885 pd=1.88 as=0.1885 ps=1.88 w=0.65 l=0.15
X269 a_20555_5509# f3 a_16602_2574# vss sky130_fd_pr__nfet_01v8_lvt ad=0.1885 pd=1.88 as=0.1885 ps=1.88 w=0.65 l=0.15
X270 a_18719_5509# a_18273_1814# a_13102_2574# vdd sky130_fd_pr__pfet_01v8_lvt ad=0.609 pd=4.78 as=0.609 ps=4.78 w=2.1 l=0.35
X271 a_9381_11896# a_8717_11890# vdd vdd sky130_fd_pr__pfet_01v8 ad=0.4356 pd=2.97 as=0.4356 ps=2.97 w=2.64 l=0.15
X272 a_14997_11890# a_14067_11933# vdd vdd sky130_fd_pr__pfet_01v8 ad=0.4455 pd=3.03 as=0.837 ps=6.02 w=2.7 l=0.15
X273 vdd in a_323_6880# vdd sky130_fd_pr__pfet_01v8_lvt ad=0.406 pd=3.38 as=0.203 ps=1.69 w=1.4 l=0.35
X274 vdd a_9937_11910# vdd vdd sky130_fd_pr__pfet_01v8_lvt ad=0.464 pd=3.78 as=0 ps=0 w=1.6 l=0.35
X275 a_10451_12702# a_9381_11896# a_16309_11910# vdd sky130_fd_pr__pfet_01v8 ad=0.4125 pd=2.83 as=0.4125 ps=2.83 w=2.5 l=0.15
X276 a_7935_2090# a_11849_1934# a_11527_2855# vdd sky130_fd_pr__pfet_01v8_lvt ad=0.667 pd=5.18 as=0.3335 ps=2.59 w=2.3 l=0.35
X277 vdd a_323_6880# a_3663_9270# vdd sky130_fd_pr__pfet_01v8_lvt ad=0.1595 pd=1.39 as=0.1595 ps=1.39 w=1.1 l=0.35
X278 a_11527_8795# a_11461_1934# a_7935_2090# vdd sky130_fd_pr__pfet_01v8_lvt ad=0.3335 pd=2.59 as=0.667 ps=5.18 w=2.3 l=0.35
X279 vdd a_20959_10029# vdd vdd sky130_fd_pr__pfet_01v8 ad=0.2805 pd=2.03 as=0 ps=0 w=1.7 l=0.15
X280 a_23199_10029# a_22753_1814# a_13102_7094# vdd sky130_fd_pr__pfet_01v8_lvt ad=0.609 pd=4.78 as=0.609 ps=4.78 w=2.1 l=0.35
X281 a_18315_1641# f1 a_13268_4274# vdd sky130_fd_pr__pfet_01v8_lvt ad=0.609 pd=4.78 as=0.609 ps=4.78 w=2.1 l=0.35
X282 a_11527_2855# a0 a_7935_6210# vss sky130_fd_pr__nfet_01v8_lvt ad=0.12375 pd=1.08 as=0.2325 ps=2.12 w=0.75 l=0.15
X283 a_22437_2720# a_20555_3409# vdd vdd sky130_fd_pr__pfet_01v8 ad=0.2805 pd=2.03 as=0.527 ps=4.02 w=1.7 l=0.15
X284 ckd1 a_9937_11910# vdd vdd sky130_fd_pr__pfet_01v8 ad=0.495 pd=3.33 as=0.495 ps=3.33 w=3 l=0.15
X285 a_30963_7375# vss vdd vdd sky130_fd_pr__pfet_01v8 ad=0.2607 pd=1.91 as=0.2607 ps=1.91 w=1.58 l=0.15
X286 a_24677_2720# a_28514_1816# vss sky130_fd_pr__res_high_po_0p69 l=2.2
X287 a_23199_3409# a_22753_3298# a_16768_4274# vss sky130_fd_pr__nfet_01v8_lvt ad=0.1885 pd=1.88 as=0.1885 ps=1.88 w=0.65 l=0.15
X288 a_323_9240# qn vss vss sky130_fd_pr__nfet_01v8_lvt ad=0.1155 pd=1.03 as=0.217 ps=2.02 w=0.7 l=0.15
X289 a_20197_7240# a_28514_6336# vss sky130_fd_pr__res_high_po_0p69 l=2.2
X290 a_30963_8465# a_29702_7094# a_30817_8037# vss sky130_fd_pr__nfet_01v8_lvt ad=0.396 pd=2.73 as=0.396 ps=2.73 w=2.4 l=0.15
X291 a_11527_4275# a_12237_1934# a_7935_6210# vdd sky130_fd_pr__pfet_01v8_lvt ad=0.3335 pd=2.59 as=0.667 ps=5.18 w=2.3 l=0.35
X292 a_29702_8794# a_28514_8208# sky130_fd_pr__cap_mim_m3_1 l=4.8 w=4.8
X293 a_18719_1641# f1 a_16768_4274# vdd sky130_fd_pr__pfet_01v8_lvt ad=0.609 pd=4.78 as=0.609 ps=4.78 w=2.1 l=0.35
X294 a_25439_3741# f6 a_16602_2574# vdd sky130_fd_pr__pfet_01v8_lvt ad=0.609 pd=4.78 as=0.609 ps=4.78 w=2.1 l=0.35
X295 a_6063_4450# a_5993_4424# vss vss sky130_fd_pr__nfet_01v8_lvt ad=0.1815 pd=1.43 as=0.341 ps=2.82 w=1.1 l=0.15
X296 a_5993_4424# a_6063_4450# vss sky130_fd_pr__res_high_po_0p35 l=9.5
X297 a_11527_4275# a2 a_7935_1490# vss sky130_fd_pr__nfet_01v8_lvt ad=0.12375 pd=1.08 as=0.2325 ps=2.12 w=0.75 l=0.15
X298 a_7935_8570# a_14961_1934# a_15027_2855# vdd sky130_fd_pr__pfet_01v8_lvt ad=0.667 pd=5.18 as=0.3335 ps=2.59 w=2.3 l=0.35
X299 a_26917_2720# a_25035_3409# vss vss sky130_fd_pr__nfet_01v8_lvt ad=0.203 pd=1.98 as=0.203 ps=1.98 w=0.7 l=0.15
X300 vdd a_13102_4274# a_13102_2574# vdd sky130_fd_pr__pfet_01v8 ad=0.868 pd=6.22 as=0.462 ps=3.13 w=2.8 l=0.15
X301 a_15678_205# b2 vss vss sky130_fd_pr__nfet_01v8 ad=0.1305 pd=1.48 as=0.1305 ps=1.48 w=0.45 l=0.18
X302 a_20458_12920# a_17675_12870# vdd vdd sky130_fd_pr__pfet_01v8 ad=0.319 pd=2.78 as=0.319 ps=2.78 w=1.1 l=0.18
X303 a_21667_12830# a_22559_11686# a_22497_11800# vdd sky130_fd_pr__pfet_01v8 ad=0.594 pd=3.93 as=1.116 ps=7.82 w=3.6 l=0.15
X304 a_28467_12830# a_29327_12830# vdd vdd sky130_fd_pr__pfet_01v8 ad=0.174 pd=1.78 as=0.174 ps=1.78 w=0.6 l=0.28
X305 a_3663_8670# a_323_2160# vss vss sky130_fd_pr__nfet_01v8_lvt ad=0.319 pd=2.78 as=0.319 ps=2.78 w=1.1 l=0.15
X306 a_7935_1490# a_12625_1934# a_11527_2855# vdd sky130_fd_pr__pfet_01v8_lvt ad=0.667 pd=5.18 as=0.3335 ps=2.59 w=2.3 l=0.35
X307 a_25035_3741# a_24993_3298# a_13102_2574# vss sky130_fd_pr__nfet_01v8_lvt ad=0.1885 pd=1.88 as=0.1885 ps=1.88 w=0.65 l=0.15
X308 a_18315_6161# a_18273_1814# a_13268_8794# vss sky130_fd_pr__nfet_01v8_lvt ad=0.1885 pd=1.88 as=0.1885 ps=1.88 w=0.65 l=0.15
X309 a_21667_12830# a_22507_12830# vss vss sky130_fd_pr__nfet_01v8 ad=0.174 pd=1.78 as=0.174 ps=1.78 w=0.6 l=0.28
X310 a_22437_6640# a_28514_6336# vss sky130_fd_pr__res_high_po_0p69 l=2.2
X311 vdd a_30963_7375# dp vdd sky130_fd_pr__pfet_01v8_lvt ad=0.812 pd=6.18 as=0.406 ps=3.09 w=2.8 l=0.35
X312 vdd a_25439_10029# vdd vdd sky130_fd_pr__pfet_01v8 ad=0.2805 pd=2.03 as=0 ps=0 w=1.7 l=0.15
X313 a_18719_6161# a_18273_1814# a_16768_8794# vss sky130_fd_pr__nfet_01v8_lvt ad=0.1885 pd=1.88 as=0.1885 ps=1.88 w=0.65 l=0.15
X314 a_11527_2855# a4 a_7935_6810# vss sky130_fd_pr__nfet_01v8_lvt ad=0.12375 pd=1.08 as=0.2325 ps=2.12 w=0.75 l=0.15
X315 a_23199_5509# f5 a_16602_2574# vdd sky130_fd_pr__pfet_01v8_lvt ad=0.609 pd=4.78 as=0.609 ps=4.78 w=2.1 l=0.35
X316 a_25439_3741# a_24993_3298# a_16602_2574# vss sky130_fd_pr__nfet_01v8_lvt ad=0.1885 pd=1.88 as=0.1885 ps=1.88 w=0.65 l=0.15
X317 a_30963_8465# a_30963_7375# vdd vdd sky130_fd_pr__pfet_01v8 ad=0.2079 pd=1.59 as=0.2079 ps=1.59 w=1.26 l=0.15
X318 a_26917_7240# a_25035_7929# vdd vdd sky130_fd_pr__pfet_01v8 ad=0.2805 pd=2.03 as=0.527 ps=4.02 w=1.7 l=0.15
X319 a_21941_11896# a_22559_11686# vss vss sky130_fd_pr__nfet_01v8_lvt ad=0.29 pd=2.58 as=0.29 ps=2.58 w=1 l=0.15
X320 a_10029_11910# a_9999_11686# a_9937_11910# vdd sky130_fd_pr__pfet_01v8 ad=0.775 pd=5.62 as=0.4125 ps=2.83 w=2.5 l=0.15
X321 a_2903_4550# a_5214_4408# vss sky130_fd_pr__res_high_po_0p69 l=1.5
X322 a_11527_4275# a6 a_7935_2090# vss sky130_fd_pr__nfet_01v8_lvt ad=0.12375 pd=1.08 as=0.2325 ps=2.12 w=0.75 l=0.15
X323 a_15737_1934# b5 vss vss sky130_fd_pr__nfet_01v8 ad=0.1305 pd=1.48 as=0.1305 ps=1.48 w=0.45 l=0.18
X324 a_9999_11686# a_9381_11896# vdd vdd sky130_fd_pr__pfet_01v8 ad=0.3465 pd=2.43 as=0.651 ps=4.82 w=2.1 l=0.15
X325 vss a_30963_7375# dp vss sky130_fd_pr__nfet_01v8_lvt ad=0.651 pd=4.82 as=0.3465 ps=2.43 w=2.1 l=0.15
X326 ckd0 a_8701_12702# vss vss sky130_fd_pr__nfet_01v8_lvt ad=0.198 pd=1.53 as=0.372 ps=3.02 w=1.2 l=0.15
X327 a_11270_13392# a_9937_11910# vdd vdd sky130_fd_pr__pfet_01v8 ad=0.7975 pd=6.08 as=0.7975 ps=6.08 w=2.75 l=0.15
X328 a_17675_12870# a_8701_12702# a_17532_13668# vss sky130_fd_pr__nfet_01v8 ad=0.1218 pd=1.42 as=0.1218 ps=1.42 w=0.42 l=0.5
X329 a_9937_11910# a_11270_13392# vdd vdd sky130_fd_pr__pfet_01v8 ad=0.7975 pd=6.08 as=0.7975 ps=6.08 w=2.75 l=0.15
X330 vdd a_22507_12830# a_17910_13392# vdd sky130_fd_pr__pfet_01v8 ad=1.023 pd=7.22 as=0.5445 ps=3.63 w=3.3 l=0.15
X331 a_6063_9170# a_5993_9144# vdd vdd sky130_fd_pr__pfet_01v8_lvt ad=0.3045 pd=2.39 as=0.609 ps=4.78 w=2.1 l=0.35
X332 a_30817_3517# a_29702_2574# a_30963_3945# vss sky130_fd_pr__nfet_01v8_lvt ad=0.396 pd=2.73 as=0.396 ps=2.73 w=2.4 l=0.15
X333 a_20555_1641# a_20513_1814# a_13268_4274# vss sky130_fd_pr__nfet_01v8_lvt ad=0.1885 pd=1.88 as=0.1885 ps=1.88 w=0.65 l=0.15
X334 a_2903_9270# a_323_4520# vdd vdd sky130_fd_pr__pfet_01v8_lvt ad=0.1595 pd=1.39 as=0.319 ps=2.78 w=1.1 l=0.35
X335 vss a_18719_6161# vss vss sky130_fd_pr__nfet_01v8_lvt ad=0.203 pd=1.98 as=0 ps=0 w=0.7 l=0.15
X336 a_20959_7929# f2 a_13268_8794# vss sky130_fd_pr__nfet_01v8_lvt ad=0.1885 pd=1.88 as=0.1885 ps=1.88 w=0.65 l=0.15
X337 a_16602_2574# a_16602_4274# vdd vdd sky130_fd_pr__pfet_01v8 ad=0.462 pd=3.13 as=0.868 ps=6.22 w=2.8 l=0.15
X338 a_30963_2855# a_30963_3945# vdd vdd sky130_fd_pr__pfet_01v8 ad=0.2079 pd=1.59 as=0.3906 ps=3.14 w=1.26 l=0.15
X339 a_20555_10029# a_20513_1814# a_13102_7094# vss sky130_fd_pr__nfet_01v8_lvt ad=0.1885 pd=1.88 as=0.1885 ps=1.88 w=0.65 l=0.15
X340 a_20959_1641# a_20513_1814# a_16768_4274# vss sky130_fd_pr__nfet_01v8_lvt ad=0.1885 pd=1.88 as=0.1885 ps=1.88 w=0.65 l=0.15
X341 a_27557_11890# a_26627_11933# vss vss sky130_fd_pr__nfet_01v8_lvt ad=0.464 pd=3.78 as=0.464 ps=3.78 w=1.6 l=0.15
X342 a_18315_10029# f1 a_16602_7094# vss sky130_fd_pr__nfet_01v8_lvt ad=0.1885 pd=1.88 as=0.1885 ps=1.88 w=0.65 l=0.15
X343 vdd vss a_30963_8465# vdd sky130_fd_pr__pfet_01v8 ad=0.2607 pd=1.91 as=0.2607 ps=1.91 w=1.58 l=0.15
X344 a_30963_7375# a_29868_8794# a_30817_8037# vss sky130_fd_pr__nfet_01v8_lvt ad=0.396 pd=2.73 as=0.396 ps=2.73 w=2.4 l=0.15
X345 a_3663_6310# a_323_9240# vss vss sky130_fd_pr__nfet_01v8_lvt ad=0.319 pd=2.78 as=0.319 ps=2.78 w=1.1 l=0.15
X346 a_25035_1641# f7 a_13268_4274# vdd sky130_fd_pr__pfet_01v8_lvt ad=0.609 pd=4.78 as=0.609 ps=4.78 w=2.1 l=0.35
X347 a_24149_11800# a_22497_11800# vdd vdd sky130_fd_pr__pfet_01v8 ad=0.7975 pd=6.08 as=0.7975 ps=6.08 w=2.75 l=0.15
X348 a_25439_7929# f6 a_16768_8794# vdd sky130_fd_pr__pfet_01v8_lvt ad=0.609 pd=4.78 as=0.609 ps=4.78 w=2.1 l=0.35
X349 a_20959_6161# a_20513_1814# a_13268_8794# vdd sky130_fd_pr__pfet_01v8_lvt ad=0.609 pd=4.78 as=0.609 ps=4.78 w=2.1 l=0.35
X350 cke3 cke1 vss vss sky130_fd_pr__nfet_01v8_lvt ad=0.1305 pd=1.48 as=0.1305 ps=1.48 w=0.45 l=0.15
X351 vdd a_323_9240# a_2903_6310# vdd sky130_fd_pr__pfet_01v8_lvt ad=0.1595 pd=1.39 as=0.1595 ps=1.39 w=1.1 l=0.35
X352 a_11527_2855# a_11461_1934# a_7935_6210# vdd sky130_fd_pr__pfet_01v8_lvt ad=0.3335 pd=2.59 as=0.667 ps=5.18 w=2.3 l=0.35
X353 vdd a_10451_12702# ckd2 vdd sky130_fd_pr__pfet_01v8 ad=0.495 pd=3.33 as=0.495 ps=3.33 w=3 l=0.15
X354 a_29868_8794# a_29702_7094# vdd vdd sky130_fd_pr__pfet_01v8 ad=0.2376 pd=1.77 as=0.4464 ps=3.5 w=1.44 l=0.15
X355 a_16309_11910# a_9999_11686# a_10451_12702# vss sky130_fd_pr__nfet_01v8_lvt ad=0.23925 pd=1.78 as=0.4495 ps=3.52 w=1.45 l=0.15
X356 a_20555_10029# f3 a_13102_7094# vdd sky130_fd_pr__pfet_01v8_lvt ad=0.609 pd=4.78 as=0.609 ps=4.78 w=2.1 l=0.35
X357 a_18315_7929# f0 a_16768_8794# vss sky130_fd_pr__nfet_01v8_lvt ad=0.1885 pd=1.88 as=0.1885 ps=1.88 w=0.65 l=0.15
X358 a_7935_3850# a_15349_1934# a_15027_4275# vdd sky130_fd_pr__pfet_01v8_lvt ad=0.667 pd=5.18 as=0.3335 ps=2.59 w=2.3 l=0.35
X359 ep a_30963_2855# vdd vdd sky130_fd_pr__pfet_01v8 ad=0.495 pd=3.33 as=0.495 ps=3.33 w=3 l=0.15
X360 vdd a_16768_2574# a_16768_4274# vdd sky130_fd_pr__pfet_01v8 ad=0.462 pd=3.13 as=0.462 ps=3.13 w=2.8 l=0.15
X361 a_7935_9170# b5 a_15027_2855# vss sky130_fd_pr__nfet_01v8_lvt ad=0.2325 pd=2.12 as=0.12375 ps=1.08 w=0.75 l=0.15
X362 vdd a_25035_3409# a_26917_2720# vdd sky130_fd_pr__pfet_01v8 ad=0.527 pd=4.02 as=0.2805 ps=2.03 w=1.7 l=0.15
X363 dp a_30963_7375# vdd vdd sky130_fd_pr__pfet_01v8 ad=0.495 pd=3.33 as=0.495 ps=3.33 w=3 l=0.15
X364 a_3663_2190# a_323_2160# vdd vdd sky130_fd_pr__pfet_01v8_lvt ad=0.1595 pd=1.39 as=0.1595 ps=1.39 w=1.1 l=0.35
X365 vdd a_10451_12702# a_21287_12830# vdd sky130_fd_pr__pfet_01v8 ad=0.62 pd=4.62 as=0.33 ps=2.33 w=2 l=0.15
X366 a_20959_10029# f3 a_16602_7094# vdd sky130_fd_pr__pfet_01v8_lvt ad=0.609 pd=4.78 as=0.609 ps=4.78 w=2.1 l=0.35
X367 vss a_20959_1641# vss vss sky130_fd_pr__nfet_01v8_lvt ad=0.203 pd=1.98 as=0 ps=0 w=0.7 l=0.15
X368 a_7935_1490# a_6063_1490# vdd vdd sky130_fd_pr__pfet_01v8_lvt ad=0.3045 pd=2.39 as=0.3045 ps=2.39 w=2.1 l=0.35
X369 a_22795_3409# f4 a_13268_4274# vdd sky130_fd_pr__pfet_01v8_lvt ad=0.609 pd=4.78 as=0.609 ps=4.78 w=2.1 l=0.35
X370 a_25035_8261# a_24993_3298# a_16602_7094# vdd sky130_fd_pr__pfet_01v8_lvt ad=0.609 pd=4.78 as=0.609 ps=4.78 w=2.1 l=0.35
X371 a_25439_7929# f6 a_13268_8794# vss sky130_fd_pr__nfet_01v8_lvt ad=0.1885 pd=1.88 as=0.1885 ps=1.88 w=0.65 l=0.15
X372 a_18315_6161# a_18273_1814# a_16768_8794# vdd sky130_fd_pr__pfet_01v8_lvt ad=0.609 pd=4.78 as=0.609 ps=4.78 w=2.1 l=0.35
X373 vdd a_6063_6210# a_7935_6210# vdd sky130_fd_pr__pfet_01v8_lvt ad=0.3045 pd=2.39 as=0.3045 ps=2.39 w=2.1 l=0.35
X374 a_27658_12850# a_20458_12920# vdd vdd sky130_fd_pr__pfet_01v8 ad=0.522 pd=4.18 as=0.522 ps=4.18 w=1.8 l=0.18
X375 a_25439_6161# a_24993_1814# a_13268_8794# vdd sky130_fd_pr__pfet_01v8_lvt ad=0.609 pd=4.78 as=0.609 ps=4.78 w=2.1 l=0.35
X376 a_7935_4450# a_16125_1934# a_15027_4275# vdd sky130_fd_pr__pfet_01v8_lvt ad=0.667 pd=5.18 as=0.3335 ps=2.59 w=2.3 l=0.35
X377 vss vdd a_30817_3517# vss sky130_fd_pr__nfet_01v8 ad=0.17835 pd=1.52 as=0.17835 ps=1.52 w=1.23 l=0.2
X378 ckd0 ckd2 vss vss sky130_fd_pr__nfet_01v8_lvt ad=0.1305 pd=1.48 as=0.1305 ps=1.48 w=0.45 l=0.15
X379 a_8701_12702# a_10451_12702# vdd vdd sky130_fd_pr__pfet_01v8 ad=0.7975 pd=6.08 as=0.7975 ps=6.08 w=2.75 l=0.15
X380 a_15027_7375# a_15737_1934# a_7935_4450# vdd sky130_fd_pr__pfet_01v8_lvt ad=0.3335 pd=2.59 as=0.667 ps=5.18 w=2.3 l=0.35
X381 a_20197_2120# a_18315_1641# vss vss sky130_fd_pr__nfet_01v8_lvt ad=0.203 pd=1.98 as=0.203 ps=1.98 w=0.7 l=0.15
X382 a_7787_11933# a_6211_11960# vss vss sky130_fd_pr__nfet_01v8 ad=0.232 pd=2.18 as=0.232 ps=2.18 w=0.8 l=0.18
X383 vdd a_18315_8261# a_20197_8740# vdd sky130_fd_pr__pfet_01v8 ad=0.527 pd=4.02 as=0.2805 ps=2.03 w=1.7 l=0.15
X384 vdd ep en vdd sky130_fd_pr__pfet_01v8 ad=0.589 pd=4.42 as=0.3135 ps=2.23 w=1.9 l=0.15
X385 a_16602_4274# a_15027_4275# sky130_fd_pr__cap_mim_m3_1 l=4.2 w=4.3
X386 a_323_2160# vss sky130_fd_pr__cap_mim_m3_1 l=1.75 w=1.75
X387 ckd3 ckd1 vss vss sky130_fd_pr__nfet_01v8_lvt ad=0.1305 pd=1.48 as=0.1305 ps=1.48 w=0.45 l=0.15
X388 a_21667_12830# a_20828_12850# a_21287_12830# vdd sky130_fd_pr__pfet_01v8 ad=0.33 pd=2.33 as=0.62 ps=4.62 w=2 l=0.15
X389 vss a_13102_8794# a_13102_7094# vss sky130_fd_pr__nfet_01v8_lvt ad=0.527 pd=4.02 as=0.2805 ps=2.03 w=1.7 l=0.15
X390 a_30817_3517# a_29868_4274# a_30963_2855# vss sky130_fd_pr__nfet_01v8_lvt ad=0.396 pd=2.73 as=0.396 ps=2.73 w=2.4 l=0.15
X391 vss a_18719_3409# vss vss sky130_fd_pr__nfet_01v8_lvt ad=0.203 pd=1.98 as=0 ps=0 w=0.7 l=0.15
X392 a_20555_7929# f2 a_16768_8794# vss sky130_fd_pr__nfet_01v8_lvt ad=0.1885 pd=1.88 as=0.1885 ps=1.88 w=0.65 l=0.15
X393 vdd a_323_6880# a_2903_3950# vdd sky130_fd_pr__pfet_01v8_lvt ad=0.1595 pd=1.39 as=0.1595 ps=1.39 w=1.1 l=0.35
X394 a_17547_12870# a_17910_13392# vdd vdd sky130_fd_pr__pfet_01v8_lvt ad=0.464 pd=3.78 as=0.464 ps=3.78 w=1.6 l=0.35
X395 vdd a_29327_12830# a_24149_11800# vdd sky130_fd_pr__pfet_01v8 ad=0.5445 pd=3.63 as=0.5445 ps=3.63 w=3.3 l=0.15
X396 a_22437_2720# a_28514_1816# vss sky130_fd_pr__res_high_po_0p69 l=2.2
X397 vdd a_18719_3741# vdd vdd sky130_fd_pr__pfet_01v8 ad=0.2805 pd=2.03 as=0 ps=0 w=1.7 l=0.15
X398 a_9937_11910# a_9381_11896# a_10029_11910# vss sky130_fd_pr__nfet_01v8_lvt ad=0.4495 pd=3.52 as=0.23925 ps=1.78 w=1.45 l=0.15
X399 vss a_25439_6161# vss vss sky130_fd_pr__nfet_01v8_lvt ad=0.203 pd=1.98 as=0 ps=0 w=0.7 l=0.15
X400 vss a_30963_8465# dn vss sky130_fd_pr__nfet_01v8_lvt ad=0.651 pd=4.82 as=0.3465 ps=2.43 w=2.1 l=0.15
X401 a_10451_12702# a_10522_11144# vdd vdd sky130_fd_pr__pfet_01v8 ad=0.5445 pd=3.63 as=1.023 ps=7.22 w=3.3 l=0.15
X402 a_20555_6161# a_20513_1814# a_16768_8794# vdd sky130_fd_pr__pfet_01v8_lvt ad=0.609 pd=4.78 as=0.609 ps=4.78 w=2.1 l=0.35
X403 vss a_5993_3733# a_6063_3850# vss sky130_fd_pr__nfet_01v8_lvt ad=0.341 pd=2.82 as=0.1815 ps=1.43 w=1.1 l=0.15
X404 vdd a_11270_13392# a_28087_12830# vdd sky130_fd_pr__pfet_01v8 ad=0.62 pd=4.62 as=0.33 ps=2.33 w=2 l=0.15
X405 a_323_6880# in vss vss sky130_fd_pr__nfet_01v8_lvt ad=0.1155 pd=1.03 as=0.217 ps=2.02 w=0.7 l=0.15
X406 a_18315_8261# f0 a_13102_7094# vdd sky130_fd_pr__pfet_01v8_lvt ad=0.609 pd=4.78 as=0.609 ps=4.78 w=2.1 l=0.35
X407 a_24677_4820# a_28514_3688# vss sky130_fd_pr__res_high_po_0p69 l=2.2
X408 vdd a_18719_3409# vdd vdd sky130_fd_pr__pfet_01v8 ad=0.527 pd=4.02 as=0 ps=0 w=1.7 l=0.15
X409 cke1 a_24149_11800# vdd vdd sky130_fd_pr__pfet_01v8 ad=0.495 pd=3.33 as=0.93 ps=6.62 w=3 l=0.15
X410 a_18719_8261# f0 a_16602_7094# vdd sky130_fd_pr__pfet_01v8_lvt ad=0.609 pd=4.78 as=0.609 ps=4.78 w=2.1 l=0.35
X411 a_30817_8037# vdd vss vss sky130_fd_pr__nfet_01v8 ad=0.17835 pd=1.52 as=0.17835 ps=1.52 w=1.23 l=0.2
X412 a_29702_4274# a_28514_3688# sky130_fd_pr__cap_mim_m3_1 l=4.8 w=4.8
X413 a_6211_11960# rst_n vdd vdd sky130_fd_pr__pfet_01v8 ad=0.33 pd=2.33 as=0.33 ps=2.33 w=2 l=0.15
X414 en a_6211_11960# a_26627_11933# vdd sky130_fd_pr__pfet_01v8_lvt ad=0.32915 pd=2.56 as=0.32915 ps=2.56 w=2.27 l=0.35
X415 vss a_27557_11890# a_22559_11686# vss sky130_fd_pr__nfet_01v8_lvt ad=0.372 pd=3.02 as=0.198 ps=1.53 w=1.2 l=0.15
X416 vdd a_13268_7094# a_13268_8794# vdd sky130_fd_pr__pfet_01v8_lvt ad=0.812 pd=6.18 as=0.406 ps=3.09 w=2.8 l=0.35
X417 vdd a_22795_8261# a_24677_8740# vdd sky130_fd_pr__pfet_01v8 ad=0.527 pd=4.02 as=0.2805 ps=2.03 w=1.7 l=0.15
X418 a_24677_6640# a_22795_6161# vss vss sky130_fd_pr__nfet_01v8_lvt ad=0.203 pd=1.98 as=0.203 ps=1.98 w=0.7 l=0.15
X419 vdd a_6063_3850# a_7935_3850# vdd sky130_fd_pr__pfet_01v8_lvt ad=0.3045 pd=2.39 as=0.3045 ps=2.39 w=2.1 l=0.35
X420 a_28467_12830# a_21941_11896# a_17910_13392# vdd sky130_fd_pr__pfet_01v8 ad=0.594 pd=3.93 as=1.116 ps=7.82 w=3.6 l=0.15
X421 a_5993_9144# a_6063_9170# vss sky130_fd_pr__res_high_po_0p35 l=9.5
X422 a_16602_7094# a_16602_8794# vdd vdd sky130_fd_pr__pfet_01v8 ad=0.462 pd=3.13 as=0.462 ps=3.13 w=2.8 l=0.15
X423 a_20197_4820# a_28514_3688# vss sky130_fd_pr__res_high_po_0p69 l=2.2
X424 vss vdd a_30217_2855# vss sky130_fd_pr__nfet_01v8 ad=0.3335 pd=2.88 as=0.16675 ps=1.44 w=1.15 l=0.2
X425 vdd a_23199_1641# vdd vdd sky130_fd_pr__pfet_01v8 ad=0.527 pd=4.02 as=0 ps=0 w=1.7 l=0.15
X426 a_10451_12702# a_10522_11144# vss vss sky130_fd_pr__nfet_01v8_lvt ad=0.2805 pd=2.03 as=0.527 ps=4.02 w=1.7 l=0.15
X427 a_21667_12830# a_7218_11110# vss vss sky130_fd_pr__nfet_01v8 ad=0.29 pd=2.58 as=0.29 ps=2.58 w=1 l=0.18
X428 a_28467_12830# a_29327_12830# vss vss sky130_fd_pr__nfet_01v8 ad=0.174 pd=1.78 as=0.174 ps=1.78 w=0.6 l=0.28
X429 a_22437_8740# a_28514_8208# vss sky130_fd_pr__res_high_po_0p69 l=2.2
X430 a_28467_12830# a_27658_12850# a_28087_12830# vdd sky130_fd_pr__pfet_01v8 ad=0.33 pd=2.33 as=0.62 ps=4.62 w=2 l=0.15
X431 a_7935_8570# b7 a_15027_8795# vss sky130_fd_pr__nfet_01v8_lvt ad=0.2325 pd=2.12 as=0.12375 ps=1.08 w=0.75 l=0.15
X432 a_11849_1934# a2 vdd vdd sky130_fd_pr__pfet_01v8 ad=0.261 pd=2.38 as=0.261 ps=2.38 w=0.9 l=0.18
X433 vdd a_24149_11800# vdd vdd sky130_fd_pr__pfet_01v8 ad=0.725 pd=5.58 as=0 ps=0 w=2.5 l=0.15
X434 a_7935_6810# a_6063_6810# vdd vdd sky130_fd_pr__pfet_01v8_lvt ad=0.3045 pd=2.39 as=0.3045 ps=2.39 w=2.1 l=0.35
X435 vdd a_20959_3741# vdd vdd sky130_fd_pr__pfet_01v8 ad=0.2805 pd=2.03 as=0 ps=0 w=1.7 l=0.15
X436 a_25035_10029# f7 a_16602_7094# vss sky130_fd_pr__nfet_01v8_lvt ad=0.1885 pd=1.88 as=0.1885 ps=1.88 w=0.65 l=0.15
X437 a_5993_3733# a_5214_3940# sky130_fd_pr__cap_mim_m3_1 l=4.2 w=4.2
X438 a_16309_11910# a_9381_11896# a_10451_12702# vdd sky130_fd_pr__pfet_01v8 ad=0.775 pd=5.62 as=0.4125 ps=2.83 w=2.5 l=0.15
X439 a_23199_8261# f4 a_13102_7094# vss sky130_fd_pr__nfet_01v8_lvt ad=0.1885 pd=1.88 as=0.1885 ps=1.88 w=0.65 l=0.15
X440 vdd a_16768_7094# a_16768_8794# vdd sky130_fd_pr__pfet_01v8 ad=0.868 pd=6.22 as=0.462 ps=3.13 w=2.8 l=0.15
X441 vdd vss a_29868_8794# vdd sky130_fd_pr__pfet_01v8 ad=0.589 pd=4.42 as=0.3135 ps=2.23 w=1.9 l=0.15
X442 a_2903_2190# a_5214_2048# vss sky130_fd_pr__res_high_po_0p69 l=1.5
X443 en ep vss vss sky130_fd_pr__nfet_01v8_lvt ad=0.261 pd=2.38 as=0.261 ps=2.38 w=0.9 l=0.15
X444 a_18273_1814# f1 vdd vdd sky130_fd_pr__pfet_01v8 ad=0.261 pd=2.38 as=0.261 ps=2.38 w=0.9 l=0.18
X445 vdd a_20959_3409# vdd vdd sky130_fd_pr__pfet_01v8 ad=0.527 pd=4.02 as=0 ps=0 w=1.7 l=0.15
X446 a_18719_3741# f0 a_13102_2574# vss sky130_fd_pr__nfet_01v8_lvt ad=0.1885 pd=1.88 as=0.1885 ps=1.88 w=0.65 l=0.15
X447 a_3663_9270# a_323_6880# vdd vdd sky130_fd_pr__pfet_01v8_lvt ad=0.1595 pd=1.39 as=0.1595 ps=1.39 w=1.1 l=0.35
X448 a_7935_2090# a_11461_1934# a_11527_8795# vdd sky130_fd_pr__pfet_01v8_lvt ad=0.667 pd=5.18 as=0.3335 ps=2.59 w=2.3 l=0.35
X449 a_13868_205# a5 vdd vdd sky130_fd_pr__pfet_01v8 ad=0.261 pd=2.38 as=0.261 ps=2.38 w=0.9 l=0.18
X450 a_22559_11686# a_21941_11896# vss vss sky130_fd_pr__nfet_01v8_lvt ad=0.29 pd=2.58 as=0.29 ps=2.58 w=1 l=0.15
X451 a_7935_8570# a_6063_8570# vdd vdd sky130_fd_pr__pfet_01v8_lvt ad=0.3045 pd=2.39 as=0.3045 ps=2.39 w=2.1 l=0.35
X452 vss a_6063_8570# a_7935_8570# vss sky130_fd_pr__nfet_01v8_lvt ad=0.527 pd=4.02 as=0.2805 ps=2.03 w=1.7 l=0.15
X453 vdd a_16602_8794# a_16602_7094# vdd sky130_fd_pr__pfet_01v8_lvt ad=0.812 pd=6.18 as=0.406 ps=3.09 w=2.8 l=0.35
X454 dp a_30963_7375# vdd vdd sky130_fd_pr__pfet_01v8 ad=0.495 pd=3.33 as=0.93 ps=6.62 w=3 l=0.15
X455 a_3663_6910# a_5214_6768# vss sky130_fd_pr__res_high_po_0p69 l=1.5
X456 a_30217_7375# a_29702_8794# a_29702_7094# vss sky130_fd_pr__nfet_01v8_lvt ad=0.396 pd=2.73 as=0.396 ps=2.73 w=2.4 l=0.15
X457 vss a_25439_3409# vss vss sky130_fd_pr__nfet_01v8_lvt ad=0.203 pd=1.98 as=0 ps=0 w=0.7 l=0.15
X458 a_14067_11933# rst_n dn vss sky130_fd_pr__nfet_01v8_lvt ad=0.2145 pd=1.63 as=0.403 ps=3.22 w=1.3 l=0.15
X459 a_8701_12702# a_9999_11686# a_16802_11144# vss sky130_fd_pr__nfet_01v8_lvt ad=0.23925 pd=1.78 as=0.4495 ps=3.52 w=1.45 l=0.15
X460 a_24993_3298# f6 vdd vdd sky130_fd_pr__pfet_01v8 ad=0.261 pd=2.38 as=0.261 ps=2.38 w=0.9 l=0.18
X461 a_20197_2720# a_18315_3409# vdd vdd sky130_fd_pr__pfet_01v8 ad=0.2805 pd=2.03 as=0.527 ps=4.02 w=1.7 l=0.15
X462 a_22497_11800# a_22559_11686# a_21667_12830# vdd sky130_fd_pr__pfet_01v8 ad=0.594 pd=3.93 as=0.594 ps=3.93 w=3.6 l=0.15
X463 a_13268_4274# a_13268_2574# vss vss sky130_fd_pr__nfet_01v8_lvt ad=0.2805 pd=2.03 as=0.527 ps=4.02 w=1.7 l=0.15
X464 vdd a_25439_3741# vdd vdd sky130_fd_pr__pfet_01v8 ad=0.2805 pd=2.03 as=0 ps=0 w=1.7 l=0.15
X465 vdd a_9937_11910# a_28947_12830# vdd sky130_fd_pr__pfet_01v8 ad=0.62 pd=4.62 as=0.33 ps=2.33 w=2 l=0.15
X466 vdd a_323_9240# a_3663_6310# vdd sky130_fd_pr__pfet_01v8_lvt ad=0.319 pd=2.78 as=0.1595 ps=1.39 w=1.1 l=0.35
X467 a_7935_6210# a_6063_6210# vdd vdd sky130_fd_pr__pfet_01v8_lvt ad=0.3045 pd=2.39 as=0.609 ps=4.78 w=2.1 l=0.35
X468 a_7935_6210# a_6063_6210# vss vss sky130_fd_pr__nfet_01v8_lvt ad=0.2805 pd=2.03 as=0.527 ps=4.02 w=1.7 l=0.15
X469 a_25035_8261# f6 a_13102_7094# vdd sky130_fd_pr__pfet_01v8_lvt ad=0.609 pd=4.78 as=0.609 ps=4.78 w=2.1 l=0.35
X470 a_2903_2190# a_323_2160# vss vss sky130_fd_pr__nfet_01v8_lvt ad=0.319 pd=2.78 as=0.319 ps=2.78 w=1.1 l=0.15
X471 a_22795_3741# a_22753_3298# a_16602_2574# vdd sky130_fd_pr__pfet_01v8_lvt ad=0.609 pd=4.78 as=0.609 ps=4.78 w=2.1 l=0.35
X472 a_26917_2120# a_25035_1641# vdd vdd sky130_fd_pr__pfet_01v8 ad=0.2805 pd=2.03 as=0.527 ps=4.02 w=1.7 l=0.15
X473 vdd a_29702_2574# a_29868_4274# vdd sky130_fd_pr__pfet_01v8 ad=0.4464 pd=3.5 as=0.2376 ps=1.77 w=1.44 l=0.15
X474 en a_30963_3945# vdd vdd sky130_fd_pr__pfet_01v8 ad=0.495 pd=3.33 as=0.495 ps=3.33 w=3 l=0.15
X475 a_25035_3409# a_24993_3298# a_16768_4274# vdd sky130_fd_pr__pfet_01v8_lvt ad=0.609 pd=4.78 as=0.609 ps=4.78 w=2.1 l=0.35
X476 vdd a_25439_3409# vdd vdd sky130_fd_pr__pfet_01v8 ad=0.527 pd=4.02 as=0 ps=0 w=1.7 l=0.15
X477 a_24677_2720# a_22795_3409# vss vss sky130_fd_pr__nfet_01v8_lvt ad=0.203 pd=1.98 as=0.203 ps=1.98 w=0.7 l=0.15
X478 a_28947_12830# a_9937_11910# vdd vdd sky130_fd_pr__pfet_01v8 ad=0.33 pd=2.33 as=0.62 ps=4.62 w=2 l=0.15
X479 a_20347_11933# a_6211_11960# ep vdd sky130_fd_pr__pfet_01v8_lvt ad=0.6583 pd=5.12 as=0.32915 ps=2.56 w=2.27 l=0.35
X480 vdd a_28467_12830# a_22497_11800# vdd sky130_fd_pr__pfet_01v8 ad=0.5445 pd=3.63 as=0.5445 ps=3.63 w=3.3 l=0.15
X481 a_7935_1490# a_12237_1934# a_11527_8795# vdd sky130_fd_pr__pfet_01v8_lvt ad=0.667 pd=5.18 as=0.3335 ps=2.59 w=2.3 l=0.35
X482 a_7935_6810# a6 a_11527_7375# vss sky130_fd_pr__nfet_01v8_lvt ad=0.2325 pd=2.12 as=0.12375 ps=1.08 w=0.75 l=0.15
X483 a_8701_12702# a_10029_11910# vdd vdd sky130_fd_pr__pfet_01v8 ad=0.5445 pd=3.63 as=1.023 ps=7.22 w=3.3 l=0.15
X484 vdd a_5993_6093# a_6063_6210# vdd sky130_fd_pr__pfet_01v8_lvt ad=0.3045 pd=2.39 as=0.3045 ps=2.39 w=2.1 l=0.35
X485 vdd a_30963_2855# ep vdd sky130_fd_pr__pfet_01v8 ad=0.93 pd=6.62 as=0.495 ps=3.33 w=3 l=0.15
X486 vdd a_9381_11896# a_9999_11686# vdd sky130_fd_pr__pfet_01v8 ad=0.651 pd=4.82 as=0.3465 ps=2.43 w=2.1 l=0.15
X487 a_28467_12830# a_22559_11686# a_17910_13392# vss sky130_fd_pr__nfet_01v8_lvt ad=0.33 pd=2.33 as=0.62 ps=4.62 w=2 l=0.15
X488 vdd a_23199_10029# vdd vdd sky130_fd_pr__pfet_01v8 ad=0.2805 pd=2.03 as=0 ps=0 w=1.7 l=0.15
X489 a_23199_3741# a_22753_3298# a_16602_2574# vss sky130_fd_pr__nfet_01v8_lvt ad=0.1885 pd=1.88 as=0.1885 ps=1.88 w=0.65 l=0.15
X490 vss a_8701_12702# ckd0 vss sky130_fd_pr__nfet_01v8_lvt ad=0.372 pd=3.02 as=0.198 ps=1.53 w=1.2 l=0.15
X491 ep a_30963_2855# vdd vdd sky130_fd_pr__pfet_01v8_lvt ad=0.406 pd=3.09 as=0.812 ps=6.18 w=2.8 l=0.35
X492 a_20197_2120# a_28514_1816# vss sky130_fd_pr__res_high_po_0p69 l=2.2
X493 a_24677_2720# a_22795_3409# vdd vdd sky130_fd_pr__pfet_01v8 ad=0.2805 pd=2.03 as=0.527 ps=4.02 w=1.7 l=0.15
X494 a_22127_12830# a_8701_12702# vdd vdd sky130_fd_pr__pfet_01v8 ad=0.33 pd=2.33 as=0.62 ps=4.62 w=2 l=0.15
X495 a_22795_8261# f4 a_16602_7094# vss sky130_fd_pr__nfet_01v8_lvt ad=0.1885 pd=1.88 as=0.1885 ps=1.88 w=0.65 l=0.15
X496 a_28514_8208# vss sky130_fd_pr__cap_mim_m3_1 l=1.6 w=1.6
X497 a_21335_13580# a_10451_12702# vss vss sky130_fd_pr__nfet_01v8_lvt ad=0.377 pd=3.18 as=0.377 ps=3.18 w=1.3 l=0.15
X498 vdd a_18550_13392# cke2 vdd sky130_fd_pr__pfet_01v8 ad=0.495 pd=3.33 as=0.495 ps=3.33 w=3 l=0.15
X499 a_16602_7094# a_16602_8794# vss vss sky130_fd_pr__nfet_01v8_lvt ad=0.2805 pd=2.03 as=0.527 ps=4.02 w=1.7 l=0.15
X500 a_11849_1934# a2 vss vss sky130_fd_pr__nfet_01v8 ad=0.1305 pd=1.48 as=0.1305 ps=1.48 w=0.45 l=0.18
X501 a_21941_11896# a_22559_11686# vdd vdd sky130_fd_pr__pfet_01v8 ad=0.3465 pd=2.43 as=0.651 ps=4.82 w=2.1 l=0.15
X502 a_25035_6161# a_24993_1814# a_13268_8794# vss sky130_fd_pr__nfet_01v8_lvt ad=0.1885 pd=1.88 as=0.1885 ps=1.88 w=0.65 l=0.15
X503 a_20555_5509# a_20513_1814# a_13102_2574# vss sky130_fd_pr__nfet_01v8_lvt ad=0.1885 pd=1.88 as=0.1885 ps=1.88 w=0.65 l=0.15
X504 a_3663_4550# a_5214_4408# vss sky130_fd_pr__res_high_po_0p69 l=1.5
X505 a_29702_2574# a_29702_4274# a_30217_2855# vss sky130_fd_pr__nfet_01v8_lvt ad=0.744 pd=5.42 as=0.396 ps=2.73 w=2.4 l=0.15
X506 a_5993_3733# a_6063_3850# vss sky130_fd_pr__res_high_po_0p35 l=9.5
X507 cke1 cke3 vdd vdd sky130_fd_pr__pfet_01v8 ad=0.6264 pd=4.9 as=0.6264 ps=4.9 w=2.16 l=0.15
X508 a_8701_12702# a_10029_11910# vss vss sky130_fd_pr__nfet_01v8_lvt ad=0.2805 pd=2.03 as=0.527 ps=4.02 w=1.7 l=0.15
X509 a_7935_3850# a_6063_3850# vdd vdd sky130_fd_pr__pfet_01v8_lvt ad=0.3045 pd=2.39 as=0.609 ps=4.78 w=2.1 l=0.35
X510 a_18315_3409# f0 a_13268_4274# vdd sky130_fd_pr__pfet_01v8_lvt ad=0.609 pd=4.78 as=0.609 ps=4.78 w=2.1 l=0.35
X511 a_25439_6161# a_24993_1814# a_16768_8794# vss sky130_fd_pr__nfet_01v8_lvt ad=0.1885 pd=1.88 as=0.1885 ps=1.88 w=0.65 l=0.15
X512 a_20959_5509# a_20513_1814# a_16602_2574# vss sky130_fd_pr__nfet_01v8_lvt ad=0.1885 pd=1.88 as=0.1885 ps=1.88 w=0.65 l=0.15
X513 vdd a_323_9240# a_3663_3950# vdd sky130_fd_pr__pfet_01v8_lvt ad=0.319 pd=2.78 as=0.1595 ps=1.39 w=1.1 l=0.35
X514 a_18273_1814# f1 vss vss sky130_fd_pr__nfet_01v8 ad=0.1305 pd=1.48 as=0.1305 ps=1.48 w=0.45 l=0.18
X515 a_30217_7375# a_29868_7094# a_29868_8794# vss sky130_fd_pr__nfet_01v8_lvt ad=0.396 pd=2.73 as=0.396 ps=2.73 w=2.4 l=0.15
X516 vdd a_323_6880# a_2903_1590# vdd sky130_fd_pr__pfet_01v8_lvt ad=0.1595 pd=1.39 as=0.1595 ps=1.39 w=1.1 l=0.35
X517 ckd2 a_10451_12702# vdd vdd sky130_fd_pr__pfet_01v8 ad=0.495 pd=3.33 as=0.495 ps=3.33 w=3 l=0.15
X518 vdd a_20555_10029# a_22437_9340# vdd sky130_fd_pr__pfet_01v8 ad=0.527 pd=4.02 as=0.2805 ps=2.03 w=1.7 l=0.15
X519 a_18719_3409# f0 a_16768_4274# vdd sky130_fd_pr__pfet_01v8_lvt ad=0.609 pd=4.78 as=0.609 ps=4.78 w=2.1 l=0.35
X520 a_25439_5509# f7 a_16602_2574# vdd sky130_fd_pr__pfet_01v8_lvt ad=0.609 pd=4.78 as=0.609 ps=4.78 w=2.1 l=0.35
X521 a_26917_8740# a_28514_8208# vss sky130_fd_pr__res_high_po_0p69 l=2.2
X522 a_13868_205# a5 vss vss sky130_fd_pr__nfet_01v8 ad=0.1305 pd=1.48 as=0.1305 ps=1.48 w=0.45 l=0.18
X523 a_10451_12702# a_9999_11686# a_16309_11910# vss sky130_fd_pr__nfet_01v8_lvt ad=0.4495 pd=3.52 as=0.23925 ps=1.78 w=1.45 l=0.15
X524 a_11270_13392# a_16802_11144# vdd vdd sky130_fd_pr__pfet_01v8 ad=0.5445 pd=3.63 as=1.023 ps=7.22 w=3.3 l=0.15
X525 vdd a_18719_6161# vdd vdd sky130_fd_pr__pfet_01v8 ad=0.2805 pd=2.03 as=0 ps=0 w=1.7 l=0.15
X526 a_7935_6210# a_11461_1934# a_11527_2855# vdd sky130_fd_pr__pfet_01v8_lvt ad=0.667 pd=5.18 as=0.3335 ps=2.59 w=2.3 l=0.35
X527 vss a_5993_1373# a_6063_1490# vss sky130_fd_pr__nfet_01v8_lvt ad=0.341 pd=2.82 as=0.1815 ps=1.43 w=1.1 l=0.15
X528 vss a_6063_1490# a_7935_1490# vss sky130_fd_pr__nfet_01v8_lvt ad=0.527 pd=4.02 as=0.2805 ps=2.03 w=1.7 l=0.15
X529 a_2903_9270# a_5214_9128# vss sky130_fd_pr__res_high_po_0p69 l=1.5
X530 vdd a_5993_3733# a_6063_3850# vdd sky130_fd_pr__pfet_01v8_lvt ad=0.3045 pd=2.39 as=0.3045 ps=2.39 w=2.1 l=0.35
X531 a_24993_3298# f6 vss vss sky130_fd_pr__nfet_01v8 ad=0.1305 pd=1.48 as=0.1305 ps=1.48 w=0.45 l=0.18
X532 a_28135_13580# a_11270_13392# vss vss sky130_fd_pr__nfet_01v8_lvt ad=0.377 pd=3.18 as=0.377 ps=3.18 w=1.3 l=0.15
X533 vdd a_14997_11890# a_9999_11686# vdd sky130_fd_pr__pfet_01v8 ad=0.4356 pd=2.97 as=0.4356 ps=2.97 w=2.64 l=0.15
X534 a_22795_7929# a_22753_3298# a_16768_8794# vdd sky130_fd_pr__pfet_01v8_lvt ad=0.609 pd=4.78 as=0.609 ps=4.78 w=2.1 l=0.35
X535 vdd vss a_29702_7094# vdd sky130_fd_pr__pfet_01v8 ad=0.589 pd=4.42 as=0.3135 ps=2.23 w=1.9 l=0.15
X536 a_18719_10029# f1 a_13102_7094# vss sky130_fd_pr__nfet_01v8_lvt ad=0.1885 pd=1.88 as=0.1885 ps=1.88 w=0.65 l=0.15
X537 a_23199_10029# a_22753_1814# a_16602_7094# vss sky130_fd_pr__nfet_01v8_lvt ad=0.1885 pd=1.88 as=0.1885 ps=1.88 w=0.65 l=0.15
X538 a_11527_4275# a0 a_7935_6810# vss sky130_fd_pr__nfet_01v8_lvt ad=0.12375 pd=1.08 as=0.2325 ps=2.12 w=0.75 l=0.15
X539 vdd a_6063_1490# a_7935_1490# vdd sky130_fd_pr__pfet_01v8_lvt ad=0.3045 pd=2.39 as=0.3045 ps=2.39 w=2.1 l=0.35
X540 a_7935_1490# a_6063_1490# vss vss sky130_fd_pr__nfet_01v8_lvt ad=0.2805 pd=2.03 as=0.527 ps=4.02 w=1.7 l=0.15
X541 a_11461_1934# a0 vdd vdd sky130_fd_pr__pfet_01v8 ad=0.261 pd=2.38 as=0.261 ps=2.38 w=0.9 l=0.18
X542 a_22795_1641# a_22753_1814# a_13268_4274# vss sky130_fd_pr__nfet_01v8_lvt ad=0.1885 pd=1.88 as=0.1885 ps=1.88 w=0.65 l=0.15
X543 a_28467_12830# a_7218_11110# vss vss sky130_fd_pr__nfet_01v8 ad=0.29 pd=2.58 as=0.29 ps=2.58 w=1 l=0.18
X544 vdd a_29868_8794# a_29702_7094# vdd sky130_fd_pr__pfet_01v8 ad=0.4464 pd=3.5 as=0.2376 ps=1.77 w=1.44 l=0.15
X545 a_29868_4274# a_29868_2574# vss sky130_fd_pr__res_high_po_0p35 l=6.5
X546 vdd a_16802_11144# a_11270_13392# vdd sky130_fd_pr__pfet_01v8 ad=0.5445 pd=3.63 as=0.5445 ps=3.63 w=3.3 l=0.15
X547 a_22437_8740# a_20555_8261# vdd vdd sky130_fd_pr__pfet_01v8 ad=0.2805 pd=2.03 as=0.527 ps=4.02 w=1.7 l=0.15
X548 a_7935_6810# a_12237_1934# a_11527_2855# vdd sky130_fd_pr__pfet_01v8_lvt ad=0.667 pd=5.18 as=0.3335 ps=2.59 w=2.3 l=0.35
X549 a_29327_12830# a_28467_12830# vdd vdd sky130_fd_pr__pfet_01v8 ad=0.174 pd=1.78 as=0.174 ps=1.78 w=0.6 l=0.28
X550 a_7935_4450# a_6063_4450# vdd vdd sky130_fd_pr__pfet_01v8_lvt ad=0.3045 pd=2.39 as=0.3045 ps=2.39 w=2.1 l=0.35
X551 a_21287_12830# a_20828_12850# a_21667_12830# vdd sky130_fd_pr__pfet_01v8 ad=0.62 pd=4.62 as=0.33 ps=2.33 w=2 l=0.15
X552 cke0 cke2 vdd vdd sky130_fd_pr__pfet_01v8 ad=0.6264 pd=4.9 as=0.6264 ps=4.9 w=2.16 l=0.15
X553 a_2903_9270# a_323_4520# vss vss sky130_fd_pr__nfet_01v8_lvt ad=0.319 pd=2.78 as=0.319 ps=2.78 w=1.1 l=0.15
X554 vdd a_20959_6161# vdd vdd sky130_fd_pr__pfet_01v8 ad=0.2805 pd=2.03 as=0 ps=0 w=1.7 l=0.15
X555 a_24149_11800# a_29327_12830# vdd vdd sky130_fd_pr__pfet_01v8 ad=0.5445 pd=3.63 as=0.5445 ps=3.63 w=3.3 l=0.15
X556 a_23199_6161# a_22753_1814# a_13268_8794# vdd sky130_fd_pr__pfet_01v8_lvt ad=0.609 pd=4.78 as=0.609 ps=4.78 w=2.1 l=0.35
X557 a_13208_205# a3 vdd vdd sky130_fd_pr__pfet_01v8 ad=0.261 pd=2.38 as=0.261 ps=2.38 w=0.9 l=0.18
X558 a_29868_4274# a_29868_2574# a_30217_2855# vss sky130_fd_pr__nfet_01v8_lvt ad=0.744 pd=5.42 as=0.396 ps=2.73 w=2.4 l=0.15
X559 vss a_24149_11800# vss vss sky130_fd_pr__nfet_01v8_lvt ad=0.2465 pd=2.28 as=0 ps=0 w=0.85 l=0.15
X560 a_30963_8465# vss vdd vdd sky130_fd_pr__pfet_01v8 ad=0.2607 pd=1.91 as=0.4898 ps=3.78 w=1.58 l=0.15
X561 en a_30963_3945# vdd vdd sky130_fd_pr__pfet_01v8 ad=0.495 pd=3.33 as=0.93 ps=6.62 w=3 l=0.15
X562 vss a_20959_10029# vss vss sky130_fd_pr__nfet_01v8_lvt ad=0.203 pd=1.98 as=0 ps=0 w=0.7 l=0.15
X563 a_11527_4275# a4 a_7935_6210# vss sky130_fd_pr__nfet_01v8_lvt ad=0.12375 pd=1.08 as=0.2325 ps=2.12 w=0.75 l=0.15
X564 a_2903_6910# a_5214_6768# vss sky130_fd_pr__res_high_po_0p69 l=1.5
X565 a_22795_10029# f5 a_13102_7094# vdd sky130_fd_pr__pfet_01v8_lvt ad=0.609 pd=4.78 as=0.609 ps=4.78 w=2.1 l=0.35
X566 a_13102_2574# a_13102_4274# vdd vdd sky130_fd_pr__pfet_01v8 ad=0.462 pd=3.13 as=0.868 ps=6.22 w=2.8 l=0.15
X567 a_13268_7094# a_11527_7375# sky130_fd_pr__cap_mim_m3_1 l=4.2 w=4.3
X568 a_28467_12830# a_21941_11896# a_17910_13392# vdd sky130_fd_pr__pfet_01v8 ad=1.116 pd=7.82 as=0.594 ps=3.93 w=3.6 l=0.15
X569 vdd a_30963_2855# ep vdd sky130_fd_pr__pfet_01v8 ad=0.495 pd=3.33 as=0.495 ps=3.33 w=3 l=0.15
X570 vss a_23199_1641# vss vss sky130_fd_pr__nfet_01v8_lvt ad=0.203 pd=1.98 as=0 ps=0 w=0.7 l=0.15
X571 a_25035_3409# f6 a_13268_4274# vdd sky130_fd_pr__pfet_01v8_lvt ad=0.609 pd=4.78 as=0.609 ps=4.78 w=2.1 l=0.35
X572 vdd a_323_4520# a_2903_6910# vdd sky130_fd_pr__pfet_01v8_lvt ad=0.1595 pd=1.39 as=0.1595 ps=1.39 w=1.1 l=0.35
X573 a_12625_1934# a6 vdd vdd sky130_fd_pr__pfet_01v8 ad=0.261 pd=2.38 as=0.261 ps=2.38 w=0.9 l=0.18
X574 vdd a_21667_12830# a_18550_13392# vdd sky130_fd_pr__pfet_01v8 ad=1.023 pd=7.22 as=0.5445 ps=3.63 w=3.3 l=0.15
X575 a_17910_13392# a_21941_11896# a_28467_12830# vdd sky130_fd_pr__pfet_01v8 ad=0.594 pd=3.93 as=0.594 ps=3.93 w=3.6 l=0.15
X576 vdd a_25439_6161# vdd vdd sky130_fd_pr__pfet_01v8 ad=0.2805 pd=2.03 as=0 ps=0 w=1.7 l=0.15
X577 a_7935_1490# a_11849_1934# a_11527_4275# vdd sky130_fd_pr__pfet_01v8_lvt ad=0.667 pd=5.18 as=0.3335 ps=2.59 w=2.3 l=0.35
X578 a_7935_3850# a_6063_3850# vss vss sky130_fd_pr__nfet_01v8_lvt ad=0.2805 pd=2.03 as=0.527 ps=4.02 w=1.7 l=0.15
X579 a_13268_4274# a_13268_2574# vss sky130_fd_pr__res_high_po_0p35 l=6.5
X580 vdd a_13268_2574# a_13268_4274# vdd sky130_fd_pr__pfet_01v8 ad=0.462 pd=3.13 as=0.462 ps=3.13 w=2.8 l=0.15
X581 vss a_10522_11144# a_10451_12702# vss sky130_fd_pr__nfet_01v8_lvt ad=0.527 pd=4.02 as=0.2805 ps=2.03 w=1.7 l=0.15
X582 vdd a_30963_3945# a_30963_2855# vdd sky130_fd_pr__pfet_01v8 ad=0.3906 pd=3.14 as=0.2079 ps=1.59 w=1.26 l=0.15
X583 a_28087_12830# a_27658_12850# a_28467_12830# vdd sky130_fd_pr__pfet_01v8 ad=0.62 pd=4.62 as=0.33 ps=2.33 w=2 l=0.15
X584 a_22437_2120# a_20555_1641# vss vss sky130_fd_pr__nfet_01v8_lvt ad=0.203 pd=1.98 as=0.203 ps=1.98 w=0.7 l=0.15
X585 a_20828_12850# a_20458_12920# vss vss sky130_fd_pr__nfet_01v8 ad=0.174 pd=1.78 as=0.174 ps=1.78 w=0.6 l=0.18
X586 a_17675_12870# a_10451_12702# a_18187_12870# vdd sky130_fd_pr__pfet_01v8_lvt ad=0.464 pd=3.78 as=0.464 ps=3.78 w=1.6 l=0.35
X587 vss a_24149_11800# vss vss sky130_fd_pr__nfet_01v8 ad=0.1218 pd=1.42 as=0 ps=0 w=0.42 l=0.5
X588 ep en vss vss sky130_fd_pr__nfet_01v8_lvt ad=0.261 pd=2.38 as=0.261 ps=2.38 w=0.9 l=0.15
X589 a_20959_3741# a_20513_3298# a_13102_2574# vdd sky130_fd_pr__pfet_01v8_lvt ad=0.609 pd=4.78 as=0.609 ps=4.78 w=2.1 l=0.35
X590 a_26627_11933# a_6211_11960# en vdd sky130_fd_pr__pfet_01v8_lvt ad=0.6583 pd=5.12 as=0.32915 ps=2.56 w=2.27 l=0.35
X591 a_5993_9144# a_5214_9128# sky130_fd_pr__cap_mim_m3_1 l=4.2 w=4.2
X592 vdd a_323_9240# a_2903_8670# vdd sky130_fd_pr__pfet_01v8_lvt ad=0.1595 pd=1.39 as=0.1595 ps=1.39 w=1.1 l=0.35
X593 a_9937_11910# a_16309_11910# vdd vdd sky130_fd_pr__pfet_01v8 ad=0.5445 pd=3.63 as=1.023 ps=7.22 w=3.3 l=0.15
X594 a_21277_11890# a_20347_11933# vdd vdd sky130_fd_pr__pfet_01v8_lvt ad=0.638 pd=4.98 as=0.638 ps=4.98 w=2.2 l=0.35
X595 vdd a_6063_6810# a_7935_6810# vdd sky130_fd_pr__pfet_01v8_lvt ad=0.3045 pd=2.39 as=0.3045 ps=2.39 w=2.1 l=0.35
X596 a_7935_9170# a_14961_1934# a_15027_4275# vdd sky130_fd_pr__pfet_01v8_lvt ad=0.667 pd=5.18 as=0.3335 ps=2.59 w=2.3 l=0.35
X597 vss a_5993_8453# a_6063_8570# vss sky130_fd_pr__nfet_01v8_lvt ad=0.341 pd=2.82 as=0.1815 ps=1.43 w=1.1 l=0.15
X598 a_11461_1934# a0 vss vss sky130_fd_pr__nfet_01v8 ad=0.1305 pd=1.48 as=0.1305 ps=1.48 w=0.45 l=0.18
X599 a_11270_13392# a_9999_11686# a_10522_11144# vdd sky130_fd_pr__pfet_01v8 ad=0.4125 pd=2.83 as=0.775 ps=5.62 w=2.5 l=0.15
X600 a_7935_2090# a_12625_1934# a_11527_4275# vdd sky130_fd_pr__pfet_01v8_lvt ad=0.667 pd=5.18 as=0.3335 ps=2.59 w=2.3 l=0.35
X601 a_18315_3741# a_18273_3298# a_16602_2574# vdd sky130_fd_pr__pfet_01v8_lvt ad=0.609 pd=4.78 as=0.609 ps=4.78 w=2.1 l=0.35
X602 a_20959_8261# f2 a_13102_7094# vss sky130_fd_pr__nfet_01v8_lvt ad=0.1885 pd=1.88 as=0.1885 ps=1.88 w=0.65 l=0.15
X603 a_7935_8570# b5 a_15027_4275# vss sky130_fd_pr__nfet_01v8_lvt ad=0.2325 pd=2.12 as=0.12375 ps=1.08 w=0.75 l=0.15
X604 vdd a_24149_11800# cke1 vdd sky130_fd_pr__pfet_01v8 ad=0.93 pd=6.62 as=0.495 ps=3.33 w=3 l=0.15
X605 a_22753_3298# f4 vdd vdd sky130_fd_pr__pfet_01v8 ad=0.261 pd=2.38 as=0.261 ps=2.38 w=0.9 l=0.18
X606 vss vdd a_30817_3517# vss sky130_fd_pr__nfet_01v8 ad=0.17835 pd=1.52 as=0.17835 ps=1.52 w=1.23 l=0.2
X607 vdd a_22497_11800# cke3 vdd sky130_fd_pr__pfet_01v8 ad=0.495 pd=3.33 as=0.495 ps=3.33 w=3 l=0.15
X608 dn rst_n a_14067_11933# vss sky130_fd_pr__nfet_01v8_lvt ad=0.403 pd=3.22 as=0.2145 ps=1.63 w=1.3 l=0.15
X609 a_16802_11144# a_9999_11686# a_8701_12702# vss sky130_fd_pr__nfet_01v8_lvt ad=0.4495 pd=3.52 as=0.23925 ps=1.78 w=1.45 l=0.15
X610 a_3663_2190# a_5214_2048# vss sky130_fd_pr__res_high_po_0p69 l=1.5
X611 a_26917_2120# a_25035_1641# vss vss sky130_fd_pr__nfet_01v8_lvt ad=0.203 pd=1.98 as=0.203 ps=1.98 w=0.7 l=0.15
X612 a_18719_1641# a_18273_1814# a_13268_4274# vdd sky130_fd_pr__pfet_01v8_lvt ad=0.609 pd=4.78 as=0.609 ps=4.78 w=2.1 l=0.35
X613 a_23199_3409# f4 a_13268_4274# vss sky130_fd_pr__nfet_01v8_lvt ad=0.1885 pd=1.88 as=0.1885 ps=1.88 w=0.65 l=0.15
X614 vss a_16602_4274# a_16602_2574# vss sky130_fd_pr__nfet_01v8_lvt ad=0.527 pd=4.02 as=0.2805 ps=2.03 w=1.7 l=0.15
X615 a_21667_12830# a_22559_11686# a_22497_11800# vdd sky130_fd_pr__pfet_01v8 ad=1.116 pd=7.82 as=0.594 ps=3.93 w=3.6 l=0.15
X616 a_25439_10029# f7 a_13102_7094# vss sky130_fd_pr__nfet_01v8_lvt ad=0.1885 pd=1.88 as=0.1885 ps=1.88 w=0.65 l=0.15
X617 vdd a_6063_8570# a_7935_8570# vdd sky130_fd_pr__pfet_01v8_lvt ad=0.3045 pd=2.39 as=0.3045 ps=2.39 w=2.1 l=0.35
X618 a_7935_8570# b3 a_15027_7375# vss sky130_fd_pr__nfet_01v8_lvt ad=0.2325 pd=2.12 as=0.12375 ps=1.08 w=0.75 l=0.15
X619 vdd vss a_30963_7375# vdd sky130_fd_pr__pfet_01v8 ad=0.2607 pd=1.91 as=0.2607 ps=1.91 w=1.58 l=0.15
X620 vdd a_18719_5509# vdd vdd sky130_fd_pr__pfet_01v8 ad=0.2805 pd=2.03 as=0 ps=0 w=1.7 l=0.15
X621 a_5993_6784# a_5214_6768# sky130_fd_pr__cap_mim_m3_1 l=4.2 w=4.2
X622 a_25439_3741# a_24993_3298# a_13102_2574# vdd sky130_fd_pr__pfet_01v8_lvt ad=0.609 pd=4.78 as=0.609 ps=4.78 w=2.1 l=0.35
X623 a_9937_11910# a_16309_11910# vss vss sky130_fd_pr__nfet_01v8_lvt ad=0.2805 pd=2.03 as=0.527 ps=4.02 w=1.7 l=0.15
X624 vdd a_25035_8261# a_26917_8740# vdd sky130_fd_pr__pfet_01v8 ad=0.527 pd=4.02 as=0.2805 ps=2.03 w=1.7 l=0.15
X625 a_20555_7929# a_20513_3298# a_13268_8794# vss sky130_fd_pr__nfet_01v8_lvt ad=0.1885 pd=1.88 as=0.1885 ps=1.88 w=0.65 l=0.15
X626 a_30817_8037# a_29702_7094# a_30963_8465# vss sky130_fd_pr__nfet_01v8_lvt ad=0.396 pd=2.73 as=0.396 ps=2.73 w=2.4 l=0.15
X627 a_13208_205# a3 vss vss sky130_fd_pr__nfet_01v8 ad=0.1305 pd=1.48 as=0.1305 ps=1.48 w=0.45 l=0.18
X628 a_7935_1490# a_6063_1490# vdd vdd sky130_fd_pr__pfet_01v8_lvt ad=0.3045 pd=2.39 as=0.609 ps=4.78 w=2.1 l=0.35
X629 a_17910_13392# a_22507_12830# vss vss sky130_fd_pr__nfet_01v8_lvt ad=0.2805 pd=2.03 as=0.527 ps=4.02 w=1.7 l=0.15
X630 a_13102_7094# a_13102_8794# vdd vdd sky130_fd_pr__pfet_01v8_lvt ad=0.406 pd=3.09 as=0.812 ps=6.18 w=2.8 l=0.35
X631 a_15027_7375# a_15349_1934# a_7935_8570# vdd sky130_fd_pr__pfet_01v8_lvt ad=0.3335 pd=2.59 as=0.667 ps=5.18 w=2.3 l=0.35
X632 vdd a_323_6880# a_3663_1590# vdd sky130_fd_pr__pfet_01v8_lvt ad=0.319 pd=2.78 as=0.1595 ps=1.39 w=1.1 l=0.35
X633 a_5993_8453# a_6063_8570# vss sky130_fd_pr__res_high_po_0p35 l=9.5
X634 a_20959_7929# a_20513_3298# a_16768_8794# vss sky130_fd_pr__nfet_01v8_lvt ad=0.1885 pd=1.88 as=0.1885 ps=1.88 w=0.65 l=0.15
X635 a_16768_8794# a_16768_7094# vdd vdd sky130_fd_pr__pfet_01v8_lvt ad=0.406 pd=3.09 as=0.812 ps=6.18 w=2.8 l=0.35
X636 a_323_4520# qp vdd vdd sky130_fd_pr__pfet_01v8_lvt ad=0.203 pd=1.69 as=0.406 ps=3.38 w=1.4 l=0.35
X637 a_7935_3850# b7 a_15027_2855# vss sky130_fd_pr__nfet_01v8_lvt ad=0.2325 pd=2.12 as=0.12375 ps=1.08 w=0.75 l=0.15
X638 a_20347_11933# a_6211_11960# ep vdd sky130_fd_pr__pfet_01v8_lvt ad=0.32915 pd=2.56 as=0.6583 ps=5.12 w=2.27 l=0.35
X639 a_18315_8261# f0 a_16602_7094# vss sky130_fd_pr__nfet_01v8_lvt ad=0.1885 pd=1.88 as=0.1885 ps=1.88 w=0.65 l=0.15
X640 a_20555_6161# f3 a_13268_8794# vdd sky130_fd_pr__pfet_01v8_lvt ad=0.609 pd=4.78 as=0.609 ps=4.78 w=2.1 l=0.35
X641 a_2903_1590# a_5214_1580# vss sky130_fd_pr__res_high_po_0p69 l=1.5
X642 a_22497_11800# a_28467_12830# vdd vdd sky130_fd_pr__pfet_01v8 ad=0.5445 pd=3.63 as=0.5445 ps=3.63 w=3.3 l=0.15
X643 vdd a_23199_3741# vdd vdd sky130_fd_pr__pfet_01v8 ad=0.2805 pd=2.03 as=0 ps=0 w=1.7 l=0.15
X644 a_20959_6161# f3 a_16768_8794# vdd sky130_fd_pr__pfet_01v8_lvt ad=0.609 pd=4.78 as=0.609 ps=4.78 w=2.1 l=0.35
X645 a_18719_6161# f1 a_13268_8794# vss sky130_fd_pr__nfet_01v8_lvt ad=0.1885 pd=1.88 as=0.1885 ps=1.88 w=0.65 l=0.15
X646 vdd a_5993_1373# a_6063_1490# vdd sky130_fd_pr__pfet_01v8_lvt ad=0.3045 pd=2.39 as=0.3045 ps=2.39 w=2.1 l=0.35
X647 a_17910_13392# a_22559_11686# a_28467_12830# vss sky130_fd_pr__nfet_01v8_lvt ad=0.62 pd=4.62 as=0.33 ps=2.33 w=2 l=0.15
X648 a_13102_7094# a_13102_8794# vdd vdd sky130_fd_pr__pfet_01v8 ad=0.462 pd=3.13 as=0.462 ps=3.13 w=2.8 l=0.15
X649 a_25439_8261# f6 a_13102_7094# vss sky130_fd_pr__nfet_01v8_lvt ad=0.1885 pd=1.88 as=0.1885 ps=1.88 w=0.65 l=0.15
X650 a_30817_8037# vdd vss vss sky130_fd_pr__nfet_01v8 ad=0.17835 pd=1.52 as=0.17835 ps=1.52 w=1.23 l=0.2
X651 a_12625_1934# a6 vss vss sky130_fd_pr__nfet_01v8 ad=0.1305 pd=1.48 as=0.1305 ps=1.48 w=0.45 l=0.18
X652 a_20555_3741# a_20513_3298# a_16602_2574# vdd sky130_fd_pr__pfet_01v8_lvt ad=0.609 pd=4.78 as=0.609 ps=4.78 w=2.1 l=0.35
X653 vdd a_30963_7375# a_30963_8465# vdd sky130_fd_pr__pfet_01v8 ad=0.2079 pd=1.59 as=0.2079 ps=1.59 w=1.26 l=0.15
X654 vss a_5993_6093# a_6063_6210# vss sky130_fd_pr__nfet_01v8_lvt ad=0.341 pd=2.82 as=0.1815 ps=1.43 w=1.1 l=0.15
X655 a_25035_1641# f7 a_16768_4274# vss sky130_fd_pr__nfet_01v8_lvt ad=0.1885 pd=1.88 as=0.1885 ps=1.88 w=0.65 l=0.15
X656 vdd a_23199_3409# vdd vdd sky130_fd_pr__pfet_01v8 ad=0.527 pd=4.02 as=0 ps=0 w=1.7 l=0.15
X657 vdd a_8701_12702# a_22127_12830# vdd sky130_fd_pr__pfet_01v8 ad=0.62 pd=4.62 as=0.33 ps=2.33 w=2 l=0.15
X658 a_6063_6210# a_5993_6093# vdd vdd sky130_fd_pr__pfet_01v8_lvt ad=0.3045 pd=2.39 as=0.3045 ps=2.39 w=2.1 l=0.35
X659 a_20959_7929# a_20513_3298# a_13268_8794# vdd sky130_fd_pr__pfet_01v8_lvt ad=0.609 pd=4.78 as=0.609 ps=4.78 w=2.1 l=0.35
X660 cke2 a_18550_13392# vdd vdd sky130_fd_pr__pfet_01v8 ad=0.495 pd=3.33 as=0.495 ps=3.33 w=3 l=0.15
X661 a_21941_11896# a_21277_11890# vss vss sky130_fd_pr__nfet_01v8_lvt ad=0.198 pd=1.53 as=0.372 ps=3.02 w=1.2 l=0.15
X662 a_7935_6210# a6 a_11527_8795# vss sky130_fd_pr__nfet_01v8_lvt ad=0.2325 pd=2.12 as=0.12375 ps=1.08 w=0.75 l=0.15
X663 a_15027_7375# a_16125_1934# a_7935_9170# vdd sky130_fd_pr__pfet_01v8_lvt ad=0.3335 pd=2.59 as=0.667 ps=5.18 w=2.3 l=0.35
X664 a_11527_4275# a_11461_1934# a_7935_6810# vdd sky130_fd_pr__pfet_01v8_lvt ad=0.3335 pd=2.59 as=0.667 ps=5.18 w=2.3 l=0.35
X665 vdd a_20959_5509# vdd vdd sky130_fd_pr__pfet_01v8 ad=0.2805 pd=2.03 as=0 ps=0 w=1.7 l=0.15
X666 vdd a_11270_13392# ckd3 vdd sky130_fd_pr__pfet_01v8 ad=0.495 pd=3.33 as=0.495 ps=3.33 w=3 l=0.15
X667 vdd a_17910_13392# cke0 vdd sky130_fd_pr__pfet_01v8 ad=0.93 pd=6.62 as=0.495 ps=3.33 w=3 l=0.15
X668 vdd a_22559_11686# a_21941_11896# vdd sky130_fd_pr__pfet_01v8 ad=0.651 pd=4.82 as=0.3465 ps=2.43 w=2.1 l=0.15
X669 dp a_30963_7375# vss vss sky130_fd_pr__nfet_01v8_lvt ad=0.3465 pd=2.43 as=0.651 ps=4.82 w=2.1 l=0.15
X670 a_23199_1641# f5 a_16768_4274# vdd sky130_fd_pr__pfet_01v8_lvt ad=0.609 pd=4.78 as=0.609 ps=4.78 w=2.1 l=0.35
X671 vdd a_13268_7094# a_13268_8794# vdd sky130_fd_pr__pfet_01v8 ad=0.868 pd=6.22 as=0.462 ps=3.13 w=2.8 l=0.15
X672 vss a_10029_11910# a_8701_12702# vss sky130_fd_pr__nfet_01v8_lvt ad=0.527 pd=4.02 as=0.2805 ps=2.03 w=1.7 l=0.15
X673 a_20555_8261# f2 a_16602_7094# vss sky130_fd_pr__nfet_01v8_lvt ad=0.1885 pd=1.88 as=0.1885 ps=1.88 w=0.65 l=0.15
X674 a_30963_2855# vss vdd vdd sky130_fd_pr__pfet_01v8 ad=0.2607 pd=1.91 as=0.2607 ps=1.91 w=1.58 l=0.15
X675 vdd a_20555_3741# a_22437_4220# vdd sky130_fd_pr__pfet_01v8 ad=0.527 pd=4.02 as=0.2805 ps=2.03 w=1.7 l=0.15
X676 a_18315_7929# a_18273_3298# a_16768_8794# vdd sky130_fd_pr__pfet_01v8_lvt ad=0.609 pd=4.78 as=0.609 ps=4.78 w=2.1 l=0.35
X677 a_7935_2090# a_6063_2090# vdd vdd sky130_fd_pr__pfet_01v8_lvt ad=0.3045 pd=2.39 as=0.3045 ps=2.39 w=2.1 l=0.35
X678 a_30963_3945# a_29702_2574# a_30817_3517# vss sky130_fd_pr__nfet_01v8_lvt ad=0.396 pd=2.73 as=0.396 ps=2.73 w=2.4 l=0.15
X679 a_20197_2720# a_28514_1816# vss sky130_fd_pr__res_high_po_0p69 l=2.2
X680 a_22795_3409# f4 a_16768_4274# vss sky130_fd_pr__nfet_01v8_lvt ad=0.1885 pd=1.88 as=0.1885 ps=1.88 w=0.65 l=0.15
X681 a_2903_6910# a_323_4520# vss vss sky130_fd_pr__nfet_01v8_lvt ad=0.319 pd=2.78 as=0.319 ps=2.78 w=1.1 l=0.15
X682 a_25035_10029# a_24993_1814# a_16602_7094# vdd sky130_fd_pr__pfet_01v8_lvt ad=0.609 pd=4.78 as=0.609 ps=4.78 w=2.1 l=0.35
X683 vdd a_18719_8261# vdd vdd sky130_fd_pr__pfet_01v8 ad=0.527 pd=4.02 as=0 ps=0 w=1.7 l=0.15
X684 a_22507_12830# a_20828_12850# a_22127_12830# vdd sky130_fd_pr__pfet_01v8 ad=0.33 pd=2.33 as=0.62 ps=4.62 w=2 l=0.15
X685 a_29327_12830# a_28467_12830# vss vss sky130_fd_pr__nfet_01v8 ad=0.174 pd=1.78 as=0.174 ps=1.78 w=0.6 l=0.28
X686 a_25439_7929# a_24993_3298# a_13268_8794# vdd sky130_fd_pr__pfet_01v8_lvt ad=0.609 pd=4.78 as=0.609 ps=4.78 w=2.1 l=0.35
X687 a_30817_8037# a_29868_8794# a_30963_7375# vss sky130_fd_pr__nfet_01v8_lvt ad=0.396 pd=2.73 as=0.396 ps=2.73 w=2.4 l=0.15
X688 a_22753_3298# f4 vss vss sky130_fd_pr__nfet_01v8 ad=0.1305 pd=1.48 as=0.1305 ps=1.48 w=0.45 l=0.18
X689 a_18315_1641# a_18273_1814# a_13268_4274# vss sky130_fd_pr__nfet_01v8_lvt ad=0.1885 pd=1.88 as=0.1885 ps=1.88 w=0.65 l=0.15
X690 a_15027_7375# b1 a_7935_3850# vss sky130_fd_pr__nfet_01v8_lvt ad=0.12375 pd=1.08 as=0.2325 ps=2.12 w=0.75 l=0.15
X691 a_23199_6161# a_22753_1814# a_16768_8794# vss sky130_fd_pr__nfet_01v8_lvt ad=0.1885 pd=1.88 as=0.1885 ps=1.88 w=0.65 l=0.15
X692 vdd a_25439_5509# vdd vdd sky130_fd_pr__pfet_01v8 ad=0.2805 pd=2.03 as=0 ps=0 w=1.7 l=0.15
X693 a_9999_11686# a_14997_11890# vdd vdd sky130_fd_pr__pfet_01v8 ad=0.4356 pd=2.97 as=0.4356 ps=2.97 w=2.64 l=0.15
X694 vdd a_323_4520# a_3663_6910# vdd sky130_fd_pr__pfet_01v8_lvt ad=0.319 pd=2.78 as=0.1595 ps=1.39 w=1.1 l=0.35
X695 a_7935_6810# a_6063_6810# vdd vdd sky130_fd_pr__pfet_01v8_lvt ad=0.3045 pd=2.39 as=0.609 ps=4.78 w=2.1 l=0.35
X696 a_15027_8795# a_15737_1934# a_7935_3850# vdd sky130_fd_pr__pfet_01v8_lvt ad=0.3335 pd=2.59 as=0.667 ps=5.18 w=2.3 l=0.35
X697 vdd a_18315_10029# a_20197_9340# vdd sky130_fd_pr__pfet_01v8 ad=0.527 pd=4.02 as=0.2805 ps=2.03 w=1.7 l=0.15
X698 a_18719_1641# a_18273_1814# a_16768_4274# vss sky130_fd_pr__nfet_01v8_lvt ad=0.1885 pd=1.88 as=0.1885 ps=1.88 w=0.65 l=0.15
X699 a_6063_3850# a_5993_3733# vdd vdd sky130_fd_pr__pfet_01v8_lvt ad=0.3045 pd=2.39 as=0.3045 ps=2.39 w=2.1 l=0.35
X700 a_22795_5509# a_22753_1814# a_16602_2574# vdd sky130_fd_pr__pfet_01v8_lvt ad=0.609 pd=4.78 as=0.609 ps=4.78 w=2.1 l=0.35
X701 a_13268_2574# a_11527_2855# sky130_fd_pr__cap_mim_m3_1 l=4.2 w=4.3
X702 a_30963_3945# a_30963_2855# vdd vdd sky130_fd_pr__pfet_01v8 ad=0.2079 pd=1.59 as=0.2079 ps=1.59 w=1.26 l=0.15
X703 a_20555_10029# f3 a_16602_7094# vss sky130_fd_pr__nfet_01v8_lvt ad=0.1885 pd=1.88 as=0.1885 ps=1.88 w=0.65 l=0.15
X704 vdd a_323_2160# a_2903_4550# vdd sky130_fd_pr__pfet_01v8_lvt ad=0.1595 pd=1.39 as=0.1595 ps=1.39 w=1.1 l=0.35
X705 a_26917_2720# a_25035_3409# vdd vdd sky130_fd_pr__pfet_01v8 ad=0.2805 pd=2.03 as=0.527 ps=4.02 w=1.7 l=0.15
X706 a_24677_8740# a_28514_8208# vss sky130_fd_pr__res_high_po_0p69 l=2.2
X707 a_16802_11144# a_16309_11910# vdd vdd sky130_fd_pr__pfet_01v8 ad=0.174 pd=1.78 as=0.174 ps=1.78 w=0.6 l=0.28
X708 a_3663_9270# a_5214_9128# vss sky130_fd_pr__res_high_po_0p69 l=1.5
X709 a_7935_2090# a_7935_1490# vss vss sky130_fd_pr__nfet_01v8_lvt ad=0.1305 pd=1.48 as=0.1305 ps=1.48 w=0.45 l=0.15
X710 a_18315_10029# f1 a_13102_7094# vdd sky130_fd_pr__pfet_01v8_lvt ad=0.609 pd=4.78 as=0.609 ps=4.78 w=2.1 l=0.35
X711 vdd a_20959_8261# vdd vdd sky130_fd_pr__pfet_01v8 ad=0.527 pd=4.02 as=0 ps=0 w=1.7 l=0.15
X712 a_20555_7929# a_20513_3298# a_16768_8794# vdd sky130_fd_pr__pfet_01v8_lvt ad=0.609 pd=4.78 as=0.609 ps=4.78 w=2.1 l=0.35
X713 a_16768_8794# a_16768_7094# vdd vdd sky130_fd_pr__pfet_01v8 ad=0.462 pd=3.13 as=0.868 ps=6.22 w=2.8 l=0.15
X714 vss a_30963_2855# ep vss sky130_fd_pr__nfet_01v8_lvt ad=0.651 pd=4.82 as=0.3465 ps=2.43 w=2.1 l=0.15
X715 a_20959_10029# f3 a_13102_7094# vss sky130_fd_pr__nfet_01v8_lvt ad=0.1885 pd=1.88 as=0.1885 ps=1.88 w=0.65 l=0.15
X716 vdd a_5993_6784# a_6063_6810# vdd sky130_fd_pr__pfet_01v8_lvt ad=0.3045 pd=2.39 as=0.3045 ps=2.39 w=2.1 l=0.35
X717 a_22795_5509# a_22753_1814# a_13102_2574# vss sky130_fd_pr__nfet_01v8_lvt ad=0.1885 pd=1.88 as=0.1885 ps=1.88 w=0.65 l=0.15
X718 vdd a_30963_3945# en vdd sky130_fd_pr__pfet_01v8_lvt ad=0.812 pd=6.18 as=0.406 ps=3.09 w=2.8 l=0.35
X719 a_11270_13392# a_16802_11144# vdd vdd sky130_fd_pr__pfet_01v8 ad=0.5445 pd=3.63 as=0.5445 ps=3.63 w=3.3 l=0.15
X720 vdd a_323_2160# a_3663_8670# vdd sky130_fd_pr__pfet_01v8_lvt ad=0.319 pd=2.78 as=0.1595 ps=1.39 w=1.1 l=0.35
X721 a_7935_8570# a_6063_8570# vdd vdd sky130_fd_pr__pfet_01v8_lvt ad=0.3045 pd=2.39 as=0.609 ps=4.78 w=2.1 l=0.35
X722 a_15027_7375# b5 a_7935_4450# vss sky130_fd_pr__nfet_01v8_lvt ad=0.12375 pd=1.08 as=0.2325 ps=2.12 w=0.75 l=0.15
X723 a_28514_6336# vss sky130_fd_pr__cap_mim_m3_1 l=1.6 w=1.6
X724 a_18719_10029# f1 a_16602_7094# vdd sky130_fd_pr__pfet_01v8_lvt ad=0.609 pd=4.78 as=0.609 ps=4.78 w=2.1 l=0.35
X725 vss a_18719_1641# vss vss sky130_fd_pr__nfet_01v8_lvt ad=0.203 pd=1.98 as=0 ps=0 w=0.7 l=0.15
X726 a_16602_4274# a_16602_2574# vss sky130_fd_pr__res_high_po_0p35 l=6.5
X727 ckd1 ckd3 vdd vdd sky130_fd_pr__pfet_01v8 ad=0.6264 pd=4.9 as=0.6264 ps=4.9 w=2.16 l=0.15
X728 a_27557_11890# a_26627_11933# vdd vdd sky130_fd_pr__pfet_01v8_lvt ad=0.638 pd=4.98 as=0.638 ps=4.98 w=2.2 l=0.35
X729 vdd a_22795_10029# a_24677_9340# vdd sky130_fd_pr__pfet_01v8 ad=0.527 pd=4.02 as=0.2805 ps=2.03 w=1.7 l=0.15
X730 vdd a_6063_4450# a_7935_4450# vdd sky130_fd_pr__pfet_01v8_lvt ad=0.3045 pd=2.39 as=0.3045 ps=2.39 w=2.1 l=0.35
X731 a_15018_205# b0 vdd vdd sky130_fd_pr__pfet_01v8 ad=0.261 pd=2.38 as=0.261 ps=2.38 w=0.9 l=0.18
X732 a_7935_2090# a4 a_11527_7375# vss sky130_fd_pr__nfet_01v8_lvt ad=0.2325 pd=2.12 as=0.12375 ps=1.08 w=0.75 l=0.15
X733 a_13102_7094# a_13102_8794# vss vss sky130_fd_pr__nfet_01v8_lvt ad=0.2805 pd=2.03 as=0.527 ps=4.02 w=1.7 l=0.15
X734 a_20197_8740# a_18315_8261# vdd vdd sky130_fd_pr__pfet_01v8 ad=0.2805 pd=2.03 as=0.527 ps=4.02 w=1.7 l=0.15
X735 a_30963_2855# a_29868_4274# a_30817_3517# vss sky130_fd_pr__nfet_01v8_lvt ad=0.396 pd=2.73 as=0.396 ps=2.73 w=2.4 l=0.15
X736 a_7787_11933# rst_n dp vss sky130_fd_pr__nfet_01v8_lvt ad=0.2145 pd=1.63 as=0.403 ps=3.22 w=1.3 l=0.15
X737 a_8701_12702# a_9381_11896# a_16802_11144# vdd sky130_fd_pr__pfet_01v8 ad=0.4125 pd=2.83 as=0.775 ps=5.62 w=2.5 l=0.15
X738 vdd a_5993_8453# a_6063_8570# vdd sky130_fd_pr__pfet_01v8_lvt ad=0.3045 pd=2.39 as=0.3045 ps=2.39 w=2.1 l=0.35
X739 vdd a_27557_11890# a_22559_11686# vdd sky130_fd_pr__pfet_01v8 ad=0.4356 pd=2.97 as=0.4356 ps=2.97 w=2.64 l=0.15
X740 a_30217_7375# vdd vss vss sky130_fd_pr__nfet_01v8 ad=0.16675 pd=1.44 as=0.3335 ps=2.88 w=1.15 l=0.2
X741 vdd a_25439_8261# vdd vdd sky130_fd_pr__pfet_01v8 ad=0.527 pd=4.02 as=0 ps=0 w=1.7 l=0.15
X742 dn a_30963_8465# vss vss sky130_fd_pr__nfet_01v8_lvt ad=0.3465 pd=2.43 as=0.651 ps=4.82 w=2.1 l=0.15
X743 a_6063_3850# a_5993_3733# vss vss sky130_fd_pr__nfet_01v8_lvt ad=0.1815 pd=1.43 as=0.341 ps=2.82 w=1.1 l=0.15
X744 a_15349_1934# b3 vdd vdd sky130_fd_pr__pfet_01v8 ad=0.261 pd=2.38 as=0.261 ps=2.38 w=0.9 l=0.18
X745 a_24149_11800# a_22559_11686# a_22507_12830# vdd sky130_fd_pr__pfet_01v8 ad=0.594 pd=3.93 as=1.116 ps=7.82 w=3.6 l=0.15
X746 a_18719_8261# a_18273_3298# a_13102_7094# vdd sky130_fd_pr__pfet_01v8_lvt ad=0.609 pd=4.78 as=0.609 ps=4.78 w=2.1 l=0.35
X747 vdd a_30963_8465# dn vdd sky130_fd_pr__pfet_01v8 ad=0.495 pd=3.33 as=0.495 ps=3.33 w=3 l=0.15
X748 a_25439_10029# a_24993_1814# a_16602_7094# vss sky130_fd_pr__nfet_01v8_lvt ad=0.1885 pd=1.88 as=0.1885 ps=1.88 w=0.65 l=0.15
X749 a_30963_8465# a_29702_7094# a_30817_8037# vss sky130_fd_pr__nfet_01v8_lvt ad=0.744 pd=5.42 as=0.396 ps=2.73 w=2.4 l=0.15
X750 a_323_2160# ip vdd vdd sky130_fd_pr__pfet_01v8_lvt ad=0.203 pd=1.69 as=0.406 ps=3.38 w=1.4 l=0.35
X751 a_5993_1373# a_5214_1580# sky130_fd_pr__cap_mim_m3_1 l=4.2 w=4.2
X752 a_26627_11933# a_6211_11960# en vdd sky130_fd_pr__pfet_01v8_lvt ad=0.32915 pd=2.56 as=0.6583 ps=5.12 w=2.27 l=0.35
X753 a_7935_9170# a_6063_9170# vdd vdd sky130_fd_pr__pfet_01v8_lvt ad=0.3045 pd=2.39 as=0.3045 ps=2.39 w=2.1 l=0.35
X754 a_24677_8740# a_22795_8261# vdd vdd sky130_fd_pr__pfet_01v8 ad=0.2805 pd=2.03 as=0.527 ps=4.02 w=1.7 l=0.15
X755 a_15027_7375# a_14961_1934# a_7935_3850# vdd sky130_fd_pr__pfet_01v8_lvt ad=0.3335 pd=2.59 as=0.667 ps=5.18 w=2.3 l=0.35
X756 vdd a_22497_11800# vdd vdd sky130_fd_pr__pfet_01v8 ad=0.725 pd=5.58 as=0 ps=0 w=2.5 l=0.15
X757 a_21941_11896# a_21277_11890# vdd vdd sky130_fd_pr__pfet_01v8 ad=0.4356 pd=2.97 as=0.8184 ps=5.9 w=2.64 l=0.15
X758 vdd a_16602_8794# a_16602_7094# vdd sky130_fd_pr__pfet_01v8 ad=0.462 pd=3.13 as=0.462 ps=3.13 w=2.8 l=0.15
X759 a_16998_205# b6 vdd vdd sky130_fd_pr__pfet_01v8 ad=0.261 pd=2.38 as=0.261 ps=2.38 w=0.9 l=0.18
X760 vdd a_23199_6161# vdd vdd sky130_fd_pr__pfet_01v8 ad=0.2805 pd=2.03 as=0 ps=0 w=1.7 l=0.15
X761 a_15027_2855# a_15737_1934# a_7935_9170# vdd sky130_fd_pr__pfet_01v8_lvt ad=0.3335 pd=2.59 as=0.667 ps=5.18 w=2.3 l=0.35
X762 cke0 a_17910_13392# vss vss sky130_fd_pr__nfet_01v8_lvt ad=0.198 pd=1.53 as=0.372 ps=3.02 w=1.2 l=0.15
X763 a_26917_6640# a_28514_6336# vss sky130_fd_pr__res_high_po_0p69 l=2.2
X764 a_10522_11144# a_9999_11686# a_11270_13392# vdd sky130_fd_pr__pfet_01v8 ad=0.4125 pd=2.83 as=0.4125 ps=2.83 w=2.5 l=0.15
X765 a_25035_10029# f7 a_13102_7094# vdd sky130_fd_pr__pfet_01v8_lvt ad=0.609 pd=4.78 as=0.609 ps=4.78 w=2.1 l=0.35
X766 a_6063_2090# a_5993_2064# vss sky130_fd_pr__res_high_po_0p35 l=9.5
X767 a_29868_8794# vss vdd vdd sky130_fd_pr__pfet_01v8 ad=0.3135 pd=2.23 as=0.589 ps=4.42 w=1.9 l=0.15
X768 cke1 cke3 vss vss sky130_fd_pr__nfet_01v8_lvt ad=0.1305 pd=1.48 as=0.1305 ps=1.48 w=0.45 l=0.15
X769 a_17910_13392# a_22507_12830# vdd vdd sky130_fd_pr__pfet_01v8 ad=0.5445 pd=3.63 as=1.023 ps=7.22 w=3.3 l=0.15
X770 a_18273_3298# f0 vdd vdd sky130_fd_pr__pfet_01v8 ad=0.261 pd=2.38 as=0.261 ps=2.38 w=0.9 l=0.18
X771 a_22175_13580# a_8701_12702# vss vss sky130_fd_pr__nfet_01v8_lvt ad=0.377 pd=3.18 as=0.377 ps=3.18 w=1.3 l=0.15
X772 cke3 a_22497_11800# vdd vdd sky130_fd_pr__pfet_01v8 ad=0.495 pd=3.33 as=0.495 ps=3.33 w=3 l=0.15
X773 vss a_25439_1641# vss vss sky130_fd_pr__nfet_01v8_lvt ad=0.203 pd=1.98 as=0 ps=0 w=0.7 l=0.15
X774 vss a_16309_11910# a_9937_11910# vss sky130_fd_pr__nfet_01v8_lvt ad=0.527 pd=4.02 as=0.2805 ps=2.03 w=1.7 l=0.15
X775 a_23199_8261# f4 a_16602_7094# vdd sky130_fd_pr__pfet_01v8_lvt ad=0.609 pd=4.78 as=0.609 ps=4.78 w=2.1 l=0.35
X776 vss a_22507_12830# a_17910_13392# vss sky130_fd_pr__nfet_01v8_lvt ad=0.527 pd=4.02 as=0.2805 ps=2.03 w=1.7 l=0.15
X777 a_7935_8570# a_6063_8570# vss vss sky130_fd_pr__nfet_01v8_lvt ad=0.2805 pd=2.03 as=0.527 ps=4.02 w=1.7 l=0.15
X778 a_15018_205# b0 vss vss sky130_fd_pr__nfet_01v8 ad=0.1305 pd=1.48 as=0.1305 ps=1.48 w=0.45 l=0.18
X779 vdd a_20555_6161# a_22437_6640# vdd sky130_fd_pr__pfet_01v8 ad=0.527 pd=4.02 as=0.2805 ps=2.03 w=1.7 l=0.15
X780 a_29702_7094# a_29702_8794# a_30217_7375# vss sky130_fd_pr__nfet_01v8_lvt ad=0.396 pd=2.73 as=0.744 ps=5.42 w=2.4 l=0.15
X781 a_2903_4550# a_323_2160# vss vss sky130_fd_pr__nfet_01v8_lvt ad=0.319 pd=2.78 as=0.319 ps=2.78 w=1.1 l=0.15
X782 a_30817_3517# vdd vss vss sky130_fd_pr__nfet_01v8 ad=0.17835 pd=1.52 as=0.17835 ps=1.52 w=1.23 l=0.2
X783 vdd a_13268_2574# a_13268_4274# vdd sky130_fd_pr__pfet_01v8_lvt ad=0.812 pd=6.18 as=0.406 ps=3.09 w=2.8 l=0.35
X784 a_24677_2120# a_22795_1641# vss vss sky130_fd_pr__nfet_01v8_lvt ad=0.203 pd=1.98 as=0.203 ps=1.98 w=0.7 l=0.15
X785 a_20959_3409# f2 a_13268_4274# vss sky130_fd_pr__nfet_01v8_lvt ad=0.1885 pd=1.88 as=0.1885 ps=1.88 w=0.65 l=0.15
X786 a_7935_9170# b3 a_15027_8795# vss sky130_fd_pr__nfet_01v8_lvt ad=0.2325 pd=2.12 as=0.12375 ps=1.08 w=0.75 l=0.15
X787 a_23199_3741# a_22753_3298# a_13102_2574# vdd sky130_fd_pr__pfet_01v8_lvt ad=0.609 pd=4.78 as=0.609 ps=4.78 w=2.1 l=0.35
X788 a_16602_2574# a_16602_4274# vdd vdd sky130_fd_pr__pfet_01v8 ad=0.462 pd=3.13 as=0.462 ps=3.13 w=2.8 l=0.15
X789 vdd a_22497_11800# cke3 vdd sky130_fd_pr__pfet_01v8 ad=0.93 pd=6.62 as=0.495 ps=3.33 w=3 l=0.15
X790 a_24149_11800# a_21941_11896# a_22507_12830# vss sky130_fd_pr__nfet_01v8_lvt ad=0.33 pd=2.33 as=0.62 ps=4.62 w=2 l=0.15
X791 vdd vss a_30963_8465# vdd sky130_fd_pr__pfet_01v8 ad=0.4898 pd=3.78 as=0.2607 ps=1.91 w=1.58 l=0.15
X792 a_30963_7375# a_29868_8794# a_30817_8037# vss sky130_fd_pr__nfet_01v8_lvt ad=0.744 pd=5.42 as=0.396 ps=2.73 w=2.4 l=0.15
X793 vdd a_323_4520# a_3663_4550# vdd sky130_fd_pr__pfet_01v8_lvt ad=0.319 pd=2.78 as=0.1595 ps=1.39 w=1.1 l=0.35
X794 a_7935_4450# a_6063_4450# vdd vdd sky130_fd_pr__pfet_01v8_lvt ad=0.3045 pd=2.39 as=0.609 ps=4.78 w=2.1 l=0.35
X795 a_15349_1934# b3 vss vss sky130_fd_pr__nfet_01v8 ad=0.1305 pd=1.48 as=0.1305 ps=1.48 w=0.45 l=0.18
X796 a_29868_4274# a_29702_2574# vdd vdd sky130_fd_pr__pfet_01v8 ad=0.2376 pd=1.77 as=0.4464 ps=3.5 w=1.44 l=0.15
X797 ep a_6211_11960# a_20347_11933# vdd sky130_fd_pr__pfet_01v8_lvt ad=0.32915 pd=2.56 as=0.32915 ps=2.56 w=2.27 l=0.35
X798 a_6063_1490# a_5993_1373# vdd vdd sky130_fd_pr__pfet_01v8_lvt ad=0.3045 pd=2.39 as=0.3045 ps=2.39 w=2.1 l=0.35
X799 a_18315_3409# f0 a_16768_4274# vss sky130_fd_pr__nfet_01v8_lvt ad=0.1885 pd=1.88 as=0.1885 ps=1.88 w=0.65 l=0.15
X800 vdd a_8717_11890# a_9381_11896# vdd sky130_fd_pr__pfet_01v8 ad=0.8184 pd=5.9 as=0.4356 ps=2.97 w=2.64 l=0.15
X801 vss a_21277_11890# a_21941_11896# vss sky130_fd_pr__nfet_01v8_lvt ad=0.372 pd=3.02 as=0.198 ps=1.53 w=1.2 l=0.15
X802 a_25035_5509# f7 a_16602_2574# vss sky130_fd_pr__nfet_01v8_lvt ad=0.1885 pd=1.88 as=0.1885 ps=1.88 w=0.65 l=0.15
X803 vdd a_323_2160# a_2903_2190# vdd sky130_fd_pr__pfet_01v8_lvt ad=0.1595 pd=1.39 as=0.1595 ps=1.39 w=1.1 l=0.35
X804 vdd a_16768_2574# a_16768_4274# vdd sky130_fd_pr__pfet_01v8 ad=0.868 pd=6.22 as=0.462 ps=3.13 w=2.8 l=0.15
X805 a_20959_5509# a_20513_1814# a_13102_2574# vdd sky130_fd_pr__pfet_01v8_lvt ad=0.609 pd=4.78 as=0.609 ps=4.78 w=2.1 l=0.35
X806 vdd vss a_29868_4274# vdd sky130_fd_pr__pfet_01v8 ad=0.589 pd=4.42 as=0.3135 ps=2.23 w=1.9 l=0.15
X807 ep a_30963_2855# vdd vdd sky130_fd_pr__pfet_01v8 ad=0.495 pd=3.33 as=0.495 ps=3.33 w=3 l=0.15
X808 a_23199_3741# f4 a_13102_2574# vss sky130_fd_pr__nfet_01v8_lvt ad=0.1885 pd=1.88 as=0.1885 ps=1.88 w=0.65 l=0.15
X809 ckd3 a_11270_13392# vdd vdd sky130_fd_pr__pfet_01v8 ad=0.495 pd=3.33 as=0.495 ps=3.33 w=3 l=0.15
X810 cke0 cke2 vss vss sky130_fd_pr__nfet_01v8_lvt ad=0.1305 pd=1.48 as=0.1305 ps=1.48 w=0.45 l=0.15
X811 vdd a_18719_7929# vdd vdd sky130_fd_pr__pfet_01v8 ad=0.2805 pd=2.03 as=0 ps=0 w=1.7 l=0.15
X812 a_25439_3409# f6 a_13268_4274# vss sky130_fd_pr__nfet_01v8_lvt ad=0.1885 pd=1.88 as=0.1885 ps=1.88 w=0.65 l=0.15
X813 vdd a_9937_11910# ckd1 vdd sky130_fd_pr__pfet_01v8 ad=0.93 pd=6.62 as=0.495 ps=3.33 w=3 l=0.15
X814 a_16802_11144# a_16309_11910# vss vss sky130_fd_pr__nfet_01v8 ad=0.174 pd=1.78 as=0.174 ps=1.78 w=0.6 l=0.28
X815 vdd a_5993_4424# a_6063_4450# vdd sky130_fd_pr__pfet_01v8_lvt ad=0.3045 pd=2.39 as=0.3045 ps=2.39 w=2.1 l=0.35
X816 a_7935_6810# a_11461_1934# a_11527_4275# vdd sky130_fd_pr__pfet_01v8_lvt ad=0.667 pd=5.18 as=0.3335 ps=2.59 w=2.3 l=0.35
X817 a_16998_205# b6 vss vss sky130_fd_pr__nfet_01v8 ad=0.1305 pd=1.48 as=0.1305 ps=1.48 w=0.45 l=0.18
X818 a_22795_7929# a_22753_3298# a_13268_8794# vss sky130_fd_pr__nfet_01v8_lvt ad=0.1885 pd=1.88 as=0.1885 ps=1.88 w=0.65 l=0.15
X819 vdd a_16602_4274# a_16602_2574# vdd sky130_fd_pr__pfet_01v8_lvt ad=0.812 pd=6.18 as=0.406 ps=3.09 w=2.8 l=0.35
X820 a_26917_9340# a_28514_8208# vss sky130_fd_pr__res_high_po_0p69 l=2.2
X821 a_30963_7375# vss vdd vdd sky130_fd_pr__pfet_01v8 ad=0.2607 pd=1.91 as=0.4898 ps=3.78 w=1.58 l=0.15
X822 a_7935_6810# a_7935_6210# vss vss sky130_fd_pr__nfet_01v8_lvt ad=0.1305 pd=1.48 as=0.1305 ps=1.48 w=0.45 l=0.15
X823 a_30963_3945# vss vdd vdd sky130_fd_pr__pfet_01v8 ad=0.2607 pd=1.91 as=0.2607 ps=1.91 w=1.58 l=0.15
X824 a_323_9240# qn vdd vdd sky130_fd_pr__pfet_01v8_lvt ad=0.203 pd=1.69 as=0.406 ps=3.38 w=1.4 l=0.35
X825 a_30963_8465# a_29702_7094# a_30817_8037# vss sky130_fd_pr__nfet_01v8_lvt ad=0.396 pd=2.73 as=0.744 ps=5.42 w=2.4 l=0.15
X826 a_18315_5509# a_18273_1814# a_16602_2574# vdd sky130_fd_pr__pfet_01v8_lvt ad=0.609 pd=4.78 as=0.609 ps=4.78 w=2.1 l=0.35
X827 a_28514_1816# vss sky130_fd_pr__cap_mim_m3_1 l=1.6 w=1.6
X828 a_30217_2855# a_29702_4274# a_29702_2574# vss sky130_fd_pr__nfet_01v8_lvt ad=0.396 pd=2.73 as=0.396 ps=2.73 w=2.4 l=0.15
X829 a_22127_12830# a_20828_12850# a_22507_12830# vdd sky130_fd_pr__pfet_01v8 ad=0.62 pd=4.62 as=0.33 ps=2.33 w=2 l=0.15
X830 a_2903_6310# a_5214_6300# vss sky130_fd_pr__res_high_po_0p69 l=1.5
X831 a_22795_6161# f5 a_13268_8794# vdd sky130_fd_pr__pfet_01v8_lvt ad=0.609 pd=4.78 as=0.609 ps=4.78 w=2.1 l=0.35
X832 vdd a_6063_2090# a_7935_2090# vdd sky130_fd_pr__pfet_01v8_lvt ad=0.3045 pd=2.39 as=0.3045 ps=2.39 w=2.1 l=0.35
X833 vdd a_18315_3741# a_20197_4220# vdd sky130_fd_pr__pfet_01v8 ad=0.527 pd=4.02 as=0.2805 ps=2.03 w=1.7 l=0.15
X834 vss a_13102_4274# a_13102_2574# vss sky130_fd_pr__nfet_01v8_lvt ad=0.527 pd=4.02 as=0.2805 ps=2.03 w=1.7 l=0.15
X835 a_18273_3298# f0 vss vss sky130_fd_pr__nfet_01v8 ad=0.1305 pd=1.48 as=0.1305 ps=1.48 w=0.45 l=0.18
X836 a_18719_3409# a_18273_3298# a_13268_4274# vdd sky130_fd_pr__pfet_01v8_lvt ad=0.609 pd=4.78 as=0.609 ps=4.78 w=2.1 l=0.35
X837 a_9381_11896# a_9999_11686# vss vss sky130_fd_pr__nfet_01v8_lvt ad=0.29 pd=2.58 as=0.29 ps=2.58 w=1 l=0.15
X838 vdd a_11270_13392# ckd3 vdd sky130_fd_pr__pfet_01v8 ad=0.93 pd=6.62 as=0.495 ps=3.33 w=3 l=0.15
X839 a_7935_6210# a2 a_11527_7375# vss sky130_fd_pr__nfet_01v8_lvt ad=0.2325 pd=2.12 as=0.12375 ps=1.08 w=0.75 l=0.15
X840 a_22437_9340# a_20555_10029# vdd vdd sky130_fd_pr__pfet_01v8 ad=0.2805 pd=2.03 as=0.527 ps=4.02 w=1.7 l=0.15
X841 a_29868_8794# a_29868_7094# a_30217_7375# vss sky130_fd_pr__nfet_01v8_lvt ad=0.396 pd=2.73 as=0.744 ps=5.42 w=2.4 l=0.15
X842 a_18315_5509# a_18273_1814# a_13102_2574# vss sky130_fd_pr__nfet_01v8_lvt ad=0.1885 pd=1.88 as=0.1885 ps=1.88 w=0.65 l=0.15
X843 a_6063_1490# a_5993_1373# vss sky130_fd_pr__res_high_po_0p35 l=9.5
X844 a_20555_3409# f2 a_16768_4274# vss sky130_fd_pr__nfet_01v8_lvt ad=0.1885 pd=1.88 as=0.1885 ps=1.88 w=0.65 l=0.15
X845 a_25439_5509# a_24993_1814# a_13102_2574# vdd sky130_fd_pr__pfet_01v8_lvt ad=0.609 pd=4.78 as=0.609 ps=4.78 w=2.1 l=0.35
X846 a_11270_13392# a_9381_11896# a_10522_11144# vss sky130_fd_pr__nfet_01v8_lvt ad=0.23925 pd=1.78 as=0.4495 ps=3.52 w=1.45 l=0.15
X847 a_11527_7375# a_11849_1934# a_7935_6210# vdd sky130_fd_pr__pfet_01v8_lvt ad=0.3335 pd=2.59 as=0.667 ps=5.18 w=2.3 l=0.35
X848 a_3663_2190# a_323_2160# vss vss sky130_fd_pr__nfet_01v8_lvt ad=0.319 pd=2.78 as=0.319 ps=2.78 w=1.1 l=0.15
X849 a_7935_6210# a_12237_1934# a_11527_4275# vdd sky130_fd_pr__pfet_01v8_lvt ad=0.667 pd=5.18 as=0.3335 ps=2.59 w=2.3 l=0.35
X850 a_5993_2064# a_5214_2048# sky130_fd_pr__cap_mim_m3_1 l=4.2 w=4.2
X851 vss a_30963_3945# en vss sky130_fd_pr__nfet_01v8_lvt ad=0.651 pd=4.82 as=0.3465 ps=2.43 w=2.1 l=0.15
X852 a_18550_13392# a_21667_12830# vdd vdd sky130_fd_pr__pfet_01v8 ad=0.5445 pd=3.63 as=1.023 ps=7.22 w=3.3 l=0.15
X853 vdd a_20959_7929# vdd vdd sky130_fd_pr__pfet_01v8 ad=0.2805 pd=2.03 as=0 ps=0 w=1.7 l=0.15
X854 a_23199_7929# a_22753_3298# a_13268_8794# vdd sky130_fd_pr__pfet_01v8_lvt ad=0.609 pd=4.78 as=0.609 ps=4.78 w=2.1 l=0.35
X855 a_18719_5509# a_18273_1814# a_16602_2574# vss sky130_fd_pr__nfet_01v8_lvt ad=0.1885 pd=1.88 as=0.1885 ps=1.88 w=0.65 l=0.15
X856 a_7935_1490# a6 a_11527_2855# vss sky130_fd_pr__nfet_01v8_lvt ad=0.2325 pd=2.12 as=0.12375 ps=1.08 w=0.75 l=0.15
X857 a_6063_1490# a_5993_1373# vss vss sky130_fd_pr__nfet_01v8_lvt ad=0.1815 pd=1.43 as=0.341 ps=2.82 w=1.1 l=0.15
X858 a_30963_7375# a_30963_8465# vdd vdd sky130_fd_pr__pfet_01v8 ad=0.2079 pd=1.59 as=0.2079 ps=1.59 w=1.26 l=0.15
X859 a_15027_8795# b1 a_7935_4450# vss sky130_fd_pr__nfet_01v8_lvt ad=0.12375 pd=1.08 as=0.2325 ps=2.12 w=0.75 l=0.15
X860 a_29702_7094# vss vdd vdd sky130_fd_pr__pfet_01v8 ad=0.3135 pd=2.23 as=0.589 ps=4.42 w=1.9 l=0.15
X861 a_30963_8465# a_30963_7375# vdd vdd sky130_fd_pr__pfet_01v8 ad=0.2079 pd=1.59 as=0.3906 ps=3.14 w=1.26 l=0.15
X862 vdd a_23199_5509# vdd vdd sky130_fd_pr__pfet_01v8 ad=0.2805 pd=2.03 as=0 ps=0 w=1.7 l=0.15
X863 a_7935_3850# b1 a_15027_7375# vss sky130_fd_pr__nfet_01v8_lvt ad=0.2325 pd=2.12 as=0.12375 ps=1.08 w=0.75 l=0.15
X864 a_25439_1641# f7 a_16768_4274# vdd sky130_fd_pr__pfet_01v8_lvt ad=0.609 pd=4.78 as=0.609 ps=4.78 w=2.1 l=0.35
X865 a_22795_3741# f4 a_16602_2574# vss sky130_fd_pr__nfet_01v8_lvt ad=0.1885 pd=1.88 as=0.1885 ps=1.88 w=0.65 l=0.15
X866 vdd a_11270_13392# vdd vdd sky130_fd_pr__pfet_01v8_lvt ad=0.464 pd=3.78 as=0 ps=0 w=1.6 l=0.35
X867 a_21277_11890# a_20347_11933# vdd vdd sky130_fd_pr__pfet_01v8 ad=0.4455 pd=3.03 as=0.837 ps=6.02 w=2.7 l=0.15
X868 a_20555_5509# a_20513_1814# a_16602_2574# vdd sky130_fd_pr__pfet_01v8_lvt ad=0.609 pd=4.78 as=0.609 ps=4.78 w=2.1 l=0.35
X869 vdd a_22795_3741# a_24677_4220# vdd sky130_fd_pr__pfet_01v8 ad=0.527 pd=4.02 as=0.2805 ps=2.03 w=1.7 l=0.15
X870 a_17675_12870# a_7218_11110# vss vss sky130_fd_pr__nfet_01v8 ad=0.29 pd=2.58 as=0.29 ps=2.58 w=1 l=0.18
X871 a_16802_11144# a_6858_11170# vdd vdd sky130_fd_pr__pfet_01v8 ad=0.522 pd=4.18 as=0.522 ps=4.18 w=1.8 l=0.18
X872 a_323_6880# in vdd vdd sky130_fd_pr__pfet_01v8_lvt ad=0.203 pd=1.69 as=0.406 ps=3.38 w=1.4 l=0.35
X873 a_6063_6810# a_5993_6784# vdd vdd sky130_fd_pr__pfet_01v8_lvt ad=0.3045 pd=2.39 as=0.3045 ps=2.39 w=2.1 l=0.35
X874 a_29702_7094# a_29868_8794# vdd vdd sky130_fd_pr__pfet_01v8 ad=0.2376 pd=1.77 as=0.4464 ps=3.5 w=1.44 l=0.15
X875 a_20555_3741# f2 a_13102_2574# vdd sky130_fd_pr__pfet_01v8_lvt ad=0.609 pd=4.78 as=0.609 ps=4.78 w=2.1 l=0.35
X876 vss a_24149_11800# cke1 vss sky130_fd_pr__nfet_01v8_lvt ad=0.372 pd=3.02 as=0.198 ps=1.53 w=1.2 l=0.15
X877 a_8701_12702# a_9381_11896# a_16802_11144# vdd sky130_fd_pr__pfet_01v8 ad=0.775 pd=5.62 as=0.4125 ps=2.83 w=2.5 l=0.15
X878 a_21667_12830# a_21941_11896# a_22497_11800# vss sky130_fd_pr__nfet_01v8_lvt ad=0.33 pd=2.33 as=0.62 ps=4.62 w=2 l=0.15
X879 a_18550_13392# a_21667_12830# vss vss sky130_fd_pr__nfet_01v8_lvt ad=0.2805 pd=2.03 as=0.527 ps=4.02 w=1.7 l=0.15
X880 a_11527_7375# a_12625_1934# a_7935_6810# vdd sky130_fd_pr__pfet_01v8_lvt ad=0.3335 pd=2.59 as=0.667 ps=5.18 w=2.3 l=0.35
X881 a_22437_4220# a_28514_3688# vss sky130_fd_pr__res_high_po_0p69 l=2.2
X882 a_25035_1641# a_24993_1814# a_13268_4274# vss sky130_fd_pr__nfet_01v8_lvt ad=0.1885 pd=1.88 as=0.1885 ps=1.88 w=0.65 l=0.15
X883 vss a_22497_11800# vss vss sky130_fd_pr__nfet_01v8_lvt ad=0.2465 pd=2.28 as=0 ps=0 w=0.85 l=0.15
X884 a_7935_4450# b7 a_15027_4275# vss sky130_fd_pr__nfet_01v8_lvt ad=0.2325 pd=2.12 as=0.12375 ps=1.08 w=0.75 l=0.15
X885 a_20959_3741# f2 a_16602_2574# vdd sky130_fd_pr__pfet_01v8_lvt ad=0.609 pd=4.78 as=0.609 ps=4.78 w=2.1 l=0.35
X886 a_15027_8795# b5 a_7935_3850# vss sky130_fd_pr__nfet_01v8_lvt ad=0.12375 pd=1.08 as=0.2325 ps=2.12 w=0.75 l=0.15
X887 vdd a_25439_7929# vdd vdd sky130_fd_pr__pfet_01v8 ad=0.2805 pd=2.03 as=0 ps=0 w=1.7 l=0.15
X888 a_16125_1934# b7 vdd vdd sky130_fd_pr__pfet_01v8 ad=0.261 pd=2.38 as=0.261 ps=2.38 w=0.9 l=0.18
X889 a_25439_1641# a_24993_1814# a_16768_4274# vss sky130_fd_pr__nfet_01v8_lvt ad=0.1885 pd=1.88 as=0.1885 ps=1.88 w=0.65 l=0.15
X890 a_23199_3409# f4 a_16768_4274# vdd sky130_fd_pr__pfet_01v8_lvt ad=0.609 pd=4.78 as=0.609 ps=4.78 w=2.1 l=0.35
X891 dp rst_n a_7787_11933# vss sky130_fd_pr__nfet_01v8_lvt ad=0.403 pd=3.22 as=0.2145 ps=1.63 w=1.3 l=0.15
X892 a_16802_11144# a_9381_11896# a_8701_12702# vdd sky130_fd_pr__pfet_01v8 ad=0.4125 pd=2.83 as=0.4125 ps=2.83 w=2.5 l=0.15
X893 a_22559_11686# a_27557_11890# vdd vdd sky130_fd_pr__pfet_01v8 ad=0.4356 pd=2.97 as=0.4356 ps=2.97 w=2.64 l=0.15
X894 a_30963_7375# a_29868_8794# a_30817_8037# vss sky130_fd_pr__nfet_01v8_lvt ad=0.396 pd=2.73 as=0.744 ps=5.42 w=2.4 l=0.15
X895 vdd a_20555_5509# a_22437_4820# vdd sky130_fd_pr__pfet_01v8 ad=0.527 pd=4.02 as=0.2805 ps=2.03 w=1.7 l=0.15
X896 a_30217_2855# a_29868_2574# a_29868_4274# vss sky130_fd_pr__nfet_01v8_lvt ad=0.396 pd=2.73 as=0.396 ps=2.73 w=2.4 l=0.15
X897 a_6063_8570# a_5993_8453# vdd vdd sky130_fd_pr__pfet_01v8_lvt ad=0.3045 pd=2.39 as=0.3045 ps=2.39 w=2.1 l=0.35
X898 a_6063_6810# a_5993_6784# vss sky130_fd_pr__res_high_po_0p35 l=9.5
X899 a_20555_8261# a_20513_3298# a_13102_7094# vss sky130_fd_pr__nfet_01v8_lvt ad=0.1885 pd=1.88 as=0.1885 ps=1.88 w=0.65 l=0.15
X900 vdd a_323_4520# a_2903_9270# vdd sky130_fd_pr__pfet_01v8_lvt ad=0.1595 pd=1.39 as=0.1595 ps=1.39 w=1.1 l=0.35
X901 a_7935_1490# a4 a_11527_8795# vss sky130_fd_pr__nfet_01v8_lvt ad=0.2325 pd=2.12 as=0.12375 ps=1.08 w=0.75 l=0.15
X902 a_22507_12830# a_22559_11686# a_24149_11800# vdd sky130_fd_pr__pfet_01v8 ad=0.594 pd=3.93 as=0.594 ps=3.93 w=3.6 l=0.15
X903 a_22795_10029# f5 a_16602_7094# vss sky130_fd_pr__nfet_01v8_lvt ad=0.1885 pd=1.88 as=0.1885 ps=1.88 w=0.65 l=0.15
X904 a_16768_8794# a_16768_7094# vss sky130_fd_pr__res_high_po_0p35 l=6.5
X905 a_20959_8261# a_20513_3298# a_16602_7094# vss sky130_fd_pr__nfet_01v8_lvt ad=0.1885 pd=1.88 as=0.1885 ps=1.88 w=0.65 l=0.15
X906 ep a_30963_2855# vdd vdd sky130_fd_pr__pfet_01v8 ad=0.495 pd=3.33 as=0.93 ps=6.62 w=3 l=0.15
X907 vdd a_23199_8261# vdd vdd sky130_fd_pr__pfet_01v8 ad=0.527 pd=4.02 as=0 ps=0 w=1.7 l=0.15
X908 a_17910_13392# a_18550_13392# vss vss sky130_fd_pr__nfet_01v8_lvt ad=0.1885 pd=1.88 as=0.1885 ps=1.88 w=0.65 l=0.15
X909 a_23199_10029# f5 a_13102_7094# vss sky130_fd_pr__nfet_01v8_lvt ad=0.1885 pd=1.88 as=0.1885 ps=1.88 w=0.65 l=0.15
X910 vss a_17910_13392# cke0 vss sky130_fd_pr__nfet_01v8_lvt ad=0.372 pd=3.02 as=0.198 ps=1.53 w=1.2 l=0.15
X911 a_6858_11170# a_6211_11960# vdd vdd sky130_fd_pr__pfet_01v8 ad=0.435 pd=3.58 as=0.435 ps=3.58 w=1.5 l=0.18
X912 a_18550_13392# a_17910_13392# vss vss sky130_fd_pr__nfet_01v8_lvt ad=0.1885 pd=1.88 as=0.1885 ps=1.88 w=0.65 l=0.15
X913 vdd a_6063_9170# a_7935_9170# vdd sky130_fd_pr__pfet_01v8_lvt ad=0.3045 pd=2.39 as=0.3045 ps=2.39 w=2.1 l=0.35
X914 vdd a_25035_10029# a_26917_9340# vdd sky130_fd_pr__pfet_01v8 ad=0.527 pd=4.02 as=0.2805 ps=2.03 w=1.7 l=0.15
X915 dp dn vdd vdd sky130_fd_pr__pfet_01v8 ad=0.3135 pd=2.23 as=0.589 ps=4.42 w=1.9 l=0.15
X916 a_10522_11144# a_6858_11170# vdd vdd sky130_fd_pr__pfet_01v8 ad=0.522 pd=4.18 as=0.522 ps=4.18 w=1.8 l=0.18
X917 vdd a_323_2160# a_3663_2190# vdd sky130_fd_pr__pfet_01v8_lvt ad=0.319 pd=2.78 as=0.1595 ps=1.39 w=1.1 l=0.35
X918 a_7935_2090# a_6063_2090# vdd vdd sky130_fd_pr__pfet_01v8_lvt ad=0.3045 pd=2.39 as=0.609 ps=4.78 w=2.1 l=0.35
X919 ckd1 a_9937_11910# vss vss sky130_fd_pr__nfet_01v8_lvt ad=0.198 pd=1.53 as=0.372 ps=3.02 w=1.2 l=0.15
X920 a_20828_12850# a_20458_12920# vdd vdd sky130_fd_pr__pfet_01v8 ad=0.522 pd=4.18 as=0.522 ps=4.18 w=1.8 l=0.18
X921 a_11270_13392# a_9999_11686# a_10522_11144# vdd sky130_fd_pr__pfet_01v8 ad=0.775 pd=5.62 as=0.4125 ps=2.83 w=2.5 l=0.15
X922 vss a_20959_8261# vss vss sky130_fd_pr__nfet_01v8_lvt ad=0.203 pd=1.98 as=0 ps=0 w=0.7 l=0.15
X923 a_26627_11933# rst_n vdd vdd sky130_fd_pr__pfet_01v8 ad=0.464 pd=3.78 as=0.464 ps=3.78 w=1.6 l=0.18
X924 a_15027_8795# a_15349_1934# a_7935_9170# vdd sky130_fd_pr__pfet_01v8_lvt ad=0.3335 pd=2.59 as=0.667 ps=5.18 w=2.3 l=0.35
X925 a_13268_8794# a_13268_7094# vdd vdd sky130_fd_pr__pfet_01v8 ad=0.462 pd=3.13 as=0.868 ps=6.22 w=2.8 l=0.15
X926 a_3663_9270# a_323_6880# vss vss sky130_fd_pr__nfet_01v8_lvt ad=0.319 pd=2.78 as=0.319 ps=2.78 w=1.1 l=0.15
X927 a_25035_7929# f6 a_16768_8794# vss sky130_fd_pr__nfet_01v8_lvt ad=0.1885 pd=1.88 as=0.1885 ps=1.88 w=0.65 l=0.15
X928 a_20555_7929# f2 a_13268_8794# vdd sky130_fd_pr__pfet_01v8_lvt ad=0.609 pd=4.78 as=0.609 ps=4.78 w=2.1 l=0.35
X929 a_6063_8570# a_5993_8453# vss vss sky130_fd_pr__nfet_01v8_lvt ad=0.1815 pd=1.43 as=0.341 ps=2.82 w=1.1 l=0.15
X930 a_7935_6210# a_6063_6210# vdd vdd sky130_fd_pr__pfet_01v8_lvt ad=0.3045 pd=2.39 as=0.3045 ps=2.39 w=2.1 l=0.35
X931 a_20959_7929# f2 a_16768_8794# vdd sky130_fd_pr__pfet_01v8_lvt ad=0.609 pd=4.78 as=0.609 ps=4.78 w=2.1 l=0.35
X932 vdd a_10522_11144# a_10451_12702# vdd sky130_fd_pr__pfet_01v8 ad=0.5445 pd=3.63 as=0.5445 ps=3.63 w=3.3 l=0.15
X933 a_24677_6640# a_28514_6336# vss sky130_fd_pr__res_high_po_0p69 l=2.2
X934 vdd a_5993_2064# a_6063_2090# vdd sky130_fd_pr__pfet_01v8_lvt ad=0.3045 pd=2.39 as=0.3045 ps=2.39 w=2.1 l=0.35
X935 a_20197_8740# a_18315_8261# vss vss sky130_fd_pr__nfet_01v8_lvt ad=0.203 pd=1.98 as=0.203 ps=1.98 w=0.7 l=0.15
X936 a_7935_4450# a_15737_1934# a_15027_7375# vdd sky130_fd_pr__pfet_01v8_lvt ad=0.667 pd=5.18 as=0.3335 ps=2.59 w=2.3 l=0.35
X937 a_25035_6161# a_24993_1814# a_16768_8794# vdd sky130_fd_pr__pfet_01v8_lvt ad=0.609 pd=4.78 as=0.609 ps=4.78 w=2.1 l=0.35
X938 a_7935_4450# a_7935_3850# vss vss sky130_fd_pr__nfet_01v8_lvt ad=0.1305 pd=1.48 as=0.1305 ps=1.48 w=0.45 l=0.15
X939 a_16602_2574# a_16602_4274# vss vss sky130_fd_pr__nfet_01v8_lvt ad=0.2805 pd=2.03 as=0.527 ps=4.02 w=1.7 l=0.15
X940 vdd a_24149_11800# cke1 vdd sky130_fd_pr__pfet_01v8 ad=0.495 pd=3.33 as=0.495 ps=3.33 w=3 l=0.15
X941 a_15027_7375# b3 a_7935_8570# vss sky130_fd_pr__nfet_01v8_lvt ad=0.12375 pd=1.08 as=0.2325 ps=2.12 w=0.75 l=0.15
X942 a_16125_1934# b7 vss vss sky130_fd_pr__nfet_01v8 ad=0.1305 pd=1.48 as=0.1305 ps=1.48 w=0.45 l=0.18
X943 a_18187_12870# a_18550_13392# vdd vdd sky130_fd_pr__pfet_01v8_lvt ad=0.464 pd=3.78 as=0.464 ps=3.78 w=1.6 l=0.35
X944 a_26917_8740# a_25035_8261# vdd vdd sky130_fd_pr__pfet_01v8 ad=0.2805 pd=2.03 as=0.527 ps=4.02 w=1.7 l=0.15
X945 a_2903_3950# a_5214_3940# vss sky130_fd_pr__res_high_po_0p69 l=1.5
X946 vdd rst_n a_6211_11960# vdd sky130_fd_pr__pfet_01v8 ad=0.62 pd=4.62 as=0.33 ps=2.33 w=2 l=0.15
X947 a_15027_8795# a_16125_1934# a_7935_8570# vdd sky130_fd_pr__pfet_01v8_lvt ad=0.3335 pd=2.59 as=0.667 ps=5.18 w=2.3 l=0.35
X948 a_29702_8794# a_29702_7094# vss sky130_fd_pr__res_high_po_0p35 l=6.5
X949 vss a_6063_4450# a_7935_4450# vss sky130_fd_pr__nfet_01v8_lvt ad=0.527 pd=4.02 as=0.2805 ps=2.03 w=1.7 l=0.15
X950 a_22507_12830# a_20458_12920# a_22175_13580# vss sky130_fd_pr__nfet_01v8_lvt ad=0.377 pd=3.18 as=0.377 ps=3.18 w=1.3 l=0.15
X951 vdd a_18315_6161# a_20197_6640# vdd sky130_fd_pr__pfet_01v8 ad=0.527 pd=4.02 as=0.2805 ps=2.03 w=1.7 l=0.15
X952 a_22507_12830# a_21941_11896# a_24149_11800# vss sky130_fd_pr__nfet_01v8_lvt ad=0.62 pd=4.62 as=0.33 ps=2.33 w=2 l=0.15
X953 vss a_9937_11910# vss vss sky130_fd_pr__nfet_01v8 ad=0.1218 pd=1.42 as=0 ps=0 w=0.42 l=0.5
X954 vdd a_18719_10029# vdd vdd sky130_fd_pr__pfet_01v8 ad=0.527 pd=4.02 as=0 ps=0 w=1.7 l=0.15
X955 a_18315_7929# a_18273_3298# a_13268_8794# vss sky130_fd_pr__nfet_01v8_lvt ad=0.1885 pd=1.88 as=0.1885 ps=1.88 w=0.65 l=0.15
X956 a_6063_6210# a_5993_6093# vss sky130_fd_pr__res_high_po_0p35 l=9.5
X957 vdd a_18719_1641# vdd vdd sky130_fd_pr__pfet_01v8 ad=0.2805 pd=2.03 as=0 ps=0 w=1.7 l=0.15
X958 a_18719_7929# a_18273_3298# a_16768_8794# vss sky130_fd_pr__nfet_01v8_lvt ad=0.1885 pd=1.88 as=0.1885 ps=1.88 w=0.65 l=0.15
X959 a_7787_11933# a_6211_11960# dp vdd sky130_fd_pr__pfet_01v8_lvt ad=0.6583 pd=5.12 as=0.32915 ps=2.56 w=2.27 l=0.35
X960 a_24677_9340# a_22795_10029# vss vss sky130_fd_pr__nfet_01v8_lvt ad=0.203 pd=1.98 as=0.203 ps=1.98 w=0.7 l=0.15
X961 vdd a_13102_8794# a_13102_7094# vdd sky130_fd_pr__pfet_01v8 ad=0.462 pd=3.13 as=0.462 ps=3.13 w=2.8 l=0.15
X962 a_15027_7375# b7 a_7935_9170# vss sky130_fd_pr__nfet_01v8_lvt ad=0.12375 pd=1.08 as=0.2325 ps=2.12 w=0.75 l=0.15
X963 a_18315_6161# f1 a_13268_8794# vdd sky130_fd_pr__pfet_01v8_lvt ad=0.609 pd=4.78 as=0.609 ps=4.78 w=2.1 l=0.35
X964 a_7935_3850# a_6063_3850# vdd vdd sky130_fd_pr__pfet_01v8_lvt ad=0.3045 pd=2.39 as=0.3045 ps=2.39 w=2.1 l=0.35
X965 a_6063_6210# a_5993_6093# vss vss sky130_fd_pr__nfet_01v8_lvt ad=0.1815 pd=1.43 as=0.341 ps=2.82 w=1.1 l=0.15
X966 a_323_4520# qp vdd vdd sky130_fd_pr__pfet_01v8_lvt ad=0.203 pd=1.69 as=0.203 ps=1.69 w=1.4 l=0.35
X967 vdd vss a_29702_2574# vdd sky130_fd_pr__pfet_01v8 ad=0.589 pd=4.42 as=0.3135 ps=2.23 w=1.9 l=0.15
X968 ckd1 ckd3 vss vss sky130_fd_pr__nfet_01v8_lvt ad=0.1305 pd=1.48 as=0.1305 ps=1.48 w=0.45 l=0.15
X969 vss a_20959_5509# vss vss sky130_fd_pr__nfet_01v8_lvt ad=0.203 pd=1.98 as=0 ps=0 w=0.7 l=0.15
X970 a_27557_11890# a_26627_11933# vdd vdd sky130_fd_pr__pfet_01v8 ad=0.4455 pd=3.03 as=0.837 ps=6.02 w=2.7 l=0.15
X971 a_25439_8261# f6 a_16602_7094# vdd sky130_fd_pr__pfet_01v8_lvt ad=0.609 pd=4.78 as=0.609 ps=4.78 w=2.1 l=0.35
X972 a_18719_6161# f1 a_16768_8794# vdd sky130_fd_pr__pfet_01v8_lvt ad=0.609 pd=4.78 as=0.609 ps=4.78 w=2.1 l=0.35
X973 a_20959_3741# f2 a_13102_2574# vss sky130_fd_pr__nfet_01v8_lvt ad=0.1885 pd=1.88 as=0.1885 ps=1.88 w=0.65 l=0.15
X974 a_18550_13392# a_21941_11896# a_29327_12830# vdd sky130_fd_pr__pfet_01v8 ad=0.594 pd=3.93 as=1.116 ps=7.82 w=3.6 l=0.15
X975 vdd a_22795_6161# a_24677_6640# vdd sky130_fd_pr__pfet_01v8 ad=0.527 pd=4.02 as=0.2805 ps=2.03 w=1.7 l=0.15
X976 a_6063_4450# a_5993_4424# vdd vdd sky130_fd_pr__pfet_01v8_lvt ad=0.3045 pd=2.39 as=0.3045 ps=2.39 w=2.1 l=0.35
X977 a_18315_10029# a_18273_1814# a_13102_7094# vss sky130_fd_pr__nfet_01v8_lvt ad=0.1885 pd=1.88 as=0.1885 ps=1.88 w=0.65 l=0.15
X978 a_7935_4450# b3 a_15027_2855# vss sky130_fd_pr__nfet_01v8_lvt ad=0.2325 pd=2.12 as=0.12375 ps=1.08 w=0.75 l=0.15
X979 vdd vss a_30963_2855# vdd sky130_fd_pr__pfet_01v8 ad=0.2607 pd=1.91 as=0.2607 ps=1.91 w=1.58 l=0.15
X980 a_13102_8794# a_13102_7094# vss sky130_fd_pr__res_high_po_0p35 l=6.5
X981 a_30817_3517# a_29702_2574# a_30963_3945# vss sky130_fd_pr__nfet_01v8_lvt ad=0.396 pd=2.73 as=0.396 ps=2.73 w=2.4 l=0.15
X982 a_22437_4220# a_20555_3741# vdd vdd sky130_fd_pr__pfet_01v8 ad=0.2805 pd=2.03 as=0.527 ps=4.02 w=1.7 l=0.15
X983 a_20197_4820# a_18315_5509# vss vss sky130_fd_pr__nfet_01v8_lvt ad=0.203 pd=1.98 as=0.203 ps=1.98 w=0.7 l=0.15
X984 vss a_6063_2090# a_7935_2090# vss sky130_fd_pr__nfet_01v8_lvt ad=0.527 pd=4.02 as=0.2805 ps=2.03 w=1.7 l=0.15
X985 a_15027_2855# a_15349_1934# a_7935_4450# vdd sky130_fd_pr__pfet_01v8_lvt ad=0.3335 pd=2.59 as=0.667 ps=5.18 w=2.3 l=0.35
X986 vdd a_20959_10029# vdd vdd sky130_fd_pr__pfet_01v8 ad=0.527 pd=4.02 as=0 ps=0 w=1.7 l=0.15
X987 a_13102_2574# a_13102_4274# vdd vdd sky130_fd_pr__pfet_01v8_lvt ad=0.406 pd=3.09 as=0.812 ps=6.18 w=2.8 l=0.35
X988 vdd a_20959_1641# vdd vdd sky130_fd_pr__pfet_01v8 ad=0.2805 pd=2.03 as=0 ps=0 w=1.7 l=0.15
X989 a_20959_10029# a_20513_1814# a_16602_7094# vss sky130_fd_pr__nfet_01v8_lvt ad=0.1885 pd=1.88 as=0.1885 ps=1.88 w=0.65 l=0.15
X990 a_7935_9170# a_6063_9170# vdd vdd sky130_fd_pr__pfet_01v8_lvt ad=0.3045 pd=2.39 as=0.609 ps=4.78 w=2.1 l=0.35
X991 a_16768_4274# a_16768_2574# vdd vdd sky130_fd_pr__pfet_01v8_lvt ad=0.406 pd=3.09 as=0.812 ps=6.18 w=2.8 l=0.35
X992 a_18315_3741# f0 a_16602_2574# vss sky130_fd_pr__nfet_01v8_lvt ad=0.1885 pd=1.88 as=0.1885 ps=1.88 w=0.65 l=0.15
X993 ckd0 a_8701_12702# vdd vdd sky130_fd_pr__pfet_01v8 ad=0.495 pd=3.33 as=0.93 ps=6.62 w=3 l=0.15
X994 a_10522_11144# a_9381_11896# a_11270_13392# vss sky130_fd_pr__nfet_01v8_lvt ad=0.4495 pd=3.52 as=0.23925 ps=1.78 w=1.45 l=0.15
X995 vdd a_323_6880# a_3663_9270# vdd sky130_fd_pr__pfet_01v8_lvt ad=0.319 pd=2.78 as=0.1595 ps=1.39 w=1.1 l=0.35
X996 a_5993_8453# a_5214_8660# sky130_fd_pr__cap_mim_m3_1 l=4.2 w=4.2
X997 a_6211_11960# rst_n vss vss sky130_fd_pr__nfet_01v8_lvt ad=0.165 pd=1.33 as=0.31 ps=2.62 w=1 l=0.15
X998 a_23199_6161# f5 a_13268_8794# vss sky130_fd_pr__nfet_01v8_lvt ad=0.1885 pd=1.88 as=0.1885 ps=1.88 w=0.65 l=0.15
X999 a_18719_1641# f1 a_13268_4274# vss sky130_fd_pr__nfet_01v8_lvt ad=0.1885 pd=1.88 as=0.1885 ps=1.88 w=0.65 l=0.15
X1000 a_23199_5509# a_22753_1814# a_13102_2574# vdd sky130_fd_pr__pfet_01v8_lvt ad=0.609 pd=4.78 as=0.609 ps=4.78 w=2.1 l=0.35
X1001 a_25439_3741# f6 a_13102_2574# vss sky130_fd_pr__nfet_01v8_lvt ad=0.1885 pd=1.88 as=0.1885 ps=1.88 w=0.65 l=0.15
X1002 vdd a_10029_11910# a_8701_12702# vdd sky130_fd_pr__pfet_01v8 ad=0.5445 pd=3.63 as=0.5445 ps=3.63 w=3.3 l=0.15
X1003 a_7935_6810# a2 a_11527_8795# vss sky130_fd_pr__nfet_01v8_lvt ad=0.2325 pd=2.12 as=0.12375 ps=1.08 w=0.75 l=0.15
X1004 a_20197_9340# a_18315_10029# vdd vdd sky130_fd_pr__pfet_01v8 ad=0.2805 pd=2.03 as=0.527 ps=4.02 w=1.7 l=0.15
X1005 a_13102_2574# a_13102_4274# vdd vdd sky130_fd_pr__pfet_01v8 ad=0.462 pd=3.13 as=0.462 ps=3.13 w=2.8 l=0.15
X1006 a_30817_3517# vdd vss vss sky130_fd_pr__nfet_01v8 ad=0.17835 pd=1.52 as=0.17835 ps=1.52 w=1.23 l=0.2
X1007 vdd a_30963_2855# a_30963_3945# vdd sky130_fd_pr__pfet_01v8 ad=0.2079 pd=1.59 as=0.2079 ps=1.59 w=1.26 l=0.15
X1008 vdd a_5993_9144# a_6063_9170# vdd sky130_fd_pr__pfet_01v8_lvt ad=0.3045 pd=2.39 as=0.3045 ps=2.39 w=2.1 l=0.35
X1009 vdd a_6063_6210# a_7935_6210# vdd sky130_fd_pr__pfet_01v8_lvt ad=0.3045 pd=2.39 as=0.3045 ps=2.39 w=2.1 l=0.35
X1010 vdd a_20347_11933# a_21277_11890# vdd sky130_fd_pr__pfet_01v8 ad=0.837 pd=6.02 as=0.4455 ps=3.03 w=2.7 l=0.15
X1011 a_15027_2855# a_16125_1934# a_7935_3850# vdd sky130_fd_pr__pfet_01v8_lvt ad=0.3335 pd=2.59 as=0.667 ps=5.18 w=2.3 l=0.35
X1012 ckd2 ckd0 vdd vdd sky130_fd_pr__pfet_01v8 ad=0.6264 pd=4.9 as=0.6264 ps=4.9 w=2.16 l=0.15
X1013 a_2903_6310# a_323_9240# vdd vdd sky130_fd_pr__pfet_01v8_lvt ad=0.1595 pd=1.39 as=0.1595 ps=1.39 w=1.1 l=0.35
X1014 vdd a_25439_10029# vdd vdd sky130_fd_pr__pfet_01v8 ad=0.527 pd=4.02 as=0 ps=0 w=1.7 l=0.15
X1015 ep a_30963_2855# vss vss sky130_fd_pr__nfet_01v8_lvt ad=0.3465 pd=2.43 as=0.651 ps=4.82 w=2.1 l=0.15
X1016 vdd a_25439_1641# vdd vdd sky130_fd_pr__pfet_01v8 ad=0.2805 pd=2.03 as=0 ps=0 w=1.7 l=0.15
X1017 vdd a_8701_12702# ckd0 vdd sky130_fd_pr__pfet_01v8 ad=0.495 pd=3.33 as=0.495 ps=3.33 w=3 l=0.15
X1018 a_22497_11800# a_21941_11896# a_21667_12830# vss sky130_fd_pr__nfet_01v8_lvt ad=0.62 pd=4.62 as=0.33 ps=2.33 w=2 l=0.15
X1019 vss a_21667_12830# a_18550_13392# vss sky130_fd_pr__nfet_01v8_lvt ad=0.527 pd=4.02 as=0.2805 ps=2.03 w=1.7 l=0.15
X1020 vdd a_13268_2574# a_13268_4274# vdd sky130_fd_pr__pfet_01v8 ad=0.868 pd=6.22 as=0.462 ps=3.13 w=2.8 l=0.15
X1021 vdd a_22497_11800# vdd vdd sky130_fd_pr__pfet_01v8_lvt ad=0.464 pd=3.78 as=0 ps=0 w=1.6 l=0.35
X1022 a_7218_11110# a_6858_11170# vss vss sky130_fd_pr__nfet_01v8 ad=0.348 pd=2.98 as=0.348 ps=2.98 w=1.2 l=0.18
X1023 a_7935_4450# b1 a_15027_8795# vss sky130_fd_pr__nfet_01v8_lvt ad=0.2325 pd=2.12 as=0.12375 ps=1.08 w=0.75 l=0.15
X1024 vss a_16768_7094# a_16768_8794# vss sky130_fd_pr__nfet_01v8_lvt ad=0.527 pd=4.02 as=0.2805 ps=2.03 w=1.7 l=0.15
X1025 a_6858_11170# a_6211_11960# vss vss sky130_fd_pr__nfet_01v8 ad=0.174 pd=1.78 as=0.174 ps=1.78 w=0.6 l=0.18
X1026 a_18719_10029# a_18273_1814# a_13102_7094# vdd sky130_fd_pr__pfet_01v8_lvt ad=0.609 pd=4.78 as=0.609 ps=4.78 w=2.1 l=0.35
X1027 a_25035_6161# f7 a_13268_8794# vdd sky130_fd_pr__pfet_01v8_lvt ad=0.609 pd=4.78 as=0.609 ps=4.78 w=2.1 l=0.35
X1028 a_25035_5509# a_24993_1814# a_13102_2574# vss sky130_fd_pr__nfet_01v8_lvt ad=0.1885 pd=1.88 as=0.1885 ps=1.88 w=0.65 l=0.15
X1029 a_22795_1641# a_22753_1814# a_16768_4274# vdd sky130_fd_pr__pfet_01v8_lvt ad=0.609 pd=4.78 as=0.609 ps=4.78 w=2.1 l=0.35
X1030 a_20555_3741# f2 a_16602_2574# vss sky130_fd_pr__nfet_01v8_lvt ad=0.1885 pd=1.88 as=0.1885 ps=1.88 w=0.65 l=0.15
X1031 a_25439_5509# a_24993_1814# a_16602_2574# vss sky130_fd_pr__nfet_01v8_lvt ad=0.1885 pd=1.88 as=0.1885 ps=1.88 w=0.65 l=0.15
X1032 vdd a_30963_2855# ep vdd sky130_fd_pr__pfet_01v8_lvt ad=0.812 pd=6.18 as=0.406 ps=3.09 w=2.8 l=0.35
X1033 a_3663_6910# a_323_4520# vss vss sky130_fd_pr__nfet_01v8_lvt ad=0.319 pd=2.78 as=0.319 ps=2.78 w=1.1 l=0.15
X1034 a_24677_9340# a_22795_10029# vdd vdd sky130_fd_pr__pfet_01v8 ad=0.2805 pd=2.03 as=0.527 ps=4.02 w=1.7 l=0.15
X1035 vss vdd a_30817_8037# vss sky130_fd_pr__nfet_01v8 ad=0.3567 pd=3.04 as=0.17835 ps=1.52 w=1.23 l=0.2
X1036 vdd a_10451_12702# ckd2 vdd sky130_fd_pr__pfet_01v8 ad=0.93 pd=6.62 as=0.495 ps=3.33 w=3 l=0.15
X1037 a_15027_8795# a_14961_1934# a_7935_4450# vdd sky130_fd_pr__pfet_01v8_lvt ad=0.3335 pd=2.59 as=0.667 ps=5.18 w=2.3 l=0.35
X1038 a_13102_8794# a_11527_8795# sky130_fd_pr__cap_mim_m3_1 l=4.2 w=4.3
X1039 a_30817_3517# a_29868_4274# a_30963_2855# vss sky130_fd_pr__nfet_01v8_lvt ad=0.396 pd=2.73 as=0.396 ps=2.73 w=2.4 l=0.15
X1040 a_20197_4220# a_28514_3688# vss sky130_fd_pr__res_high_po_0p69 l=2.2
X1041 vdd a_23199_7929# vdd vdd sky130_fd_pr__pfet_01v8 ad=0.2805 pd=2.03 as=0 ps=0 w=1.7 l=0.15
X1042 a_15027_2855# b1 a_7935_8570# vss sky130_fd_pr__nfet_01v8_lvt ad=0.12375 pd=1.08 as=0.2325 ps=2.12 w=0.75 l=0.15
X1043 a_23199_1641# a_22753_1814# a_16768_4274# vss sky130_fd_pr__nfet_01v8_lvt ad=0.1885 pd=1.88 as=0.1885 ps=1.88 w=0.65 l=0.15
X1044 a_24149_11800# a_22559_11686# a_22507_12830# vdd sky130_fd_pr__pfet_01v8 ad=1.116 pd=7.82 as=0.594 ps=3.93 w=3.6 l=0.15
X1045 a_22795_6161# f5 a_16768_8794# vss sky130_fd_pr__nfet_01v8_lvt ad=0.1885 pd=1.88 as=0.1885 ps=1.88 w=0.65 l=0.15
X1046 a_15027_4275# a_15737_1934# a_7935_8570# vdd sky130_fd_pr__pfet_01v8_lvt ad=0.3335 pd=2.59 as=0.667 ps=5.18 w=2.3 l=0.35
X1047 a_323_4520# vss sky130_fd_pr__cap_mim_m3_1 l=1.75 w=1.75
X1048 a_3663_6310# a_323_9240# vdd vdd sky130_fd_pr__pfet_01v8_lvt ad=0.1595 pd=1.39 as=0.319 ps=2.78 w=1.1 l=0.35
X1049 vdd a_6063_3850# a_7935_3850# vdd sky130_fd_pr__pfet_01v8_lvt ad=0.3045 pd=2.39 as=0.3045 ps=2.39 w=2.1 l=0.35
X1050 vdd a_18315_5509# a_20197_4820# vdd sky130_fd_pr__pfet_01v8 ad=0.527 pd=4.02 as=0.2805 ps=2.03 w=1.7 l=0.15
X1051 a_24677_4220# a_28514_3688# vss sky130_fd_pr__res_high_po_0p69 l=2.2
X1052 a_26917_7240# a_28514_6336# vss sky130_fd_pr__res_high_po_0p69 l=2.2
X1053 dn a_30963_8465# vdd vdd sky130_fd_pr__pfet_01v8 ad=0.495 pd=3.33 as=0.495 ps=3.33 w=3 l=0.15
X1054 vdd vss a_30963_7375# vdd sky130_fd_pr__pfet_01v8 ad=0.4898 pd=3.78 as=0.2607 ps=1.91 w=1.58 l=0.15
X1055 a_2903_3950# a_323_6880# vdd vdd sky130_fd_pr__pfet_01v8_lvt ad=0.1595 pd=1.39 as=0.1595 ps=1.39 w=1.1 l=0.35
X1056 a_20555_3409# a_20513_3298# a_13268_4274# vss sky130_fd_pr__nfet_01v8_lvt ad=0.1885 pd=1.88 as=0.1885 ps=1.88 w=0.65 l=0.15
X1057 vdd a_25035_3741# a_26917_4220# vdd sky130_fd_pr__pfet_01v8 ad=0.527 pd=4.02 as=0.2805 ps=2.03 w=1.7 l=0.15
X1058 a_22795_3741# f4 a_13102_2574# vdd sky130_fd_pr__pfet_01v8_lvt ad=0.609 pd=4.78 as=0.609 ps=4.78 w=2.1 l=0.35
X1059 a_2903_8670# a_5214_8660# vss sky130_fd_pr__res_high_po_0p69 l=1.5
X1060 a_14528_205# a7 vdd vdd sky130_fd_pr__pfet_01v8 ad=0.261 pd=2.38 as=0.261 ps=2.38 w=0.9 l=0.18
X1061 a_16768_4274# a_16768_2574# vdd vdd sky130_fd_pr__pfet_01v8 ad=0.462 pd=3.13 as=0.868 ps=6.22 w=2.8 l=0.15
X1062 a_20959_3409# a_20513_3298# a_16768_4274# vss sky130_fd_pr__nfet_01v8_lvt ad=0.1885 pd=1.88 as=0.1885 ps=1.88 w=0.65 l=0.15
X1063 vss a_6063_9170# a_7935_9170# vss sky130_fd_pr__nfet_01v8_lvt ad=0.527 pd=4.02 as=0.2805 ps=2.03 w=1.7 l=0.15
X1064 a_23199_10029# f5 a_16602_7094# vdd sky130_fd_pr__pfet_01v8_lvt ad=0.609 pd=4.78 as=0.609 ps=4.78 w=2.1 l=0.35
X1065 a_15027_2855# b5 a_7935_9170# vss sky130_fd_pr__nfet_01v8_lvt ad=0.12375 pd=1.08 as=0.2325 ps=2.12 w=0.75 l=0.15
X1066 vss a_9937_11910# ckd1 vss sky130_fd_pr__nfet_01v8_lvt ad=0.372 pd=3.02 as=0.198 ps=1.53 w=1.2 l=0.15
X1067 a_9381_11896# a_8717_11890# vdd vdd sky130_fd_pr__pfet_01v8 ad=0.4356 pd=2.97 as=0.8184 ps=5.9 w=2.64 l=0.15
X1068 a_7935_1490# a0 a_11527_7375# vss sky130_fd_pr__nfet_01v8_lvt ad=0.2325 pd=2.12 as=0.12375 ps=1.08 w=0.75 l=0.15
X1069 vdd a_20555_7929# a_22437_7240# vdd sky130_fd_pr__pfet_01v8 ad=0.527 pd=4.02 as=0.2805 ps=2.03 w=1.7 l=0.15
X1070 vdd a_30963_7375# dp vdd sky130_fd_pr__pfet_01v8 ad=0.495 pd=3.33 as=0.495 ps=3.33 w=3 l=0.15
X1071 a_25439_3409# f6 a_16768_4274# vdd sky130_fd_pr__pfet_01v8_lvt ad=0.609 pd=4.78 as=0.609 ps=4.78 w=2.1 l=0.35
X1072 a_17910_13392# a_18550_13392# vdd vdd sky130_fd_pr__pfet_01v8 ad=0.7975 pd=6.08 as=0.7975 ps=6.08 w=2.75 l=0.15
X1073 a_10522_11144# a_10029_11910# vdd vdd sky130_fd_pr__pfet_01v8 ad=0.174 pd=1.78 as=0.174 ps=1.78 w=0.6 l=0.28
X1074 a_18550_13392# a_17910_13392# vdd vdd sky130_fd_pr__pfet_01v8 ad=0.7975 pd=6.08 as=0.7975 ps=6.08 w=2.75 l=0.15
X1075 vdd a_29327_12830# a_24149_11800# vdd sky130_fd_pr__pfet_01v8 ad=1.023 pd=7.22 as=0.5445 ps=3.63 w=3.3 l=0.15
X1076 a_7935_1490# a_6063_1490# vdd vdd sky130_fd_pr__pfet_01v8_lvt ad=0.3045 pd=2.39 as=0.3045 ps=2.39 w=2.1 l=0.35
X1077 vdd a_22795_5509# a_24677_4820# vdd sky130_fd_pr__pfet_01v8 ad=0.527 pd=4.02 as=0.2805 ps=2.03 w=1.7 l=0.15
X1078 ckd1 a_9937_11910# vdd vdd sky130_fd_pr__pfet_01v8 ad=0.495 pd=3.33 as=0.93 ps=6.62 w=3 l=0.15
X1079 a_323_2160# ip vdd vdd sky130_fd_pr__pfet_01v8_lvt ad=0.203 pd=1.69 as=0.203 ps=1.69 w=1.4 l=0.35
X1080 a_7935_6810# a4 a_11527_2855# vss sky130_fd_pr__nfet_01v8_lvt ad=0.2325 pd=2.12 as=0.12375 ps=1.08 w=0.75 l=0.15
X1081 a_20555_5509# f3 a_13102_2574# vdd sky130_fd_pr__pfet_01v8_lvt ad=0.609 pd=4.78 as=0.609 ps=4.78 w=2.1 l=0.35
X1082 a_10451_12702# a_10522_11144# vdd vdd sky130_fd_pr__pfet_01v8 ad=0.5445 pd=3.63 as=0.5445 ps=3.63 w=3.3 l=0.15
X1083 a_22795_8261# a_22753_3298# a_13102_7094# vss sky130_fd_pr__nfet_01v8_lvt ad=0.1885 pd=1.88 as=0.1885 ps=1.88 w=0.65 l=0.15
X1084 a_24677_9340# a_28514_8208# vss sky130_fd_pr__res_high_po_0p69 l=2.2
X1085 vdd a_30963_7375# a_30963_8465# vdd sky130_fd_pr__pfet_01v8 ad=0.3906 pd=3.14 as=0.2079 ps=1.59 w=1.26 l=0.15
X1086 vss a_20959_7929# vss vss sky130_fd_pr__nfet_01v8_lvt ad=0.203 pd=1.98 as=0 ps=0 w=0.7 l=0.15
X1087 vdd dn dp vdd sky130_fd_pr__pfet_01v8 ad=0.589 pd=4.42 as=0.3135 ps=2.23 w=1.9 l=0.15
X1088 a_7935_2090# a6 a_11527_4275# vss sky130_fd_pr__nfet_01v8_lvt ad=0.2325 pd=2.12 as=0.12375 ps=1.08 w=0.75 l=0.15
X1089 a_20959_5509# f3 a_16602_2574# vdd sky130_fd_pr__pfet_01v8_lvt ad=0.609 pd=4.78 as=0.609 ps=4.78 w=2.1 l=0.35
X1090 a_3663_6310# a_5214_6300# vss sky130_fd_pr__res_high_po_0p69 l=1.5
X1091 a_3663_3950# a_323_9240# vdd vdd sky130_fd_pr__pfet_01v8_lvt ad=0.1595 pd=1.39 as=0.319 ps=2.78 w=1.1 l=0.35
X1092 a_30217_2855# vdd vss vss sky130_fd_pr__nfet_01v8 ad=0.16675 pd=1.44 as=0.3335 ps=2.88 w=1.15 l=0.2
X1093 a_30817_8037# vdd vss vss sky130_fd_pr__nfet_01v8 ad=0.17835 pd=1.52 as=0.3567 ps=3.04 w=1.23 l=0.2
X1094 a_6063_2090# a_5993_2064# vdd vdd sky130_fd_pr__pfet_01v8_lvt ad=0.3045 pd=2.39 as=0.3045 ps=2.39 w=2.1 l=0.35
X1095 a_5993_6093# a_5214_6300# sky130_fd_pr__cap_mim_m3_1 l=4.2 w=4.2
X1096 vdd a_6063_6210# a_7935_6210# vdd sky130_fd_pr__pfet_01v8_lvt ad=0.609 pd=4.78 as=0.3045 ps=2.39 w=2.1 l=0.35
X1097 a_11527_7375# a_12237_1934# a_7935_2090# vdd sky130_fd_pr__pfet_01v8_lvt ad=0.3335 pd=2.59 as=0.667 ps=5.18 w=2.3 l=0.35
X1098 a_22437_6640# a_20555_6161# vdd vdd sky130_fd_pr__pfet_01v8 ad=0.2805 pd=2.03 as=0.527 ps=4.02 w=1.7 l=0.15
X1099 vdd a_21277_11890# a_21941_11896# vdd sky130_fd_pr__pfet_01v8 ad=0.4356 pd=2.97 as=0.4356 ps=2.97 w=2.64 l=0.15
X1100 a_20197_7240# a_18315_7929# vss vss sky130_fd_pr__nfet_01v8_lvt ad=0.203 pd=1.98 as=0.203 ps=1.98 w=0.7 l=0.15
X1101 a_30963_3945# a_29702_2574# a_30817_3517# vss sky130_fd_pr__nfet_01v8_lvt ad=0.744 pd=5.42 as=0.396 ps=2.73 w=2.4 l=0.15
X1102 a_22437_2120# a_28514_1816# vss sky130_fd_pr__res_high_po_0p69 l=2.2
X1103 vdd a_18719_3741# vdd vdd sky130_fd_pr__pfet_01v8 ad=0.527 pd=4.02 as=0 ps=0 w=1.7 l=0.15
X1104 a_15027_2855# a_14961_1934# a_7935_8570# vdd sky130_fd_pr__pfet_01v8_lvt ad=0.3335 pd=2.59 as=0.667 ps=5.18 w=2.3 l=0.35
X1105 a_15027_8795# b3 a_7935_9170# vss sky130_fd_pr__nfet_01v8_lvt ad=0.12375 pd=1.08 as=0.2325 ps=2.12 w=0.75 l=0.15
X1106 vdd a_16602_4274# a_16602_2574# vdd sky130_fd_pr__pfet_01v8 ad=0.462 pd=3.13 as=0.462 ps=3.13 w=2.8 l=0.15
X1107 vss a_23199_8261# vss vss sky130_fd_pr__nfet_01v8_lvt ad=0.203 pd=1.98 as=0 ps=0 w=0.7 l=0.15
X1108 a_22795_7929# f4 a_13268_8794# vdd sky130_fd_pr__pfet_01v8_lvt ad=0.609 pd=4.78 as=0.609 ps=4.78 w=2.1 l=0.35
X1109 vss vdd a_30217_7375# vss sky130_fd_pr__nfet_01v8 ad=0.16675 pd=1.44 as=0.16675 ps=1.44 w=1.15 l=0.2
X1110 vdd a_16309_11910# a_9937_11910# vdd sky130_fd_pr__pfet_01v8 ad=0.5445 pd=3.63 as=0.5445 ps=3.63 w=3.3 l=0.15
X1111 a_26917_2120# a_28514_1816# vss sky130_fd_pr__res_high_po_0p69 l=2.2
X1112 a_22559_11686# a_21941_11896# vdd vdd sky130_fd_pr__pfet_01v8 ad=0.3465 pd=2.43 as=0.651 ps=4.82 w=2.1 l=0.15
X1113 vdd a_22507_12830# a_17910_13392# vdd sky130_fd_pr__pfet_01v8 ad=0.5445 pd=3.63 as=0.5445 ps=3.63 w=3.3 l=0.15
X1114 vdd a_26627_11933# a_27557_11890# vdd sky130_fd_pr__pfet_01v8 ad=0.837 pd=6.02 as=0.4455 ps=3.03 w=2.7 l=0.15
X1115 a_29868_4274# vss vdd vdd sky130_fd_pr__pfet_01v8 ad=0.3135 pd=2.23 as=0.589 ps=4.42 w=1.9 l=0.15
X1116 a_7935_9170# a_7935_8570# vss vss sky130_fd_pr__nfet_01v8_lvt ad=0.1305 pd=1.48 as=0.1305 ps=1.48 w=0.45 l=0.15
X1117 a_22437_8740# a_20555_8261# vss vss sky130_fd_pr__nfet_01v8_lvt ad=0.203 pd=1.98 as=0.203 ps=1.98 w=0.7 l=0.15
X1118 a_3663_3950# a_5214_3940# vss sky130_fd_pr__res_high_po_0p69 l=1.5
X1119 a_14528_205# a7 vss vss sky130_fd_pr__nfet_01v8 ad=0.1305 pd=1.48 as=0.1305 ps=1.48 w=0.45 l=0.18
X1120 a_15027_8795# b7 a_7935_8570# vss sky130_fd_pr__nfet_01v8_lvt ad=0.12375 pd=1.08 as=0.2325 ps=2.12 w=0.75 l=0.15
X1121 a_30217_7375# vdd vss vss sky130_fd_pr__nfet_01v8 ad=0.16675 pd=1.44 as=0.16675 ps=1.44 w=1.15 l=0.2
X1122 vss a_5993_2064# a_6063_2090# vss sky130_fd_pr__nfet_01v8_lvt ad=0.341 pd=2.82 as=0.1815 ps=1.43 w=1.1 l=0.15
X1123 ckd2 a_10451_12702# vss vss sky130_fd_pr__nfet_01v8_lvt ad=0.198 pd=1.53 as=0.372 ps=3.02 w=1.2 l=0.15
X1124 a_9381_11896# a_8717_11890# vss vss sky130_fd_pr__nfet_01v8_lvt ad=0.198 pd=1.53 as=0.372 ps=3.02 w=1.2 l=0.15
X1125 a_29327_12830# a_21941_11896# a_18550_13392# vdd sky130_fd_pr__pfet_01v8 ad=0.594 pd=3.93 as=0.594 ps=3.93 w=3.6 l=0.15
X1126 vdd a_20959_3741# vdd vdd sky130_fd_pr__pfet_01v8 ad=0.527 pd=4.02 as=0 ps=0 w=1.7 l=0.15
X1127 a_11527_8795# a_11849_1934# a_7935_6810# vdd sky130_fd_pr__pfet_01v8_lvt ad=0.3335 pd=2.59 as=0.667 ps=5.18 w=2.3 l=0.35
X1128 a_7935_6810# a_6063_6810# vdd vdd sky130_fd_pr__pfet_01v8_lvt ad=0.3045 pd=2.39 as=0.3045 ps=2.39 w=2.1 l=0.35
X1129 a_7935_6810# a_7935_6210# vdd vdd sky130_fd_pr__pfet_01v8_lvt ad=0.609 pd=4.78 as=0.609 ps=4.78 w=2.1 l=0.35
X1130 a_16768_8794# a_16768_7094# vdd vdd sky130_fd_pr__pfet_01v8 ad=0.462 pd=3.13 as=0.462 ps=3.13 w=2.8 l=0.15
X1131 vdd a_6063_3850# a_7935_3850# vdd sky130_fd_pr__pfet_01v8_lvt ad=0.609 pd=4.78 as=0.3045 ps=2.39 w=2.1 l=0.35
X1132 vdd vss a_30963_3945# vdd sky130_fd_pr__pfet_01v8 ad=0.2607 pd=1.91 as=0.2607 ps=1.91 w=1.58 l=0.15
X1133 a_22795_8261# a_22753_3298# a_16602_7094# vdd sky130_fd_pr__pfet_01v8_lvt ad=0.609 pd=4.78 as=0.609 ps=4.78 w=2.1 l=0.35
X1134 a_25035_7929# a_24993_3298# a_13268_8794# vss sky130_fd_pr__nfet_01v8_lvt ad=0.1885 pd=1.88 as=0.1885 ps=1.88 w=0.65 l=0.15
X1135 a_29702_2574# a_29702_4274# a_30217_2855# vss sky130_fd_pr__nfet_01v8_lvt ad=0.396 pd=2.73 as=0.744 ps=5.42 w=2.4 l=0.15
X1136 a_20959_1641# a_20513_1814# a_13268_4274# vdd sky130_fd_pr__pfet_01v8_lvt ad=0.609 pd=4.78 as=0.609 ps=4.78 w=2.1 l=0.35
X1137 a_22437_7240# a_28514_6336# vss sky130_fd_pr__res_high_po_0p69 l=2.2
X1138 a_3663_4550# a_323_4520# vss vss sky130_fd_pr__nfet_01v8_lvt ad=0.319 pd=2.78 as=0.319 ps=2.78 w=1.1 l=0.15
X1139 vss rst_n a_6211_11960# vss sky130_fd_pr__nfet_01v8_lvt ad=0.31 pd=2.62 as=0.165 ps=1.33 w=1 l=0.15
X1140 a_16309_11910# a_7218_11110# vss vss sky130_fd_pr__nfet_01v8 ad=0.29 pd=2.58 as=0.29 ps=2.58 w=1 l=0.18
X1141 a_25439_7929# a_24993_3298# a_16768_8794# vss sky130_fd_pr__nfet_01v8_lvt ad=0.1885 pd=1.88 as=0.1885 ps=1.88 w=0.65 l=0.15
X1142 a_13102_2574# a_13102_4274# vss vss sky130_fd_pr__nfet_01v8_lvt ad=0.2805 pd=2.03 as=0.527 ps=4.02 w=1.7 l=0.15
X1143 a_20197_4220# a_18315_3741# vdd vdd sky130_fd_pr__pfet_01v8 ad=0.2805 pd=2.03 as=0.527 ps=4.02 w=1.7 l=0.15
X1144 vdd a_28467_12830# a_22497_11800# vdd sky130_fd_pr__pfet_01v8 ad=1.023 pd=7.22 as=0.5445 ps=3.63 w=3.3 l=0.15
X1145 a_22497_11800# a_24149_11800# vss vss sky130_fd_pr__nfet_01v8_lvt ad=0.1885 pd=1.88 as=0.1885 ps=1.88 w=0.65 l=0.15
X1146 a_11527_7375# a2 a_7935_6210# vss sky130_fd_pr__nfet_01v8_lvt ad=0.12375 pd=1.08 as=0.2325 ps=2.12 w=0.75 l=0.15
X1147 a_26917_8740# a_25035_8261# vss vss sky130_fd_pr__nfet_01v8_lvt ad=0.203 pd=1.98 as=0.203 ps=1.98 w=0.7 l=0.15
X1148 a_20513_1814# f3 vdd vdd sky130_fd_pr__pfet_01v8 ad=0.261 pd=2.38 as=0.261 ps=2.38 w=0.9 l=0.18
X1149 a_13102_4274# a_11527_4275# sky130_fd_pr__cap_mim_m3_1 l=4.2 w=4.3
X1150 a_30963_2855# a_29868_4274# a_30817_3517# vss sky130_fd_pr__nfet_01v8_lvt ad=0.744 pd=5.42 as=0.396 ps=2.73 w=2.4 l=0.15
X1151 a_8701_12702# a_10029_11910# vdd vdd sky130_fd_pr__pfet_01v8 ad=0.5445 pd=3.63 as=0.5445 ps=3.63 w=3.3 l=0.15
X1152 a_11527_8795# a_12625_1934# a_7935_6210# vdd sky130_fd_pr__pfet_01v8_lvt ad=0.3335 pd=2.59 as=0.667 ps=5.18 w=2.3 l=0.35
X1153 a_7935_8570# a_6063_8570# vdd vdd sky130_fd_pr__pfet_01v8_lvt ad=0.3045 pd=2.39 as=0.3045 ps=2.39 w=2.1 l=0.35
X1154 a_323_9240# qn vdd vdd sky130_fd_pr__pfet_01v8_lvt ad=0.203 pd=1.69 as=0.203 ps=1.69 w=1.4 l=0.35
X1155 a_18719_5509# f1 a_13102_2574# vss sky130_fd_pr__nfet_01v8_lvt ad=0.1885 pd=1.88 as=0.1885 ps=1.88 w=0.65 l=0.15
X1156 en a_30963_3945# vss vss sky130_fd_pr__nfet_01v8_lvt ad=0.3465 pd=2.43 as=0.651 ps=4.82 w=2.1 l=0.15
X1157 vdd a_6063_1490# a_7935_1490# vdd sky130_fd_pr__pfet_01v8_lvt ad=0.3045 pd=2.39 as=0.3045 ps=2.39 w=2.1 l=0.35
X1158 a_18315_1641# a_18273_1814# a_16768_4274# vdd sky130_fd_pr__pfet_01v8_lvt ad=0.609 pd=4.78 as=0.609 ps=4.78 w=2.1 l=0.35
X1159 a_25035_3741# a_24993_3298# a_16602_2574# vdd sky130_fd_pr__pfet_01v8_lvt ad=0.609 pd=4.78 as=0.609 ps=4.78 w=2.1 l=0.35
X1160 vdd a_25439_3741# vdd vdd sky130_fd_pr__pfet_01v8 ad=0.527 pd=4.02 as=0 ps=0 w=1.7 l=0.15
X1161 vdd a_13102_8794# a_13102_7094# vdd sky130_fd_pr__pfet_01v8_lvt ad=0.812 pd=6.18 as=0.406 ps=3.09 w=2.8 l=0.35
X1162 a_7935_8570# a_15349_1934# a_15027_7375# vdd sky130_fd_pr__pfet_01v8_lvt ad=0.667 pd=5.18 as=0.3335 ps=2.59 w=2.3 l=0.35
X1163 a_20959_6161# f3 a_13268_8794# vss sky130_fd_pr__nfet_01v8_lvt ad=0.1885 pd=1.88 as=0.1885 ps=1.88 w=0.65 l=0.15
X1164 vdd a_30963_8465# a_30963_7375# vdd sky130_fd_pr__pfet_01v8 ad=0.2079 pd=1.59 as=0.2079 ps=1.59 w=1.26 l=0.15
X1165 vss a_23199_5509# vss vss sky130_fd_pr__nfet_01v8_lvt ad=0.203 pd=1.98 as=0 ps=0 w=0.7 l=0.15
X1166 vdd a_18550_13392# cke2 vdd sky130_fd_pr__pfet_01v8 ad=0.93 pd=6.62 as=0.495 ps=3.33 w=3 l=0.15
X1167 a_26917_9340# a_25035_10029# vss vss sky130_fd_pr__nfet_01v8_lvt ad=0.203 pd=1.98 as=0.203 ps=1.98 w=0.7 l=0.15
X1168 vdd a_16768_7094# a_16768_8794# vdd sky130_fd_pr__pfet_01v8_lvt ad=0.812 pd=6.18 as=0.406 ps=3.09 w=2.8 l=0.35
X1169 vdd qp a_323_4520# vdd sky130_fd_pr__pfet_01v8_lvt ad=0.203 pd=1.69 as=0.203 ps=1.69 w=1.4 l=0.35
X1170 a_2903_1590# a_323_6880# vdd vdd sky130_fd_pr__pfet_01v8_lvt ad=0.1595 pd=1.39 as=0.1595 ps=1.39 w=1.1 l=0.35
X1171 a_25439_1641# a_24993_1814# a_13268_4274# vdd sky130_fd_pr__pfet_01v8_lvt ad=0.609 pd=4.78 as=0.609 ps=4.78 w=2.1 l=0.35
X1172 ckd0 a_8701_12702# vdd vdd sky130_fd_pr__pfet_01v8 ad=0.495 pd=3.33 as=0.495 ps=3.33 w=3 l=0.15
X1173 a_6063_9170# a_5993_9144# vdd vdd sky130_fd_pr__pfet_01v8_lvt ad=0.3045 pd=2.39 as=0.3045 ps=2.39 w=2.1 l=0.35
X1174 vdd a_25035_6161# a_26917_6640# vdd sky130_fd_pr__pfet_01v8 ad=0.527 pd=4.02 as=0.2805 ps=2.03 w=1.7 l=0.15
X1175 vdd a_30963_3945# en vdd sky130_fd_pr__pfet_01v8 ad=0.495 pd=3.33 as=0.495 ps=3.33 w=3 l=0.15
X1176 vdd a_18719_3409# vdd vdd sky130_fd_pr__pfet_01v8 ad=0.2805 pd=2.03 as=0 ps=0 w=1.7 l=0.15
X1177 vdd a_30963_8465# dn vdd sky130_fd_pr__pfet_01v8 ad=0.93 pd=6.62 as=0.495 ps=3.33 w=3 l=0.15
X1178 vss a_6063_6810# a_7935_6810# vss sky130_fd_pr__nfet_01v8_lvt ad=0.527 pd=4.02 as=0.2805 ps=2.03 w=1.7 l=0.15
X1179 a_11527_7375# a6 a_7935_6810# vss sky130_fd_pr__nfet_01v8_lvt ad=0.12375 pd=1.08 as=0.2325 ps=2.12 w=0.75 l=0.15
X1180 a_7935_4450# a_7935_3850# vdd vdd sky130_fd_pr__pfet_01v8_lvt ad=0.609 pd=4.78 as=0.609 ps=4.78 w=2.1 l=0.35
X1181 a_24677_4220# a_22795_3741# vdd vdd sky130_fd_pr__pfet_01v8 ad=0.2805 pd=2.03 as=0.527 ps=4.02 w=1.7 l=0.15
X1182 a_18315_6161# f1 a_16768_8794# vss sky130_fd_pr__nfet_01v8_lvt ad=0.1885 pd=1.88 as=0.1885 ps=1.88 w=0.65 l=0.15
X1183 dn a_30963_8465# vdd vdd sky130_fd_pr__pfet_01v8_lvt ad=0.406 pd=3.09 as=0.812 ps=6.18 w=2.8 l=0.35
X1184 a_22437_4820# a_20555_5509# vss vss sky130_fd_pr__nfet_01v8_lvt ad=0.203 pd=1.98 as=0.203 ps=1.98 w=0.7 l=0.15
X1185 a_18010_13668# a_17910_13392# vss vss sky130_fd_pr__nfet_01v8 ad=0.1218 pd=1.42 as=0.1218 ps=1.42 w=0.42 l=0.5
X1186 a_7218_11110# a_6858_11170# vdd vdd sky130_fd_pr__pfet_01v8 ad=0.87 pd=6.58 as=0.87 ps=6.58 w=3 l=0.18
X1187 vdd a_16602_8794# a_16602_7094# vdd sky130_fd_pr__pfet_01v8 ad=0.868 pd=6.22 as=0.462 ps=3.13 w=2.8 l=0.15
X1188 vdd a_23199_10029# vdd vdd sky130_fd_pr__pfet_01v8 ad=0.527 pd=4.02 as=0 ps=0 w=1.7 l=0.15
X1189 a_25035_8261# f6 a_16602_7094# vss sky130_fd_pr__nfet_01v8_lvt ad=0.1885 pd=1.88 as=0.1885 ps=1.88 w=0.65 l=0.15
X1190 a_30963_2855# vss vdd vdd sky130_fd_pr__pfet_01v8 ad=0.2607 pd=1.91 as=0.4898 ps=3.78 w=1.58 l=0.15
X1191 vdd a_5993_6093# a_6063_6210# vdd sky130_fd_pr__pfet_01v8_lvt ad=0.609 pd=4.78 as=0.3045 ps=2.39 w=2.1 l=0.35
X1192 a_30963_3945# a_29702_2574# a_30817_3517# vss sky130_fd_pr__nfet_01v8_lvt ad=0.396 pd=2.73 as=0.744 ps=5.42 w=2.4 l=0.15
X1193 vdd a_23199_1641# vdd vdd sky130_fd_pr__pfet_01v8 ad=0.2805 pd=2.03 as=0 ps=0 w=1.7 l=0.15
X1194 vss a_18719_10029# vss vss sky130_fd_pr__nfet_01v8_lvt ad=0.203 pd=1.98 as=0 ps=0 w=0.7 l=0.15
X1195 vdd a_323_9240# a_2903_6310# vdd sky130_fd_pr__pfet_01v8_lvt ad=0.319 pd=2.78 as=0.1595 ps=1.39 w=1.1 l=0.35
X1196 a_7935_9170# a_16125_1934# a_15027_7375# vdd sky130_fd_pr__pfet_01v8_lvt ad=0.667 pd=5.18 as=0.3335 ps=2.59 w=2.3 l=0.35
X1197 a_25439_6161# f7 a_13268_8794# vss sky130_fd_pr__nfet_01v8_lvt ad=0.1885 pd=1.88 as=0.1885 ps=1.88 w=0.65 l=0.15
X1198 a_20555_1641# a_20513_1814# a_16768_4274# vdd sky130_fd_pr__pfet_01v8_lvt ad=0.609 pd=4.78 as=0.609 ps=4.78 w=2.1 l=0.35
X1199 a_10522_11144# a_10029_11910# vss vss sky130_fd_pr__nfet_01v8 ad=0.174 pd=1.78 as=0.174 ps=1.78 w=0.6 l=0.28
X1200 a_7935_2090# a2 a_11527_2855# vss sky130_fd_pr__nfet_01v8_lvt ad=0.2325 pd=2.12 as=0.12375 ps=1.08 w=0.75 l=0.15
X1201 a_29868_4274# a_29868_2574# a_30217_2855# vss sky130_fd_pr__nfet_01v8_lvt ad=0.396 pd=2.73 as=0.744 ps=5.42 w=2.4 l=0.15
X1202 a_18315_3741# f0 a_13102_2574# vdd sky130_fd_pr__pfet_01v8_lvt ad=0.609 pd=4.78 as=0.609 ps=4.78 w=2.1 l=0.35
X1203 a_10029_11910# a_7218_11110# vss vss sky130_fd_pr__nfet_01v8 ad=0.29 pd=2.58 as=0.29 ps=2.58 w=1 l=0.18
X1204 a_14067_11933# a_6211_11960# dn vdd sky130_fd_pr__pfet_01v8_lvt ad=0.6583 pd=5.12 as=0.32915 ps=2.56 w=2.27 l=0.35
X1205 a_20347_11933# rst_n ep vss sky130_fd_pr__nfet_01v8_lvt ad=0.2145 pd=1.63 as=0.403 ps=3.22 w=1.3 l=0.15
X1206 a_22437_4820# a_20555_5509# vdd vdd sky130_fd_pr__pfet_01v8 ad=0.2805 pd=2.03 as=0.527 ps=4.02 w=1.7 l=0.15
X1207 a_323_6880# in vdd vdd sky130_fd_pr__pfet_01v8_lvt ad=0.203 pd=1.69 as=0.203 ps=1.69 w=1.4 l=0.35
X1208 a_23199_5509# a_22753_1814# a_16602_2574# vss sky130_fd_pr__nfet_01v8_lvt ad=0.1885 pd=1.88 as=0.1885 ps=1.88 w=0.65 l=0.15
X1209 a_3663_1590# a_323_6880# vdd vdd sky130_fd_pr__pfet_01v8_lvt ad=0.1595 pd=1.39 as=0.319 ps=2.78 w=1.1 l=0.35
X1210 a_18719_3741# f0 a_16602_2574# vdd sky130_fd_pr__pfet_01v8_lvt ad=0.609 pd=4.78 as=0.609 ps=4.78 w=2.1 l=0.35
X1211 a_6211_11960# rst_n vdd vdd sky130_fd_pr__pfet_01v8 ad=0.33 pd=2.33 as=0.62 ps=4.62 w=2 l=0.15
X1212 vdd a_14997_11890# a_9999_11686# vdd sky130_fd_pr__pfet_01v8 ad=0.8184 pd=5.9 as=0.4356 ps=2.97 w=2.64 l=0.15
X1213 a_2903_3950# a_323_6880# vss vss sky130_fd_pr__nfet_01v8_lvt ad=0.319 pd=2.78 as=0.319 ps=2.78 w=1.1 l=0.15
X1214 a_11527_2855# a_11849_1934# a_7935_2090# vdd sky130_fd_pr__pfet_01v8_lvt ad=0.3335 pd=2.59 as=0.667 ps=5.18 w=2.3 l=0.35
X1215 vdd a_20959_3409# vdd vdd sky130_fd_pr__pfet_01v8 ad=0.2805 pd=2.03 as=0 ps=0 w=1.7 l=0.15
X1216 a_26917_4820# a_25035_5509# vss vss sky130_fd_pr__nfet_01v8_lvt ad=0.203 pd=1.98 as=0.203 ps=1.98 w=0.7 l=0.15
X1217 a_30963_3945# a_30963_2855# vdd vdd sky130_fd_pr__pfet_01v8 ad=0.2079 pd=1.59 as=0.3906 ps=3.14 w=1.26 l=0.15
X1218 vss a_5993_9144# a_6063_9170# vss sky130_fd_pr__nfet_01v8_lvt ad=0.341 pd=2.82 as=0.1815 ps=1.43 w=1.1 l=0.15
X1219 a_14961_1934# b1 vdd vdd sky130_fd_pr__pfet_01v8 ad=0.261 pd=2.38 as=0.261 ps=2.38 w=0.9 l=0.18
X1220 a_18315_8261# a_18273_3298# a_13102_7094# vss sky130_fd_pr__nfet_01v8_lvt ad=0.1885 pd=1.88 as=0.1885 ps=1.88 w=0.65 l=0.15
X1221 a_20555_6161# f3 a_16768_8794# vss sky130_fd_pr__nfet_01v8_lvt ad=0.1885 pd=1.88 as=0.1885 ps=1.88 w=0.65 l=0.15
X1222 a_7935_8570# b1 a_15027_2855# vss sky130_fd_pr__nfet_01v8_lvt ad=0.2325 pd=2.12 as=0.12375 ps=1.08 w=0.75 l=0.15
X1223 vdd a_20555_1641# a_22437_2120# vdd sky130_fd_pr__pfet_01v8 ad=0.527 pd=4.02 as=0.2805 ps=2.03 w=1.7 l=0.15
X1224 a_8717_11890# a_7787_11933# vss vss sky130_fd_pr__nfet_01v8_lvt ad=0.464 pd=3.78 as=0.464 ps=3.78 w=1.6 l=0.15
X1225 a_25035_7929# a_24993_3298# a_16768_8794# vdd sky130_fd_pr__pfet_01v8_lvt ad=0.609 pd=4.78 as=0.609 ps=4.78 w=2.1 l=0.35
X1226 vdd a_18719_6161# vdd vdd sky130_fd_pr__pfet_01v8 ad=0.527 pd=4.02 as=0 ps=0 w=1.7 l=0.15
X1227 a_20513_1814# f3 vss vss sky130_fd_pr__nfet_01v8 ad=0.1305 pd=1.48 as=0.1305 ps=1.48 w=0.45 l=0.18
X1228 vdd a_16802_11144# a_11270_13392# vdd sky130_fd_pr__pfet_01v8 ad=1.023 pd=7.22 as=0.5445 ps=3.63 w=3.3 l=0.15
X1229 vdd a_323_9240# a_3663_6310# vdd sky130_fd_pr__pfet_01v8_lvt ad=0.1595 pd=1.39 as=0.1595 ps=1.39 w=1.1 l=0.35
X1230 a_7935_3850# b3 a_15027_4275# vss sky130_fd_pr__nfet_01v8_lvt ad=0.2325 pd=2.12 as=0.12375 ps=1.08 w=0.75 l=0.15
X1231 vdd a_6063_6810# a_7935_6810# vdd sky130_fd_pr__pfet_01v8_lvt ad=0.3045 pd=2.39 as=0.3045 ps=2.39 w=2.1 l=0.35
X1232 a_7935_3850# a_15737_1934# a_15027_8795# vdd sky130_fd_pr__pfet_01v8_lvt ad=0.667 pd=5.18 as=0.3335 ps=2.59 w=2.3 l=0.35
X1233 a_18719_8261# a_18273_3298# a_16602_7094# vss sky130_fd_pr__nfet_01v8_lvt ad=0.1885 pd=1.88 as=0.1885 ps=1.88 w=0.65 l=0.15
X1234 vdd a_5993_3733# a_6063_3850# vdd sky130_fd_pr__pfet_01v8_lvt ad=0.609 pd=4.78 as=0.3045 ps=2.39 w=2.1 l=0.35
X1235 a_11527_2855# a_12625_1934# a_7935_1490# vdd sky130_fd_pr__pfet_01v8_lvt ad=0.3335 pd=2.59 as=0.667 ps=5.18 w=2.3 l=0.35
X1236 a_26917_9340# a_25035_10029# vdd vdd sky130_fd_pr__pfet_01v8 ad=0.2805 pd=2.03 as=0.527 ps=4.02 w=1.7 l=0.15
X1237 a_26917_4220# a_28514_3688# vss sky130_fd_pr__res_high_po_0p69 l=2.2
X1238 a_2903_6910# a_323_4520# vdd vdd sky130_fd_pr__pfet_01v8_lvt ad=0.1595 pd=1.39 as=0.1595 ps=1.39 w=1.1 l=0.35
X1239 dp a_30963_7375# vdd vdd sky130_fd_pr__pfet_01v8_lvt ad=0.406 pd=3.09 as=0.812 ps=6.18 w=2.8 l=0.35
X1240 vdd a_323_6880# a_2903_3950# vdd sky130_fd_pr__pfet_01v8_lvt ad=0.319 pd=2.78 as=0.1595 ps=1.39 w=1.1 l=0.35
X1241 a_16338_205# b4 vdd vdd sky130_fd_pr__pfet_01v8 ad=0.261 pd=2.38 as=0.261 ps=2.38 w=0.9 l=0.18
X1242 vdd a_25439_3409# vdd vdd sky130_fd_pr__pfet_01v8 ad=0.2805 pd=2.03 as=0 ps=0 w=1.7 l=0.15
X1243 a_7935_2090# a0 a_11527_8795# vss sky130_fd_pr__nfet_01v8_lvt ad=0.2325 pd=2.12 as=0.12375 ps=1.08 w=0.75 l=0.15
X1244 vss a_13268_7094# a_13268_8794# vss sky130_fd_pr__nfet_01v8_lvt ad=0.527 pd=4.02 as=0.2805 ps=2.03 w=1.7 l=0.15
X1245 vdd a_18315_7929# a_20197_7240# vdd sky130_fd_pr__pfet_01v8 ad=0.527 pd=4.02 as=0.2805 ps=2.03 w=1.7 l=0.15
X1246 a_3663_1590# a_5214_1580# vss sky130_fd_pr__res_high_po_0p69 l=1.5
X1247 a_30963_2855# a_29868_4274# a_30817_3517# vss sky130_fd_pr__nfet_01v8_lvt ad=0.396 pd=2.73 as=0.744 ps=5.42 w=2.4 l=0.15
X1248 a_22795_3409# a_22753_3298# a_16768_4274# vdd sky130_fd_pr__pfet_01v8_lvt ad=0.609 pd=4.78 as=0.609 ps=4.78 w=2.1 l=0.35
X1249 vdd a_6063_8570# a_7935_8570# vdd sky130_fd_pr__pfet_01v8_lvt ad=0.3045 pd=2.39 as=0.3045 ps=2.39 w=2.1 l=0.35
X1250 vss a_18719_8261# vss vss sky130_fd_pr__nfet_01v8_lvt ad=0.203 pd=1.98 as=0 ps=0 w=0.7 l=0.15
X1251 a_20555_3741# a_20513_3298# a_13102_2574# vss sky130_fd_pr__nfet_01v8_lvt ad=0.1885 pd=1.88 as=0.1885 ps=1.88 w=0.65 l=0.15
X1252 vdd a_20959_6161# vdd vdd sky130_fd_pr__pfet_01v8 ad=0.527 pd=4.02 as=0 ps=0 w=1.7 l=0.15
X1253 a_22437_9340# a_20555_10029# vss vss sky130_fd_pr__nfet_01v8_lvt ad=0.203 pd=1.98 as=0.203 ps=1.98 w=0.7 l=0.15
X1254 a_2903_8670# a_323_9240# vdd vdd sky130_fd_pr__pfet_01v8_lvt ad=0.1595 pd=1.39 as=0.1595 ps=1.39 w=1.1 l=0.35
X1255 a_18315_7929# f0 a_13268_8794# vdd sky130_fd_pr__pfet_01v8_lvt ad=0.609 pd=4.78 as=0.609 ps=4.78 w=2.1 l=0.35
X1256 a_7935_4450# a_6063_4450# vdd vdd sky130_fd_pr__pfet_01v8_lvt ad=0.3045 pd=2.39 as=0.3045 ps=2.39 w=2.1 l=0.35
X1257 vdd a_6063_1490# a_7935_1490# vdd sky130_fd_pr__pfet_01v8_lvt ad=0.609 pd=4.78 as=0.3045 ps=2.39 w=2.1 l=0.35
X1258 a_22795_3409# a_22753_3298# a_13268_4274# vss sky130_fd_pr__nfet_01v8_lvt ad=0.1885 pd=1.88 as=0.1885 ps=1.88 w=0.65 l=0.15
X1259 a_20959_3741# a_20513_3298# a_16602_2574# vss sky130_fd_pr__nfet_01v8_lvt ad=0.1885 pd=1.88 as=0.1885 ps=1.88 w=0.65 l=0.15
X1260 a_21941_11896# a_21277_11890# vdd vdd sky130_fd_pr__pfet_01v8 ad=0.4356 pd=2.97 as=0.4356 ps=2.97 w=2.64 l=0.15
X1261 vdd a_29868_4274# a_29702_2574# vdd sky130_fd_pr__pfet_01v8 ad=0.4464 pd=3.5 as=0.2376 ps=1.77 w=1.44 l=0.15
X1262 a_26917_4820# a_28514_3688# vss sky130_fd_pr__res_high_po_0p69 l=2.2
X1263 a_25035_3741# f6 a_13102_2574# vdd sky130_fd_pr__pfet_01v8_lvt ad=0.609 pd=4.78 as=0.609 ps=4.78 w=2.1 l=0.35
X1264 a_18719_7929# f0 a_16768_8794# vdd sky130_fd_pr__pfet_01v8_lvt ad=0.609 pd=4.78 as=0.609 ps=4.78 w=2.1 l=0.35
X1265 a_22437_9340# a_28514_8208# vss sky130_fd_pr__res_high_po_0p69 l=2.2
X1266 vss a_17675_12870# vss vss sky130_fd_pr__nfet_01v8 ad=0.348 pd=2.98 as=0 ps=0 w=1.2 l=1.2
X1267 a_25439_10029# f7 a_16602_7094# vdd sky130_fd_pr__pfet_01v8_lvt ad=0.609 pd=4.78 as=0.609 ps=4.78 w=2.1 l=0.35
X1268 a_20959_8261# a_20513_3298# a_13102_7094# vdd sky130_fd_pr__pfet_01v8_lvt ad=0.609 pd=4.78 as=0.609 ps=4.78 w=2.1 l=0.35
X1269 vdd a_30963_8465# dn vdd sky130_fd_pr__pfet_01v8 ad=0.495 pd=3.33 as=0.495 ps=3.33 w=3 l=0.15
X1270 vdd a_323_9240# a_3663_3950# vdd sky130_fd_pr__pfet_01v8_lvt ad=0.1595 pd=1.39 as=0.1595 ps=1.39 w=1.1 l=0.35
X1271 a_3663_6910# a_323_4520# vdd vdd sky130_fd_pr__pfet_01v8_lvt ad=0.1595 pd=1.39 as=0.319 ps=2.78 w=1.1 l=0.35
X1272 a_7935_4450# a_6063_4450# vss vss sky130_fd_pr__nfet_01v8_lvt ad=0.2805 pd=2.03 as=0.527 ps=4.02 w=1.7 l=0.15
X1273 a_16768_7094# a_15027_7375# sky130_fd_pr__cap_mim_m3_1 l=4.2 w=4.3
X1274 cke2 a_18550_13392# vss vss sky130_fd_pr__nfet_01v8_lvt ad=0.198 pd=1.53 as=0.372 ps=3.02 w=1.2 l=0.15
X1275 vdd a_22795_7929# a_24677_7240# vdd sky130_fd_pr__pfet_01v8 ad=0.527 pd=4.02 as=0.2805 ps=2.03 w=1.7 l=0.15
X1276 a_20197_6640# a_18315_6161# vdd vdd sky130_fd_pr__pfet_01v8 ad=0.2805 pd=2.03 as=0.527 ps=4.02 w=1.7 l=0.15
X1277 a_9937_11910# a_16309_11910# vdd vdd sky130_fd_pr__pfet_01v8 ad=0.5445 pd=3.63 as=0.5445 ps=3.63 w=3.3 l=0.15
X1278 a_6063_6210# a_5993_6093# vdd vdd sky130_fd_pr__pfet_01v8_lvt ad=0.3045 pd=2.39 as=0.609 ps=4.78 w=2.1 l=0.35
X1279 vdd a_25035_5509# a_26917_4820# vdd sky130_fd_pr__pfet_01v8 ad=0.527 pd=4.02 as=0.2805 ps=2.03 w=1.7 l=0.15
X1280 ckd2 ckd0 vss vss sky130_fd_pr__nfet_01v8_lvt ad=0.1305 pd=1.48 as=0.1305 ps=1.48 w=0.45 l=0.15
X1281 vdd a_21941_11896# a_22559_11686# vdd sky130_fd_pr__pfet_01v8 ad=0.651 pd=4.82 as=0.3465 ps=2.43 w=2.1 l=0.15
X1282 a_17910_13392# a_22507_12830# vdd vdd sky130_fd_pr__pfet_01v8 ad=0.5445 pd=3.63 as=0.5445 ps=3.63 w=3.3 l=0.15
X1283 a_2903_6310# a_323_9240# vdd vdd sky130_fd_pr__pfet_01v8_lvt ad=0.1595 pd=1.39 as=0.319 ps=2.78 w=1.1 l=0.35
X1284 a_22795_5509# f5 a_13102_2574# vdd sky130_fd_pr__pfet_01v8_lvt ad=0.609 pd=4.78 as=0.609 ps=4.78 w=2.1 l=0.35
X1285 a_18315_8261# a_18273_3298# a_16602_7094# vdd sky130_fd_pr__pfet_01v8_lvt ad=0.609 pd=4.78 as=0.609 ps=4.78 w=2.1 l=0.35
X1286 a_18719_7929# f0 a_13268_8794# vss sky130_fd_pr__nfet_01v8_lvt ad=0.1885 pd=1.88 as=0.1885 ps=1.88 w=0.65 l=0.15
X1287 vdd a_25439_6161# vdd vdd sky130_fd_pr__pfet_01v8 ad=0.527 pd=4.02 as=0 ps=0 w=1.7 l=0.15
X1288 a_13268_4274# a_13268_2574# vdd vdd sky130_fd_pr__pfet_01v8 ad=0.462 pd=3.13 as=0.868 ps=6.22 w=2.8 l=0.15
X1289 a_14961_1934# b1 vss vss sky130_fd_pr__nfet_01v8 ad=0.1305 pd=1.48 as=0.1305 ps=1.48 w=0.45 l=0.18
X1290 vss a_20959_3741# vss vss sky130_fd_pr__nfet_01v8_lvt ad=0.203 pd=1.98 as=0 ps=0 w=0.7 l=0.15
X1291 vss a_23199_7929# vss vss sky130_fd_pr__nfet_01v8_lvt ad=0.203 pd=1.98 as=0 ps=0 w=0.7 l=0.15
X1292 vdd ip a_323_2160# vdd sky130_fd_pr__pfet_01v8_lvt ad=0.203 pd=1.69 as=0.203 ps=1.69 w=1.4 l=0.35
X1293 a_15027_4275# a_15349_1934# a_7935_3850# vdd sky130_fd_pr__pfet_01v8_lvt ad=0.3335 pd=2.59 as=0.667 ps=5.18 w=2.3 l=0.35
X1294 a_30963_2855# a_30963_3945# vdd vdd sky130_fd_pr__pfet_01v8 ad=0.2079 pd=1.59 as=0.2079 ps=1.59 w=1.26 l=0.15
X1295 dp a_6211_11960# a_7787_11933# vdd sky130_fd_pr__pfet_01v8_lvt ad=0.32915 pd=2.56 as=0.32915 ps=2.56 w=2.27 l=0.35
X1296 vdd a_21277_11890# a_21941_11896# vdd sky130_fd_pr__pfet_01v8 ad=0.8184 pd=5.9 as=0.4356 ps=2.97 w=2.64 l=0.15
X1297 a_3663_8670# a_323_2160# vdd vdd sky130_fd_pr__pfet_01v8_lvt ad=0.1595 pd=1.39 as=0.319 ps=2.78 w=1.1 l=0.35
X1298 a_15027_4275# b1 a_7935_9170# vss sky130_fd_pr__nfet_01v8_lvt ad=0.12375 pd=1.08 as=0.2325 ps=2.12 w=0.75 l=0.15
X1299 a_29702_2574# vss vdd vdd sky130_fd_pr__pfet_01v8 ad=0.3135 pd=2.23 as=0.589 ps=4.42 w=1.9 l=0.15
X1300 vss a_8717_11890# a_9381_11896# vss sky130_fd_pr__nfet_01v8_lvt ad=0.372 pd=3.02 as=0.198 ps=1.53 w=1.2 l=0.15
X1301 a_18550_13392# a_21941_11896# a_29327_12830# vdd sky130_fd_pr__pfet_01v8 ad=1.116 pd=7.82 as=0.594 ps=3.93 w=3.6 l=0.15
X1302 a_18719_6161# a_18273_1814# a_13268_8794# vdd sky130_fd_pr__pfet_01v8_lvt ad=0.609 pd=4.78 as=0.609 ps=4.78 w=2.1 l=0.35
X1303 vss a_10451_12702# ckd2 vss sky130_fd_pr__nfet_01v8_lvt ad=0.372 pd=3.02 as=0.198 ps=1.53 w=1.2 l=0.15
X1304 a_25439_8261# a_24993_3298# a_13102_7094# vdd sky130_fd_pr__pfet_01v8_lvt ad=0.609 pd=4.78 as=0.609 ps=4.78 w=2.1 l=0.35
X1305 a_29868_7094# a_28514_6336# sky130_fd_pr__cap_mim_m3_1 l=4.8 w=4.8
X1306 a_28514_3688# vss sky130_fd_pr__cap_mim_m3_1 l=1.6 w=1.6
X1307 a_7935_2090# a_7935_1490# vdd vdd sky130_fd_pr__pfet_01v8_lvt ad=0.609 pd=4.78 as=0.609 ps=4.78 w=2.1 l=0.35
X1308 a_7935_9170# a_15737_1934# a_15027_2855# vdd sky130_fd_pr__pfet_01v8_lvt ad=0.667 pd=5.18 as=0.3335 ps=2.59 w=2.3 l=0.35
X1309 a_20197_4220# a_18315_3741# vss vss sky130_fd_pr__nfet_01v8_lvt ad=0.203 pd=1.98 as=0.203 ps=1.98 w=0.7 l=0.15
X1310 a_24677_6640# a_22795_6161# vdd vdd sky130_fd_pr__pfet_01v8 ad=0.2805 pd=2.03 as=0.527 ps=4.02 w=1.7 l=0.15
X1311 ckd2 a_10451_12702# vdd vdd sky130_fd_pr__pfet_01v8 ad=0.495 pd=3.33 as=0.93 ps=6.62 w=3 l=0.15
X1312 vdd a_16309_11910# a_9937_11910# vdd sky130_fd_pr__pfet_01v8 ad=1.023 pd=7.22 as=0.5445 ps=3.63 w=3.3 l=0.15
X1313 a_22437_7240# a_20555_7929# vss vss sky130_fd_pr__nfet_01v8_lvt ad=0.203 pd=1.98 as=0.203 ps=1.98 w=0.7 l=0.15
X1314 a_16338_205# b4 vss vss sky130_fd_pr__nfet_01v8 ad=0.1305 pd=1.48 as=0.1305 ps=1.48 w=0.45 l=0.18
X1315 vss vdd a_30817_8037# vss sky130_fd_pr__nfet_01v8 ad=0.17835 pd=1.52 as=0.17835 ps=1.52 w=1.23 l=0.2
X1316 vss a_18719_5509# vss vss sky130_fd_pr__nfet_01v8_lvt ad=0.203 pd=1.98 as=0 ps=0 w=0.7 l=0.15
X1317 a_15027_2855# b3 a_7935_4450# vss sky130_fd_pr__nfet_01v8_lvt ad=0.12375 pd=1.08 as=0.2325 ps=2.12 w=0.75 l=0.15
X1318 a_7935_2090# a_6063_2090# vss vss sky130_fd_pr__nfet_01v8_lvt ad=0.2805 pd=2.03 as=0.527 ps=4.02 w=1.7 l=0.15
X1319 a_15027_4275# a_16125_1934# a_7935_4450# vdd sky130_fd_pr__pfet_01v8_lvt ad=0.3335 pd=2.59 as=0.667 ps=5.18 w=2.3 l=0.35
X1320 a_15027_4275# b5 a_7935_8570# vss sky130_fd_pr__nfet_01v8_lvt ad=0.12375 pd=1.08 as=0.2325 ps=2.12 w=0.75 l=0.15
X1321 vss a_25439_8261# vss vss sky130_fd_pr__nfet_01v8_lvt ad=0.203 pd=1.98 as=0 ps=0 w=0.7 l=0.15
X1322 a_26627_11933# rst_n en vss sky130_fd_pr__nfet_01v8_lvt ad=0.2145 pd=1.63 as=0.403 ps=3.22 w=1.3 l=0.15
X1323 a_20555_8261# a_20513_3298# a_16602_7094# vdd sky130_fd_pr__pfet_01v8_lvt ad=0.609 pd=4.78 as=0.609 ps=4.78 w=2.1 l=0.35
X1324 a_25035_7929# f6 a_13268_8794# vdd sky130_fd_pr__pfet_01v8_lvt ad=0.609 pd=4.78 as=0.609 ps=4.78 w=2.1 l=0.35
X1325 dn dp vdd vdd sky130_fd_pr__pfet_01v8 ad=0.3135 pd=2.23 as=0.589 ps=4.42 w=1.9 l=0.15
X1326 vss qp a_323_4520# vss sky130_fd_pr__nfet_01v8_lvt ad=0.217 pd=2.02 as=0.1155 ps=1.03 w=0.7 l=0.15
X1327 a_6063_3850# a_5993_3733# vdd vdd sky130_fd_pr__pfet_01v8_lvt ad=0.3045 pd=2.39 as=0.609 ps=4.78 w=2.1 l=0.35
X1328 vdd a_6063_6810# a_7935_6810# vdd sky130_fd_pr__pfet_01v8_lvt ad=0.609 pd=4.78 as=0.3045 ps=2.39 w=2.1 l=0.35
X1329 a_30817_8037# vdd vss vss sky130_fd_pr__nfet_01v8 ad=0.17835 pd=1.52 as=0.17835 ps=1.52 w=1.23 l=0.2
X1330 a_2903_3950# a_323_6880# vdd vdd sky130_fd_pr__pfet_01v8_lvt ad=0.1595 pd=1.39 as=0.319 ps=2.78 w=1.1 l=0.35
X1331 a_14997_11890# a_14067_11933# vdd vdd sky130_fd_pr__pfet_01v8_lvt ad=0.638 pd=4.98 as=0.638 ps=4.98 w=2.2 l=0.35
X1332 a_23199_7929# a_22753_3298# a_16768_8794# vss sky130_fd_pr__nfet_01v8_lvt ad=0.1885 pd=1.88 as=0.1885 ps=1.88 w=0.65 l=0.15
X1333 a_24677_7240# a_28514_6336# vss sky130_fd_pr__res_high_po_0p69 l=2.2
X1334 vdd a_18719_5509# vdd vdd sky130_fd_pr__pfet_01v8 ad=0.527 pd=4.02 as=0 ps=0 w=1.7 l=0.15
X1335 a_2903_1590# a_323_6880# vss vss sky130_fd_pr__nfet_01v8_lvt ad=0.319 pd=2.78 as=0.319 ps=2.78 w=1.1 l=0.15
X1336 a_22497_11800# a_24149_11800# vdd vdd sky130_fd_pr__pfet_01v8 ad=0.7975 pd=6.08 as=0.7975 ps=6.08 w=2.75 l=0.15
X1337 a_7935_6210# a4 a_11527_4275# vss sky130_fd_pr__nfet_01v8_lvt ad=0.2325 pd=2.12 as=0.12375 ps=1.08 w=0.75 l=0.15
X1338 a_3663_8670# a_5214_8660# vss sky130_fd_pr__res_high_po_0p69 l=1.5
X1339 a_11527_8795# a2 a_7935_6810# vss sky130_fd_pr__nfet_01v8_lvt ad=0.12375 pd=1.08 as=0.2325 ps=2.12 w=0.75 l=0.15
X1340 vdd a_13102_4274# a_13102_2574# vdd sky130_fd_pr__pfet_01v8 ad=0.462 pd=3.13 as=0.462 ps=3.13 w=2.8 l=0.15
X1341 a_15027_2855# b7 a_7935_3850# vss sky130_fd_pr__nfet_01v8_lvt ad=0.12375 pd=1.08 as=0.2325 ps=2.12 w=0.75 l=0.15
X1342 vss a_5993_6784# a_6063_6810# vss sky130_fd_pr__nfet_01v8_lvt ad=0.341 pd=2.82 as=0.1815 ps=1.43 w=1.1 l=0.15
X1343 a_24677_8740# a_22795_8261# vss vss sky130_fd_pr__nfet_01v8_lvt ad=0.203 pd=1.98 as=0.203 ps=1.98 w=0.7 l=0.15
X1344 a_26917_7240# a_25035_7929# vss vss sky130_fd_pr__nfet_01v8_lvt ad=0.203 pd=1.98 as=0.203 ps=1.98 w=0.7 l=0.15
X1345 a_23199_6161# f5 a_16768_8794# vdd sky130_fd_pr__pfet_01v8_lvt ad=0.609 pd=4.78 as=0.609 ps=4.78 w=2.1 l=0.35
X1346 a_16768_4274# a_16768_2574# vss sky130_fd_pr__res_high_po_0p35 l=6.5
X1347 vdd a_23199_3741# vdd vdd sky130_fd_pr__pfet_01v8 ad=0.527 pd=4.02 as=0 ps=0 w=1.7 l=0.15
X1348 vdd a_6063_8570# a_7935_8570# vdd sky130_fd_pr__pfet_01v8_lvt ad=0.609 pd=4.78 as=0.3045 ps=2.39 w=2.1 l=0.35
X1349 a_24149_11800# a_29327_12830# vdd vdd sky130_fd_pr__pfet_01v8 ad=0.5445 pd=3.63 as=1.023 ps=7.22 w=3.3 l=0.15
X1350 a_13268_8794# a_13268_7094# vdd vdd sky130_fd_pr__pfet_01v8_lvt ad=0.406 pd=3.09 as=0.812 ps=6.18 w=2.8 l=0.35
X1351 vdd a_6063_4450# a_7935_4450# vdd sky130_fd_pr__pfet_01v8_lvt ad=0.3045 pd=2.39 as=0.3045 ps=2.39 w=2.1 l=0.35
X1352 a_8717_11890# a_7787_11933# vdd vdd sky130_fd_pr__pfet_01v8 ad=0.4455 pd=3.03 as=0.837 ps=6.02 w=2.7 l=0.15
X1353 a_16768_8794# a_16768_7094# vss vss sky130_fd_pr__nfet_01v8_lvt ad=0.2805 pd=2.03 as=0.527 ps=4.02 w=1.7 l=0.15
X1354 vdd a_5993_1373# a_6063_1490# vdd sky130_fd_pr__pfet_01v8_lvt ad=0.609 pd=4.78 as=0.3045 ps=2.39 w=2.1 l=0.35
X1355 a_23199_1641# a_22753_1814# a_13268_4274# vdd sky130_fd_pr__pfet_01v8_lvt ad=0.609 pd=4.78 as=0.609 ps=4.78 w=2.1 l=0.35
X1356 ep en vdd vdd sky130_fd_pr__pfet_01v8 ad=0.3135 pd=2.23 as=0.589 ps=4.42 w=1.9 l=0.15
X1357 a_30963_3945# vss vdd vdd sky130_fd_pr__pfet_01v8 ad=0.2607 pd=1.91 as=0.4898 ps=3.78 w=1.58 l=0.15
X1358 a_2903_4550# a_323_2160# vdd vdd sky130_fd_pr__pfet_01v8_lvt ad=0.1595 pd=1.39 as=0.1595 ps=1.39 w=1.1 l=0.35
X1359 vdd a_323_6880# a_2903_1590# vdd sky130_fd_pr__pfet_01v8_lvt ad=0.319 pd=2.78 as=0.1595 ps=1.39 w=1.1 l=0.35
X1360 a_11527_8795# a6 a_7935_6210# vss sky130_fd_pr__nfet_01v8_lvt ad=0.12375 pd=1.08 as=0.2325 ps=2.12 w=0.75 l=0.15
X1361 vdd a_20959_5509# vdd vdd sky130_fd_pr__pfet_01v8 ad=0.527 pd=4.02 as=0 ps=0 w=1.7 l=0.15
X1362 ep rst_n a_20347_11933# vss sky130_fd_pr__nfet_01v8_lvt ad=0.403 pd=3.22 as=0.2145 ps=1.63 w=1.3 l=0.15
X1363 vss ip a_323_2160# vss sky130_fd_pr__nfet_01v8_lvt ad=0.217 pd=2.02 as=0.1155 ps=1.03 w=0.7 l=0.15
X1364 a_10029_11910# a_9999_11686# a_9937_11910# vdd sky130_fd_pr__pfet_01v8 ad=0.4125 pd=2.83 as=0.775 ps=5.62 w=2.5 l=0.15
X1365 a_7935_6210# a_7935_6810# vdd vdd sky130_fd_pr__pfet_01v8_lvt ad=0.609 pd=4.78 as=0.609 ps=4.78 w=2.1 l=0.35
X1366 a_13268_8794# a_13268_7094# vdd vdd sky130_fd_pr__pfet_01v8 ad=0.462 pd=3.13 as=0.462 ps=3.13 w=2.8 l=0.15
X1367 a_25035_3409# f6 a_16768_4274# vss sky130_fd_pr__nfet_01v8_lvt ad=0.1885 pd=1.88 as=0.1885 ps=1.88 w=0.65 l=0.15
X1368 a_23199_1641# f5 a_13268_4274# vss sky130_fd_pr__nfet_01v8_lvt ad=0.1885 pd=1.88 as=0.1885 ps=1.88 w=0.65 l=0.15
X1369 a_20959_3409# a_20513_3298# a_13268_4274# vdd sky130_fd_pr__pfet_01v8_lvt ad=0.609 pd=4.78 as=0.609 ps=4.78 w=2.1 l=0.35
X1370 vdd a_21667_12830# a_18550_13392# vdd sky130_fd_pr__pfet_01v8 ad=0.5445 pd=3.63 as=0.5445 ps=3.63 w=3.3 l=0.15
X1371 a_24149_11800# a_29327_12830# vss vss sky130_fd_pr__nfet_01v8_lvt ad=0.2805 pd=2.03 as=0.527 ps=4.02 w=1.7 l=0.15
X1372 vss a_25439_5509# vss vss sky130_fd_pr__nfet_01v8_lvt ad=0.203 pd=1.98 as=0 ps=0 w=0.7 l=0.15
X1373 vdd qn a_323_9240# vdd sky130_fd_pr__pfet_01v8_lvt ad=0.203 pd=1.69 as=0.203 ps=1.69 w=1.4 l=0.35
X1374 a_24677_2120# a_28514_1816# vss sky130_fd_pr__res_high_po_0p69 l=2.2
X1375 a_7935_2090# a_6063_2090# vdd vdd sky130_fd_pr__pfet_01v8_lvt ad=0.3045 pd=2.39 as=0.3045 ps=2.39 w=2.1 l=0.35
X1376 a_20197_4820# a_18315_5509# vdd vdd sky130_fd_pr__pfet_01v8 ad=0.2805 pd=2.03 as=0.527 ps=4.02 w=1.7 l=0.15
X1377 a_30963_7375# a_30963_8465# vdd vdd sky130_fd_pr__pfet_01v8 ad=0.2079 pd=1.59 as=0.3906 ps=3.14 w=1.26 l=0.15
X1378 a_22753_1814# f5 vdd vdd sky130_fd_pr__pfet_01v8 ad=0.261 pd=2.38 as=0.261 ps=2.38 w=0.9 l=0.18
X1379 a_17675_12870# a_10451_12702# a_18010_13668# vss sky130_fd_pr__nfet_01v8 ad=0.1218 pd=1.42 as=0.1218 ps=1.42 w=0.42 l=0.5
X1380 a_16602_7094# a_16602_8794# vdd vdd sky130_fd_pr__pfet_01v8_lvt ad=0.406 pd=3.09 as=0.812 ps=6.18 w=2.8 l=0.35
X1381 a_7935_9170# a_7935_8570# vdd vdd sky130_fd_pr__pfet_01v8_lvt ad=0.609 pd=4.78 as=0.609 ps=4.78 w=2.1 l=0.35
X1382 vdd a_323_6880# a_3663_1590# vdd sky130_fd_pr__pfet_01v8_lvt ad=0.1595 pd=1.39 as=0.1595 ps=1.39 w=1.1 l=0.35
X1383 a_26917_4220# a_25035_3741# vdd vdd sky130_fd_pr__pfet_01v8 ad=0.2805 pd=2.03 as=0.527 ps=4.02 w=1.7 l=0.15
X1384 vdd a_24149_11800# vdd vdd sky130_fd_pr__pfet_01v8_lvt ad=0.464 pd=3.78 as=0 ps=0 w=1.6 l=0.35
X1385 a_24677_4820# a_22795_5509# vss vss sky130_fd_pr__nfet_01v8_lvt ad=0.203 pd=1.98 as=0.203 ps=1.98 w=0.7 l=0.15
X1386 a_3663_4550# a_323_4520# vdd vdd sky130_fd_pr__pfet_01v8_lvt ad=0.1595 pd=1.39 as=0.319 ps=2.78 w=1.1 l=0.35
X1387 a_29702_4274# a_29702_2574# vss sky130_fd_pr__res_high_po_0p35 l=6.5
X1388 a_18315_3409# a_18273_3298# a_16768_4274# vdd sky130_fd_pr__pfet_01v8_lvt ad=0.609 pd=4.78 as=0.609 ps=4.78 w=2.1 l=0.35
X1389 a_25035_5509# a_24993_1814# a_16602_2574# vdd sky130_fd_pr__pfet_01v8_lvt ad=0.609 pd=4.78 as=0.609 ps=4.78 w=2.1 l=0.35
X1390 vdd a_25439_5509# vdd vdd sky130_fd_pr__pfet_01v8 ad=0.527 pd=4.02 as=0 ps=0 w=1.7 l=0.15
X1391 a_7935_6210# a_11849_1934# a_11527_7375# vdd sky130_fd_pr__pfet_01v8_lvt ad=0.667 pd=5.18 as=0.3335 ps=2.59 w=2.3 l=0.35
X1392 a_3663_6310# a_323_9240# vdd vdd sky130_fd_pr__pfet_01v8_lvt ad=0.1595 pd=1.39 as=0.1595 ps=1.39 w=1.1 l=0.35
X1393 a_16768_2574# a_15027_2855# sky130_fd_pr__cap_mim_m3_1 l=4.2 w=4.3
X1394 vdd a_18315_1641# a_20197_2120# vdd sky130_fd_pr__pfet_01v8 ad=0.527 pd=4.02 as=0.2805 ps=2.03 w=1.7 l=0.15
X1395 vss a_16768_2574# a_16768_4274# vss sky130_fd_pr__nfet_01v8_lvt ad=0.527 pd=4.02 as=0.2805 ps=2.03 w=1.7 l=0.15
X1396 a_7935_9170# a_6063_9170# vss vss sky130_fd_pr__nfet_01v8_lvt ad=0.2805 pd=2.03 as=0.527 ps=4.02 w=1.7 l=0.15
X1397 dp a_30963_7375# vdd vdd sky130_fd_pr__pfet_01v8 ad=0.495 pd=3.33 as=0.495 ps=3.33 w=3 l=0.15
X1398 a_25439_3409# a_24993_3298# a_13268_4274# vdd sky130_fd_pr__pfet_01v8_lvt ad=0.609 pd=4.78 as=0.609 ps=4.78 w=2.1 l=0.35
X1399 cke3 a_22497_11800# vss vss sky130_fd_pr__nfet_01v8_lvt ad=0.198 pd=1.53 as=0.372 ps=3.02 w=1.2 l=0.15
X1400 a_11527_7375# a0 a_7935_1490# vss sky130_fd_pr__nfet_01v8_lvt ad=0.12375 pd=1.08 as=0.2325 ps=2.12 w=0.75 l=0.15
X1401 a_22437_7240# a_20555_7929# vdd vdd sky130_fd_pr__pfet_01v8 ad=0.2805 pd=2.03 as=0.527 ps=4.02 w=1.7 l=0.15
X1402 a_18315_3409# a_18273_3298# a_13268_4274# vss sky130_fd_pr__nfet_01v8_lvt ad=0.1885 pd=1.88 as=0.1885 ps=1.88 w=0.65 l=0.15
X1403 a_11527_8795# a_12237_1934# a_7935_1490# vdd sky130_fd_pr__pfet_01v8_lvt ad=0.3335 pd=2.59 as=0.667 ps=5.18 w=2.3 l=0.35
X1404 vss vdd a_30817_3517# vss sky130_fd_pr__nfet_01v8 ad=0.3567 pd=3.04 as=0.17835 ps=1.52 w=1.23 l=0.2
X1405 a_18719_3409# a_18273_3298# a_16768_4274# vss sky130_fd_pr__nfet_01v8_lvt ad=0.1885 pd=1.88 as=0.1885 ps=1.88 w=0.65 l=0.15
X1406 a_24677_4820# a_22795_5509# vdd vdd sky130_fd_pr__pfet_01v8 ad=0.2805 pd=2.03 as=0.527 ps=4.02 w=1.7 l=0.15
X1407 vdd a_27557_11890# a_22559_11686# vdd sky130_fd_pr__pfet_01v8 ad=0.8184 pd=5.9 as=0.4356 ps=2.97 w=2.64 l=0.15
X1408 a_15027_4275# a_14961_1934# a_7935_9170# vdd sky130_fd_pr__pfet_01v8_lvt ad=0.3335 pd=2.59 as=0.667 ps=5.18 w=2.3 l=0.35
X1409 a_2903_8670# a_323_9240# vss vss sky130_fd_pr__nfet_01v8_lvt ad=0.319 pd=2.78 as=0.319 ps=2.78 w=1.1 l=0.15
X1410 vdd a_13102_8794# a_13102_7094# vdd sky130_fd_pr__pfet_01v8 ad=0.868 pd=6.22 as=0.462 ps=3.13 w=2.8 l=0.15
X1411 a_7935_3850# a_14961_1934# a_15027_7375# vdd sky130_fd_pr__pfet_01v8_lvt ad=0.667 pd=5.18 as=0.3335 ps=2.59 w=2.3 l=0.35
X1412 vdd in a_323_6880# vdd sky130_fd_pr__pfet_01v8_lvt ad=0.203 pd=1.69 as=0.203 ps=1.69 w=1.4 l=0.35
X1413 vdd a_5993_6784# a_6063_6810# vdd sky130_fd_pr__pfet_01v8_lvt ad=0.609 pd=4.78 as=0.3045 ps=2.39 w=2.1 l=0.35
X1414 a_12548_205# a1 vdd vdd sky130_fd_pr__pfet_01v8 ad=0.261 pd=2.38 as=0.261 ps=2.38 w=0.9 l=0.18
X1415 vdd a_23199_3409# vdd vdd sky130_fd_pr__pfet_01v8 ad=0.2805 pd=2.03 as=0 ps=0 w=1.7 l=0.15
X1416 vdd a_323_4520# a_2903_6910# vdd sky130_fd_pr__pfet_01v8_lvt ad=0.319 pd=2.78 as=0.1595 ps=1.39 w=1.1 l=0.35
X1417 a_7935_6810# a_12625_1934# a_11527_7375# vdd sky130_fd_pr__pfet_01v8_lvt ad=0.667 pd=5.18 as=0.3335 ps=2.59 w=2.3 l=0.35
X1418 a_25035_8261# a_24993_3298# a_13102_7094# vss sky130_fd_pr__nfet_01v8_lvt ad=0.1885 pd=1.88 as=0.1885 ps=1.88 w=0.65 l=0.15
X1419 a_29868_2574# a_28514_1816# sky130_fd_pr__cap_mim_m3_1 l=4.8 w=4.8
X1420 a_22795_1641# f5 a_16768_4274# vss sky130_fd_pr__nfet_01v8_lvt ad=0.1885 pd=1.88 as=0.1885 ps=1.88 w=0.65 l=0.15
X1421 a_20555_3409# a_20513_3298# a_16768_4274# vdd sky130_fd_pr__pfet_01v8_lvt ad=0.609 pd=4.78 as=0.609 ps=4.78 w=2.1 l=0.35
X1422 cke0 a_17910_13392# vdd vdd sky130_fd_pr__pfet_01v8 ad=0.495 pd=3.33 as=0.93 ps=6.62 w=3 l=0.15
X1423 a_8717_11890# a_7787_11933# vdd vdd sky130_fd_pr__pfet_01v8_lvt ad=0.638 pd=4.98 as=0.638 ps=4.98 w=2.2 l=0.35
X1424 a_11527_7375# a4 a_7935_2090# vss sky130_fd_pr__nfet_01v8_lvt ad=0.12375 pd=1.08 as=0.2325 ps=2.12 w=0.75 l=0.15
X1425 a_25439_8261# a_24993_3298# a_16602_7094# vss sky130_fd_pr__nfet_01v8_lvt ad=0.1885 pd=1.88 as=0.1885 ps=1.88 w=0.65 l=0.15
X1426 a_18315_5509# f1 a_13102_2574# vdd sky130_fd_pr__pfet_01v8_lvt ad=0.609 pd=4.78 as=0.609 ps=4.78 w=2.1 l=0.35
X1427 vdd a_22795_1641# a_24677_2120# vdd sky130_fd_pr__pfet_01v8 ad=0.527 pd=4.02 as=0.2805 ps=2.03 w=1.7 l=0.15
X1428 a_20555_1641# f3 a_13268_4274# vdd sky130_fd_pr__pfet_01v8_lvt ad=0.609 pd=4.78 as=0.609 ps=4.78 w=2.1 l=0.35
X1429 vss a_18719_7929# vss vss sky130_fd_pr__nfet_01v8_lvt ad=0.203 pd=1.98 as=0 ps=0 w=0.7 l=0.15
X1430 a_13102_4274# a_13102_2574# vss sky130_fd_pr__res_high_po_0p35 l=6.5
X1431 a_18719_5509# f1 a_16602_2574# vdd sky130_fd_pr__pfet_01v8_lvt ad=0.609 pd=4.78 as=0.609 ps=4.78 w=2.1 l=0.35
X1432 vss a_18550_13392# cke2 vss sky130_fd_pr__nfet_01v8_lvt ad=0.372 pd=3.02 as=0.198 ps=1.53 w=1.2 l=0.15
X1433 vdd vss a_30963_2855# vdd sky130_fd_pr__pfet_01v8 ad=0.4898 pd=3.78 as=0.2607 ps=1.91 w=1.58 l=0.15
X1434 a_12237_1934# a4 vdd vdd sky130_fd_pr__pfet_01v8 ad=0.261 pd=2.38 as=0.261 ps=2.38 w=0.9 l=0.18
X1435 vdd a_5993_8453# a_6063_8570# vdd sky130_fd_pr__pfet_01v8_lvt ad=0.609 pd=4.78 as=0.3045 ps=2.39 w=2.1 l=0.35
X1436 vdd a_18719_8261# vdd vdd sky130_fd_pr__pfet_01v8 ad=0.2805 pd=2.03 as=0 ps=0 w=1.7 l=0.15
X1437 a_20959_1641# f3 a_16768_4274# vdd sky130_fd_pr__pfet_01v8_lvt ad=0.609 pd=4.78 as=0.609 ps=4.78 w=2.1 l=0.35
X1438 ckd3 a_11270_13392# vss vss sky130_fd_pr__nfet_01v8_lvt ad=0.198 pd=1.53 as=0.372 ps=3.02 w=1.2 l=0.15
X1439 vdd a_323_9240# a_2903_8670# vdd sky130_fd_pr__pfet_01v8_lvt ad=0.319 pd=2.78 as=0.1595 ps=1.39 w=1.1 l=0.35
X1440 a_3663_3950# a_323_9240# vdd vdd sky130_fd_pr__pfet_01v8_lvt ad=0.1595 pd=1.39 as=0.1595 ps=1.39 w=1.1 l=0.35
X1441 a_6063_1490# a_5993_1373# vdd vdd sky130_fd_pr__pfet_01v8_lvt ad=0.3045 pd=2.39 as=0.609 ps=4.78 w=2.1 l=0.35
X1442 vdd a_6063_4450# a_7935_4450# vdd sky130_fd_pr__pfet_01v8_lvt ad=0.609 pd=4.78 as=0.3045 ps=2.39 w=2.1 l=0.35
X1443 a_2903_1590# a_323_6880# vdd vdd sky130_fd_pr__pfet_01v8_lvt ad=0.1595 pd=1.39 as=0.319 ps=2.78 w=1.1 l=0.35
X1444 cke2 a_18550_13392# vdd vdd sky130_fd_pr__pfet_01v8 ad=0.495 pd=3.33 as=0.93 ps=6.62 w=3 l=0.15
X1445 a_22795_10029# a_22753_1814# a_16602_7094# vdd sky130_fd_pr__pfet_01v8_lvt ad=0.609 pd=4.78 as=0.609 ps=4.78 w=2.1 l=0.35
X1446 a_7935_6210# a0 a_11527_2855# vss sky130_fd_pr__nfet_01v8_lvt ad=0.2325 pd=2.12 as=0.12375 ps=1.08 w=0.75 l=0.15
X1447 vdd a_20555_3409# a_22437_2720# vdd sky130_fd_pr__pfet_01v8 ad=0.527 pd=4.02 as=0.2805 ps=2.03 w=1.7 l=0.15
X1448 cke2 cke0 vdd vdd sky130_fd_pr__pfet_01v8 ad=0.6264 pd=4.9 as=0.6264 ps=4.9 w=2.16 l=0.15
X1449 a_22507_12830# a_21667_12830# vdd vdd sky130_fd_pr__pfet_01v8 ad=0.174 pd=1.78 as=0.174 ps=1.78 w=0.6 l=0.28
X1450 vss qn a_323_9240# vss sky130_fd_pr__nfet_01v8_lvt ad=0.217 pd=2.02 as=0.1155 ps=1.03 w=0.7 l=0.15
X1451 a_22753_1814# f5 vss vss sky130_fd_pr__nfet_01v8 ad=0.1305 pd=1.48 as=0.1305 ps=1.48 w=0.45 l=0.18
X1452 vdd a_17910_13392# cke0 vdd sky130_fd_pr__pfet_01v8 ad=0.495 pd=3.33 as=0.495 ps=3.33 w=3 l=0.15
X1453 a_22497_11800# a_28467_12830# vss vss sky130_fd_pr__nfet_01v8_lvt ad=0.2805 pd=2.03 as=0.527 ps=4.02 w=1.7 l=0.15
X1454 vss a_25439_10029# vss vss sky130_fd_pr__nfet_01v8_lvt ad=0.203 pd=1.98 as=0 ps=0 w=0.7 l=0.15
X1455 vdd a_323_4520# a_3663_6910# vdd sky130_fd_pr__pfet_01v8_lvt ad=0.1595 pd=1.39 as=0.1595 ps=1.39 w=1.1 l=0.35
X1456 a_20555_6161# a_20513_1814# a_13268_8794# vss sky130_fd_pr__nfet_01v8_lvt ad=0.1885 pd=1.88 as=0.1885 ps=1.88 w=0.65 l=0.15
X1457 a_30817_8037# a_29702_7094# a_30963_8465# vss sky130_fd_pr__nfet_01v8_lvt ad=0.396 pd=2.73 as=0.396 ps=2.73 w=2.4 l=0.15
X1458 a_2903_6310# a_323_9240# vss vss sky130_fd_pr__nfet_01v8_lvt ad=0.319 pd=2.78 as=0.319 ps=2.78 w=1.1 l=0.15
X1459 vss a_5993_4424# a_6063_4450# vss sky130_fd_pr__nfet_01v8_lvt ad=0.341 pd=2.82 as=0.1815 ps=1.43 w=1.1 l=0.15
X1460 a_7935_1490# a2 a_11527_4275# vss sky130_fd_pr__nfet_01v8_lvt ad=0.2325 pd=2.12 as=0.12375 ps=1.08 w=0.75 l=0.15
X1461 a_16602_7094# a_16602_8794# vdd vdd sky130_fd_pr__pfet_01v8 ad=0.462 pd=3.13 as=0.868 ps=6.22 w=2.8 l=0.15
X1462 a_20959_6161# a_20513_1814# a_16768_8794# vss sky130_fd_pr__nfet_01v8_lvt ad=0.1885 pd=1.88 as=0.1885 ps=1.88 w=0.65 l=0.15
X1463 a_22795_3741# a_22753_3298# a_13102_2574# vss sky130_fd_pr__nfet_01v8_lvt ad=0.1885 pd=1.88 as=0.1885 ps=1.88 w=0.65 l=0.15
X1464 vdd a_30963_2855# a_30963_3945# vdd sky130_fd_pr__pfet_01v8 ad=0.3906 pd=3.14 as=0.2079 ps=1.59 w=1.26 l=0.15
X1465 a_7935_9170# a_6063_9170# vdd vdd sky130_fd_pr__pfet_01v8_lvt ad=0.3045 pd=2.39 as=0.3045 ps=2.39 w=2.1 l=0.35
X1466 vdd a_23199_6161# vdd vdd sky130_fd_pr__pfet_01v8 ad=0.527 pd=4.02 as=0 ps=0 w=1.7 l=0.15
X1467 a_20458_12920# a_17675_12870# vss vss sky130_fd_pr__nfet_01v8 ad=0.2465 pd=2.28 as=0.2465 ps=2.28 w=0.85 l=0.18
X1468 a_14997_11890# a_14067_11933# vss vss sky130_fd_pr__nfet_01v8_lvt ad=0.464 pd=3.78 as=0.464 ps=3.78 w=1.6 l=0.15
X1469 a_11527_7375# a_11461_1934# a_7935_1490# vdd sky130_fd_pr__pfet_01v8_lvt ad=0.3335 pd=2.59 as=0.667 ps=5.18 w=2.3 l=0.35
X1470 a_6063_2090# a_5993_2064# vss vss sky130_fd_pr__nfet_01v8_lvt ad=0.1815 pd=1.43 as=0.341 ps=2.82 w=1.1 l=0.15
X1471 vdd a_6063_2090# a_7935_2090# vdd sky130_fd_pr__pfet_01v8_lvt ad=0.3045 pd=2.39 as=0.3045 ps=2.39 w=2.1 l=0.35
X1472 a_30817_3517# vdd vss vss sky130_fd_pr__nfet_01v8 ad=0.17835 pd=1.52 as=0.3567 ps=3.04 w=1.23 l=0.2
X1473 a_29327_12830# a_27658_12850# a_28947_12830# vdd sky130_fd_pr__pfet_01v8 ad=0.33 pd=2.33 as=0.62 ps=4.62 w=2 l=0.15
X1474 vdd a_323_2160# a_3663_8670# vdd sky130_fd_pr__pfet_01v8_lvt ad=0.1595 pd=1.39 as=0.1595 ps=1.39 w=1.1 l=0.35
X1475 a_7935_9170# a_15349_1934# a_15027_8795# vdd sky130_fd_pr__pfet_01v8_lvt ad=0.667 pd=5.18 as=0.3335 ps=2.59 w=2.3 l=0.35
X1476 vdd a_20959_8261# vdd vdd sky130_fd_pr__pfet_01v8 ad=0.2805 pd=2.03 as=0 ps=0 w=1.7 l=0.15
X1477 a_23199_8261# a_22753_3298# a_13102_7094# vdd sky130_fd_pr__pfet_01v8_lvt ad=0.609 pd=4.78 as=0.609 ps=4.78 w=2.1 l=0.35
X1478 vdd a_16768_7094# a_16768_8794# vdd sky130_fd_pr__pfet_01v8 ad=0.462 pd=3.13 as=0.462 ps=3.13 w=2.8 l=0.15
X1479 a_7935_9170# b1 a_15027_4275# vss sky130_fd_pr__nfet_01v8_lvt ad=0.2325 pd=2.12 as=0.12375 ps=1.08 w=0.75 l=0.15
X1480 a_10029_11910# a_10522_11144# vdd vdd sky130_fd_pr__pfet_01v8 ad=0.174 pd=1.78 as=0.174 ps=1.78 w=0.6 l=0.28
X1481 a_7935_4450# b5 a_15027_7375# vss sky130_fd_pr__nfet_01v8_lvt ad=0.2325 pd=2.12 as=0.12375 ps=1.08 w=0.75 l=0.15
X1482 a_2903_2190# a_323_2160# vdd vdd sky130_fd_pr__pfet_01v8_lvt ad=0.1595 pd=1.39 as=0.1595 ps=1.39 w=1.1 l=0.35
X1483 vdd a_25035_7929# a_26917_7240# vdd sky130_fd_pr__pfet_01v8 ad=0.527 pd=4.02 as=0.2805 ps=2.03 w=1.7 l=0.15
X1484 a_11527_2855# a_12237_1934# a_7935_6810# vdd sky130_fd_pr__pfet_01v8_lvt ad=0.3335 pd=2.59 as=0.667 ps=5.18 w=2.3 l=0.35
X1485 a_9999_11686# a_14997_11890# vdd vdd sky130_fd_pr__pfet_01v8 ad=0.4356 pd=2.97 as=0.8184 ps=5.9 w=2.64 l=0.15
X1486 en rst_n a_26627_11933# vss sky130_fd_pr__nfet_01v8_lvt ad=0.403 pd=3.22 as=0.2145 ps=1.63 w=1.3 l=0.15
X1487 vss a_20959_6161# vss vss sky130_fd_pr__nfet_01v8_lvt ad=0.203 pd=1.98 as=0 ps=0 w=0.7 l=0.15
X1488 a_7935_3850# a_7935_4450# vdd vdd sky130_fd_pr__pfet_01v8_lvt ad=0.609 pd=4.78 as=0.609 ps=4.78 w=2.1 l=0.35
X1489 a_12548_205# a1 vss vss sky130_fd_pr__nfet_01v8 ad=0.1305 pd=1.48 as=0.1305 ps=1.48 w=0.45 l=0.18
X1490 a_25035_5509# f7 a_13102_2574# vdd sky130_fd_pr__pfet_01v8_lvt ad=0.609 pd=4.78 as=0.609 ps=4.78 w=2.1 l=0.35
X1491 a_20513_3298# f2 vdd vdd sky130_fd_pr__pfet_01v8 ad=0.261 pd=2.38 as=0.261 ps=2.38 w=0.9 l=0.18
X1492 vss a_23199_3741# vss vss sky130_fd_pr__nfet_01v8_lvt ad=0.203 pd=1.98 as=0 ps=0 w=0.7 l=0.15
X1493 vss vdd a_30217_2855# vss sky130_fd_pr__nfet_01v8 ad=0.16675 pd=1.44 as=0.16675 ps=1.44 w=1.15 l=0.2
X1494 vss a_25439_7929# vss vss sky130_fd_pr__nfet_01v8_lvt ad=0.203 pd=1.98 as=0 ps=0 w=0.7 l=0.15
X1495 a_7935_8570# a_16125_1934# a_15027_8795# vdd sky130_fd_pr__pfet_01v8_lvt ad=0.667 pd=5.18 as=0.3335 ps=2.59 w=2.3 l=0.35
X1496 a_20197_6640# a_18315_6161# vss vss sky130_fd_pr__nfet_01v8_lvt ad=0.203 pd=1.98 as=0.203 ps=1.98 w=0.7 l=0.15
X1497 vss vdd a_30817_8037# vss sky130_fd_pr__nfet_01v8 ad=0.17835 pd=1.52 as=0.17835 ps=1.52 w=1.23 l=0.2
X1498 vdd a_25439_8261# vdd vdd sky130_fd_pr__pfet_01v8 ad=0.2805 pd=2.03 as=0 ps=0 w=1.7 l=0.15
X1499 vdd dp dn vdd sky130_fd_pr__pfet_01v8 ad=0.589 pd=4.42 as=0.3135 ps=2.23 w=1.9 l=0.15
X1500 a_12237_1934# a4 vss vss sky130_fd_pr__nfet_01v8 ad=0.1305 pd=1.48 as=0.1305 ps=1.48 w=0.45 l=0.18
X1501 a_6063_6810# a_5993_6784# vdd vdd sky130_fd_pr__pfet_01v8_lvt ad=0.3045 pd=2.39 as=0.609 ps=4.78 w=2.1 l=0.35
.ends
