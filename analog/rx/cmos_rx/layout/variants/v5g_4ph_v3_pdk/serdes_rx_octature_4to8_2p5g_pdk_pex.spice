* NGSPICE file created from serdes_rx_octature_4to8_2p5g_pdk.ext - technology: sky130A

.subckt serdes_rx_octature_4to8_2p5g_pdk ip qp in qn cb0 cb1 cb2 cb3 cb4 cb5 cb6 cb7
+ vdd vss
X0 cb3 a_6063_8350# vdd vdd sky130_fd_pr__pfet_01v8_lvt ad=0.3045 pd=2.39 as=0.3045 ps=2.39 w=2.1 l=0.35
X1 vdd a_6063_5390# cb6 vdd sky130_fd_pr__pfet_01v8_lvt ad=0.609 pd=4.78 as=0.3045 ps=2.39 w=2.1 l=0.35
X2 vdd a_6063_1270# cb0 vdd sky130_fd_pr__pfet_01v8_lvt ad=0.3045 pd=2.39 as=0.3045 ps=2.39 w=2.1 l=0.35
X3 a_6063_1270# a_5993_1244# vss vss sky130_fd_pr__nfet_01v8_lvt ad=0.1815 pd=1.43 as=0.341 ps=2.82 w=1.1 l=0.15
X4 vdd a_323_1340# a_3663_7850# vdd sky130_fd_pr__pfet_01v8_lvt ad=0.1595 pd=1.39 as=0.1595 ps=1.39 w=1.1 l=0.35
X5 a_323_3700# vss sky130_fd_pr__cap_mim_m3_1 l=1.75 w=1.75
X6 a_2903_1370# a_323_1340# vdd vdd sky130_fd_pr__pfet_01v8_lvt ad=0.1595 pd=1.39 as=0.1595 ps=1.39 w=1.1 l=0.35
X7 vdd in a_323_6060# vdd sky130_fd_pr__pfet_01v8_lvt ad=0.203 pd=1.69 as=0.203 ps=1.69 w=1.4 l=0.35
X8 cb5 cb1 vdd vdd sky130_fd_pr__pfet_01v8_lvt ad=0.609 pd=4.78 as=0.609 ps=4.78 w=2.1 l=0.35
X9 cb2 a_6063_5990# vdd vdd sky130_fd_pr__pfet_01v8_lvt ad=0.3045 pd=2.39 as=0.3045 ps=2.39 w=2.1 l=0.35
X10 cb2 cb6 vdd vdd sky130_fd_pr__pfet_01v8_lvt ad=0.609 pd=4.78 as=0.609 ps=4.78 w=2.1 l=0.35
X11 a_5993_7633# a_5214_7840# sky130_fd_pr__cap_mim_m3_1 l=4.2 w=4.2
X12 cb2 a_6063_5990# vss vss sky130_fd_pr__nfet_01v8_lvt ad=0.2805 pd=2.03 as=0.527 ps=4.02 w=1.7 l=0.15
X13 a_3663_3130# a_323_8420# vdd vdd sky130_fd_pr__pfet_01v8_lvt ad=0.1595 pd=1.39 as=0.1595 ps=1.39 w=1.1 l=0.35
X14 a_3663_1370# a_323_1340# vdd vdd sky130_fd_pr__pfet_01v8_lvt ad=0.1595 pd=1.39 as=0.319 ps=2.78 w=1.1 l=0.35
X15 vss qn a_323_8420# vss sky130_fd_pr__nfet_01v8_lvt ad=0.217 pd=2.02 as=0.1155 ps=1.03 w=0.7 l=0.15
X16 a_6063_7750# a_5993_7633# vdd vdd sky130_fd_pr__pfet_01v8_lvt ad=0.3045 pd=2.39 as=0.609 ps=4.78 w=2.1 l=0.35
X17 vdd qp a_323_3700# vdd sky130_fd_pr__pfet_01v8_lvt ad=0.406 pd=3.38 as=0.203 ps=1.69 w=1.4 l=0.35
X18 a_5993_5273# a_5214_5480# sky130_fd_pr__cap_mim_m3_1 l=4.2 w=4.2
X19 a_2903_7850# a_323_8420# vdd vdd sky130_fd_pr__pfet_01v8_lvt ad=0.1595 pd=1.39 as=0.319 ps=2.78 w=1.1 l=0.35
X20 vdd a_323_1340# a_2903_3730# vdd sky130_fd_pr__pfet_01v8_lvt ad=0.319 pd=2.78 as=0.1595 ps=1.39 w=1.1 l=0.35
X21 vdd a_5993_3604# a_6063_3630# vdd sky130_fd_pr__pfet_01v8_lvt ad=0.609 pd=4.78 as=0.3045 ps=2.39 w=2.1 l=0.35
X22 vdd a_6063_8350# cb3 vdd sky130_fd_pr__pfet_01v8_lvt ad=0.3045 pd=2.39 as=0.3045 ps=2.39 w=2.1 l=0.35
X23 a_2903_8450# a_323_3700# vdd vdd sky130_fd_pr__pfet_01v8_lvt ad=0.1595 pd=1.39 as=0.1595 ps=1.39 w=1.1 l=0.35
X24 vdd a_323_8420# a_2903_5490# vdd sky130_fd_pr__pfet_01v8_lvt ad=0.319 pd=2.78 as=0.1595 ps=1.39 w=1.1 l=0.35
X25 vdd a_5993_5273# a_6063_5390# vdd sky130_fd_pr__pfet_01v8_lvt ad=0.609 pd=4.78 as=0.3045 ps=2.39 w=2.1 l=0.35
X26 vdd a_6063_1270# cb0 vdd sky130_fd_pr__pfet_01v8_lvt ad=0.609 pd=4.78 as=0.3045 ps=2.39 w=2.1 l=0.35
X27 vss in a_323_6060# vss sky130_fd_pr__nfet_01v8_lvt ad=0.217 pd=2.02 as=0.1155 ps=1.03 w=0.7 l=0.15
X28 vdd a_323_3700# a_3663_3730# vdd sky130_fd_pr__pfet_01v8_lvt ad=0.1595 pd=1.39 as=0.1595 ps=1.39 w=1.1 l=0.35
X29 a_2903_3130# a_323_6060# vss vss sky130_fd_pr__nfet_01v8_lvt ad=0.319 pd=2.78 as=0.319 ps=2.78 w=1.1 l=0.15
X30 vss a_5993_8324# a_6063_8350# vss sky130_fd_pr__nfet_01v8_lvt ad=0.341 pd=2.82 as=0.1815 ps=1.43 w=1.1 l=0.15
X31 a_3663_8450# a_323_6060# vdd vdd sky130_fd_pr__pfet_01v8_lvt ad=0.1595 pd=1.39 as=0.319 ps=2.78 w=1.1 l=0.35
X32 vdd a_323_8420# a_3663_5490# vdd sky130_fd_pr__pfet_01v8_lvt ad=0.1595 pd=1.39 as=0.1595 ps=1.39 w=1.1 l=0.35
X33 vdd a_6063_5990# cb2 vdd sky130_fd_pr__pfet_01v8_lvt ad=0.3045 pd=2.39 as=0.3045 ps=2.39 w=2.1 l=0.35
X34 vdd a_6063_670# cb4 vdd sky130_fd_pr__pfet_01v8_lvt ad=0.3045 pd=2.39 as=0.3045 ps=2.39 w=2.1 l=0.35
X35 cb4 cb0 vdd vdd sky130_fd_pr__pfet_01v8_lvt ad=0.609 pd=4.78 as=0.609 ps=4.78 w=2.1 l=0.35
X36 a_6063_3630# a_5993_3604# vdd vdd sky130_fd_pr__pfet_01v8_lvt ad=0.3045 pd=2.39 as=0.609 ps=4.78 w=2.1 l=0.35
X37 a_2903_3730# a_323_1340# vdd vdd sky130_fd_pr__pfet_01v8_lvt ad=0.1595 pd=1.39 as=0.319 ps=2.78 w=1.1 l=0.35
X38 a_3663_7850# a_323_1340# vdd vdd sky130_fd_pr__pfet_01v8_lvt ad=0.1595 pd=1.39 as=0.1595 ps=1.39 w=1.1 l=0.35
X39 a_2903_5490# a_323_8420# vdd vdd sky130_fd_pr__pfet_01v8_lvt ad=0.1595 pd=1.39 as=0.319 ps=2.78 w=1.1 l=0.35
X40 a_6063_5390# a_5993_5273# vdd vdd sky130_fd_pr__pfet_01v8_lvt ad=0.3045 pd=2.39 as=0.609 ps=4.78 w=2.1 l=0.35
X41 vdd a_6063_8350# cb3 vdd sky130_fd_pr__pfet_01v8_lvt ad=0.609 pd=4.78 as=0.3045 ps=2.39 w=2.1 l=0.35
X42 cb5 cb1 vss vss sky130_fd_pr__nfet_01v8_lvt ad=0.1305 pd=1.48 as=0.1305 ps=1.48 w=0.45 l=0.15
X43 vdd ip a_323_1340# vdd sky130_fd_pr__pfet_01v8_lvt ad=0.406 pd=3.38 as=0.203 ps=1.69 w=1.4 l=0.35
X44 a_323_3700# qp vss vss sky130_fd_pr__nfet_01v8_lvt ad=0.1155 pd=1.03 as=0.217 ps=2.02 w=0.7 l=0.15
X45 vdd a_5993_1244# a_6063_1270# vdd sky130_fd_pr__pfet_01v8_lvt ad=0.609 pd=4.78 as=0.3045 ps=2.39 w=2.1 l=0.35
X46 vdd a_323_1340# a_2903_1370# vdd sky130_fd_pr__pfet_01v8_lvt ad=0.319 pd=2.78 as=0.1595 ps=1.39 w=1.1 l=0.35
X47 a_6063_5990# a_5993_5964# vss vss sky130_fd_pr__nfet_01v8_lvt ad=0.1815 pd=1.43 as=0.341 ps=2.82 w=1.1 l=0.15
X48 a_2903_6090# a_323_3700# vdd vdd sky130_fd_pr__pfet_01v8_lvt ad=0.1595 pd=1.39 as=0.1595 ps=1.39 w=1.1 l=0.35
X49 cb4 cb0 vss vss sky130_fd_pr__nfet_01v8_lvt ad=0.1305 pd=1.48 as=0.1305 ps=1.48 w=0.45 l=0.15
X50 cb7 cb3 vdd vdd sky130_fd_pr__pfet_01v8_lvt ad=0.609 pd=4.78 as=0.609 ps=4.78 w=2.1 l=0.35
X51 vdd a_6063_5990# cb2 vdd sky130_fd_pr__pfet_01v8_lvt ad=0.609 pd=4.78 as=0.3045 ps=2.39 w=2.1 l=0.35
X52 vdd a_5993_553# a_6063_670# vdd sky130_fd_pr__pfet_01v8_lvt ad=0.609 pd=4.78 as=0.3045 ps=2.39 w=2.1 l=0.35
X53 vdd a_323_1340# a_3663_1370# vdd sky130_fd_pr__pfet_01v8_lvt ad=0.1595 pd=1.39 as=0.1595 ps=1.39 w=1.1 l=0.35
X54 a_323_1340# ip vss vss sky130_fd_pr__nfet_01v8_lvt ad=0.1155 pd=1.03 as=0.217 ps=2.02 w=0.7 l=0.15
X55 a_3663_6090# a_323_3700# vdd vdd sky130_fd_pr__pfet_01v8_lvt ad=0.1595 pd=1.39 as=0.319 ps=2.78 w=1.1 l=0.35
X56 vdd qn a_323_8420# vdd sky130_fd_pr__pfet_01v8_lvt ad=0.406 pd=3.38 as=0.203 ps=1.69 w=1.4 l=0.35
X57 cb6 cb2 vdd vdd sky130_fd_pr__pfet_01v8_lvt ad=0.609 pd=4.78 as=0.609 ps=4.78 w=2.1 l=0.35
X58 vdd a_5993_8324# a_6063_8350# vdd sky130_fd_pr__pfet_01v8_lvt ad=0.609 pd=4.78 as=0.3045 ps=2.39 w=2.1 l=0.35
X59 a_3663_3730# a_323_3700# vdd vdd sky130_fd_pr__pfet_01v8_lvt ad=0.1595 pd=1.39 as=0.1595 ps=1.39 w=1.1 l=0.35
X60 a_6063_1270# a_5993_1244# vdd vdd sky130_fd_pr__pfet_01v8_lvt ad=0.3045 pd=2.39 as=0.609 ps=4.78 w=2.1 l=0.35
X61 vdd a_323_3700# a_2903_8450# vdd sky130_fd_pr__pfet_01v8_lvt ad=0.319 pd=2.78 as=0.1595 ps=1.39 w=1.1 l=0.35
X62 vss a_6063_3030# cb5 vss sky130_fd_pr__nfet_01v8_lvt ad=0.527 pd=4.02 as=0.2805 ps=2.03 w=1.7 l=0.15
X63 a_2903_1370# a_323_1340# vdd vdd sky130_fd_pr__pfet_01v8_lvt ad=0.1595 pd=1.39 as=0.319 ps=2.78 w=1.1 l=0.35
X64 a_3663_5490# a_323_8420# vdd vdd sky130_fd_pr__pfet_01v8_lvt ad=0.1595 pd=1.39 as=0.1595 ps=1.39 w=1.1 l=0.35
X65 a_323_1340# vss sky130_fd_pr__cap_mim_m3_1 l=1.75 w=1.75
X66 a_3663_770# a_323_6060# vdd vdd sky130_fd_pr__pfet_01v8_lvt ad=0.1595 pd=1.39 as=0.1595 ps=1.39 w=1.1 l=0.35
X67 vdd a_323_6060# a_3663_8450# vdd sky130_fd_pr__pfet_01v8_lvt ad=0.1595 pd=1.39 as=0.1595 ps=1.39 w=1.1 l=0.35
X68 vdd a_323_6060# a_2903_770# vdd sky130_fd_pr__pfet_01v8_lvt ad=0.1595 pd=1.39 as=0.1595 ps=1.39 w=1.1 l=0.35
X69 vdd a_5993_5964# a_6063_5990# vdd sky130_fd_pr__pfet_01v8_lvt ad=0.609 pd=4.78 as=0.3045 ps=2.39 w=2.1 l=0.35
X70 a_6063_3630# a_5993_3604# vss vss sky130_fd_pr__nfet_01v8_lvt ad=0.1815 pd=1.43 as=0.341 ps=2.82 w=1.1 l=0.15
X71 a_5993_3604# a_6063_3630# vss sky130_fd_pr__res_high_po_0p35 l=9.5
X72 a_3663_7850# a_323_1340# vss vss sky130_fd_pr__nfet_01v8_lvt ad=0.319 pd=2.78 as=0.319 ps=2.78 w=1.1 l=0.15
X73 cb0 cb4 vss vss sky130_fd_pr__nfet_01v8_lvt ad=0.1305 pd=1.48 as=0.1305 ps=1.48 w=0.45 l=0.15
X74 cb5 a_6063_3030# vdd vdd sky130_fd_pr__pfet_01v8_lvt ad=0.3045 pd=2.39 as=0.3045 ps=2.39 w=2.1 l=0.35
X75 a_2903_8450# a_323_3700# vdd vdd sky130_fd_pr__pfet_01v8_lvt ad=0.1595 pd=1.39 as=0.319 ps=2.78 w=1.1 l=0.35
X76 a_6063_8350# a_5993_8324# vdd vdd sky130_fd_pr__pfet_01v8_lvt ad=0.3045 pd=2.39 as=0.609 ps=4.78 w=2.1 l=0.35
X77 cb7 cb3 vss vss sky130_fd_pr__nfet_01v8_lvt ad=0.1305 pd=1.48 as=0.1305 ps=1.48 w=0.45 l=0.15
X78 vdd in a_323_6060# vdd sky130_fd_pr__pfet_01v8_lvt ad=0.406 pd=3.38 as=0.203 ps=1.69 w=1.4 l=0.35
X79 a_3663_5490# a_323_8420# vss vss sky130_fd_pr__nfet_01v8_lvt ad=0.319 pd=2.78 as=0.319 ps=2.78 w=1.1 l=0.15
X80 a_323_8420# qn vss vss sky130_fd_pr__nfet_01v8_lvt ad=0.1155 pd=1.03 as=0.217 ps=2.02 w=0.7 l=0.15
X81 vdd a_323_3700# a_2903_6090# vdd sky130_fd_pr__pfet_01v8_lvt ad=0.319 pd=2.78 as=0.1595 ps=1.39 w=1.1 l=0.35
X82 a_3663_1370# a_323_1340# vdd vdd sky130_fd_pr__pfet_01v8_lvt ad=0.1595 pd=1.39 as=0.1595 ps=1.39 w=1.1 l=0.35
X83 a_6063_5990# a_5993_5964# vdd vdd sky130_fd_pr__pfet_01v8_lvt ad=0.3045 pd=2.39 as=0.609 ps=4.78 w=2.1 l=0.35
X84 cb6 cb2 vss vss sky130_fd_pr__nfet_01v8_lvt ad=0.1305 pd=1.48 as=0.1305 ps=1.48 w=0.45 l=0.15
X85 vdd a_323_3700# a_3663_6090# vdd sky130_fd_pr__pfet_01v8_lvt ad=0.1595 pd=1.39 as=0.1595 ps=1.39 w=1.1 l=0.35
X86 a_323_6060# in vss vss sky130_fd_pr__nfet_01v8_lvt ad=0.1155 pd=1.03 as=0.217 ps=2.02 w=0.7 l=0.15
X87 a_6063_8350# a_5993_8324# vss vss sky130_fd_pr__nfet_01v8_lvt ad=0.1815 pd=1.43 as=0.341 ps=2.82 w=1.1 l=0.15
X88 a_5993_5964# a_5214_5948# sky130_fd_pr__cap_mim_m3_1 l=4.2 w=4.2
X89 cb0 cb4 vdd vdd sky130_fd_pr__pfet_01v8_lvt ad=0.609 pd=4.78 as=0.609 ps=4.78 w=2.1 l=0.35
X90 cb4 a_6063_670# vdd vdd sky130_fd_pr__pfet_01v8_lvt ad=0.3045 pd=2.39 as=0.609 ps=4.78 w=2.1 l=0.35
X91 a_2903_770# a_5214_760# vss sky130_fd_pr__res_high_po_0p69 l=1.5
X92 a_3663_8450# a_323_6060# vdd vdd sky130_fd_pr__pfet_01v8_lvt ad=0.1595 pd=1.39 as=0.1595 ps=1.39 w=1.1 l=0.35
X93 a_2903_1370# a_5214_1228# vss sky130_fd_pr__res_high_po_0p69 l=1.5
X94 a_2903_6090# a_323_3700# vdd vdd sky130_fd_pr__pfet_01v8_lvt ad=0.1595 pd=1.39 as=0.319 ps=2.78 w=1.1 l=0.35
X95 cb7 a_6063_7750# vdd vdd sky130_fd_pr__pfet_01v8_lvt ad=0.3045 pd=2.39 as=0.3045 ps=2.39 w=2.1 l=0.35
X96 vss a_6063_7750# cb7 vss sky130_fd_pr__nfet_01v8_lvt ad=0.527 pd=4.02 as=0.2805 ps=2.03 w=1.7 l=0.15
X97 vdd a_323_6060# a_2903_3130# vdd sky130_fd_pr__pfet_01v8_lvt ad=0.1595 pd=1.39 as=0.1595 ps=1.39 w=1.1 l=0.35
X98 a_3663_3130# a_323_8420# vss vss sky130_fd_pr__nfet_01v8_lvt ad=0.319 pd=2.78 as=0.319 ps=2.78 w=1.1 l=0.15
X99 a_2903_1370# a_323_1340# vss vss sky130_fd_pr__nfet_01v8_lvt ad=0.319 pd=2.78 as=0.319 ps=2.78 w=1.1 l=0.15
X100 a_5993_8324# a_6063_8350# vss sky130_fd_pr__res_high_po_0p35 l=9.5
X101 vss a_6063_5390# cb6 vss sky130_fd_pr__nfet_01v8_lvt ad=0.527 pd=4.02 as=0.2805 ps=2.03 w=1.7 l=0.15
X102 vdd a_6063_3030# cb5 vdd sky130_fd_pr__pfet_01v8_lvt ad=0.3045 pd=2.39 as=0.3045 ps=2.39 w=2.1 l=0.35
X103 a_3663_3730# a_5214_3588# vss sky130_fd_pr__res_high_po_0p69 l=1.5
X104 a_5993_2913# a_6063_3030# vss sky130_fd_pr__res_high_po_0p35 l=9.5
X105 a_2903_8450# a_5214_8308# vss sky130_fd_pr__res_high_po_0p69 l=1.5
X106 a_5993_3604# a_5214_3588# sky130_fd_pr__cap_mim_m3_1 l=4.2 w=4.2
X107 a_6063_670# a_5993_553# vdd vdd sky130_fd_pr__pfet_01v8_lvt ad=0.3045 pd=2.39 as=0.609 ps=4.78 w=2.1 l=0.35
X108 a_5993_553# a_5214_760# sky130_fd_pr__cap_mim_m3_1 l=4.2 w=4.2
X109 cb1 a_6063_3630# vdd vdd sky130_fd_pr__pfet_01v8_lvt ad=0.3045 pd=2.39 as=0.3045 ps=2.39 w=2.1 l=0.35
X110 a_3663_6090# a_323_3700# vdd vdd sky130_fd_pr__pfet_01v8_lvt ad=0.1595 pd=1.39 as=0.1595 ps=1.39 w=1.1 l=0.35
X111 a_2903_6090# a_5214_5948# vss sky130_fd_pr__res_high_po_0p69 l=1.5
X112 a_3663_770# a_323_6060# vss vss sky130_fd_pr__nfet_01v8_lvt ad=0.319 pd=2.78 as=0.319 ps=2.78 w=1.1 l=0.15
X113 cb6 a_6063_5390# vdd vdd sky130_fd_pr__pfet_01v8_lvt ad=0.3045 pd=2.39 as=0.3045 ps=2.39 w=2.1 l=0.35
X114 vdd a_323_8420# a_3663_3130# vdd sky130_fd_pr__pfet_01v8_lvt ad=0.319 pd=2.78 as=0.1595 ps=1.39 w=1.1 l=0.35
X115 cb5 a_6063_3030# vss vss sky130_fd_pr__nfet_01v8_lvt ad=0.2805 pd=2.03 as=0.527 ps=4.02 w=1.7 l=0.15
X116 cb5 a_6063_3030# vdd vdd sky130_fd_pr__pfet_01v8_lvt ad=0.3045 pd=2.39 as=0.609 ps=4.78 w=2.1 l=0.35
X117 vdd a_323_6060# a_2903_770# vdd sky130_fd_pr__pfet_01v8_lvt ad=0.319 pd=2.78 as=0.1595 ps=1.39 w=1.1 l=0.35
X118 vdd a_323_8420# a_2903_7850# vdd sky130_fd_pr__pfet_01v8_lvt ad=0.1595 pd=1.39 as=0.1595 ps=1.39 w=1.1 l=0.35
X119 vdd a_5993_2913# a_6063_3030# vdd sky130_fd_pr__pfet_01v8_lvt ad=0.3045 pd=2.39 as=0.3045 ps=2.39 w=2.1 l=0.35
X120 vss a_6063_670# cb4 vss sky130_fd_pr__nfet_01v8_lvt ad=0.527 pd=4.02 as=0.2805 ps=2.03 w=1.7 l=0.15
X121 vss a_5993_7633# a_6063_7750# vss sky130_fd_pr__nfet_01v8_lvt ad=0.341 pd=2.82 as=0.1815 ps=1.43 w=1.1 l=0.15
X122 cb4 a_6063_670# vss vss sky130_fd_pr__nfet_01v8_lvt ad=0.2805 pd=2.03 as=0.527 ps=4.02 w=1.7 l=0.15
X123 vdd a_6063_7750# cb7 vdd sky130_fd_pr__pfet_01v8_lvt ad=0.3045 pd=2.39 as=0.3045 ps=2.39 w=2.1 l=0.35
X124 a_3663_1370# a_5214_1228# vss sky130_fd_pr__res_high_po_0p69 l=1.5
X125 a_323_3700# qp vdd vdd sky130_fd_pr__pfet_01v8_lvt ad=0.203 pd=1.69 as=0.406 ps=3.38 w=1.4 l=0.35
X126 a_323_8420# vss sky130_fd_pr__cap_mim_m3_1 l=1.75 w=1.75
X127 vss a_5993_5273# a_6063_5390# vss sky130_fd_pr__nfet_01v8_lvt ad=0.341 pd=2.82 as=0.1815 ps=1.43 w=1.1 l=0.15
X128 a_2903_6090# a_323_3700# vss vss sky130_fd_pr__nfet_01v8_lvt ad=0.319 pd=2.78 as=0.319 ps=2.78 w=1.1 l=0.15
X129 cb0 a_6063_1270# vdd vdd sky130_fd_pr__pfet_01v8_lvt ad=0.3045 pd=2.39 as=0.3045 ps=2.39 w=2.1 l=0.35
X130 a_2903_3730# a_5214_3588# vss sky130_fd_pr__res_high_po_0p69 l=1.5
X131 cb4 a_6063_670# vdd vdd sky130_fd_pr__pfet_01v8_lvt ad=0.3045 pd=2.39 as=0.3045 ps=2.39 w=2.1 l=0.35
X132 vdd a_323_1340# a_2903_3730# vdd sky130_fd_pr__pfet_01v8_lvt ad=0.1595 pd=1.39 as=0.1595 ps=1.39 w=1.1 l=0.35
X133 a_3663_8450# a_5214_8308# vss sky130_fd_pr__res_high_po_0p69 l=1.5
X134 a_5993_7633# a_6063_7750# vss sky130_fd_pr__res_high_po_0p35 l=9.5
X135 cb7 a_6063_7750# vdd vdd sky130_fd_pr__pfet_01v8_lvt ad=0.3045 pd=2.39 as=0.609 ps=4.78 w=2.1 l=0.35
X136 a_3663_770# a_5214_760# vss sky130_fd_pr__res_high_po_0p69 l=1.5
X137 vdd a_323_1340# a_3663_7850# vdd sky130_fd_pr__pfet_01v8_lvt ad=0.319 pd=2.78 as=0.1595 ps=1.39 w=1.1 l=0.35
X138 vdd a_323_8420# a_2903_5490# vdd sky130_fd_pr__pfet_01v8_lvt ad=0.1595 pd=1.39 as=0.1595 ps=1.39 w=1.1 l=0.35
X139 vdd a_6063_3630# cb1 vdd sky130_fd_pr__pfet_01v8_lvt ad=0.3045 pd=2.39 as=0.3045 ps=2.39 w=2.1 l=0.35
X140 vdd a_5993_7633# a_6063_7750# vdd sky130_fd_pr__pfet_01v8_lvt ad=0.3045 pd=2.39 as=0.3045 ps=2.39 w=2.1 l=0.35
X141 vdd a_6063_670# cb4 vdd sky130_fd_pr__pfet_01v8_lvt ad=0.609 pd=4.78 as=0.3045 ps=2.39 w=2.1 l=0.35
X142 vdd a_6063_5390# cb6 vdd sky130_fd_pr__pfet_01v8_lvt ad=0.3045 pd=2.39 as=0.3045 ps=2.39 w=2.1 l=0.35
X143 cb3 a_6063_8350# vdd vdd sky130_fd_pr__pfet_01v8_lvt ad=0.3045 pd=2.39 as=0.3045 ps=2.39 w=2.1 l=0.35
X144 a_323_1340# ip vdd vdd sky130_fd_pr__pfet_01v8_lvt ad=0.203 pd=1.69 as=0.406 ps=3.38 w=1.4 l=0.35
X145 a_6063_3030# a_5993_2913# vdd vdd sky130_fd_pr__pfet_01v8_lvt ad=0.3045 pd=2.39 as=0.3045 ps=2.39 w=2.1 l=0.35
X146 a_6063_1270# a_5993_1244# vss sky130_fd_pr__res_high_po_0p35 l=9.5
X147 vss a_5993_2913# a_6063_3030# vss sky130_fd_pr__nfet_01v8_lvt ad=0.341 pd=2.82 as=0.1815 ps=1.43 w=1.1 l=0.15
X148 cb7 a_6063_7750# vss vss sky130_fd_pr__nfet_01v8_lvt ad=0.2805 pd=2.03 as=0.527 ps=4.02 w=1.7 l=0.15
X149 a_2903_3730# a_323_1340# vss vss sky130_fd_pr__nfet_01v8_lvt ad=0.319 pd=2.78 as=0.319 ps=2.78 w=1.1 l=0.15
X150 cb2 a_6063_5990# vdd vdd sky130_fd_pr__pfet_01v8_lvt ad=0.3045 pd=2.39 as=0.3045 ps=2.39 w=2.1 l=0.35
X151 vdd a_323_3700# a_3663_3730# vdd sky130_fd_pr__pfet_01v8_lvt ad=0.319 pd=2.78 as=0.1595 ps=1.39 w=1.1 l=0.35
X152 cb1 a_6063_3630# vdd vdd sky130_fd_pr__pfet_01v8_lvt ad=0.3045 pd=2.39 as=0.609 ps=4.78 w=2.1 l=0.35
X153 vdd a_323_1340# a_2903_1370# vdd sky130_fd_pr__pfet_01v8_lvt ad=0.1595 pd=1.39 as=0.1595 ps=1.39 w=1.1 l=0.35
X154 a_3663_6090# a_5214_5948# vss sky130_fd_pr__res_high_po_0p69 l=1.5
X155 cb6 a_6063_5390# vdd vdd sky130_fd_pr__pfet_01v8_lvt ad=0.3045 pd=2.39 as=0.609 ps=4.78 w=2.1 l=0.35
X156 vdd a_5993_3604# a_6063_3630# vdd sky130_fd_pr__pfet_01v8_lvt ad=0.3045 pd=2.39 as=0.3045 ps=2.39 w=2.1 l=0.35
X157 a_323_8420# qn vdd vdd sky130_fd_pr__pfet_01v8_lvt ad=0.203 pd=1.69 as=0.406 ps=3.38 w=1.4 l=0.35
X158 vdd a_323_8420# a_3663_5490# vdd sky130_fd_pr__pfet_01v8_lvt ad=0.319 pd=2.78 as=0.1595 ps=1.39 w=1.1 l=0.35
X159 a_2903_5490# a_5214_5480# vss sky130_fd_pr__res_high_po_0p69 l=1.5
X160 cb6 a_6063_5390# vss vss sky130_fd_pr__nfet_01v8_lvt ad=0.2805 pd=2.03 as=0.527 ps=4.02 w=1.7 l=0.15
X161 vdd a_6063_1270# cb0 vdd sky130_fd_pr__pfet_01v8_lvt ad=0.3045 pd=2.39 as=0.3045 ps=2.39 w=2.1 l=0.35
X162 a_6063_670# a_5993_553# vdd vdd sky130_fd_pr__pfet_01v8_lvt ad=0.3045 pd=2.39 as=0.3045 ps=2.39 w=2.1 l=0.35
X163 a_2903_770# a_323_6060# vdd vdd sky130_fd_pr__pfet_01v8_lvt ad=0.1595 pd=1.39 as=0.1595 ps=1.39 w=1.1 l=0.35
X164 vdd a_5993_5273# a_6063_5390# vdd sky130_fd_pr__pfet_01v8_lvt ad=0.3045 pd=2.39 as=0.3045 ps=2.39 w=2.1 l=0.35
X165 a_6063_670# a_5993_553# vss sky130_fd_pr__res_high_po_0p35 l=9.5
X166 vdd a_323_6060# a_3663_770# vdd sky130_fd_pr__pfet_01v8_lvt ad=0.1595 pd=1.39 as=0.1595 ps=1.39 w=1.1 l=0.35
X167 a_3663_1370# a_323_1340# vss vss sky130_fd_pr__nfet_01v8_lvt ad=0.319 pd=2.78 as=0.319 ps=2.78 w=1.1 l=0.15
X168 vdd a_323_3700# a_2903_8450# vdd sky130_fd_pr__pfet_01v8_lvt ad=0.1595 pd=1.39 as=0.1595 ps=1.39 w=1.1 l=0.35
X169 a_6063_7750# a_5993_7633# vdd vdd sky130_fd_pr__pfet_01v8_lvt ad=0.3045 pd=2.39 as=0.3045 ps=2.39 w=2.1 l=0.35
X170 cb2 cb6 vss vss sky130_fd_pr__nfet_01v8_lvt ad=0.1305 pd=1.48 as=0.1305 ps=1.48 w=0.45 l=0.15
X171 a_2903_8450# a_323_3700# vss vss sky130_fd_pr__nfet_01v8_lvt ad=0.319 pd=2.78 as=0.319 ps=2.78 w=1.1 l=0.15
X172 vdd a_6063_8350# cb3 vdd sky130_fd_pr__pfet_01v8_lvt ad=0.3045 pd=2.39 as=0.3045 ps=2.39 w=2.1 l=0.35
X173 a_2903_770# a_323_6060# vdd vdd sky130_fd_pr__pfet_01v8_lvt ad=0.1595 pd=1.39 as=0.319 ps=2.78 w=1.1 l=0.35
X174 cb0 a_6063_1270# vdd vdd sky130_fd_pr__pfet_01v8_lvt ad=0.3045 pd=2.39 as=0.609 ps=4.78 w=2.1 l=0.35
X175 vdd a_323_1340# a_3663_1370# vdd sky130_fd_pr__pfet_01v8_lvt ad=0.319 pd=2.78 as=0.1595 ps=1.39 w=1.1 l=0.35
X176 a_6063_7750# a_5993_7633# vss vss sky130_fd_pr__nfet_01v8_lvt ad=0.1815 pd=1.43 as=0.341 ps=2.82 w=1.1 l=0.15
X177 a_5993_2913# a_5214_3120# sky130_fd_pr__cap_mim_m3_1 l=4.2 w=4.2
X178 vdd a_5993_1244# a_6063_1270# vdd sky130_fd_pr__pfet_01v8_lvt ad=0.3045 pd=2.39 as=0.3045 ps=2.39 w=2.1 l=0.35
X179 a_323_6060# in vdd vdd sky130_fd_pr__pfet_01v8_lvt ad=0.203 pd=1.69 as=0.406 ps=3.38 w=1.4 l=0.35
X180 a_2903_3130# a_5214_3120# vss sky130_fd_pr__res_high_po_0p69 l=1.5
X181 cb1 cb5 vss vss sky130_fd_pr__nfet_01v8_lvt ad=0.1305 pd=1.48 as=0.1305 ps=1.48 w=0.45 l=0.15
X182 vdd a_6063_5990# cb2 vdd sky130_fd_pr__pfet_01v8_lvt ad=0.3045 pd=2.39 as=0.3045 ps=2.39 w=2.1 l=0.35
X183 vss a_6063_3630# cb1 vss sky130_fd_pr__nfet_01v8_lvt ad=0.527 pd=4.02 as=0.2805 ps=2.03 w=1.7 l=0.15
X184 a_6063_5990# a_5993_5964# vss sky130_fd_pr__res_high_po_0p35 l=9.5
X185 a_6063_5390# a_5993_5273# vss vss sky130_fd_pr__nfet_01v8_lvt ad=0.1815 pd=1.43 as=0.341 ps=2.82 w=1.1 l=0.15
X186 a_323_3700# qp vdd vdd sky130_fd_pr__pfet_01v8_lvt ad=0.203 pd=1.69 as=0.203 ps=1.69 w=1.4 l=0.35
X187 cb4 a_6063_670# vdd vdd sky130_fd_pr__pfet_01v8_lvt ad=0.3045 pd=2.39 as=0.3045 ps=2.39 w=2.1 l=0.35
X188 a_6063_3630# a_5993_3604# vdd vdd sky130_fd_pr__pfet_01v8_lvt ad=0.3045 pd=2.39 as=0.3045 ps=2.39 w=2.1 l=0.35
X189 vss a_6063_1270# cb0 vss sky130_fd_pr__nfet_01v8_lvt ad=0.527 pd=4.02 as=0.2805 ps=2.03 w=1.7 l=0.15
X190 vdd a_323_6060# a_3663_8450# vdd sky130_fd_pr__pfet_01v8_lvt ad=0.319 pd=2.78 as=0.1595 ps=1.39 w=1.1 l=0.35
X191 vdd a_323_3700# a_2903_6090# vdd sky130_fd_pr__pfet_01v8_lvt ad=0.1595 pd=1.39 as=0.1595 ps=1.39 w=1.1 l=0.35
X192 a_6063_5390# a_5993_5273# vdd vdd sky130_fd_pr__pfet_01v8_lvt ad=0.3045 pd=2.39 as=0.3045 ps=2.39 w=2.1 l=0.35
X193 cb3 a_6063_8350# vdd vdd sky130_fd_pr__pfet_01v8_lvt ad=0.3045 pd=2.39 as=0.609 ps=4.78 w=2.1 l=0.35
X194 vdd a_5993_8324# a_6063_8350# vdd sky130_fd_pr__pfet_01v8_lvt ad=0.3045 pd=2.39 as=0.3045 ps=2.39 w=2.1 l=0.35
X195 a_6063_5390# a_5993_5273# vss sky130_fd_pr__res_high_po_0p35 l=9.5
X196 cb2 a_6063_5990# vdd vdd sky130_fd_pr__pfet_01v8_lvt ad=0.3045 pd=2.39 as=0.609 ps=4.78 w=2.1 l=0.35
X197 a_3663_6090# a_323_3700# vss vss sky130_fd_pr__nfet_01v8_lvt ad=0.319 pd=2.78 as=0.319 ps=2.78 w=1.1 l=0.15
X198 cb5 a_6063_3030# vdd vdd sky130_fd_pr__pfet_01v8_lvt ad=0.3045 pd=2.39 as=0.3045 ps=2.39 w=2.1 l=0.35
X199 vdd a_5993_5964# a_6063_5990# vdd sky130_fd_pr__pfet_01v8_lvt ad=0.3045 pd=2.39 as=0.3045 ps=2.39 w=2.1 l=0.35
X200 vss a_6063_8350# cb3 vss sky130_fd_pr__nfet_01v8_lvt ad=0.527 pd=4.02 as=0.2805 ps=2.03 w=1.7 l=0.15
X201 a_6063_3030# a_5993_2913# vss vss sky130_fd_pr__nfet_01v8_lvt ad=0.1815 pd=1.43 as=0.341 ps=2.82 w=1.1 l=0.15
X202 a_3663_770# a_323_6060# vdd vdd sky130_fd_pr__pfet_01v8_lvt ad=0.1595 pd=1.39 as=0.319 ps=2.78 w=1.1 l=0.35
X203 a_323_1340# ip vdd vdd sky130_fd_pr__pfet_01v8_lvt ad=0.203 pd=1.69 as=0.203 ps=1.69 w=1.4 l=0.35
X204 a_5993_8324# a_5214_8308# sky130_fd_pr__cap_mim_m3_1 l=4.2 w=4.2
X205 a_2903_770# a_323_6060# vss vss sky130_fd_pr__nfet_01v8_lvt ad=0.319 pd=2.78 as=0.319 ps=2.78 w=1.1 l=0.15
X206 a_6063_1270# a_5993_1244# vdd vdd sky130_fd_pr__pfet_01v8_lvt ad=0.3045 pd=2.39 as=0.3045 ps=2.39 w=2.1 l=0.35
X207 vdd a_323_3700# a_3663_6090# vdd sky130_fd_pr__pfet_01v8_lvt ad=0.319 pd=2.78 as=0.1595 ps=1.39 w=1.1 l=0.35
X208 vdd a_6063_3030# cb5 vdd sky130_fd_pr__pfet_01v8_lvt ad=0.3045 pd=2.39 as=0.3045 ps=2.39 w=2.1 l=0.35
X209 vdd a_323_6060# a_3663_770# vdd sky130_fd_pr__pfet_01v8_lvt ad=0.319 pd=2.78 as=0.1595 ps=1.39 w=1.1 l=0.35
X210 a_2903_7850# a_5214_7840# vss sky130_fd_pr__res_high_po_0p69 l=1.5
X211 cb3 cb7 vss vss sky130_fd_pr__nfet_01v8_lvt ad=0.1305 pd=1.48 as=0.1305 ps=1.48 w=0.45 l=0.15
X212 a_2903_3130# a_323_6060# vdd vdd sky130_fd_pr__pfet_01v8_lvt ad=0.1595 pd=1.39 as=0.1595 ps=1.39 w=1.1 l=0.35
X213 vss a_5993_1244# a_6063_1270# vss sky130_fd_pr__nfet_01v8_lvt ad=0.341 pd=2.82 as=0.1815 ps=1.43 w=1.1 l=0.15
X214 cb7 a_6063_7750# vdd vdd sky130_fd_pr__pfet_01v8_lvt ad=0.3045 pd=2.39 as=0.3045 ps=2.39 w=2.1 l=0.35
X215 a_3663_3730# a_323_3700# vss vss sky130_fd_pr__nfet_01v8_lvt ad=0.319 pd=2.78 as=0.319 ps=2.78 w=1.1 l=0.15
X216 a_323_8420# qn vdd vdd sky130_fd_pr__pfet_01v8_lvt ad=0.203 pd=1.69 as=0.203 ps=1.69 w=1.4 l=0.35
X217 vdd qp a_323_3700# vdd sky130_fd_pr__pfet_01v8_lvt ad=0.203 pd=1.69 as=0.203 ps=1.69 w=1.4 l=0.35
X218 a_3663_3130# a_323_8420# vdd vdd sky130_fd_pr__pfet_01v8_lvt ad=0.1595 pd=1.39 as=0.319 ps=2.78 w=1.1 l=0.35
X219 a_6063_8350# a_5993_8324# vdd vdd sky130_fd_pr__pfet_01v8_lvt ad=0.3045 pd=2.39 as=0.3045 ps=2.39 w=2.1 l=0.35
X220 vss a_6063_5990# cb2 vss sky130_fd_pr__nfet_01v8_lvt ad=0.527 pd=4.02 as=0.2805 ps=2.03 w=1.7 l=0.15
X221 vss a_5993_553# a_6063_670# vss sky130_fd_pr__nfet_01v8_lvt ad=0.341 pd=2.82 as=0.1815 ps=1.43 w=1.1 l=0.15
X222 a_3663_3130# a_5214_3120# vss sky130_fd_pr__res_high_po_0p69 l=1.5
X223 a_6063_670# a_5993_553# vss vss sky130_fd_pr__nfet_01v8_lvt ad=0.1815 pd=1.43 as=0.341 ps=2.82 w=1.1 l=0.15
X224 a_6063_5990# a_5993_5964# vdd vdd sky130_fd_pr__pfet_01v8_lvt ad=0.3045 pd=2.39 as=0.3045 ps=2.39 w=2.1 l=0.35
X225 vdd a_6063_3030# cb5 vdd sky130_fd_pr__pfet_01v8_lvt ad=0.609 pd=4.78 as=0.3045 ps=2.39 w=2.1 l=0.35
X226 vdd a_6063_7750# cb7 vdd sky130_fd_pr__pfet_01v8_lvt ad=0.3045 pd=2.39 as=0.3045 ps=2.39 w=2.1 l=0.35
X227 a_2903_7850# a_323_8420# vdd vdd sky130_fd_pr__pfet_01v8_lvt ad=0.1595 pd=1.39 as=0.1595 ps=1.39 w=1.1 l=0.35
X228 cb1 cb5 vdd vdd sky130_fd_pr__pfet_01v8_lvt ad=0.609 pd=4.78 as=0.609 ps=4.78 w=2.1 l=0.35
X229 cb1 a_6063_3630# vdd vdd sky130_fd_pr__pfet_01v8_lvt ad=0.3045 pd=2.39 as=0.3045 ps=2.39 w=2.1 l=0.35
X230 a_3663_8450# a_323_6060# vss vss sky130_fd_pr__nfet_01v8_lvt ad=0.319 pd=2.78 as=0.319 ps=2.78 w=1.1 l=0.15
X231 cb6 a_6063_5390# vdd vdd sky130_fd_pr__pfet_01v8_lvt ad=0.3045 pd=2.39 as=0.3045 ps=2.39 w=2.1 l=0.35
X232 cb1 a_6063_3630# vss vss sky130_fd_pr__nfet_01v8_lvt ad=0.2805 pd=2.03 as=0.527 ps=4.02 w=1.7 l=0.15
X233 a_3663_7850# a_323_1340# vdd vdd sky130_fd_pr__pfet_01v8_lvt ad=0.1595 pd=1.39 as=0.319 ps=2.78 w=1.1 l=0.35
X234 a_323_6060# in vdd vdd sky130_fd_pr__pfet_01v8_lvt ad=0.203 pd=1.69 as=0.203 ps=1.69 w=1.4 l=0.35
X235 vdd a_6063_670# cb4 vdd sky130_fd_pr__pfet_01v8_lvt ad=0.3045 pd=2.39 as=0.3045 ps=2.39 w=2.1 l=0.35
X236 vdd ip a_323_1340# vdd sky130_fd_pr__pfet_01v8_lvt ad=0.203 pd=1.69 as=0.203 ps=1.69 w=1.4 l=0.35
X237 vdd a_323_6060# a_2903_3130# vdd sky130_fd_pr__pfet_01v8_lvt ad=0.319 pd=2.78 as=0.1595 ps=1.39 w=1.1 l=0.35
X238 vdd a_5993_2913# a_6063_3030# vdd sky130_fd_pr__pfet_01v8_lvt ad=0.609 pd=4.78 as=0.3045 ps=2.39 w=2.1 l=0.35
X239 cb0 a_6063_1270# vss vss sky130_fd_pr__nfet_01v8_lvt ad=0.2805 pd=2.03 as=0.527 ps=4.02 w=1.7 l=0.15
X240 vss qp a_323_3700# vss sky130_fd_pr__nfet_01v8_lvt ad=0.217 pd=2.02 as=0.1155 ps=1.03 w=0.7 l=0.15
X241 a_3663_7850# a_5214_7840# vss sky130_fd_pr__res_high_po_0p69 l=1.5
X242 vss a_5993_5964# a_6063_5990# vss sky130_fd_pr__nfet_01v8_lvt ad=0.341 pd=2.82 as=0.1815 ps=1.43 w=1.1 l=0.15
X243 a_5993_1244# a_5214_1228# sky130_fd_pr__cap_mim_m3_1 l=4.2 w=4.2
X244 vdd a_6063_7750# cb7 vdd sky130_fd_pr__pfet_01v8_lvt ad=0.609 pd=4.78 as=0.3045 ps=2.39 w=2.1 l=0.35
X245 vdd a_323_8420# a_3663_3130# vdd sky130_fd_pr__pfet_01v8_lvt ad=0.1595 pd=1.39 as=0.1595 ps=1.39 w=1.1 l=0.35
X246 vdd a_6063_3630# cb1 vdd sky130_fd_pr__pfet_01v8_lvt ad=0.3045 pd=2.39 as=0.3045 ps=2.39 w=2.1 l=0.35
X247 a_2903_3730# a_323_1340# vdd vdd sky130_fd_pr__pfet_01v8_lvt ad=0.1595 pd=1.39 as=0.1595 ps=1.39 w=1.1 l=0.35
X248 vdd qn a_323_8420# vdd sky130_fd_pr__pfet_01v8_lvt ad=0.203 pd=1.69 as=0.203 ps=1.69 w=1.4 l=0.35
X249 vdd a_6063_5390# cb6 vdd sky130_fd_pr__pfet_01v8_lvt ad=0.3045 pd=2.39 as=0.3045 ps=2.39 w=2.1 l=0.35
X250 vss ip a_323_1340# vss sky130_fd_pr__nfet_01v8_lvt ad=0.217 pd=2.02 as=0.1155 ps=1.03 w=0.7 l=0.15
X251 a_2903_5490# a_323_8420# vdd vdd sky130_fd_pr__pfet_01v8_lvt ad=0.1595 pd=1.39 as=0.1595 ps=1.39 w=1.1 l=0.35
X252 cb3 cb7 vdd vdd sky130_fd_pr__pfet_01v8_lvt ad=0.609 pd=4.78 as=0.609 ps=4.78 w=2.1 l=0.35
X253 cb0 a_6063_1270# vdd vdd sky130_fd_pr__pfet_01v8_lvt ad=0.3045 pd=2.39 as=0.3045 ps=2.39 w=2.1 l=0.35
X254 cb3 a_6063_8350# vss vss sky130_fd_pr__nfet_01v8_lvt ad=0.2805 pd=2.03 as=0.527 ps=4.02 w=1.7 l=0.15
X255 a_3663_3730# a_323_3700# vdd vdd sky130_fd_pr__pfet_01v8_lvt ad=0.1595 pd=1.39 as=0.319 ps=2.78 w=1.1 l=0.35
X256 a_6063_3030# a_5993_2913# vdd vdd sky130_fd_pr__pfet_01v8_lvt ad=0.3045 pd=2.39 as=0.609 ps=4.78 w=2.1 l=0.35
X257 vdd a_5993_553# a_6063_670# vdd sky130_fd_pr__pfet_01v8_lvt ad=0.3045 pd=2.39 as=0.3045 ps=2.39 w=2.1 l=0.35
X258 a_3663_5490# a_323_8420# vdd vdd sky130_fd_pr__pfet_01v8_lvt ad=0.1595 pd=1.39 as=0.319 ps=2.78 w=1.1 l=0.35
X259 a_2903_3130# a_323_6060# vdd vdd sky130_fd_pr__pfet_01v8_lvt ad=0.1595 pd=1.39 as=0.319 ps=2.78 w=1.1 l=0.35
X260 a_2903_7850# a_323_8420# vss vss sky130_fd_pr__nfet_01v8_lvt ad=0.319 pd=2.78 as=0.319 ps=2.78 w=1.1 l=0.15
X261 vdd a_323_8420# a_2903_7850# vdd sky130_fd_pr__pfet_01v8_lvt ad=0.319 pd=2.78 as=0.1595 ps=1.39 w=1.1 l=0.35
X262 vdd a_5993_7633# a_6063_7750# vdd sky130_fd_pr__pfet_01v8_lvt ad=0.609 pd=4.78 as=0.3045 ps=2.39 w=2.1 l=0.35
X263 vdd a_6063_3630# cb1 vdd sky130_fd_pr__pfet_01v8_lvt ad=0.609 pd=4.78 as=0.3045 ps=2.39 w=2.1 l=0.35
X264 a_3663_5490# a_5214_5480# vss sky130_fd_pr__res_high_po_0p69 l=1.5
X265 a_2903_5490# a_323_8420# vss vss sky130_fd_pr__nfet_01v8_lvt ad=0.319 pd=2.78 as=0.319 ps=2.78 w=1.1 l=0.15
X266 vss a_5993_3604# a_6063_3630# vss sky130_fd_pr__nfet_01v8_lvt ad=0.341 pd=2.82 as=0.1815 ps=1.43 w=1.1 l=0.15
X267 a_323_6060# vss sky130_fd_pr__cap_mim_m3_1 l=1.75 w=1.75
C0 vdd a_5993_5273# 0.81714f
C1 vdd a_2903_3130# 0.9495f
C2 a_5993_3604# a_323_3700# 0
C3 a_323_1340# a_2903_770# 0.00703f
C4 a_6063_8350# a_6063_5390# 0.02864f
C5 cb3 a_5993_7633# 0
C6 a_3663_5490# a_323_8420# 0.29388f
C7 a_2903_5490# a_5214_5480# 0.16302f
C8 a_6063_5990# a_6063_7750# 0.34161f
C9 a_5993_8324# vdd 0.829f
C10 a_6063_7750# a_5214_7840# 0.01578f
C11 a_6063_7750# a_6063_3630# 0
C12 a_323_8420# a_3663_1370# 0
C13 a_5214_3588# a_6063_3630# 0.01568f
C14 a_5993_1244# cb4 0
C15 a_5214_3120# a_5214_1228# 0.14832f
C16 a_5214_760# a_323_6060# 0.06847f
C17 a_5214_5948# a_5993_7633# 0.01165f
C18 a_323_1340# a_3663_1370# 0.29388f
C19 a_2903_1370# a_323_6060# 0.0075f
C20 a_5993_1244# a_6063_3030# 0.22659f
C21 a_6063_8350# cb2 0
C22 a_2903_6090# vdd 0.9495f
C23 a_323_3700# a_5993_5964# 0
C24 a_6063_7750# a_6063_5390# 0.45752f
C25 qn a_323_8420# 0.3194f
C26 a_323_1340# a_5214_3588# 0.01548f
C27 cb5 a_6063_3630# 0.00594f
C28 qn a_323_1340# 0
C29 a_323_8420# a_323_6060# 1.01124f
C30 cb6 cb7 0.00148f
C31 cb2 a_6063_7750# 0.00156f
C32 a_5214_3120# a_323_8420# 0.05299f
C33 a_5993_5273# a_5214_5480# 1.9646f
C34 vdd a_2903_7850# 0.9495f
C35 a_323_1340# a_323_6060# 0.75112f
C36 a_323_3700# a_5214_5948# 0.06847f
C37 a_6063_8350# a_5993_3604# 0
C38 vdd a_3663_8450# 0.37254f
C39 vdd a_3663_7850# 0.37193f
C40 a_5993_2913# a_2903_3730# 0.00351f
C41 cb6 a_5993_5273# 0.0015f
C42 a_6063_670# a_5214_1228# 0
C43 a_5214_8308# vdd 0.09188f
C44 ip a_323_6060# 0
C45 a_323_3700# a_2903_3730# 0.10132f
C46 cb1 a_5993_2913# 0
C47 a_5214_760# a_6063_670# 0.01895f
C48 a_2903_8450# a_323_6060# 0.10185f
C49 a_5993_553# a_5214_1228# 0.01883f
C50 a_2903_6090# a_5214_5480# 0.01703f
C51 vdd a_5214_1228# 0.09076f
C52 a_6063_8350# a_5993_5964# 0.20443f
C53 a_5993_3604# a_6063_7750# 0.00139f
C54 a_5993_3604# a_5214_3588# 1.9587f
C55 a_5993_553# a_5214_760# 1.9646f
C56 a_6063_670# a_6063_3630# 0.02864f
C57 a_5993_553# a_2903_1370# 0.00351f
C58 a_5214_760# vdd 0.08275f
C59 a_3663_6090# a_2903_6090# 0.25738f
C60 cb0 a_6063_3630# 0
C61 a_2903_1370# vdd 0.9495f
C62 in a_323_3700# 0.00584f
C63 a_6063_8350# cb3 0.59992f
C64 a_5993_553# a_6063_3630# 0
C65 a_5993_1244# a_5993_2913# 0.11363f
C66 cb5 cb4 0.00148f
C67 a_6063_5990# vdd 1.6322f
C68 a_3663_3730# a_323_8420# 0.00219f
C69 vdd a_5214_7840# 0.09076f
C70 vdd a_6063_3630# 1.70274f
C71 a_6063_8350# a_5993_7633# 0.01615f
C72 a_6063_670# a_6063_5390# 0.0033f
C73 a_6063_7750# a_5993_5964# 0.22659f
C74 a_5993_3604# cb5 0
C75 cb5 a_6063_3030# 0.59285f
C76 a_3663_3730# a_323_1340# 0.00289f
C77 vdd a_323_8420# 4.08666f
C78 a_5993_3604# a_5214_3120# 0.01845f
C79 a_5993_5273# a_2903_5490# 0.00484f
C80 a_5214_3120# a_6063_3030# 0.01578f
C81 a_3663_6090# a_2903_7850# 0
C82 a_5993_2913# a_3663_3130# 0.00506f
C83 vdd a_6063_5390# 2.09958f
C84 a_3663_770# a_5214_760# 0.33733f
C85 a_3663_6090# a_3663_7850# 0.00947f
C86 a_6063_7750# cb3 0.01266f
C87 vdd a_323_1340# 4.25758f
C88 a_323_3700# a_3663_3130# 0.00135f
C89 a_6063_7750# a_5993_7633# 0.53461f
C90 a_323_8420# qp 0
C91 a_3663_5490# a_2903_3730# 0
C92 a_323_3700# a_2903_770# 0
C93 a_6063_7750# a_5214_5948# 0
C94 ip vdd 0.58015f
C95 a_2903_6090# a_2903_5490# 0.30672f
C96 vdd a_2903_8450# 0.95022f
C97 cb2 vdd 1.39881f
C98 a_323_1340# qp 0.00535f
C99 a_6063_670# cb4 0.59157f
C100 a_323_3700# a_3663_5490# 0.00219f
C101 a_5214_3588# a_2903_3730# 0.16302f
C102 cb0 cb4 0.53691f
C103 a_5993_8324# cb7 0
C104 ip qp 0
C105 a_3663_770# a_323_1340# 0.00135f
C106 a_5993_1244# a_2903_770# 0.00351f
C107 a_5993_3604# a_6063_670# 0.01578f
C108 a_5993_2913# a_5214_3588# 0.01906f
C109 a_6063_670# a_6063_3030# 0.45752f
C110 a_6063_5990# cb6 0.00533f
C111 a_3663_3730# a_5993_3604# 0.00506f
C112 a_5993_553# cb4 0.0015f
C113 cb6 a_6063_3630# 0.00127f
C114 cb0 a_6063_3030# 0.00156f
C115 a_323_8420# a_5214_5480# 0.06847f
C116 a_3663_6090# a_5214_7840# 0.00196f
C117 vdd cb4 1.25159f
C118 a_323_3700# a_5214_3588# 0.05299f
C119 a_5993_553# a_6063_3030# 0.18257f
C120 a_6063_5390# a_5214_5480# 0.01612f
C121 a_323_6060# a_2903_3730# 0.0032f
C122 a_5993_3604# vdd 0.81716f
C123 vdd a_6063_3030# 1.63195f
C124 a_3663_6090# a_323_8420# 0.00133f
C125 a_5993_1244# a_3663_1370# 0.00506f
C126 a_323_3700# qn 0.00439f
C127 a_5214_1228# a_6063_1270# 0.01568f
C128 a_5214_3120# a_2903_3730# 0.01703f
C129 cb6 a_6063_5390# 0.59157f
C130 a_2903_6090# a_5993_5273# 0.00351f
C131 cb5 a_5993_2913# 0.00287f
C132 cb5 cb1 0.53691f
C133 a_3663_6090# a_323_1340# 0
C134 in qn 0
C135 a_323_3700# a_323_6060# 1.03153f
C136 a_5993_2913# a_5214_3120# 1.96442f
C137 a_3663_1370# a_3663_3130# 0.00947f
C138 vdd a_5993_5964# 0.79721f
C139 in a_323_6060# 0.31953f
C140 a_6063_1270# a_6063_3630# 0.4606f
C141 cb6 cb2 0.53691f
C142 vdd cb3 1.39911f
C143 a_5993_1244# a_5214_3120# 0.01165f
C144 a_6063_5390# a_6063_1270# 0
C145 a_5993_8324# a_2903_7850# 0.00351f
C146 a_6063_8350# a_6063_7750# 0.26782f
C147 vdd a_5993_7633# 0.79626f
C148 a_5993_8324# a_3663_8450# 0.00506f
C149 a_323_8420# a_2903_5490# 0.43704f
C150 a_5993_3604# a_5214_5480# 0.01165f
C151 vdd a_5214_5948# 0.09076f
C152 a_3663_3730# a_2903_3730# 0.25738f
C153 a_323_6060# a_3663_3130# 0.00289f
C154 a_3663_5490# a_5214_3588# 0.00196f
C155 a_5214_8308# a_5993_8324# 1.9587f
C156 a_2903_6090# a_2903_7850# 0.00156f
C157 a_5993_2913# a_6063_670# 0.22518f
C158 a_323_1340# a_2903_5490# 0
C159 a_5214_3120# a_3663_3130# 0.33733f
C160 cb0 cb1 0
C161 a_323_6060# a_2903_770# 0.43636f
C162 a_2903_6090# a_3663_7850# 0
C163 vdd a_2903_3730# 0.9495f
C164 a_3663_3730# a_323_3700# 0.29099f
C165 a_6063_5990# cb7 0.00172f
C166 a_5993_553# a_5993_2913# 0
C167 a_2903_1370# a_2903_3130# 0.00156f
C168 a_5993_5964# a_5214_5480# 0.01895f
C169 vdd a_5993_2913# 0.79626f
C170 vdd cb1 1.39851f
C171 a_3663_5490# a_323_6060# 0
C172 a_323_3700# vdd 4.25929f
C173 a_6063_5990# a_5993_5273# 0.01215f
C174 a_323_6060# a_3663_1370# 0.00133f
C175 a_5993_5273# a_6063_3630# 0.00141f
C176 cb6 a_5993_5964# 0
C177 a_3663_6090# a_5993_5964# 0.00506f
C178 a_6063_1270# cb4 0.00533f
C179 a_5993_1244# a_6063_670# 0.03306f
C180 cb7 a_6063_5390# 0
C181 a_6063_5990# a_5993_8324# 0.18589f
C182 a_5214_3120# a_3663_1370# 0.00196f
C183 cb0 a_5993_1244# 0.00439f
C184 a_5993_8324# a_5214_7840# 0.01845f
C185 in vdd 0.58015f
C186 a_3663_7850# a_2903_7850# 0.25738f
C187 a_323_8420# a_5993_5273# 0
C188 a_2903_3130# a_323_8420# 0.10241f
C189 a_5993_3604# a_6063_1270# 0.18589f
C190 a_6063_3030# a_6063_1270# 0.34161f
C191 a_5993_553# a_5993_1244# 0.15452f
C192 a_5214_8308# a_2903_7850# 0.01703f
C193 a_323_3700# qp 0.32109f
C194 a_6063_5390# a_5993_5273# 0.54277f
C195 a_5214_3120# a_5214_3588# 0.34199f
C196 vdd a_5993_1244# 0.79669f
C197 a_5214_5948# a_5214_5480# 0.34199f
C198 qn a_323_6060# 0.0015f
C199 a_323_1340# a_2903_3130# 0.00317f
C200 a_5214_8308# a_3663_8450# 0.33733f
C201 a_5993_8324# a_6063_5390# 0.01578f
C202 in qp 0
C203 cb2 cb7 0.00253f
C204 a_3663_6090# a_5214_5948# 0.33733f
C205 a_2903_6090# a_323_8420# 0.00805f
C206 a_5214_3120# a_323_6060# 0.01548f
C207 vdd a_3663_3130# 0.37193f
C208 a_2903_6090# a_323_1340# 0
C209 a_5993_553# a_2903_770# 0.00484f
C210 a_5993_8324# a_2903_8450# 0.00484f
C211 vdd a_2903_770# 0.93315f
C212 a_5993_5964# a_2903_5490# 0.00351f
C213 a_2903_7850# a_5214_7840# 0.16302f
C214 a_3663_3730# a_3663_5490# 0.00947f
C215 cb6 cb1 0.00253f
C216 a_6063_8350# vdd 1.70635f
C217 a_3663_7850# a_5214_7840# 0.33733f
C218 a_3663_6090# a_323_3700# 0.29388f
C219 a_2903_7850# a_323_8420# 0.33692f
C220 vdd a_3663_5490# 0.37193f
C221 a_6063_5990# a_5214_8308# 0
C222 a_5214_760# a_5214_1228# 0.34199f
C223 a_5214_3588# a_6063_670# 0.00403f
C224 a_5214_8308# a_5214_7840# 0.34199f
C225 a_3663_3730# a_5214_3588# 0.33733f
C226 a_2903_1370# a_5214_1228# 0.16302f
C227 vdd a_3663_1370# 0.37193f
C228 a_3663_7850# a_323_8420# 0.00291f
C229 a_5993_3604# a_5993_5273# 0.11019f
C230 a_5993_3604# a_2903_3130# 0.00351f
C231 a_2903_7850# a_323_1340# 0.10102f
C232 a_5214_760# a_2903_1370# 0.01703f
C233 a_6063_7750# vdd 1.63259f
C234 a_323_1340# a_3663_8450# 0.00133f
C235 vdd a_5214_3588# 0.09076f
C236 a_3663_7850# a_323_1340# 0.29099f
C237 a_5214_5948# a_2903_5490# 0.01703f
C238 a_3663_770# a_2903_770# 0.25738f
C239 a_5214_8308# a_6063_5390# 0.00403f
C240 a_5993_2913# a_6063_1270# 0.20849f
C241 cb1 a_6063_1270# 0.00135f
C242 cb5 a_6063_670# 0
C243 vdd qn 0.58099f
C244 a_2903_7850# a_2903_8450# 0.30672f
C245 cb0 cb5 0.00253f
C246 a_5214_3120# a_6063_670# 0.00111f
C247 a_2903_3730# a_2903_5490# 0.00156f
C248 a_5993_5964# a_5993_5273# 0.15452f
C249 a_5993_553# a_323_6060# 0
C250 a_3663_8450# a_2903_8450# 0.25738f
C251 a_6063_5990# a_5214_7840# 0
C252 cb7 cb3 0.53691f
C253 a_323_1340# a_5214_1228# 0.06847f
C254 vdd a_323_6060# 3.92362f
C255 a_2903_1370# a_323_8420# 0.00172f
C256 vdd cb5 1.27794f
C257 a_5214_8308# a_2903_8450# 0.16302f
C258 cb7 a_5993_7633# 0.00287f
C259 vdd a_5214_3120# 0.09076f
C260 a_323_3700# a_2903_5490# 0.00683f
C261 a_323_8420# a_5214_7840# 0.01548f
C262 a_2903_1370# a_323_1340# 0.43562f
C263 cb6 a_6063_8350# 0.00336f
C264 a_3663_5490# a_5214_5480# 0.33733f
C265 a_5993_1244# a_6063_1270# 0.55156f
C266 a_6063_5990# a_6063_5390# 0.2697f
C267 a_5993_5273# a_5993_7633# 0
C268 a_6063_5390# a_5214_7840# 0.00111f
C269 a_6063_5390# a_6063_3630# 0.01286f
C270 a_2903_6090# a_5993_5964# 0.00484f
C271 a_5993_8324# cb3 0.00655f
C272 a_323_6060# qp 0.00528f
C273 a_323_1340# a_5214_7840# 0.05299f
C274 a_5214_5948# a_5993_5273# 0.01883f
C275 a_5993_8324# a_5993_7633# 0.15552f
C276 a_6063_7750# a_5214_5480# 0.00214f
C277 a_5214_3588# a_5214_5480# 0.14832f
C278 a_323_1340# a_323_8420# 0.86015f
C279 a_3663_770# a_323_6060# 0.29388f
C280 a_2903_3130# a_2903_3730# 0.30672f
C281 a_6063_5990# cb2 0.60075f
C282 a_2903_8450# a_5214_7840# 0.01703f
C283 cb0 a_6063_670# 0.01276f
C284 a_5993_2913# a_2903_3130# 0.00484f
C285 ip a_323_8420# 0
C286 a_2903_6090# a_5214_5948# 0.16302f
C287 a_5214_1228# a_6063_3030# 0
C288 a_5993_553# a_6063_670# 0.57865f
C289 a_2903_8450# a_323_8420# 0.0036f
C290 vdd a_6063_670# 1.82883f
C291 a_323_3700# a_2903_3130# 0.00489f
C292 cb0 vdd 1.39421f
C293 a_3663_3730# vdd 0.37193f
C294 ip a_323_1340# 0.32625f
C295 a_5214_760# a_6063_3030# 0.00214f
C296 cb2 a_6063_5390# 0.01276f
C297 a_323_1340# a_2903_8450# 0.00387f
C298 a_6063_3630# cb4 0.00336f
C299 cb6 cb5 0.00148f
C300 a_5993_553# vdd 0.74342f
C301 a_2903_7850# a_5993_7633# 0.00484f
C302 a_5993_3604# a_6063_3630# 0.5962f
C303 a_6063_3030# a_6063_3630# 0.26782f
C304 a_3663_5490# a_2903_5490# 0.25738f
C305 a_5214_3588# a_6063_1270# 0
C306 a_3663_7850# a_5993_7633# 0.00506f
C307 a_2903_6090# a_323_3700# 0.43592f
C308 a_5214_5948# a_3663_7850# 0.00196f
C309 a_5214_8308# a_5993_7633# 0.01906f
C310 vdd qp 0.58015f
C311 a_5993_3604# a_6063_5390# 0.00249f
C312 a_6063_5990# a_5993_5964# 0.55156f
C313 a_5993_5964# a_5214_7840# 0.01165f
C314 a_5993_5964# a_6063_3630# 0
C315 a_2903_3130# a_3663_3130# 0.25738f
C316 a_6063_8350# cb7 0.00594f
C317 a_3663_770# a_5993_553# 0.00506f
C318 cb5 a_6063_1270# 0.00172f
C319 a_3663_770# vdd 0.36814f
C320 a_5214_3120# a_6063_1270# 0
C321 a_323_3700# a_2903_7850# 0.00339f
C322 a_6063_8350# a_5993_5273# 0
C323 a_3663_3730# a_5214_5480# 0.00196f
C324 a_6063_5990# cb3 0.00135f
C325 a_323_3700# a_3663_8450# 0.00289f
C326 a_323_3700# a_3663_7850# 0
C327 a_323_6060# a_2903_5490# 0.0016f
C328 a_5993_5964# a_6063_5390# 0.03306f
C329 a_6063_8350# a_5993_8324# 0.5962f
C330 a_6063_5990# a_5993_7633# 0.20849f
C331 a_5993_7633# a_5214_7840# 1.96442f
C332 a_5214_8308# a_323_3700# 0.01548f
C333 a_3663_5490# a_5993_5273# 0.00506f
C334 vdd a_5214_5480# 0.09076f
C335 a_6063_7750# cb7 0.59285f
C336 a_6063_5990# a_5214_5948# 0.01568f
C337 a_2903_3130# a_3663_1370# 0
C338 a_5993_2913# a_5214_1228# 0.01165f
C339 a_5214_5948# a_5214_7840# 0.14832f
C340 cb6 vdd 1.27764f
C341 a_3663_6090# vdd 0.37193f
C342 a_6063_7750# a_5993_5273# 0.18257f
C343 a_5214_3588# a_5993_5273# 0.01165f
C344 a_5214_3588# a_2903_3130# 0.01703f
C345 cb2 a_5993_5964# 0.00439f
C346 a_6063_5390# a_5993_7633# 0.22518f
C347 a_323_1340# a_5993_7633# 0
C348 a_6063_7750# a_5993_8324# 0.01297f
C349 a_5214_5948# a_6063_5390# 0
C350 a_323_3700# a_2903_1370# 0
C351 a_5993_3604# a_6063_3030# 0.01297f
C352 a_5993_2913# a_6063_3630# 0.01615f
C353 cb1 a_6063_3630# 0.59992f
C354 a_323_8420# a_2903_3730# 0.00602f
C355 a_6063_670# a_6063_1270# 0.2697f
C356 cb2 cb3 0
C357 a_5993_1244# a_5214_1228# 1.96348f
C358 cb0 a_6063_1270# 0.60075f
C359 a_2903_3130# a_323_6060# 0.33533f
C360 a_5993_2913# a_323_8420# 0
C361 a_2903_8450# a_5993_7633# 0.00351f
C362 a_323_1340# a_2903_3730# 0.3346f
C363 a_5214_760# a_5993_1244# 0.01895f
C364 a_5993_553# a_6063_1270# 0.01215f
C365 a_5214_3120# a_2903_3130# 0.16302f
C366 vdd a_6063_1270# 1.632f
C367 a_323_3700# a_323_8420# 0.67977f
C368 a_5993_8324# a_323_6060# 0
C369 a_2903_1370# a_5993_1244# 0.00484f
C370 cb1 a_6063_5390# 0.00127f
C371 a_5993_3604# a_5993_5964# 0
C372 a_3663_3730# a_2903_5490# 0
C373 a_5214_1228# a_3663_3130# 0.00196f
C374 a_5214_8308# a_6063_8350# 0.01568f
C375 a_323_3700# a_323_1340# 0.87896f
C376 a_5993_1244# a_6063_3630# 0.20443f
C377 in a_323_8420# 0.00515f
C378 vdd a_2903_5490# 0.9495f
C379 a_2903_6090# a_323_6060# 0
C380 a_5214_1228# a_2903_770# 0.01703f
C381 a_2903_1370# a_3663_3130# 0
C382 in a_323_1340# 0
C383 cb2 cb1 0
C384 a_323_3700# ip 0.00544f
C385 a_5214_760# a_2903_770# 0.16302f
C386 a_323_3700# a_2903_8450# 0.3348f
C387 a_2903_1370# a_2903_770# 0.30672f
C388 a_5993_1244# a_323_1340# 0
C389 a_5214_1228# a_3663_1370# 0.33733f
C390 a_323_8420# a_3663_3130# 0.29099f
C391 a_6063_5990# a_6063_8350# 0.4606f
C392 a_2903_7850# a_323_6060# 0.00459f
C393 a_6063_8350# a_6063_3630# 0.00345f
C394 a_5993_3604# a_2903_3730# 0.00484f
C395 cb7 vdd 1.27851f
C396 a_2903_1370# a_3663_1370# 0.25738f
C397 a_3663_8450# a_323_6060# 0.29099f
C398 a_3663_7850# a_323_6060# 0.00133f
C399 a_5993_5964# a_5993_7633# 0.11363f
C400 a_323_8420# a_2903_770# 0.00106f
C401 a_5993_3604# a_5993_2913# 0.15552f
C402 a_323_1340# a_3663_3130# 0
C403 a_5993_2913# a_6063_3030# 0.53461f
C404 a_5993_3604# cb1 0.00655f
C405 cb1 a_6063_3030# 0.01266f
C406 a_5214_5948# a_5993_5964# 1.96348f
C407 a_5214_8308# a_323_6060# 0.05299f
C408 cb4 vss 1.58508f
C409 cb0 vss 1.29362f
C410 ip vss 0.82855f
C411 cb5 vss 1.5624f
C412 cb1 vss 1.28395f
C413 qp vss 0.82798f
C414 cb6 vss 1.55746f
C415 cb2 vss 1.28933f
C416 in vss 0.82798f
C417 cb7 vss 1.56643f
C418 cb3 vss 1.29154f
C419 qn vss 0.82693f
C420 vdd vss 71.8703f
C421 a_6063_670# vss 2.25128f
C422 a_5993_553# vss 1.50125f
C423 a_5214_760# vss 1.97138f
C424 a_5214_1228# vss 1.75469f
C425 a_3663_770# vss 0.79261f
C426 a_2903_770# vss 0.67f
C427 a_6063_1270# vss 1.8858f
C428 a_3663_1370# vss 0.76249f
C429 a_2903_1370# vss 0.65591f
C430 a_5993_1244# vss 1.30961f
C431 a_6063_3030# vss 1.88298f
C432 a_5993_2913# vss 1.24071f
C433 a_5214_3120# vss 1.75317f
C434 a_5214_3588# vss 1.75692f
C435 a_3663_3130# vss 0.76249f
C436 a_2903_3130# vss 0.65572f
C437 a_3663_3730# vss 0.76249f
C438 a_2903_3730# vss 0.65591f
C439 a_5993_3604# vss 1.49719f
C440 a_6063_3630# vss 2.65208f
C441 a_6063_5390# vss 2.16672f
C442 a_5993_5273# vss 1.255f
C443 a_5214_5480# vss 1.74678f
C444 a_5214_5948# vss 1.75469f
C445 a_3663_5490# vss 0.76249f
C446 a_2903_5490# vss 0.65572f
C447 a_6063_5990# vss 1.88522f
C448 a_3663_6090# vss 0.76249f
C449 a_2903_6090# vss 0.65591f
C450 a_5993_5964# vss 1.30692f
C451 a_6063_7750# vss 1.87912f
C452 a_5993_7633# vss 1.24071f
C453 a_5214_7840# vss 1.75317f
C454 a_5214_8308# vss 1.90447f
C455 a_3663_7850# vss 0.76249f
C456 a_2903_7850# vss 0.65577f
C457 a_323_1340# vss 10.4325f
C458 a_3663_8450# vss 0.79128f
C459 a_2903_8450# vss 0.6614f
C460 a_323_8420# vss 10.2896f
C461 a_5993_8324# vss 1.72939f
C462 a_323_6060# vss 10.4088f
C463 a_323_3700# vss 10.3919f
C464 a_6063_8350# vss 2.67883f
.ends
