* Exact flattened LVS reference netlist for serdes_rx_octature_4to8_2p5g_pdk
* Source subckt: serdes_rx_octature_4to8_2p5g (analog/rx/cmos_rx/spice/rx_pi_4ph_iq_5g_v3.spice)
.subckt serdes_rx_octature_4to8_2p5g_pdk ip qp in qn cb0 cb1 cb2 cb3 cb4 cb5 cb6 cb7 vdd vss
X1 t_ips ip vss vss sky130_fd_pr__nfet_01v8_lvt w=1.4 l=0.15
X2 t_ips ip vdd vdd sky130_fd_pr__pfet_01v8_lvt w=5.6 l=0.35
X3 t_qps qp vss vss sky130_fd_pr__nfet_01v8_lvt w=1.4 l=0.15
X4 t_qps qp vdd vdd sky130_fd_pr__pfet_01v8_lvt w=5.6 l=0.35
X5 t_ins in vss vss sky130_fd_pr__nfet_01v8_lvt w=1.4 l=0.15
X6 t_ins in vdd vdd sky130_fd_pr__pfet_01v8_lvt w=5.6 l=0.35
X7 t_qns qn vss vss sky130_fd_pr__nfet_01v8_lvt w=1.4 l=0.15
X8 t_qns qn vdd vdd sky130_fd_pr__pfet_01v8_lvt w=5.6 l=0.35
X9 t_ips vss sky130_fd_pr__cap_mim_m3_1 w=1.75 l=1.75
X10 t_qps vss sky130_fd_pr__cap_mim_m3_1 w=1.75 l=1.75
X11 t_ins vss sky130_fd_pr__cap_mim_m3_1 w=1.75 l=1.75
X12 t_qns vss sky130_fd_pr__cap_mim_m3_1 w=1.75 l=1.75
X13 t_Xo0_da t_ips vss vss sky130_fd_pr__nfet_01v8_lvt w=1.1 l=0.15
X14 t_Xo0_da t_ips vdd vdd sky130_fd_pr__pfet_01v8_lvt w=4.4 l=0.35
X15 t_Xo0_db t_ips vss vss sky130_fd_pr__nfet_01v8_lvt w=1.1 l=0.15
X16 t_Xo0_db t_ips vdd vdd sky130_fd_pr__pfet_01v8_lvt w=4.4 l=0.35
X17 t_Xo0_da t_m0 vss sky130_fd_pr__res_high_po_0p69 l=1.5
X18 t_Xo0_db t_m0 vss sky130_fd_pr__res_high_po_0p69 l=1.5
X19 t_Xo1_da t_ips vss vss sky130_fd_pr__nfet_01v8_lvt w=1.1 l=0.15
X20 t_Xo1_da t_ips vdd vdd sky130_fd_pr__pfet_01v8_lvt w=4.4 l=0.35
X21 t_Xo1_db t_qps vss vss sky130_fd_pr__nfet_01v8_lvt w=1.1 l=0.15
X22 t_Xo1_db t_qps vdd vdd sky130_fd_pr__pfet_01v8_lvt w=4.4 l=0.35
X23 t_Xo1_da t_m1 vss sky130_fd_pr__res_high_po_0p69 l=1.5
X24 t_Xo1_db t_m1 vss sky130_fd_pr__res_high_po_0p69 l=1.5
X25 t_Xo2_da t_qps vss vss sky130_fd_pr__nfet_01v8_lvt w=1.1 l=0.15
X26 t_Xo2_da t_qps vdd vdd sky130_fd_pr__pfet_01v8_lvt w=4.4 l=0.35
X27 t_Xo2_db t_qps vss vss sky130_fd_pr__nfet_01v8_lvt w=1.1 l=0.15
X28 t_Xo2_db t_qps vdd vdd sky130_fd_pr__pfet_01v8_lvt w=4.4 l=0.35
X29 t_Xo2_da t_m2 vss sky130_fd_pr__res_high_po_0p69 l=1.5
X30 t_Xo2_db t_m2 vss sky130_fd_pr__res_high_po_0p69 l=1.5
X31 t_Xo3_da t_qps vss vss sky130_fd_pr__nfet_01v8_lvt w=1.1 l=0.15
X32 t_Xo3_da t_qps vdd vdd sky130_fd_pr__pfet_01v8_lvt w=4.4 l=0.35
X33 t_Xo3_db t_ins vss vss sky130_fd_pr__nfet_01v8_lvt w=1.1 l=0.15
X34 t_Xo3_db t_ins vdd vdd sky130_fd_pr__pfet_01v8_lvt w=4.4 l=0.35
X35 t_Xo3_da t_m3 vss sky130_fd_pr__res_high_po_0p69 l=1.5
X36 t_Xo3_db t_m3 vss sky130_fd_pr__res_high_po_0p69 l=1.5
X37 t_Xo4_da t_ins vss vss sky130_fd_pr__nfet_01v8_lvt w=1.1 l=0.15
X38 t_Xo4_da t_ins vdd vdd sky130_fd_pr__pfet_01v8_lvt w=4.4 l=0.35
X39 t_Xo4_db t_ins vss vss sky130_fd_pr__nfet_01v8_lvt w=1.1 l=0.15
X40 t_Xo4_db t_ins vdd vdd sky130_fd_pr__pfet_01v8_lvt w=4.4 l=0.35
X41 t_Xo4_da t_m4 vss sky130_fd_pr__res_high_po_0p69 l=1.5
X42 t_Xo4_db t_m4 vss sky130_fd_pr__res_high_po_0p69 l=1.5
X43 t_Xo5_da t_ins vss vss sky130_fd_pr__nfet_01v8_lvt w=1.1 l=0.15
X44 t_Xo5_da t_ins vdd vdd sky130_fd_pr__pfet_01v8_lvt w=4.4 l=0.35
X45 t_Xo5_db t_qns vss vss sky130_fd_pr__nfet_01v8_lvt w=1.1 l=0.15
X46 t_Xo5_db t_qns vdd vdd sky130_fd_pr__pfet_01v8_lvt w=4.4 l=0.35
X47 t_Xo5_da t_m5 vss sky130_fd_pr__res_high_po_0p69 l=1.5
X48 t_Xo5_db t_m5 vss sky130_fd_pr__res_high_po_0p69 l=1.5
X49 t_Xo6_da t_qns vss vss sky130_fd_pr__nfet_01v8_lvt w=1.1 l=0.15
X50 t_Xo6_da t_qns vdd vdd sky130_fd_pr__pfet_01v8_lvt w=4.4 l=0.35
X51 t_Xo6_db t_qns vss vss sky130_fd_pr__nfet_01v8_lvt w=1.1 l=0.15
X52 t_Xo6_db t_qns vdd vdd sky130_fd_pr__pfet_01v8_lvt w=4.4 l=0.35
X53 t_Xo6_da t_m6 vss sky130_fd_pr__res_high_po_0p69 l=1.5
X54 t_Xo6_db t_m6 vss sky130_fd_pr__res_high_po_0p69 l=1.5
X55 t_Xo7_da t_qns vss vss sky130_fd_pr__nfet_01v8_lvt w=1.1 l=0.15
X56 t_Xo7_da t_qns vdd vdd sky130_fd_pr__pfet_01v8_lvt w=4.4 l=0.35
X57 t_Xo7_db t_ips vss vss sky130_fd_pr__nfet_01v8_lvt w=1.1 l=0.15
X58 t_Xo7_db t_ips vdd vdd sky130_fd_pr__pfet_01v8_lvt w=4.4 l=0.35
X59 t_Xo7_da t_m7 vss sky130_fd_pr__res_high_po_0p69 l=1.5
X60 t_Xo7_db t_m7 vss sky130_fd_pr__res_high_po_0p69 l=1.5
X61 t_Xrec04_acp t_m0 sky130_fd_pr__cap_mim_m3_1 w=4.2 l=4.2
X62 t_Xrec04_acn t_m4 sky130_fd_pr__cap_mim_m3_1 w=4.2 l=4.2
X63 t_Xrec04_acp t_o0 vss sky130_fd_pr__res_high_po_0p35 l=9.5
X64 t_Xrec04_acn t_o4 vss sky130_fd_pr__res_high_po_0p35 l=9.5
X65 t_o0 t_Xrec04_acp vss vss sky130_fd_pr__nfet_01v8_lvt w=2.2 l=0.15
X66 t_o0 t_Xrec04_acp vdd vdd sky130_fd_pr__pfet_01v8_lvt w=8.4 l=0.35
X67 t_o4 t_Xrec04_acn vss vss sky130_fd_pr__nfet_01v8_lvt w=2.2 l=0.15
X68 t_o4 t_Xrec04_acn vdd vdd sky130_fd_pr__pfet_01v8_lvt w=8.4 l=0.35
X69 t_Xrec15_acp t_m1 sky130_fd_pr__cap_mim_m3_1 w=4.2 l=4.2
X70 t_Xrec15_acn t_m5 sky130_fd_pr__cap_mim_m3_1 w=4.2 l=4.2
X71 t_Xrec15_acp t_o1 vss sky130_fd_pr__res_high_po_0p35 l=9.5
X72 t_Xrec15_acn t_o5 vss sky130_fd_pr__res_high_po_0p35 l=9.5
X73 t_o1 t_Xrec15_acp vss vss sky130_fd_pr__nfet_01v8_lvt w=2.2 l=0.15
X74 t_o1 t_Xrec15_acp vdd vdd sky130_fd_pr__pfet_01v8_lvt w=8.4 l=0.35
X75 t_o5 t_Xrec15_acn vss vss sky130_fd_pr__nfet_01v8_lvt w=2.2 l=0.15
X76 t_o5 t_Xrec15_acn vdd vdd sky130_fd_pr__pfet_01v8_lvt w=8.4 l=0.35
X77 t_Xrec26_acp t_m2 sky130_fd_pr__cap_mim_m3_1 w=4.2 l=4.2
X78 t_Xrec26_acn t_m6 sky130_fd_pr__cap_mim_m3_1 w=4.2 l=4.2
X79 t_Xrec26_acp t_o2 vss sky130_fd_pr__res_high_po_0p35 l=9.5
X80 t_Xrec26_acn t_o6 vss sky130_fd_pr__res_high_po_0p35 l=9.5
X81 t_o2 t_Xrec26_acp vss vss sky130_fd_pr__nfet_01v8_lvt w=2.2 l=0.15
X82 t_o2 t_Xrec26_acp vdd vdd sky130_fd_pr__pfet_01v8_lvt w=8.4 l=0.35
X83 t_o6 t_Xrec26_acn vss vss sky130_fd_pr__nfet_01v8_lvt w=2.2 l=0.15
X84 t_o6 t_Xrec26_acn vdd vdd sky130_fd_pr__pfet_01v8_lvt w=8.4 l=0.35
X85 t_Xrec37_acp t_m3 sky130_fd_pr__cap_mim_m3_1 w=4.2 l=4.2
X86 t_Xrec37_acn t_m7 sky130_fd_pr__cap_mim_m3_1 w=4.2 l=4.2
X87 t_Xrec37_acp t_o3 vss sky130_fd_pr__res_high_po_0p35 l=9.5
X88 t_Xrec37_acn t_o7 vss sky130_fd_pr__res_high_po_0p35 l=9.5
X89 t_o3 t_Xrec37_acp vss vss sky130_fd_pr__nfet_01v8_lvt w=2.2 l=0.15
X90 t_o3 t_Xrec37_acp vdd vdd sky130_fd_pr__pfet_01v8_lvt w=8.4 l=0.35
X91 t_o7 t_Xrec37_acn vss vss sky130_fd_pr__nfet_01v8_lvt w=2.2 l=0.15
X92 t_o7 t_Xrec37_acn vdd vdd sky130_fd_pr__pfet_01v8_lvt w=8.4 l=0.35
X93 cb0 t_o0 vss vss sky130_fd_pr__nfet_01v8_lvt w=3.4 l=0.15
X94 cb0 t_o0 vdd vdd sky130_fd_pr__pfet_01v8_lvt w=12.6 l=0.35
X95 cb1 t_o1 vss vss sky130_fd_pr__nfet_01v8_lvt w=3.4 l=0.15
X96 cb1 t_o1 vdd vdd sky130_fd_pr__pfet_01v8_lvt w=12.6 l=0.35
X97 cb2 t_o2 vss vss sky130_fd_pr__nfet_01v8_lvt w=3.4 l=0.15
X98 cb2 t_o2 vdd vdd sky130_fd_pr__pfet_01v8_lvt w=12.6 l=0.35
X99 cb3 t_o3 vss vss sky130_fd_pr__nfet_01v8_lvt w=3.4 l=0.15
X100 cb3 t_o3 vdd vdd sky130_fd_pr__pfet_01v8_lvt w=12.6 l=0.35
X101 cb4 t_o4 vss vss sky130_fd_pr__nfet_01v8_lvt w=3.4 l=0.15
X102 cb4 t_o4 vdd vdd sky130_fd_pr__pfet_01v8_lvt w=12.6 l=0.35
X103 cb5 t_o5 vss vss sky130_fd_pr__nfet_01v8_lvt w=3.4 l=0.15
X104 cb5 t_o5 vdd vdd sky130_fd_pr__pfet_01v8_lvt w=12.6 l=0.35
X105 cb6 t_o6 vss vss sky130_fd_pr__nfet_01v8_lvt w=3.4 l=0.15
X106 cb6 t_o6 vdd vdd sky130_fd_pr__pfet_01v8_lvt w=12.6 l=0.35
X107 cb7 t_o7 vss vss sky130_fd_pr__nfet_01v8_lvt w=3.4 l=0.15
X108 cb7 t_o7 vdd vdd sky130_fd_pr__pfet_01v8_lvt w=12.6 l=0.35
X109 cb4 cb0 vss vss sky130_fd_pr__nfet_01v8_lvt w=0.45 l=0.15
X110 cb4 cb0 vdd vdd sky130_fd_pr__pfet_01v8_lvt w=2.1 l=0.35
X111 cb0 cb4 vss vss sky130_fd_pr__nfet_01v8_lvt w=0.45 l=0.15
X112 cb0 cb4 vdd vdd sky130_fd_pr__pfet_01v8_lvt w=2.1 l=0.35
X113 cb5 cb1 vss vss sky130_fd_pr__nfet_01v8_lvt w=0.45 l=0.15
X114 cb5 cb1 vdd vdd sky130_fd_pr__pfet_01v8_lvt w=2.1 l=0.35
X115 cb1 cb5 vss vss sky130_fd_pr__nfet_01v8_lvt w=0.45 l=0.15
X116 cb1 cb5 vdd vdd sky130_fd_pr__pfet_01v8_lvt w=2.1 l=0.35
X117 cb6 cb2 vss vss sky130_fd_pr__nfet_01v8_lvt w=0.45 l=0.15
X118 cb6 cb2 vdd vdd sky130_fd_pr__pfet_01v8_lvt w=2.1 l=0.35
X119 cb2 cb6 vss vss sky130_fd_pr__nfet_01v8_lvt w=0.45 l=0.15
X120 cb2 cb6 vdd vdd sky130_fd_pr__pfet_01v8_lvt w=2.1 l=0.35
X121 cb7 cb3 vss vss sky130_fd_pr__nfet_01v8_lvt w=0.45 l=0.15
X122 cb7 cb3 vdd vdd sky130_fd_pr__pfet_01v8_lvt w=2.1 l=0.35
X123 cb3 cb7 vss vss sky130_fd_pr__nfet_01v8_lvt w=0.45 l=0.15
X124 cb3 cb7 vdd vdd sky130_fd_pr__pfet_01v8_lvt w=2.1 l=0.35
.ends serdes_rx_octature_4to8_2p5g_pdk
