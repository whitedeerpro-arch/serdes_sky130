* NGSPICE file created from serdes_rx_pi_4ph_5g_pdk.ext - technology: sky130A

.subckt serdes_rx_pi_4ph_5g_pdk ip qp in qn a0 a1 a2 a3 a4 a5 a6 a7 b0 b1 b2 b3 b4
+ b5 b6 b7 f0 f1 f2 f3 f4 f5 f6 f7 rst_n dp dn ep en ckd0 ckd1 ckd2 ckd3 cke0 cke1
+ cke2 cke3 vdd vss
X0 vdd a_20437_11105# a_21035_11810# vdd sky130_fd_pr__pfet_01v8 ad=1.085 pd=7.62 as=0.5775 ps=3.83 w=3.5 l=0.15
X1 a_2903_6910# a_323_4520# vdd vdd sky130_fd_pr__pfet_01v8_lvt ad=0.1595 pd=1.39 as=0.319 ps=2.78 w=1.1 l=0.35
X2 a_30963_8465# vss vdd vdd sky130_fd_pr__pfet_01v8 ad=0.2607 pd=1.91 as=0.2607 ps=1.91 w=1.58 l=0.15
X3 a_30817_8037# a_29868_8794# a_30963_7375# vss sky130_fd_pr__nfet_01v8_lvt ad=0.396 pd=2.73 as=0.396 ps=2.73 w=2.4 l=0.15
X4 a_3663_2190# a_323_2160# vdd vdd sky130_fd_pr__pfet_01v8_lvt ad=0.1595 pd=1.39 as=0.319 ps=2.78 w=1.1 l=0.35
X5 a_30217_2855# vdd vss vss sky130_fd_pr__nfet_01v8 ad=0.16675 pd=1.44 as=0.16675 ps=1.44 w=1.15 l=0.2
X6 en a_30963_3945# vdd vdd sky130_fd_pr__pfet_01v8 ad=0.495 pd=3.33 as=0.495 ps=3.33 w=3 l=0.15
X7 a_26917_2720# a_28514_1816# vss sky130_fd_pr__res_high_po_0p69 l=2.2
X8 a_22437_4220# a_20555_3741# vss vss sky130_fd_pr__nfet_01v8_lvt ad=0.203 pd=1.98 as=0.203 ps=1.98 w=0.7 l=0.15
X9 a_26917_6640# a_25035_6161# vdd vdd sky130_fd_pr__pfet_01v8 ad=0.2805 pd=2.03 as=0.527 ps=4.02 w=1.7 l=0.15
X10 a_5993_4424# a_5214_4408# sky130_fd_pr__cap_mim_m3_1 l=4.2 w=4.2
X11 a_27857_13560# a_20590_13570# a_28197_13560# vss sky130_fd_pr__nfet_01v8_lvt ad=0.465 pd=3.62 as=0.2475 ps=1.83 w=1.5 l=0.15
X12 vdd a_23615_11840# cke1 vdd sky130_fd_pr__pfet_01v8 ad=0.495 pd=3.33 as=0.495 ps=3.33 w=3 l=0.15
X13 a_12947_11933# rst_n dn vss sky130_fd_pr__nfet_01v8_lvt ad=0.2145 pd=1.63 as=0.403 ps=3.22 w=1.3 l=0.15
X14 a_24677_7240# a_22795_7929# vss vss sky130_fd_pr__nfet_01v8_lvt ad=0.203 pd=1.98 as=0.203 ps=1.98 w=0.7 l=0.15
X15 dn a_30963_8465# vdd vdd sky130_fd_pr__pfet_01v8 ad=0.495 pd=3.33 as=0.495 ps=3.33 w=3 l=0.15
X16 vdd a_29702_7094# a_29868_8794# vdd sky130_fd_pr__pfet_01v8 ad=0.4464 pd=3.5 as=0.2376 ps=1.77 w=1.44 l=0.15
X17 a_11527_4275# a_11849_1934# a_7935_1490# vdd sky130_fd_pr__pfet_01v8_lvt ad=0.3335 pd=2.59 as=0.667 ps=5.18 w=2.3 l=0.35
X18 a_7935_6810# a_6063_6810# vss vss sky130_fd_pr__nfet_01v8_lvt ad=0.2805 pd=2.03 as=0.527 ps=4.02 w=1.7 l=0.15
X19 a_7935_6210# a_7935_6810# vss vss sky130_fd_pr__nfet_01v8_lvt ad=0.1305 pd=1.48 as=0.1305 ps=1.48 w=0.45 l=0.15
X20 a_16768_4274# a_16768_2574# vdd vdd sky130_fd_pr__pfet_01v8 ad=0.462 pd=3.13 as=0.462 ps=3.13 w=2.8 l=0.15
X21 vss a_17855_12810# vss vss sky130_fd_pr__nfet_01v8 ad=0.2755 pd=2.48 as=103.8757 ps=894 w=0.95 l=0.95
X22 vdd a_30963_2855# ep vdd sky130_fd_pr__pfet_01v8 ad=0.495 pd=3.33 as=0.495 ps=3.33 w=3 l=0.15
X23 vdd a_30963_7375# dp vdd sky130_fd_pr__pfet_01v8 ad=0.93 pd=6.62 as=0.495 ps=3.33 w=3 l=0.15
X24 vdd qp a_323_4520# vdd sky130_fd_pr__pfet_01v8_lvt ad=0.406 pd=3.38 as=0.203 ps=1.69 w=1.4 l=0.35
X25 a_7595_11810# a_6997_11105# vdd vdd sky130_fd_pr__pfet_01v8 ad=0.5775 pd=3.83 as=0.5775 ps=3.83 w=3.5 l=0.15
X26 a_6063_8570# a_5993_8453# vdd vdd sky130_fd_pr__pfet_01v8_lvt ad=0.3045 pd=2.39 as=0.609 ps=4.78 w=2.1 l=0.35
X27 vdd a_18719_7929# vdd vdd sky130_fd_pr__pfet_01v8 ad=0.527 pd=4.02 as=335.65521 ps=2.53876k w=1.7 l=0.15
X28 a_2903_8670# a_323_9240# vdd vdd sky130_fd_pr__pfet_01v8_lvt ad=0.1595 pd=1.39 as=0.319 ps=2.78 w=1.1 l=0.35
X29 vss a_10409_12702# ckd2 vss sky130_fd_pr__nfet_01v8_lvt ad=0.403 pd=3.22 as=0.2145 ps=1.63 w=1.3 l=0.15
X30 a_8819_12702# a_7595_11810# a_15825_11602# vdd sky130_fd_pr__pfet_01v8_lvt ad=0.6525 pd=5.08 as=0.6525 ps=5.08 w=2.25 l=0.35
X31 a_22795_10029# a_22753_1814# a_13102_7094# vss sky130_fd_pr__nfet_01v8_lvt ad=0.1885 pd=1.88 as=0.1885 ps=1.88 w=0.65 l=0.15
X32 a_23199_5509# f5 a_13102_2574# vss sky130_fd_pr__nfet_01v8_lvt ad=0.1885 pd=1.88 as=0.1885 ps=1.88 w=0.65 l=0.15
X33 vdd a_5993_4424# a_6063_4450# vdd sky130_fd_pr__pfet_01v8_lvt ad=0.609 pd=4.78 as=0.3045 ps=2.39 w=2.1 l=0.35
X34 a_11527_2855# a2 a_7935_2090# vss sky130_fd_pr__nfet_01v8_lvt ad=0.12375 pd=1.08 as=0.2325 ps=2.12 w=0.75 l=0.15
X35 a_20197_9340# a_28514_8208# vss sky130_fd_pr__res_high_po_0p69 l=2.2
X36 vss vdd a_30217_7375# vss sky130_fd_pr__nfet_01v8 ad=0.3335 pd=2.88 as=0.16675 ps=1.44 w=1.15 l=0.2
X37 vdd a_323_2160# a_2903_4550# vdd sky130_fd_pr__pfet_01v8_lvt ad=0.319 pd=2.78 as=0.1595 ps=1.39 w=1.1 l=0.35
X38 vdd en ep vdd sky130_fd_pr__pfet_01v8 ad=0.589 pd=4.42 as=0.3135 ps=2.23 w=1.9 l=0.15
X39 vss a_20959_3409# vss vss sky130_fd_pr__nfet_01v8_lvt ad=0.203 pd=1.98 as=0 ps=0 w=0.7 l=0.15
X40 a_26917_4220# a_25035_3741# vss vss sky130_fd_pr__nfet_01v8_lvt ad=0.203 pd=1.98 as=0.203 ps=1.98 w=0.7 l=0.15
X41 a_18719_3741# a_18273_3298# a_13102_2574# vdd sky130_fd_pr__pfet_01v8_lvt ad=0.609 pd=4.78 as=0.609 ps=4.78 w=2.1 l=0.35
X42 a_11527_4275# a_12625_1934# a_7935_2090# vdd sky130_fd_pr__pfet_01v8_lvt ad=0.3335 pd=2.59 as=0.667 ps=5.18 w=2.3 l=0.35
X43 a_25439_6161# f7 a_16768_8794# vdd sky130_fd_pr__pfet_01v8_lvt ad=0.609 pd=4.78 as=0.609 ps=4.78 w=2.1 l=0.35
X44 a_20959_1641# f3 a_13268_4274# vss sky130_fd_pr__nfet_01v8_lvt ad=0.1885 pd=1.88 as=0.1885 ps=1.88 w=0.65 l=0.15
X45 a_7935_4450# a_15349_1934# a_15027_2855# vdd sky130_fd_pr__pfet_01v8_lvt ad=0.667 pd=5.18 as=0.3335 ps=2.59 w=2.3 l=0.35
X46 a_21035_11810# a_21927_11686# vdd vdd sky130_fd_pr__pfet_01v8_lvt ad=0.16675 pd=1.44 as=0.3335 ps=2.88 w=1.15 l=0.35
X47 a_20437_11105# a_19667_11933# vdd vdd sky130_fd_pr__pfet_01v8_lvt ad=1.015 pd=7.58 as=1.015 ps=7.58 w=3.5 l=0.35
X48 a_19667_11933# a_6157_11685# vss vss sky130_fd_pr__nfet_01v8 ad=0.232 pd=2.18 as=0.232 ps=2.18 w=0.8 l=0.18
X49 vss a_27157_11105# a_21927_11686# vss sky130_fd_pr__nfet_01v8_lvt ad=0.5425 pd=4.12 as=0.28875 ps=2.08 w=1.75 l=0.15
X50 vdd a_13102_4274# a_13102_2574# vdd sky130_fd_pr__pfet_01v8_lvt ad=0.812 pd=6.18 as=0.406 ps=3.09 w=2.8 l=0.35
X51 a_6063_9170# a_5993_9144# vss vss sky130_fd_pr__nfet_01v8_lvt ad=0.1815 pd=1.43 as=0.341 ps=2.82 w=1.1 l=0.15
X52 vdd a_6063_9170# a_7935_9170# vdd sky130_fd_pr__pfet_01v8_lvt ad=0.3045 pd=2.39 as=0.3045 ps=2.39 w=2.1 l=0.35
X53 vdd a_16768_2574# a_16768_4274# vdd sky130_fd_pr__pfet_01v8_lvt ad=0.812 pd=6.18 as=0.406 ps=3.09 w=2.8 l=0.35
X54 ckd0 a_8819_12702# vdd vdd sky130_fd_pr__pfet_01v8 ad=0.93 pd=6.62 as=0.495 ps=3.33 w=3 l=0.15
X55 a_10409_12702# a_9105_11602# vss vss sky130_fd_pr__nfet_01v8_lvt ad=0.3135 pd=2.23 as=0.589 ps=4.42 w=1.9 l=0.15
X56 a_20555_8261# f2 a_13102_7094# vdd sky130_fd_pr__pfet_01v8_lvt ad=0.609 pd=4.78 as=0.609 ps=4.78 w=2.1 l=0.35
X57 a_22437_2120# a_20555_1641# vdd vdd sky130_fd_pr__pfet_01v8 ad=0.2805 pd=2.03 as=0.527 ps=4.02 w=1.7 l=0.15
X58 a_26387_11933# rst_n en vss sky130_fd_pr__nfet_01v8_lvt ad=0.2145 pd=1.63 as=0.403 ps=3.22 w=1.3 l=0.15
X59 a_20197_2720# a_18315_3409# vss vss sky130_fd_pr__nfet_01v8_lvt ad=0.203 pd=1.98 as=0.203 ps=1.98 w=0.7 l=0.15
X60 a_20959_8261# f2 a_16602_7094# vdd sky130_fd_pr__pfet_01v8_lvt ad=0.609 pd=4.78 as=0.609 ps=4.78 w=2.1 l=0.35
X61 a_18719_8261# f0 a_13102_7094# vss sky130_fd_pr__nfet_01v8_lvt ad=0.1885 pd=1.88 as=0.1885 ps=1.88 w=0.65 l=0.15
X62 vdd a_20959_7929# vdd vdd sky130_fd_pr__pfet_01v8 ad=0.527 pd=4.02 as=0 ps=0 w=1.7 l=0.15
X63 dn dp vss vss sky130_fd_pr__nfet_01v8_lvt ad=0.261 pd=2.38 as=0.261 ps=2.38 w=0.9 l=0.15
X64 a_3663_1590# a_323_6880# vdd vdd sky130_fd_pr__pfet_01v8_lvt ad=0.1595 pd=1.39 as=0.1595 ps=1.39 w=1.1 l=0.35
X65 a_11527_2855# a6 a_7935_1490# vss sky130_fd_pr__nfet_01v8_lvt ad=0.12375 pd=1.08 as=0.2325 ps=2.12 w=0.75 l=0.15
X66 vdd a_6063_2090# a_7935_2090# vdd sky130_fd_pr__pfet_01v8_lvt ad=0.609 pd=4.78 as=0.3045 ps=2.39 w=2.1 l=0.35
X67 a_20513_3298# f2 vss vss sky130_fd_pr__nfet_01v8 ad=0.1305 pd=1.48 as=0.1305 ps=1.48 w=0.45 l=0.18
X68 vdd a_15237_11085# a_8425_11085# vdd sky130_fd_pr__pfet_01v8 ad=0.5775 pd=3.83 as=0.5775 ps=3.83 w=3.5 l=0.15
X69 a_20197_9340# a_18315_10029# vss vss sky130_fd_pr__nfet_01v8_lvt ad=0.203 pd=1.98 as=0.203 ps=1.98 w=0.7 l=0.15
X70 a_2903_9270# a_323_4520# vdd vdd sky130_fd_pr__pfet_01v8_lvt ad=0.1595 pd=1.39 as=0.1595 ps=1.39 w=1.1 l=0.35
X71 a_15027_4275# b3 a_7935_3850# vss sky130_fd_pr__nfet_01v8_lvt ad=0.12375 pd=1.08 as=0.2325 ps=2.12 w=0.75 l=0.15
X72 vdd a_8819_12702# ckd0 vdd sky130_fd_pr__pfet_01v8 ad=0.495 pd=3.33 as=0.495 ps=3.33 w=3 l=0.15
X73 vdd a_16602_4274# a_16602_2574# vdd sky130_fd_pr__pfet_01v8 ad=0.868 pd=6.22 as=0.462 ps=3.13 w=2.8 l=0.15
X74 vdd a_23199_5509# vdd vdd sky130_fd_pr__pfet_01v8 ad=0.527 pd=4.02 as=0 ps=0 w=1.7 l=0.15
X75 a_18315_1641# f1 a_16768_4274# vss sky130_fd_pr__nfet_01v8_lvt ad=0.1885 pd=1.88 as=0.1885 ps=1.88 w=0.65 l=0.15
X76 a_25035_3741# f6 a_16602_2574# vss sky130_fd_pr__nfet_01v8_lvt ad=0.1885 pd=1.88 as=0.1885 ps=1.88 w=0.65 l=0.15
X77 vss in a_323_6880# vss sky130_fd_pr__nfet_01v8_lvt ad=0.217 pd=2.02 as=0.1155 ps=1.03 w=0.7 l=0.15
X78 a_20959_10029# a_20513_1814# a_13102_7094# vdd sky130_fd_pr__pfet_01v8_lvt ad=0.609 pd=4.78 as=0.609 ps=4.78 w=2.1 l=0.35
X79 vdd a_323_4520# a_3663_4550# vdd sky130_fd_pr__pfet_01v8_lvt ad=0.1595 pd=1.39 as=0.1595 ps=1.39 w=1.1 l=0.35
X80 a_7935_3850# a_16125_1934# a_15027_2855# vdd sky130_fd_pr__pfet_01v8_lvt ad=0.667 pd=5.18 as=0.3335 ps=2.59 w=2.3 l=0.35
X81 a_25439_1641# f7 a_13268_4274# vss sky130_fd_pr__nfet_01v8_lvt ad=0.1885 pd=1.88 as=0.1885 ps=1.88 w=0.65 l=0.15
X82 a_25035_10029# a_24993_1814# a_13102_7094# vss sky130_fd_pr__nfet_01v8_lvt ad=0.1885 pd=1.88 as=0.1885 ps=1.88 w=0.65 l=0.15
X83 a_11527_8795# a0 a_7935_2090# vss sky130_fd_pr__nfet_01v8_lvt ad=0.12375 pd=1.08 as=0.2325 ps=2.12 w=0.75 l=0.15
X84 a_13268_8794# a_13268_7094# vss vss sky130_fd_pr__nfet_01v8_lvt ad=0.2805 pd=2.03 as=0.527 ps=4.02 w=1.7 l=0.15
X85 a_20197_7240# a_18315_7929# vdd vdd sky130_fd_pr__pfet_01v8 ad=0.2805 pd=2.03 as=0.527 ps=4.02 w=1.7 l=0.15
X86 a_23199_3409# a_22753_3298# a_13268_4274# vdd sky130_fd_pr__pfet_01v8_lvt ad=0.609 pd=4.78 as=0.609 ps=4.78 w=2.1 l=0.35
X87 a_23199_3741# f4 a_16602_2574# vdd sky130_fd_pr__pfet_01v8_lvt ad=0.609 pd=4.78 as=0.609 ps=4.78 w=2.1 l=0.35
X88 vss a_8425_11085# ckd1 vss sky130_fd_pr__nfet_01v8_lvt ad=0.403 pd=3.22 as=0.2145 ps=1.63 w=1.3 l=0.15
X89 ckd3 a_10175_11935# vdd vdd sky130_fd_pr__pfet_01v8_lvt ad=0.87 pd=6.58 as=0.87 ps=6.58 w=3 l=0.35
X90 a_29868_8794# a_29868_7094# vss sky130_fd_pr__res_high_po_0p35 l=6.5
X91 a_15027_4275# b7 a_7935_4450# vss sky130_fd_pr__nfet_01v8_lvt ad=0.12375 pd=1.08 as=0.2325 ps=2.12 w=0.75 l=0.15
X92 vdd a_10175_11935# ckd3 vdd sky130_fd_pr__pfet_01v8 ad=0.495 pd=3.33 as=0.495 ps=3.33 w=3 l=0.15
X93 a_18315_10029# a_18273_1814# a_16602_7094# vdd sky130_fd_pr__pfet_01v8_lvt ad=0.609 pd=4.78 as=0.609 ps=4.78 w=2.1 l=0.35
X94 vdd a_25439_7929# vdd vdd sky130_fd_pr__pfet_01v8 ad=0.527 pd=4.02 as=0 ps=0 w=1.7 l=0.15
X95 a_22795_5509# f5 a_16602_2574# vss sky130_fd_pr__nfet_01v8_lvt ad=0.1885 pd=1.88 as=0.1885 ps=1.88 w=0.65 l=0.15
X96 vdd a_21927_11686# a_21035_11810# vdd sky130_fd_pr__pfet_01v8_lvt ad=0.3335 pd=2.88 as=0.16675 ps=1.44 w=1.15 l=0.35
X97 a_3663_9270# a_323_6880# vdd vdd sky130_fd_pr__pfet_01v8_lvt ad=0.1595 pd=1.39 as=0.319 ps=2.78 w=1.1 l=0.35
X98 a_23615_11840# a_29097_13560# vdd vdd sky130_fd_pr__pfet_01v8 ad=1.085 pd=7.62 as=0.5775 ps=3.83 w=3.5 l=0.15
X99 a_3663_3950# a_323_9240# vss vss sky130_fd_pr__nfet_01v8_lvt ad=0.319 pd=2.78 as=0.319 ps=2.78 w=1.1 l=0.15
X100 a_29702_2574# a_29868_4274# vdd vdd sky130_fd_pr__pfet_01v8 ad=0.2376 pd=1.77 as=0.4464 ps=3.5 w=1.44 l=0.15
X101 a_21927_11686# a_27157_11105# vdd vdd sky130_fd_pr__pfet_01v8_lvt ad=1.015 pd=7.58 as=1.015 ps=7.58 w=3.5 l=0.35
X102 a_18719_7929# a_18273_3298# a_13268_8794# vdd sky130_fd_pr__pfet_01v8_lvt ad=0.609 pd=4.78 as=0.609 ps=4.78 w=2.1 l=0.35
X103 a_20555_1641# f3 a_16768_4274# vss sky130_fd_pr__nfet_01v8_lvt ad=0.1885 pd=1.88 as=0.1885 ps=1.88 w=0.65 l=0.15
X104 a_25035_3409# a_24993_3298# a_13268_4274# vss sky130_fd_pr__nfet_01v8_lvt ad=0.1885 pd=1.88 as=0.1885 ps=1.88 w=0.65 l=0.15
X105 vss a_6997_11105# a_7595_11810# vss sky130_fd_pr__nfet_01v8_lvt ad=0.5425 pd=4.12 as=0.28875 ps=2.08 w=1.75 l=0.15
X106 a_25439_10029# a_24993_1814# a_13102_7094# vdd sky130_fd_pr__pfet_01v8_lvt ad=0.609 pd=4.78 as=0.609 ps=4.78 w=2.1 l=0.35
X107 dn a_30963_8465# vdd vdd sky130_fd_pr__pfet_01v8 ad=0.495 pd=3.33 as=0.93 ps=6.62 w=3 l=0.15
X108 vdd vss a_30963_3945# vdd sky130_fd_pr__pfet_01v8 ad=0.4898 pd=3.78 as=0.2607 ps=1.91 w=1.58 l=0.15
X109 a_18315_3741# a_18273_3298# a_13102_2574# vss sky130_fd_pr__nfet_01v8_lvt ad=0.1885 pd=1.88 as=0.1885 ps=1.88 w=0.65 l=0.15
X110 a_11527_8795# a4 a_7935_1490# vss sky130_fd_pr__nfet_01v8_lvt ad=0.12375 pd=1.08 as=0.2325 ps=2.12 w=0.75 l=0.15
X111 a_23199_8261# a_22753_3298# a_16602_7094# vss sky130_fd_pr__nfet_01v8_lvt ad=0.1885 pd=1.88 as=0.1885 ps=1.88 w=0.65 l=0.15
X112 a_7935_1490# a_7935_2090# vdd vdd sky130_fd_pr__pfet_01v8_lvt ad=0.609 pd=4.78 as=0.609 ps=4.78 w=2.1 l=0.35
X113 a_24677_7240# a_22795_7929# vdd vdd sky130_fd_pr__pfet_01v8 ad=0.2805 pd=2.03 as=0.527 ps=4.02 w=1.7 l=0.15
X114 a_20197_6640# a_28514_6336# vss sky130_fd_pr__res_high_po_0p69 l=2.2
X115 a_7935_8570# a_15737_1934# a_15027_4275# vdd sky130_fd_pr__pfet_01v8_lvt ad=0.667 pd=5.18 as=0.3335 ps=2.59 w=2.3 l=0.35
X116 a_25439_3409# a_24993_3298# a_16768_4274# vss sky130_fd_pr__nfet_01v8_lvt ad=0.1885 pd=1.88 as=0.1885 ps=1.88 w=0.65 l=0.15
X117 a_18719_3741# a_18273_3298# a_16602_2574# vss sky130_fd_pr__nfet_01v8_lvt ad=0.1885 pd=1.88 as=0.1885 ps=1.88 w=0.65 l=0.15
X118 a_6227_11933# rst_n dp vss sky130_fd_pr__nfet_01v8_lvt ad=0.2145 pd=1.63 as=0.403 ps=3.22 w=1.3 l=0.15
X119 vdd a_30963_7375# dp vdd sky130_fd_pr__pfet_01v8 ad=0.495 pd=3.33 as=0.495 ps=3.33 w=3 l=0.15
X120 a_26917_4820# a_25035_5509# vdd vdd sky130_fd_pr__pfet_01v8 ad=0.2805 pd=2.03 as=0.527 ps=4.02 w=1.7 l=0.15
X121 a_15237_11085# a_7595_11810# a_10409_12702# vdd sky130_fd_pr__pfet_01v8_lvt ad=0.6525 pd=5.08 as=0.6525 ps=5.08 w=2.25 l=0.35
X122 a_28757_13560# a_20590_13570# a_29097_13560# vss sky130_fd_pr__nfet_01v8_lvt ad=0.465 pd=3.62 as=0.2475 ps=1.83 w=1.5 l=0.15
X123 a_29702_7094# a_29702_8794# a_30217_7375# vss sky130_fd_pr__nfet_01v8_lvt ad=0.744 pd=5.42 as=0.396 ps=2.73 w=2.4 l=0.15
X124 a_24993_1814# f7 vdd vdd sky130_fd_pr__pfet_01v8 ad=0.261 pd=2.38 as=0.261 ps=2.38 w=0.9 l=0.18
X125 a_3663_6910# a_323_4520# vdd vdd sky130_fd_pr__pfet_01v8_lvt ad=0.1595 pd=1.39 as=0.1595 ps=1.39 w=1.1 l=0.35
X126 a_20555_10029# a_20513_1814# a_16602_7094# vdd sky130_fd_pr__pfet_01v8_lvt ad=0.609 pd=4.78 as=0.609 ps=4.78 w=2.1 l=0.35
X127 vss a_13268_2574# a_13268_4274# vss sky130_fd_pr__nfet_01v8_lvt ad=0.527 pd=4.02 as=0.2805 ps=2.03 w=1.7 l=0.15
X128 vdd a_30963_3945# a_30963_2855# vdd sky130_fd_pr__pfet_01v8 ad=0.2079 pd=1.59 as=0.2079 ps=1.59 w=1.26 l=0.15
X129 vdd a_18315_3409# a_20197_2720# vdd sky130_fd_pr__pfet_01v8 ad=0.527 pd=4.02 as=0.2805 ps=2.03 w=1.7 l=0.15
X130 a_13268_8794# a_13268_7094# vss sky130_fd_pr__res_high_po_0p35 l=6.5
X131 a_6063_4450# a_5993_4424# vdd vdd sky130_fd_pr__pfet_01v8_lvt ad=0.3045 pd=2.39 as=0.609 ps=4.78 w=2.1 l=0.35
X132 a_323_9240# vss sky130_fd_pr__cap_mim_m3_1 l=1.75 w=1.75
X133 vdd a_30963_8465# a_30963_7375# vdd sky130_fd_pr__pfet_01v8 ad=0.3906 pd=3.14 as=0.2079 ps=1.59 w=1.26 l=0.15
X134 vss a_6063_6210# a_7935_6210# vss sky130_fd_pr__nfet_01v8_lvt ad=0.527 pd=4.02 as=0.2805 ps=2.03 w=1.7 l=0.15
X135 a_2903_4550# a_323_2160# vdd vdd sky130_fd_pr__pfet_01v8_lvt ad=0.1595 pd=1.39 as=0.319 ps=2.78 w=1.1 l=0.35
X136 vdd a_25035_1641# a_26917_2120# vdd sky130_fd_pr__pfet_01v8 ad=0.527 pd=4.02 as=0.2805 ps=2.03 w=1.7 l=0.15
X137 dp dn vss vss sky130_fd_pr__nfet_01v8_lvt ad=0.261 pd=2.38 as=0.261 ps=2.38 w=0.9 l=0.15
X138 vdd a_30963_3945# en vdd sky130_fd_pr__pfet_01v8 ad=0.93 pd=6.62 as=0.495 ps=3.33 w=3 l=0.15
X139 a_22795_1641# f5 a_13268_4274# vdd sky130_fd_pr__pfet_01v8_lvt ad=0.609 pd=4.78 as=0.609 ps=4.78 w=2.1 l=0.35
X140 vss a_18719_3741# vss vss sky130_fd_pr__nfet_01v8_lvt ad=0.203 pd=1.98 as=0 ps=0 w=0.7 l=0.15
X141 a_7935_3850# a_7935_4450# vss vss sky130_fd_pr__nfet_01v8_lvt ad=0.1305 pd=1.48 as=0.1305 ps=1.48 w=0.45 l=0.15
X142 vdd a_21035_11810# a_21927_11686# vdd sky130_fd_pr__pfet_01v8_lvt ad=0.3335 pd=2.88 as=0.16675 ps=1.44 w=1.15 l=0.35
X143 a_7935_1490# a_11461_1934# a_11527_7375# vdd sky130_fd_pr__pfet_01v8_lvt ad=0.667 pd=5.18 as=0.3335 ps=2.59 w=2.3 l=0.35
X144 a_23199_7929# f4 a_16768_8794# vdd sky130_fd_pr__pfet_01v8_lvt ad=0.609 pd=4.78 as=0.609 ps=4.78 w=2.1 l=0.35
X145 en a_30963_3945# vdd vdd sky130_fd_pr__pfet_01v8_lvt ad=0.406 pd=3.09 as=0.812 ps=6.18 w=2.8 l=0.35
X146 a_18719_10029# a_18273_1814# a_16602_7094# vss sky130_fd_pr__nfet_01v8_lvt ad=0.1885 pd=1.88 as=0.1885 ps=1.88 w=0.65 l=0.15
X147 a_3663_8670# a_323_2160# vdd vdd sky130_fd_pr__pfet_01v8_lvt ad=0.1595 pd=1.39 as=0.1595 ps=1.39 w=1.1 l=0.35
X148 vdd ip a_323_2160# vdd sky130_fd_pr__pfet_01v8_lvt ad=0.406 pd=3.38 as=0.203 ps=1.69 w=1.4 l=0.35
X149 a_22437_4820# a_28514_3688# vss sky130_fd_pr__res_high_po_0p69 l=2.2
X150 vss a_23615_11840# vss vss sky130_fd_pr__nfet_01v8 ad=0.2465 pd=2.28 as=0 ps=0 w=0.85 l=0.35
X151 a_10409_12702# a_9105_11602# vdd vdd sky130_fd_pr__pfet_01v8_lvt ad=1.015 pd=7.58 as=1.015 ps=7.58 w=3.5 l=0.35
X152 vdd a_6063_9170# a_7935_9170# vdd sky130_fd_pr__pfet_01v8_lvt ad=0.609 pd=4.78 as=0.3045 ps=2.39 w=2.1 l=0.35
X153 a_7595_11810# a_6997_11105# vdd vdd sky130_fd_pr__pfet_01v8_lvt ad=1.015 pd=7.58 as=1.015 ps=7.58 w=3.5 l=0.35
X154 a_323_6880# vss sky130_fd_pr__cap_mim_m3_1 l=1.75 w=1.75
X155 vdd a_22795_3409# a_24677_2720# vdd sky130_fd_pr__pfet_01v8 ad=0.527 pd=4.02 as=0.2805 ps=2.03 w=1.7 l=0.15
X156 a_7935_3850# b5 a_15027_8795# vss sky130_fd_pr__nfet_01v8_lvt ad=0.2325 pd=2.12 as=0.12375 ps=1.08 w=0.75 l=0.15
X157 a_323_4520# qp vss vss sky130_fd_pr__nfet_01v8_lvt ad=0.1155 pd=1.03 as=0.217 ps=2.02 w=0.7 l=0.15
X158 vdd a_5993_2064# a_6063_2090# vdd sky130_fd_pr__pfet_01v8_lvt ad=0.609 pd=4.78 as=0.3045 ps=2.39 w=2.1 l=0.35
X159 a_20555_3409# f2 a_13268_4274# vdd sky130_fd_pr__pfet_01v8_lvt ad=0.609 pd=4.78 as=0.609 ps=4.78 w=2.1 l=0.35
X160 a_22795_6161# a_22753_1814# a_13268_8794# vss sky130_fd_pr__nfet_01v8_lvt ad=0.1885 pd=1.88 as=0.1885 ps=1.88 w=0.65 l=0.15
X161 vdd a_323_2160# a_2903_2190# vdd sky130_fd_pr__pfet_01v8_lvt ad=0.319 pd=2.78 as=0.1595 ps=1.39 w=1.1 l=0.35
X162 vss a_10175_11935# vss vss sky130_fd_pr__nfet_01v8 ad=0.2465 pd=2.28 as=0 ps=0 w=0.85 l=0.35
X163 cke3 a_21865_11030# vdd vdd sky130_fd_pr__pfet_01v8 ad=0.93 pd=6.62 as=0.495 ps=3.33 w=3 l=0.15
X164 vss a_16602_8794# a_16602_7094# vss sky130_fd_pr__nfet_01v8_lvt ad=0.527 pd=4.02 as=0.2805 ps=2.03 w=1.7 l=0.15
X165 a_23199_7929# f4 a_13268_8794# vss sky130_fd_pr__nfet_01v8_lvt ad=0.1885 pd=1.88 as=0.1885 ps=1.88 w=0.65 l=0.15
X166 a_7935_2090# a_12237_1934# a_11527_7375# vdd sky130_fd_pr__pfet_01v8_lvt ad=0.667 pd=5.18 as=0.3335 ps=2.59 w=2.3 l=0.35
X167 a_20959_3409# f2 a_16768_4274# vdd sky130_fd_pr__pfet_01v8_lvt ad=0.609 pd=4.78 as=0.609 ps=4.78 w=2.1 l=0.35
X168 a_6063_6810# a_5993_6784# vss vss sky130_fd_pr__nfet_01v8_lvt ad=0.1815 pd=1.43 as=0.341 ps=2.82 w=1.1 l=0.15
X169 a_20437_11105# a_19667_11933# vss vss sky130_fd_pr__nfet_01v8_lvt ad=0.20625 pd=1.58 as=0.3875 ps=3.12 w=1.25 l=0.15
X170 cke1 a_23615_11840# vdd vdd sky130_fd_pr__pfet_01v8 ad=0.93 pd=6.62 as=0.495 ps=3.33 w=3 l=0.15
X171 a_29868_8794# a_29868_7094# a_30217_7375# vss sky130_fd_pr__nfet_01v8_lvt ad=0.744 pd=5.42 as=0.396 ps=2.73 w=2.4 l=0.15
X172 vdd a_23615_11840# vdd vdd sky130_fd_pr__pfet_01v8 ad=0.406 pd=3.38 as=0 ps=0 w=1.4 l=0.15
X173 vdd a_23199_8261# vdd vdd sky130_fd_pr__pfet_01v8 ad=0.2805 pd=2.03 as=0 ps=0 w=1.7 l=0.15
X174 vdd a_18719_1641# vdd vdd sky130_fd_pr__pfet_01v8 ad=0.527 pd=4.02 as=0 ps=0 w=1.7 l=0.15
X175 a_7935_1490# a_7935_2090# vss vss sky130_fd_pr__nfet_01v8_lvt ad=0.1305 pd=1.48 as=0.1305 ps=1.48 w=0.45 l=0.15
X176 a_13102_7094# a_13102_8794# vdd vdd sky130_fd_pr__pfet_01v8 ad=0.462 pd=3.13 as=0.868 ps=6.22 w=2.8 l=0.15
X177 ckd0 ckd2 vss vss sky130_fd_pr__nfet_01v8_lvt ad=0.1305 pd=1.48 as=0.1305 ps=1.48 w=0.45 l=0.15
X178 vdd a_6997_11105# a_7595_11810# vdd sky130_fd_pr__pfet_01v8 ad=1.085 pd=7.62 as=0.5775 ps=3.83 w=3.5 l=0.15
X179 a_7935_8570# a_7935_9170# vdd vdd sky130_fd_pr__pfet_01v8_lvt ad=0.609 pd=4.78 as=0.609 ps=4.78 w=2.1 l=0.35
X180 a_24993_1814# f7 vss vss sky130_fd_pr__nfet_01v8 ad=0.1305 pd=1.48 as=0.1305 ps=1.48 w=0.45 l=0.18
X181 a_28197_13560# a_29097_13560# vss vss sky130_fd_pr__nfet_01v8 ad=0.174 pd=1.78 as=0.174 ps=1.78 w=0.6 l=0.28
X182 vss a_23199_6161# vss vss sky130_fd_pr__nfet_01v8_lvt ad=0.203 pd=1.98 as=0 ps=0 w=0.7 l=0.15
X183 vdd a_323_2160# a_3663_2190# vdd sky130_fd_pr__pfet_01v8_lvt ad=0.1595 pd=1.39 as=0.1595 ps=1.39 w=1.1 l=0.35
X184 vss vdd a_30817_3517# vss sky130_fd_pr__nfet_01v8 ad=0.17835 pd=1.52 as=0.17835 ps=1.52 w=1.23 l=0.2
X185 a_23615_11840# a_21035_11810# a_21477_13560# vss sky130_fd_pr__nfet_01v8_lvt ad=0.33 pd=2.33 as=0.62 ps=4.62 w=2 l=0.15
X186 vss a_25439_3741# vss vss sky130_fd_pr__nfet_01v8_lvt ad=0.203 pd=1.98 as=0 ps=0 w=0.7 l=0.15
X187 a_323_2160# ip vss vss sky130_fd_pr__nfet_01v8_lvt ad=0.1155 pd=1.03 as=0.217 ps=2.02 w=0.7 l=0.15
X188 a_7935_6810# a0 a_11527_4275# vss sky130_fd_pr__nfet_01v8_lvt ad=0.2325 pd=2.12 as=0.12375 ps=1.08 w=0.75 l=0.15
X189 en ep vdd vdd sky130_fd_pr__pfet_01v8 ad=0.3135 pd=2.23 as=0.589 ps=4.42 w=1.9 l=0.15
X190 a_7935_6810# a_11849_1934# a_11527_8795# vdd sky130_fd_pr__pfet_01v8_lvt ad=0.667 pd=5.18 as=0.3335 ps=2.59 w=2.3 l=0.35
X191 a_7935_6210# a_6063_6210# vdd vdd sky130_fd_pr__pfet_01v8_lvt ad=0.3045 pd=2.39 as=0.3045 ps=2.39 w=2.1 l=0.35
X192 vdd a_13268_7094# a_13268_8794# vdd sky130_fd_pr__pfet_01v8 ad=0.462 pd=3.13 as=0.462 ps=3.13 w=2.8 l=0.15
X193 a_30817_3517# vdd vss vss sky130_fd_pr__nfet_01v8 ad=0.17835 pd=1.52 as=0.17835 ps=1.52 w=1.23 l=0.2
X194 a_21477_13560# a_7035_12870# vdd vdd sky130_fd_pr__pfet_01v8 ad=0.522 pd=4.18 as=0.522 ps=4.18 w=1.8 l=0.18
X195 vdd a_20555_8261# a_22437_8740# vdd sky130_fd_pr__pfet_01v8 ad=0.527 pd=4.02 as=0.2805 ps=2.03 w=1.7 l=0.15
X196 a_22437_6640# a_20555_6161# vss vss sky130_fd_pr__nfet_01v8_lvt ad=0.203 pd=1.98 as=0.203 ps=1.98 w=0.7 l=0.15
X197 a_23615_11840# a_21865_11030# vss vss sky130_fd_pr__nfet_01v8_lvt ad=0.1885 pd=1.88 as=0.1885 ps=1.88 w=0.65 l=0.15
X198 a_22795_7929# f4 a_16768_8794# vss sky130_fd_pr__nfet_01v8_lvt ad=0.1885 pd=1.88 as=0.1885 ps=1.88 w=0.65 l=0.15
X199 a_3663_1590# a_323_6880# vss vss sky130_fd_pr__nfet_01v8_lvt ad=0.319 pd=2.78 as=0.319 ps=2.78 w=1.1 l=0.15
X200 vdd a_20959_1641# vdd vdd sky130_fd_pr__pfet_01v8 ad=0.527 pd=4.02 as=0 ps=0 w=1.7 l=0.15
X201 vss a_9105_11602# a_10409_12702# vss sky130_fd_pr__nfet_01v8_lvt ad=0.589 pd=4.42 as=0.3135 ps=2.23 w=1.9 l=0.15
X202 a_18745_12784# a_18105_12784# vdd vdd sky130_fd_pr__pfet_01v8_lvt ad=0.609 pd=4.78 as=0.609 ps=4.78 w=2.1 l=0.35
X203 a_20959_5509# f3 a_13102_2574# vss sky130_fd_pr__nfet_01v8_lvt ad=0.1885 pd=1.88 as=0.1885 ps=1.88 w=0.65 l=0.15
X204 a_24677_4220# a_22795_3741# vss vss sky130_fd_pr__nfet_01v8_lvt ad=0.203 pd=1.98 as=0.203 ps=1.98 w=0.7 l=0.15
X205 en rst_n a_26387_11933# vss sky130_fd_pr__nfet_01v8_lvt ad=0.403 pd=3.22 as=0.2145 ps=1.63 w=1.3 l=0.15
X206 a_7935_4450# a_14961_1934# a_15027_8795# vdd sky130_fd_pr__pfet_01v8_lvt ad=0.667 pd=5.18 as=0.3335 ps=2.59 w=2.3 l=0.35
X207 a_8425_11085# a_15237_11085# vdd vdd sky130_fd_pr__pfet_01v8 ad=1.085 pd=7.62 as=0.5775 ps=3.83 w=3.5 l=0.15
X208 a_19667_11933# a_6157_11685# ep vdd sky130_fd_pr__pfet_01v8_lvt ad=0.6583 pd=5.12 as=0.32915 ps=2.56 w=2.27 l=0.35
X209 a_22795_6161# a_22753_1814# a_16768_8794# vdd sky130_fd_pr__pfet_01v8_lvt ad=0.609 pd=4.78 as=0.609 ps=4.78 w=2.1 l=0.35
X210 vdd a_30963_3945# en vdd sky130_fd_pr__pfet_01v8 ad=0.495 pd=3.33 as=0.495 ps=3.33 w=3 l=0.15
X211 a_6227_11933# a_6157_11685# vss vss sky130_fd_pr__nfet_01v8 ad=0.232 pd=2.18 as=0.232 ps=2.18 w=0.8 l=0.18
X212 a_7935_6210# a_12625_1934# a_11527_8795# vdd sky130_fd_pr__pfet_01v8_lvt ad=0.667 pd=5.18 as=0.3335 ps=2.59 w=2.3 l=0.35
X213 a_13268_4274# a_13268_2574# vdd vdd sky130_fd_pr__pfet_01v8_lvt ad=0.406 pd=3.09 as=0.812 ps=6.18 w=2.8 l=0.35
X214 a_15678_205# b2 vdd vdd sky130_fd_pr__pfet_01v8 ad=0.261 pd=2.38 as=0.261 ps=2.38 w=0.9 l=0.18
X215 vdd qn a_323_9240# vdd sky130_fd_pr__pfet_01v8_lvt ad=0.406 pd=3.38 as=0.203 ps=1.69 w=1.4 l=0.35
X216 a_20197_2120# a_18315_1641# vdd vdd sky130_fd_pr__pfet_01v8 ad=0.2805 pd=2.03 as=0.527 ps=4.02 w=1.7 l=0.15
X217 a_10175_11935# a_7595_11810# a_9105_11602# vss sky130_fd_pr__nfet_01v8_lvt ad=0.23925 pd=1.78 as=0.4495 ps=3.52 w=1.45 l=0.15
X218 a_18315_5509# f1 a_16602_2574# vss sky130_fd_pr__nfet_01v8_lvt ad=0.1885 pd=1.88 as=0.1885 ps=1.88 w=0.65 l=0.15
X219 a_16768_4274# a_16768_2574# vss vss sky130_fd_pr__nfet_01v8_lvt ad=0.2805 pd=2.03 as=0.527 ps=4.02 w=1.7 l=0.15
X220 a_20197_8740# a_28514_8208# vss sky130_fd_pr__res_high_po_0p69 l=2.2
X221 vss vdd a_30817_8037# vss sky130_fd_pr__nfet_01v8 ad=0.17835 pd=1.52 as=0.17835 ps=1.52 w=1.23 l=0.2
X222 a_26917_6640# a_25035_6161# vss vss sky130_fd_pr__nfet_01v8_lvt ad=0.203 pd=1.98 as=0.203 ps=1.98 w=0.7 l=0.15
X223 ckd0 a_8819_12702# vss vss sky130_fd_pr__nfet_01v8_lvt ad=0.2145 pd=1.63 as=0.403 ps=3.22 w=1.3 l=0.15
X224 vdd a_5993_9144# a_6063_9170# vdd sky130_fd_pr__pfet_01v8_lvt ad=0.609 pd=4.78 as=0.3045 ps=2.39 w=2.1 l=0.35
X225 vdd a_18719_10029# vdd vdd sky130_fd_pr__pfet_01v8 ad=0.2805 pd=2.03 as=0 ps=0 w=1.7 l=0.15
X226 a_3663_4550# a_323_4520# vdd vdd sky130_fd_pr__pfet_01v8_lvt ad=0.1595 pd=1.39 as=0.1595 ps=1.39 w=1.1 l=0.35
X227 vdd a_25439_1641# vdd vdd sky130_fd_pr__pfet_01v8 ad=0.527 pd=4.02 as=0 ps=0 w=1.7 l=0.15
X228 a_18719_3409# f0 a_13268_4274# vss sky130_fd_pr__nfet_01v8_lvt ad=0.1885 pd=1.88 as=0.1885 ps=1.88 w=0.65 l=0.15
X229 vdd a_323_4520# a_2903_9270# vdd sky130_fd_pr__pfet_01v8_lvt ad=0.319 pd=2.78 as=0.1595 ps=1.39 w=1.1 l=0.35
X230 a_25439_5509# f7 a_13102_2574# vss sky130_fd_pr__nfet_01v8_lvt ad=0.1885 pd=1.88 as=0.1885 ps=1.88 w=0.65 l=0.15
X231 a_6063_2090# a_5993_2064# vdd vdd sky130_fd_pr__pfet_01v8_lvt ad=0.3045 pd=2.39 as=0.609 ps=4.78 w=2.1 l=0.35
X232 a_7935_3850# a_6063_3850# vdd vdd sky130_fd_pr__pfet_01v8_lvt ad=0.3045 pd=2.39 as=0.3045 ps=2.39 w=2.1 l=0.35
X233 a_13268_4274# a_13268_2574# vdd vdd sky130_fd_pr__pfet_01v8 ad=0.462 pd=3.13 as=0.462 ps=3.13 w=2.8 l=0.15
X234 a_25035_1641# a_24993_1814# a_16768_4274# vdd sky130_fd_pr__pfet_01v8_lvt ad=0.609 pd=4.78 as=0.609 ps=4.78 w=2.1 l=0.35
X235 vss a_23199_3409# vss vss sky130_fd_pr__nfet_01v8_lvt ad=0.203 pd=1.98 as=0 ps=0 w=0.7 l=0.15
X236 a_23615_11840# a_21927_11686# a_21477_13560# vdd sky130_fd_pr__pfet_01v8 ad=0.5775 pd=3.83 as=1.085 ps=7.62 w=3.5 l=0.15
X237 a_2903_2190# a_323_2160# vdd vdd sky130_fd_pr__pfet_01v8_lvt ad=0.1595 pd=1.39 as=0.319 ps=2.78 w=1.1 l=0.35
X238 vss a_6063_3850# a_7935_3850# vss sky130_fd_pr__nfet_01v8_lvt ad=0.527 pd=4.02 as=0.2805 ps=2.03 w=1.7 l=0.15
X239 a_15737_1934# b5 vdd vdd sky130_fd_pr__pfet_01v8 ad=0.261 pd=2.38 as=0.261 ps=2.38 w=0.9 l=0.18
X240 ckd3 a_10175_11935# vdd vdd sky130_fd_pr__pfet_01v8 ad=0.93 pd=6.62 as=0.495 ps=3.33 w=3 l=0.15
X241 a_7935_9170# b7 a_15027_7375# vss sky130_fd_pr__nfet_01v8_lvt ad=0.2325 pd=2.12 as=0.12375 ps=1.08 w=0.75 l=0.15
X242 vdd a_30963_8465# dn vdd sky130_fd_pr__pfet_01v8_lvt ad=0.812 pd=6.18 as=0.406 ps=3.09 w=2.8 l=0.35
X243 cke3 cke1 vss vss sky130_fd_pr__nfet_01v8_lvt ad=0.1305 pd=1.48 as=0.1305 ps=1.48 w=0.45 l=0.15
X244 vss a_23199_10029# vss vss sky130_fd_pr__nfet_01v8_lvt ad=0.203 pd=1.98 as=0 ps=0 w=0.7 l=0.15
X245 a_16602_8794# a_16602_7094# vss sky130_fd_pr__res_high_po_0p35 l=6.5
X246 a_22795_8261# f4 a_13102_7094# vdd sky130_fd_pr__pfet_01v8_lvt ad=0.609 pd=4.78 as=0.609 ps=4.78 w=2.1 l=0.35
X247 a_24677_2120# a_22795_1641# vdd vdd sky130_fd_pr__pfet_01v8 ad=0.2805 pd=2.03 as=0.527 ps=4.02 w=1.7 l=0.15
X248 ckd3 a_10175_11935# vss vss sky130_fd_pr__nfet_01v8_lvt ad=0.2145 pd=1.63 as=0.403 ps=3.22 w=1.3 l=0.15
X249 a_16602_2574# a_16602_4274# vdd vdd sky130_fd_pr__pfet_01v8_lvt ad=0.406 pd=3.09 as=0.812 ps=6.18 w=2.8 l=0.35
X250 a_16602_8794# a_15027_8795# sky130_fd_pr__cap_mim_m3_1 l=4.2 w=4.3
X251 a_22437_2720# a_20555_3409# vss vss sky130_fd_pr__nfet_01v8_lvt ad=0.203 pd=1.98 as=0.203 ps=1.98 w=0.7 l=0.15
X252 a_7935_8570# a_7935_9170# vss vss sky130_fd_pr__nfet_01v8_lvt ad=0.1305 pd=1.48 as=0.1305 ps=1.48 w=0.45 l=0.15
X253 vdd a_23199_7929# vdd vdd sky130_fd_pr__pfet_01v8 ad=0.527 pd=4.02 as=0 ps=0 w=1.7 l=0.15
X254 a_25035_6161# f7 a_16768_8794# vss sky130_fd_pr__nfet_01v8_lvt ad=0.1885 pd=1.88 as=0.1885 ps=1.88 w=0.65 l=0.15
X255 a_20555_5509# f3 a_16602_2574# vss sky130_fd_pr__nfet_01v8_lvt ad=0.1885 pd=1.88 as=0.1885 ps=1.88 w=0.65 l=0.15
X256 a_18719_5509# a_18273_1814# a_13102_2574# vdd sky130_fd_pr__pfet_01v8_lvt ad=0.609 pd=4.78 as=0.609 ps=4.78 w=2.1 l=0.35
X257 cke0 a_18105_12784# vss vss sky130_fd_pr__nfet_01v8_lvt ad=0.2145 pd=1.63 as=0.403 ps=3.22 w=1.3 l=0.15
X258 a_21927_11686# a_21035_11810# vdd vdd sky130_fd_pr__pfet_01v8_lvt ad=0.16675 pd=1.44 as=0.3335 ps=2.88 w=1.15 l=0.35
X259 cke2 a_18745_12784# vdd vdd sky130_fd_pr__pfet_01v8 ad=0.495 pd=3.33 as=0.93 ps=6.62 w=3 l=0.15
X260 dp rst_n a_6227_11933# vss sky130_fd_pr__nfet_01v8_lvt ad=0.403 pd=3.22 as=0.2145 ps=1.63 w=1.3 l=0.15
X261 vdd in a_323_6880# vdd sky130_fd_pr__pfet_01v8_lvt ad=0.406 pd=3.38 as=0.203 ps=1.69 w=1.4 l=0.35
X262 a_28197_13560# a_21035_11810# a_18105_12784# vdd sky130_fd_pr__pfet_01v8_lvt ad=0.928 pd=6.98 as=0.928 ps=6.98 w=3.2 l=0.35
X263 a_7935_2090# a_11849_1934# a_11527_2855# vdd sky130_fd_pr__pfet_01v8_lvt ad=0.667 pd=5.18 as=0.3335 ps=2.59 w=2.3 l=0.35
X264 vdd a_323_6880# a_3663_9270# vdd sky130_fd_pr__pfet_01v8_lvt ad=0.1595 pd=1.39 as=0.1595 ps=1.39 w=1.1 l=0.35
X265 a_11527_8795# a_11461_1934# a_7935_2090# vdd sky130_fd_pr__pfet_01v8_lvt ad=0.3335 pd=2.59 as=0.667 ps=5.18 w=2.3 l=0.35
X266 vdd a_20959_10029# vdd vdd sky130_fd_pr__pfet_01v8 ad=0.2805 pd=2.03 as=0 ps=0 w=1.7 l=0.15
X267 a_23199_10029# a_22753_1814# a_13102_7094# vdd sky130_fd_pr__pfet_01v8_lvt ad=0.609 pd=4.78 as=0.609 ps=4.78 w=2.1 l=0.35
X268 a_18315_1641# f1 a_13268_4274# vdd sky130_fd_pr__pfet_01v8_lvt ad=0.609 pd=4.78 as=0.609 ps=4.78 w=2.1 l=0.35
X269 a_11527_2855# a0 a_7935_6210# vss sky130_fd_pr__nfet_01v8_lvt ad=0.12375 pd=1.08 as=0.2325 ps=2.12 w=0.75 l=0.15
X270 a_22437_2720# a_20555_3409# vdd vdd sky130_fd_pr__pfet_01v8 ad=0.2805 pd=2.03 as=0.527 ps=4.02 w=1.7 l=0.15
X271 a_18745_12784# a_21927_11686# a_29097_13560# vss sky130_fd_pr__nfet_01v8_lvt ad=0.33 pd=2.33 as=0.62 ps=4.62 w=2 l=0.15
X272 a_30963_7375# vss vdd vdd sky130_fd_pr__pfet_01v8 ad=0.2607 pd=1.91 as=0.2607 ps=1.91 w=1.58 l=0.15
X273 a_24677_2720# a_28514_1816# vss sky130_fd_pr__res_high_po_0p69 l=2.2
X274 a_23199_3409# a_22753_3298# a_16768_4274# vss sky130_fd_pr__nfet_01v8_lvt ad=0.1885 pd=1.88 as=0.1885 ps=1.88 w=0.65 l=0.15
X275 a_323_9240# qn vss vss sky130_fd_pr__nfet_01v8_lvt ad=0.1155 pd=1.03 as=0.217 ps=2.02 w=0.7 l=0.15
X276 a_20197_7240# a_28514_6336# vss sky130_fd_pr__res_high_po_0p69 l=2.2
X277 a_30963_8465# a_29702_7094# a_30817_8037# vss sky130_fd_pr__nfet_01v8_lvt ad=0.396 pd=2.73 as=0.396 ps=2.73 w=2.4 l=0.15
X278 a_11527_4275# a_12237_1934# a_7935_6210# vdd sky130_fd_pr__pfet_01v8_lvt ad=0.3335 pd=2.59 as=0.667 ps=5.18 w=2.3 l=0.35
X279 a_29702_8794# a_28514_8208# sky130_fd_pr__cap_mim_m3_1 l=4.8 w=4.8
X280 a_18719_1641# f1 a_16768_4274# vdd sky130_fd_pr__pfet_01v8_lvt ad=0.609 pd=4.78 as=0.609 ps=4.78 w=2.1 l=0.35
X281 a_25439_3741# f6 a_16602_2574# vdd sky130_fd_pr__pfet_01v8_lvt ad=0.609 pd=4.78 as=0.609 ps=4.78 w=2.1 l=0.35
X282 a_6063_4450# a_5993_4424# vss vss sky130_fd_pr__nfet_01v8_lvt ad=0.1815 pd=1.43 as=0.341 ps=2.82 w=1.1 l=0.15
X283 a_5993_4424# a_6063_4450# vss sky130_fd_pr__res_high_po_0p35 l=9.5
X284 a_11527_4275# a2 a_7935_1490# vss sky130_fd_pr__nfet_01v8_lvt ad=0.12375 pd=1.08 as=0.2325 ps=2.12 w=0.75 l=0.15
X285 a_7935_8570# a_14961_1934# a_15027_2855# vdd sky130_fd_pr__pfet_01v8_lvt ad=0.667 pd=5.18 as=0.3335 ps=2.59 w=2.3 l=0.35
X286 a_26917_2720# a_25035_3409# vss vss sky130_fd_pr__nfet_01v8_lvt ad=0.203 pd=1.98 as=0.203 ps=1.98 w=0.7 l=0.15
X287 vdd a_13102_4274# a_13102_2574# vdd sky130_fd_pr__pfet_01v8 ad=0.868 pd=6.22 as=0.462 ps=3.13 w=2.8 l=0.15
X288 a_15678_205# b2 vss vss sky130_fd_pr__nfet_01v8 ad=0.1305 pd=1.48 as=0.1305 ps=1.48 w=0.45 l=0.18
X289 a_3663_8670# a_323_2160# vss vss sky130_fd_pr__nfet_01v8_lvt ad=0.319 pd=2.78 as=0.319 ps=2.78 w=1.1 l=0.15
X290 a_7935_1490# a_12625_1934# a_11527_2855# vdd sky130_fd_pr__pfet_01v8_lvt ad=0.667 pd=5.18 as=0.3335 ps=2.59 w=2.3 l=0.35
X291 a_25035_3741# a_24993_3298# a_13102_2574# vss sky130_fd_pr__nfet_01v8_lvt ad=0.1885 pd=1.88 as=0.1885 ps=1.88 w=0.65 l=0.15
X292 a_21865_11030# a_23615_11840# vdd vdd sky130_fd_pr__pfet_01v8_lvt ad=0.609 pd=4.78 as=0.609 ps=4.78 w=2.1 l=0.35
X293 a_18315_6161# a_18273_1814# a_13268_8794# vss sky130_fd_pr__nfet_01v8_lvt ad=0.1885 pd=1.88 as=0.1885 ps=1.88 w=0.65 l=0.15
X294 a_22437_6640# a_28514_6336# vss sky130_fd_pr__res_high_po_0p69 l=2.2
X295 vdd a_30963_7375# dp vdd sky130_fd_pr__pfet_01v8_lvt ad=0.812 pd=6.18 as=0.406 ps=3.09 w=2.8 l=0.35
X296 vdd a_25439_10029# vdd vdd sky130_fd_pr__pfet_01v8 ad=0.2805 pd=2.03 as=0 ps=0 w=1.7 l=0.15
X297 a_18719_6161# a_18273_1814# a_16768_8794# vss sky130_fd_pr__nfet_01v8_lvt ad=0.1885 pd=1.88 as=0.1885 ps=1.88 w=0.65 l=0.15
X298 a_11527_2855# a4 a_7935_6810# vss sky130_fd_pr__nfet_01v8_lvt ad=0.12375 pd=1.08 as=0.2325 ps=2.12 w=0.75 l=0.15
X299 a_23199_5509# f5 a_16602_2574# vdd sky130_fd_pr__pfet_01v8_lvt ad=0.609 pd=4.78 as=0.609 ps=4.78 w=2.1 l=0.35
X300 a_25439_3741# a_24993_3298# a_16602_2574# vss sky130_fd_pr__nfet_01v8_lvt ad=0.1885 pd=1.88 as=0.1885 ps=1.88 w=0.65 l=0.15
X301 a_26387_11933# a_6157_11685# en vdd sky130_fd_pr__pfet_01v8_lvt ad=0.6583 pd=5.12 as=0.32915 ps=2.56 w=2.27 l=0.35
X302 a_30963_8465# a_30963_7375# vdd vdd sky130_fd_pr__pfet_01v8 ad=0.2079 pd=1.59 as=0.2079 ps=1.59 w=1.26 l=0.15
X303 a_7587_12850# a_7035_12870# vss vss sky130_fd_pr__nfet_01v8_lvt ad=0.1815 pd=1.43 as=0.341 ps=2.82 w=1.1 l=0.15
X304 a_26917_7240# a_25035_7929# vdd vdd sky130_fd_pr__pfet_01v8 ad=0.2805 pd=2.03 as=0.527 ps=4.02 w=1.7 l=0.15
X305 a_2903_4550# a_5214_4408# vss sky130_fd_pr__res_high_po_0p69 l=1.5
X306 a_11527_4275# a6 a_7935_2090# vss sky130_fd_pr__nfet_01v8_lvt ad=0.12375 pd=1.08 as=0.2325 ps=2.12 w=0.75 l=0.15
X307 a_15737_1934# b5 vss vss sky130_fd_pr__nfet_01v8 ad=0.1305 pd=1.48 as=0.1305 ps=1.48 w=0.45 l=0.18
X308 vss a_30963_7375# dp vss sky130_fd_pr__nfet_01v8_lvt ad=0.651 pd=4.82 as=0.3465 ps=2.43 w=2.1 l=0.15
X309 cke0 cke2 vdd vdd sky130_fd_pr__pfet_01v8_lvt ad=0.406 pd=3.38 as=0.406 ps=3.38 w=1.4 l=0.35
X310 a_6063_9170# a_5993_9144# vdd vdd sky130_fd_pr__pfet_01v8_lvt ad=0.3045 pd=2.39 as=0.609 ps=4.78 w=2.1 l=0.35
X311 a_30817_3517# a_29702_2574# a_30963_3945# vss sky130_fd_pr__nfet_01v8_lvt ad=0.396 pd=2.73 as=0.396 ps=2.73 w=2.4 l=0.15
X312 a_20555_1641# a_20513_1814# a_13268_4274# vss sky130_fd_pr__nfet_01v8_lvt ad=0.1885 pd=1.88 as=0.1885 ps=1.88 w=0.65 l=0.15
X313 vss a_19667_11933# a_20437_11105# vss sky130_fd_pr__nfet_01v8_lvt ad=0.3875 pd=3.12 as=0.20625 ps=1.58 w=1.25 l=0.15
X314 a_2903_9270# a_323_4520# vdd vdd sky130_fd_pr__pfet_01v8_lvt ad=0.1595 pd=1.39 as=0.319 ps=2.78 w=1.1 l=0.35
X315 vss a_18719_6161# vss vss sky130_fd_pr__nfet_01v8_lvt ad=0.203 pd=1.98 as=0 ps=0 w=0.7 l=0.15
X316 a_6157_11685# rst_n vss vss sky130_fd_pr__nfet_01v8_lvt ad=0.165 pd=1.33 as=0.31 ps=2.62 w=1 l=0.15
X317 a_18745_12784# a_21035_11810# a_29097_13560# vdd sky130_fd_pr__pfet_01v8 ad=0.5775 pd=3.83 as=1.085 ps=7.62 w=3.5 l=0.15
X318 a_20959_7929# f2 a_13268_8794# vss sky130_fd_pr__nfet_01v8_lvt ad=0.1885 pd=1.88 as=0.1885 ps=1.88 w=0.65 l=0.15
X319 a_16602_2574# a_16602_4274# vdd vdd sky130_fd_pr__pfet_01v8 ad=0.462 pd=3.13 as=0.868 ps=6.22 w=2.8 l=0.15
X320 a_30963_2855# a_30963_3945# vdd vdd sky130_fd_pr__pfet_01v8 ad=0.2079 pd=1.59 as=0.3906 ps=3.14 w=1.26 l=0.15
X321 a_20555_10029# a_20513_1814# a_13102_7094# vss sky130_fd_pr__nfet_01v8_lvt ad=0.1885 pd=1.88 as=0.1885 ps=1.88 w=0.65 l=0.15
X322 a_20959_1641# a_20513_1814# a_16768_4274# vss sky130_fd_pr__nfet_01v8_lvt ad=0.1885 pd=1.88 as=0.1885 ps=1.88 w=0.65 l=0.15
X323 ckd3 ckd1 vss vss sky130_fd_pr__nfet_01v8_lvt ad=0.1305 pd=1.48 as=0.1305 ps=1.48 w=0.45 l=0.15
X324 a_18315_10029# f1 a_16602_7094# vss sky130_fd_pr__nfet_01v8_lvt ad=0.1885 pd=1.88 as=0.1885 ps=1.88 w=0.65 l=0.15
X325 vdd vss a_30963_8465# vdd sky130_fd_pr__pfet_01v8 ad=0.2607 pd=1.91 as=0.2607 ps=1.91 w=1.58 l=0.15
X326 a_30963_7375# a_29868_8794# a_30817_8037# vss sky130_fd_pr__nfet_01v8_lvt ad=0.396 pd=2.73 as=0.396 ps=2.73 w=2.4 l=0.15
X327 a_3663_6310# a_323_9240# vss vss sky130_fd_pr__nfet_01v8_lvt ad=0.319 pd=2.78 as=0.319 ps=2.78 w=1.1 l=0.15
X328 a_25035_1641# f7 a_13268_4274# vdd sky130_fd_pr__pfet_01v8_lvt ad=0.609 pd=4.78 as=0.609 ps=4.78 w=2.1 l=0.35
X329 a_25439_7929# f6 a_16768_8794# vdd sky130_fd_pr__pfet_01v8_lvt ad=0.609 pd=4.78 as=0.609 ps=4.78 w=2.1 l=0.35
X330 a_20959_6161# a_20513_1814# a_13268_8794# vdd sky130_fd_pr__pfet_01v8_lvt ad=0.609 pd=4.78 as=0.609 ps=4.78 w=2.1 l=0.35
X331 vdd a_323_9240# a_2903_6310# vdd sky130_fd_pr__pfet_01v8_lvt ad=0.1595 pd=1.39 as=0.1595 ps=1.39 w=1.1 l=0.35
X332 a_11527_2855# a_11461_1934# a_7935_6210# vdd sky130_fd_pr__pfet_01v8_lvt ad=0.3335 pd=2.59 as=0.667 ps=5.18 w=2.3 l=0.35
X333 a_29868_8794# a_29702_7094# vdd vdd sky130_fd_pr__pfet_01v8 ad=0.2376 pd=1.77 as=0.4464 ps=3.5 w=1.44 l=0.15
X334 a_20555_10029# f3 a_13102_7094# vdd sky130_fd_pr__pfet_01v8_lvt ad=0.609 pd=4.78 as=0.609 ps=4.78 w=2.1 l=0.35
X335 a_18315_7929# f0 a_16768_8794# vss sky130_fd_pr__nfet_01v8_lvt ad=0.1885 pd=1.88 as=0.1885 ps=1.88 w=0.65 l=0.15
X336 a_7935_3850# a_15349_1934# a_15027_4275# vdd sky130_fd_pr__pfet_01v8_lvt ad=0.667 pd=5.18 as=0.3335 ps=2.59 w=2.3 l=0.35
X337 ep a_30963_2855# vdd vdd sky130_fd_pr__pfet_01v8 ad=0.495 pd=3.33 as=0.495 ps=3.33 w=3 l=0.15
X338 vdd a_16768_2574# a_16768_4274# vdd sky130_fd_pr__pfet_01v8 ad=0.462 pd=3.13 as=0.462 ps=3.13 w=2.8 l=0.15
X339 a_21477_13560# a_21035_11810# a_23615_11840# vss sky130_fd_pr__nfet_01v8_lvt ad=0.62 pd=4.62 as=0.33 ps=2.33 w=2 l=0.15
X340 a_7935_9170# b5 a_15027_2855# vss sky130_fd_pr__nfet_01v8_lvt ad=0.2325 pd=2.12 as=0.12375 ps=1.08 w=0.75 l=0.15
X341 vdd a_25035_3409# a_26917_2720# vdd sky130_fd_pr__pfet_01v8 ad=0.527 pd=4.02 as=0.2805 ps=2.03 w=1.7 l=0.15
X342 dp a_30963_7375# vdd vdd sky130_fd_pr__pfet_01v8 ad=0.495 pd=3.33 as=0.495 ps=3.33 w=3 l=0.15
X343 a_3663_2190# a_323_2160# vdd vdd sky130_fd_pr__pfet_01v8_lvt ad=0.1595 pd=1.39 as=0.1595 ps=1.39 w=1.1 l=0.35
X344 a_20959_10029# f3 a_16602_7094# vdd sky130_fd_pr__pfet_01v8_lvt ad=0.609 pd=4.78 as=0.609 ps=4.78 w=2.1 l=0.35
X345 vss a_20959_1641# vss vss sky130_fd_pr__nfet_01v8_lvt ad=0.203 pd=1.98 as=0 ps=0 w=0.7 l=0.15
X346 a_7935_1490# a_6063_1490# vdd vdd sky130_fd_pr__pfet_01v8_lvt ad=0.3045 pd=2.39 as=0.3045 ps=2.39 w=2.1 l=0.35
X347 a_22795_3409# f4 a_13268_4274# vdd sky130_fd_pr__pfet_01v8_lvt ad=0.609 pd=4.78 as=0.609 ps=4.78 w=2.1 l=0.35
X348 a_25035_8261# a_24993_3298# a_16602_7094# vdd sky130_fd_pr__pfet_01v8_lvt ad=0.609 pd=4.78 as=0.609 ps=4.78 w=2.1 l=0.35
X349 a_25439_7929# f6 a_13268_8794# vss sky130_fd_pr__nfet_01v8_lvt ad=0.1885 pd=1.88 as=0.1885 ps=1.88 w=0.65 l=0.15
X350 a_18315_6161# a_18273_1814# a_16768_8794# vdd sky130_fd_pr__pfet_01v8_lvt ad=0.609 pd=4.78 as=0.609 ps=4.78 w=2.1 l=0.35
X351 vdd a_6063_6210# a_7935_6210# vdd sky130_fd_pr__pfet_01v8_lvt ad=0.3045 pd=2.39 as=0.3045 ps=2.39 w=2.1 l=0.35
X352 a_25439_6161# a_24993_1814# a_13268_8794# vdd sky130_fd_pr__pfet_01v8_lvt ad=0.609 pd=4.78 as=0.609 ps=4.78 w=2.1 l=0.35
X353 a_7935_4450# a_16125_1934# a_15027_4275# vdd sky130_fd_pr__pfet_01v8_lvt ad=0.667 pd=5.18 as=0.3335 ps=2.59 w=2.3 l=0.35
X354 vss vdd a_30817_3517# vss sky130_fd_pr__nfet_01v8 ad=0.17835 pd=1.52 as=0.17835 ps=1.52 w=1.23 l=0.2
X355 a_8517_11085# a_8487_11686# a_8425_11085# vdd sky130_fd_pr__pfet_01v8_lvt ad=0.6525 pd=5.08 as=0.6525 ps=5.08 w=2.25 l=0.35
X356 a_19667_11933# a_6157_11685# ep vdd sky130_fd_pr__pfet_01v8_lvt ad=0.32915 pd=2.56 as=0.6583 ps=5.12 w=2.27 l=0.35
X357 a_15027_7375# a_15737_1934# a_7935_4450# vdd sky130_fd_pr__pfet_01v8_lvt ad=0.3335 pd=2.59 as=0.667 ps=5.18 w=2.3 l=0.35
X358 a_20197_2120# a_18315_1641# vss vss sky130_fd_pr__nfet_01v8_lvt ad=0.203 pd=1.98 as=0.203 ps=1.98 w=0.7 l=0.15
X359 vdd a_18315_8261# a_20197_8740# vdd sky130_fd_pr__pfet_01v8 ad=0.527 pd=4.02 as=0.2805 ps=2.03 w=1.7 l=0.15
X360 vdd ep en vdd sky130_fd_pr__pfet_01v8 ad=0.589 pd=4.42 as=0.3135 ps=2.23 w=1.9 l=0.15
X361 a_16602_4274# a_15027_4275# sky130_fd_pr__cap_mim_m3_1 l=4.2 w=4.3
X362 a_323_2160# vss sky130_fd_pr__cap_mim_m3_1 l=1.75 w=1.75
X363 vss a_13102_8794# a_13102_7094# vss sky130_fd_pr__nfet_01v8_lvt ad=0.527 pd=4.02 as=0.2805 ps=2.03 w=1.7 l=0.15
X364 a_30817_3517# a_29868_4274# a_30963_2855# vss sky130_fd_pr__nfet_01v8_lvt ad=0.396 pd=2.73 as=0.396 ps=2.73 w=2.4 l=0.15
X365 vss a_18719_3409# vss vss sky130_fd_pr__nfet_01v8_lvt ad=0.203 pd=1.98 as=0 ps=0 w=0.7 l=0.15
X366 a_20555_7929# f2 a_16768_8794# vss sky130_fd_pr__nfet_01v8_lvt ad=0.1885 pd=1.88 as=0.1885 ps=1.88 w=0.65 l=0.15
X367 vdd a_323_6880# a_2903_3950# vdd sky130_fd_pr__pfet_01v8_lvt ad=0.1595 pd=1.39 as=0.1595 ps=1.39 w=1.1 l=0.35
X368 a_9105_11602# a_7595_11810# a_10175_11935# vss sky130_fd_pr__nfet_01v8_lvt ad=0.4495 pd=3.52 as=0.23925 ps=1.78 w=1.45 l=0.15
X369 a_22437_2720# a_28514_1816# vss sky130_fd_pr__res_high_po_0p69 l=2.2
X370 vdd a_18719_3741# vdd vdd sky130_fd_pr__pfet_01v8 ad=0.2805 pd=2.03 as=0 ps=0 w=1.7 l=0.15
X371 a_7595_11810# a_8487_11686# vdd vdd sky130_fd_pr__pfet_01v8_lvt ad=0.16675 pd=1.44 as=0.3335 ps=2.88 w=1.15 l=0.35
X372 vss a_25439_6161# vss vss sky130_fd_pr__nfet_01v8_lvt ad=0.203 pd=1.98 as=0 ps=0 w=0.7 l=0.15
X373 vss a_30963_8465# dn vss sky130_fd_pr__nfet_01v8_lvt ad=0.651 pd=4.82 as=0.3465 ps=2.43 w=2.1 l=0.15
X374 a_27857_13560# a_10175_11935# vss vss sky130_fd_pr__nfet_01v8_lvt ad=0.2475 pd=1.83 as=0.465 ps=3.62 w=1.5 l=0.15
X375 a_20555_6161# a_20513_1814# a_16768_8794# vdd sky130_fd_pr__pfet_01v8_lvt ad=0.609 pd=4.78 as=0.609 ps=4.78 w=2.1 l=0.35
X376 vss a_5993_3733# a_6063_3850# vss sky130_fd_pr__nfet_01v8_lvt ad=0.341 pd=2.82 as=0.1815 ps=1.43 w=1.1 l=0.15
X377 vss a_8819_12702# ckd0 vss sky130_fd_pr__nfet_01v8_lvt ad=0.403 pd=3.22 as=0.2145 ps=1.63 w=1.3 l=0.15
X378 a_323_6880# in vss vss sky130_fd_pr__nfet_01v8_lvt ad=0.1155 pd=1.03 as=0.217 ps=2.02 w=0.7 l=0.15
X379 a_18315_8261# f0 a_13102_7094# vdd sky130_fd_pr__pfet_01v8_lvt ad=0.609 pd=4.78 as=0.609 ps=4.78 w=2.1 l=0.35
X380 a_24677_4820# a_28514_3688# vss sky130_fd_pr__res_high_po_0p69 l=2.2
X381 vdd a_18719_3409# vdd vdd sky130_fd_pr__pfet_01v8 ad=0.527 pd=4.02 as=0 ps=0 w=1.7 l=0.15
X382 a_18719_8261# f0 a_16602_7094# vdd sky130_fd_pr__pfet_01v8_lvt ad=0.609 pd=4.78 as=0.609 ps=4.78 w=2.1 l=0.35
X383 a_30817_8037# vdd vss vss sky130_fd_pr__nfet_01v8 ad=0.17835 pd=1.52 as=0.17835 ps=1.52 w=1.23 l=0.2
X384 a_21477_13560# a_21927_11686# a_23615_11840# vdd sky130_fd_pr__pfet_01v8 ad=1.085 pd=7.62 as=0.5775 ps=3.83 w=3.5 l=0.15
X385 a_29702_4274# a_28514_3688# sky130_fd_pr__cap_mim_m3_1 l=4.8 w=4.8
X386 vdd a_13268_7094# a_13268_8794# vdd sky130_fd_pr__pfet_01v8_lvt ad=0.812 pd=6.18 as=0.406 ps=3.09 w=2.8 l=0.35
X387 vdd a_22795_8261# a_24677_8740# vdd sky130_fd_pr__pfet_01v8 ad=0.527 pd=4.02 as=0.2805 ps=2.03 w=1.7 l=0.15
X388 a_24677_6640# a_22795_6161# vss vss sky130_fd_pr__nfet_01v8_lvt ad=0.203 pd=1.98 as=0.203 ps=1.98 w=0.7 l=0.15
X389 vdd a_6063_3850# a_7935_3850# vdd sky130_fd_pr__pfet_01v8_lvt ad=0.3045 pd=2.39 as=0.3045 ps=2.39 w=2.1 l=0.35
X390 a_21477_13560# a_20590_13570# a_21137_13560# vss sky130_fd_pr__nfet_01v8_lvt ad=0.2475 pd=1.83 as=0.465 ps=3.62 w=1.5 l=0.15
X391 a_5993_9144# a_6063_9170# vss sky130_fd_pr__res_high_po_0p35 l=9.5
X392 a_16602_7094# a_16602_8794# vdd vdd sky130_fd_pr__pfet_01v8 ad=0.462 pd=3.13 as=0.462 ps=3.13 w=2.8 l=0.15
X393 a_20197_4820# a_28514_3688# vss sky130_fd_pr__res_high_po_0p69 l=2.2
X394 vss vdd a_30217_2855# vss sky130_fd_pr__nfet_01v8 ad=0.3335 pd=2.88 as=0.16675 ps=1.44 w=1.15 l=0.2
X395 vdd a_23199_1641# vdd vdd sky130_fd_pr__pfet_01v8 ad=0.527 pd=4.02 as=0 ps=0 w=1.7 l=0.15
X396 a_22437_8740# a_28514_8208# vss sky130_fd_pr__res_high_po_0p69 l=2.2
X397 vss a_10175_11935# ckd3 vss sky130_fd_pr__nfet_01v8_lvt ad=0.403 pd=3.22 as=0.2145 ps=1.63 w=1.3 l=0.15
X398 a_10409_12702# a_8819_12702# vss vss sky130_fd_pr__nfet_01v8_lvt ad=0.1885 pd=1.88 as=0.1885 ps=1.88 w=0.65 l=0.15
X399 a_7935_8570# b7 a_15027_8795# vss sky130_fd_pr__nfet_01v8_lvt ad=0.2325 pd=2.12 as=0.12375 ps=1.08 w=0.75 l=0.15
X400 a_11849_1934# a2 vdd vdd sky130_fd_pr__pfet_01v8 ad=0.261 pd=2.38 as=0.261 ps=2.38 w=0.9 l=0.18
X401 vss a_18105_12784# cke0 vss sky130_fd_pr__nfet_01v8_lvt ad=0.403 pd=3.22 as=0.2145 ps=1.63 w=1.3 l=0.15
X402 cke2 a_18745_12784# vdd vdd sky130_fd_pr__pfet_01v8_lvt ad=0.87 pd=6.58 as=0.87 ps=6.58 w=3 l=0.35
X403 a_10175_11935# a_8487_11686# a_9105_11602# vdd sky130_fd_pr__pfet_01v8_lvt ad=0.6525 pd=5.08 as=0.6525 ps=5.08 w=2.25 l=0.35
X404 a_7935_6810# a_6063_6810# vdd vdd sky130_fd_pr__pfet_01v8_lvt ad=0.3045 pd=2.39 as=0.3045 ps=2.39 w=2.1 l=0.35
X405 vdd a_20959_3741# vdd vdd sky130_fd_pr__pfet_01v8 ad=0.2805 pd=2.03 as=0 ps=0 w=1.7 l=0.15
X406 vdd a_18745_12784# cke2 vdd sky130_fd_pr__pfet_01v8 ad=0.495 pd=3.33 as=0.495 ps=3.33 w=3 l=0.15
X407 a_25035_10029# f7 a_16602_7094# vss sky130_fd_pr__nfet_01v8_lvt ad=0.1885 pd=1.88 as=0.1885 ps=1.88 w=0.65 l=0.15
X408 a_5993_3733# a_5214_3940# sky130_fd_pr__cap_mim_m3_1 l=4.2 w=4.2
X409 a_23199_8261# f4 a_13102_7094# vss sky130_fd_pr__nfet_01v8_lvt ad=0.1885 pd=1.88 as=0.1885 ps=1.88 w=0.65 l=0.15
X410 vdd a_16768_7094# a_16768_8794# vdd sky130_fd_pr__pfet_01v8 ad=0.868 pd=6.22 as=0.462 ps=3.13 w=2.8 l=0.15
X411 vdd vss a_29868_8794# vdd sky130_fd_pr__pfet_01v8 ad=0.589 pd=4.42 as=0.3135 ps=2.23 w=1.9 l=0.15
X412 a_2903_2190# a_5214_2048# vss sky130_fd_pr__res_high_po_0p69 l=1.5
X413 en ep vss vss sky130_fd_pr__nfet_01v8_lvt ad=0.261 pd=2.38 as=0.261 ps=2.38 w=0.9 l=0.15
X414 a_18273_1814# f1 vdd vdd sky130_fd_pr__pfet_01v8 ad=0.261 pd=2.38 as=0.261 ps=2.38 w=0.9 l=0.18
X415 vdd a_8487_11686# a_7595_11810# vdd sky130_fd_pr__pfet_01v8_lvt ad=0.3335 pd=2.88 as=0.16675 ps=1.44 w=1.15 l=0.35
X416 a_17727_12810# a_18105_12784# vdd vdd sky130_fd_pr__pfet_01v8_lvt ad=0.638 pd=4.98 as=0.638 ps=4.98 w=2.2 l=0.35
X417 vdd a_20959_3409# vdd vdd sky130_fd_pr__pfet_01v8 ad=0.527 pd=4.02 as=0 ps=0 w=1.7 l=0.15
X418 a_18719_3741# f0 a_13102_2574# vss sky130_fd_pr__nfet_01v8_lvt ad=0.1885 pd=1.88 as=0.1885 ps=1.88 w=0.65 l=0.15
X419 a_29097_13560# a_21927_11686# a_18745_12784# vss sky130_fd_pr__nfet_01v8_lvt ad=0.62 pd=4.62 as=0.33 ps=2.33 w=2 l=0.15
X420 a_3663_9270# a_323_6880# vdd vdd sky130_fd_pr__pfet_01v8_lvt ad=0.1595 pd=1.39 as=0.1595 ps=1.39 w=1.1 l=0.35
X421 a_7935_2090# a_11461_1934# a_11527_8795# vdd sky130_fd_pr__pfet_01v8_lvt ad=0.667 pd=5.18 as=0.3335 ps=2.59 w=2.3 l=0.35
X422 a_13868_205# a5 vdd vdd sky130_fd_pr__pfet_01v8 ad=0.261 pd=2.38 as=0.261 ps=2.38 w=0.9 l=0.18
X423 a_8819_12702# a_8517_11085# vdd vdd sky130_fd_pr__pfet_01v8_lvt ad=1.015 pd=7.58 as=1.015 ps=7.58 w=3.5 l=0.35
X424 a_7935_8570# a_6063_8570# vdd vdd sky130_fd_pr__pfet_01v8_lvt ad=0.3045 pd=2.39 as=0.3045 ps=2.39 w=2.1 l=0.35
X425 vss a_6063_8570# a_7935_8570# vss sky130_fd_pr__nfet_01v8_lvt ad=0.527 pd=4.02 as=0.2805 ps=2.03 w=1.7 l=0.15
X426 vdd a_16602_8794# a_16602_7094# vdd sky130_fd_pr__pfet_01v8_lvt ad=0.812 pd=6.18 as=0.406 ps=3.09 w=2.8 l=0.35
X427 dp a_30963_7375# vdd vdd sky130_fd_pr__pfet_01v8 ad=0.495 pd=3.33 as=0.93 ps=6.62 w=3 l=0.15
X428 a_3663_6910# a_5214_6768# vss sky130_fd_pr__res_high_po_0p69 l=1.5
X429 a_30217_7375# a_29702_8794# a_29702_7094# vss sky130_fd_pr__nfet_01v8_lvt ad=0.396 pd=2.73 as=0.396 ps=2.73 w=2.4 l=0.15
X430 vss a_25439_3409# vss vss sky130_fd_pr__nfet_01v8_lvt ad=0.203 pd=1.98 as=0 ps=0 w=0.7 l=0.15
X431 a_24993_3298# f6 vdd vdd sky130_fd_pr__pfet_01v8 ad=0.261 pd=2.38 as=0.261 ps=2.38 w=0.9 l=0.18
X432 a_20197_2720# a_18315_3409# vdd vdd sky130_fd_pr__pfet_01v8 ad=0.2805 pd=2.03 as=0.527 ps=4.02 w=1.7 l=0.15
X433 a_13268_4274# a_13268_2574# vss vss sky130_fd_pr__nfet_01v8_lvt ad=0.2805 pd=2.03 as=0.527 ps=4.02 w=1.7 l=0.15
X434 vdd a_25439_3741# vdd vdd sky130_fd_pr__pfet_01v8 ad=0.2805 pd=2.03 as=0 ps=0 w=1.7 l=0.15
X435 vdd a_323_9240# a_3663_6310# vdd sky130_fd_pr__pfet_01v8_lvt ad=0.319 pd=2.78 as=0.1595 ps=1.39 w=1.1 l=0.35
X436 a_7935_6210# a_6063_6210# vdd vdd sky130_fd_pr__pfet_01v8_lvt ad=0.3045 pd=2.39 as=0.609 ps=4.78 w=2.1 l=0.35
X437 a_7935_6210# a_6063_6210# vss vss sky130_fd_pr__nfet_01v8_lvt ad=0.2805 pd=2.03 as=0.527 ps=4.02 w=1.7 l=0.15
X438 a_8819_12702# a_8517_11085# vdd vdd sky130_fd_pr__pfet_01v8 ad=0.5775 pd=3.83 as=1.085 ps=7.62 w=3.5 l=0.15
X439 a_25035_8261# f6 a_13102_7094# vdd sky130_fd_pr__pfet_01v8_lvt ad=0.609 pd=4.78 as=0.609 ps=4.78 w=2.1 l=0.35
X440 a_2903_2190# a_323_2160# vss vss sky130_fd_pr__nfet_01v8_lvt ad=0.319 pd=2.78 as=0.319 ps=2.78 w=1.1 l=0.15
X441 a_22795_3741# a_22753_3298# a_16602_2574# vdd sky130_fd_pr__pfet_01v8_lvt ad=0.609 pd=4.78 as=0.609 ps=4.78 w=2.1 l=0.35
X442 a_26917_2120# a_25035_1641# vdd vdd sky130_fd_pr__pfet_01v8 ad=0.2805 pd=2.03 as=0.527 ps=4.02 w=1.7 l=0.15
X443 vdd a_29702_2574# a_29868_4274# vdd sky130_fd_pr__pfet_01v8 ad=0.4464 pd=3.5 as=0.2376 ps=1.77 w=1.44 l=0.15
X444 en a_30963_3945# vdd vdd sky130_fd_pr__pfet_01v8 ad=0.495 pd=3.33 as=0.495 ps=3.33 w=3 l=0.15
X445 a_25035_3409# a_24993_3298# a_16768_4274# vdd sky130_fd_pr__pfet_01v8_lvt ad=0.609 pd=4.78 as=0.609 ps=4.78 w=2.1 l=0.35
X446 vdd a_25439_3409# vdd vdd sky130_fd_pr__pfet_01v8 ad=0.527 pd=4.02 as=0 ps=0 w=1.7 l=0.15
X447 a_24677_2720# a_22795_3409# vss vss sky130_fd_pr__nfet_01v8_lvt ad=0.203 pd=1.98 as=0.203 ps=1.98 w=0.7 l=0.15
X448 vss a_7035_12870# a_7587_12850# vss sky130_fd_pr__nfet_01v8_lvt ad=0.341 pd=2.82 as=0.1815 ps=1.43 w=1.1 l=0.15
X449 a_7935_1490# a_12237_1934# a_11527_8795# vdd sky130_fd_pr__pfet_01v8_lvt ad=0.667 pd=5.18 as=0.3335 ps=2.59 w=2.3 l=0.35
X450 a_7935_6810# a6 a_11527_7375# vss sky130_fd_pr__nfet_01v8_lvt ad=0.2325 pd=2.12 as=0.12375 ps=1.08 w=0.75 l=0.15
X451 vdd a_5993_6093# a_6063_6210# vdd sky130_fd_pr__pfet_01v8_lvt ad=0.3045 pd=2.39 as=0.3045 ps=2.39 w=2.1 l=0.35
X452 vdd a_30963_2855# ep vdd sky130_fd_pr__pfet_01v8 ad=0.93 pd=6.62 as=0.495 ps=3.33 w=3 l=0.15
X453 a_8425_11085# a_15237_11085# vss vss sky130_fd_pr__nfet_01v8_lvt ad=0.3135 pd=2.23 as=0.589 ps=4.42 w=1.9 l=0.15
X454 vdd a_23199_10029# vdd vdd sky130_fd_pr__pfet_01v8 ad=0.2805 pd=2.03 as=0 ps=0 w=1.7 l=0.15
X455 a_23199_3741# a_22753_3298# a_16602_2574# vss sky130_fd_pr__nfet_01v8_lvt ad=0.1885 pd=1.88 as=0.1885 ps=1.88 w=0.65 l=0.15
X456 ep a_30963_2855# vdd vdd sky130_fd_pr__pfet_01v8_lvt ad=0.406 pd=3.09 as=0.812 ps=6.18 w=2.8 l=0.35
X457 a_20197_2120# a_28514_1816# vss sky130_fd_pr__res_high_po_0p69 l=2.2
X458 a_24677_2720# a_22795_3409# vdd vdd sky130_fd_pr__pfet_01v8 ad=0.2805 pd=2.03 as=0.527 ps=4.02 w=1.7 l=0.15
X459 a_15825_11602# a_15237_11085# vss vss sky130_fd_pr__nfet_01v8 ad=0.174 pd=1.78 as=0.174 ps=1.78 w=0.6 l=0.28
X460 a_22795_8261# f4 a_16602_7094# vss sky130_fd_pr__nfet_01v8_lvt ad=0.1885 pd=1.88 as=0.1885 ps=1.88 w=0.65 l=0.15
X461 a_28514_8208# vss sky130_fd_pr__cap_mim_m3_1 l=1.6 w=1.6
X462 a_16602_7094# a_16602_8794# vss vss sky130_fd_pr__nfet_01v8_lvt ad=0.2805 pd=2.03 as=0.527 ps=4.02 w=1.7 l=0.15
X463 a_11849_1934# a2 vss vss sky130_fd_pr__nfet_01v8 ad=0.1305 pd=1.48 as=0.1305 ps=1.48 w=0.45 l=0.18
X464 vss rst_n a_6157_11685# vss sky130_fd_pr__nfet_01v8_lvt ad=0.31 pd=2.62 as=0.165 ps=1.33 w=1 l=0.15
X465 a_29097_13560# a_21035_11810# a_18745_12784# vdd sky130_fd_pr__pfet_01v8 ad=1.085 pd=7.62 as=0.5775 ps=3.83 w=3.5 l=0.15
X466 a_25035_6161# a_24993_1814# a_13268_8794# vss sky130_fd_pr__nfet_01v8_lvt ad=0.1885 pd=1.88 as=0.1885 ps=1.88 w=0.65 l=0.15
X467 a_20555_5509# a_20513_1814# a_13102_2574# vss sky130_fd_pr__nfet_01v8_lvt ad=0.1885 pd=1.88 as=0.1885 ps=1.88 w=0.65 l=0.15
X468 a_3663_4550# a_5214_4408# vss sky130_fd_pr__res_high_po_0p69 l=1.5
X469 a_29702_2574# a_29702_4274# a_30217_2855# vss sky130_fd_pr__nfet_01v8_lvt ad=0.744 pd=5.42 as=0.396 ps=2.73 w=2.4 l=0.15
X470 a_5993_3733# a_6063_3850# vss sky130_fd_pr__res_high_po_0p35 l=9.5
X471 a_28757_13560# a_8425_11085# vss vss sky130_fd_pr__nfet_01v8_lvt ad=0.2475 pd=1.83 as=0.465 ps=3.62 w=1.5 l=0.15
X472 vdd a_21865_11030# vdd vdd sky130_fd_pr__pfet_01v8 ad=0.406 pd=3.38 as=0 ps=0 w=1.4 l=0.15
X473 a_18745_12784# a_21957_11030# vdd vdd sky130_fd_pr__pfet_01v8 ad=0.5775 pd=3.83 as=1.085 ps=7.62 w=3.5 l=0.15
X474 a_21957_11030# a_7587_12850# vss vss sky130_fd_pr__nfet_01v8 ad=0.29 pd=2.58 as=0.29 ps=2.58 w=1 l=0.18
X475 a_7935_3850# a_6063_3850# vdd vdd sky130_fd_pr__pfet_01v8_lvt ad=0.3045 pd=2.39 as=0.609 ps=4.78 w=2.1 l=0.35
X476 a_18315_3409# f0 a_13268_4274# vdd sky130_fd_pr__pfet_01v8_lvt ad=0.609 pd=4.78 as=0.609 ps=4.78 w=2.1 l=0.35
X477 a_25439_6161# a_24993_1814# a_16768_8794# vss sky130_fd_pr__nfet_01v8_lvt ad=0.1885 pd=1.88 as=0.1885 ps=1.88 w=0.65 l=0.15
X478 a_20959_5509# a_20513_1814# a_16602_2574# vss sky130_fd_pr__nfet_01v8_lvt ad=0.1885 pd=1.88 as=0.1885 ps=1.88 w=0.65 l=0.15
X479 vdd a_323_9240# a_3663_3950# vdd sky130_fd_pr__pfet_01v8_lvt ad=0.319 pd=2.78 as=0.1595 ps=1.39 w=1.1 l=0.35
X480 a_18273_1814# f1 vss vss sky130_fd_pr__nfet_01v8 ad=0.1305 pd=1.48 as=0.1305 ps=1.48 w=0.45 l=0.18
X481 a_30217_7375# a_29868_7094# a_29868_8794# vss sky130_fd_pr__nfet_01v8_lvt ad=0.396 pd=2.73 as=0.396 ps=2.73 w=2.4 l=0.15
X482 vdd a_323_6880# a_2903_1590# vdd sky130_fd_pr__pfet_01v8_lvt ad=0.1595 pd=1.39 as=0.1595 ps=1.39 w=1.1 l=0.35
X483 a_7035_12870# a_6157_11685# vdd vdd sky130_fd_pr__pfet_01v8_lvt ad=0.464 pd=3.78 as=0.464 ps=3.78 w=1.6 l=0.35
X484 vdd a_20555_10029# a_22437_9340# vdd sky130_fd_pr__pfet_01v8 ad=0.527 pd=4.02 as=0.2805 ps=2.03 w=1.7 l=0.15
X485 a_18719_3409# f0 a_16768_4274# vdd sky130_fd_pr__pfet_01v8_lvt ad=0.609 pd=4.78 as=0.609 ps=4.78 w=2.1 l=0.35
X486 a_25439_5509# f7 a_16602_2574# vdd sky130_fd_pr__pfet_01v8_lvt ad=0.609 pd=4.78 as=0.609 ps=4.78 w=2.1 l=0.35
X487 a_26917_8740# a_28514_8208# vss sky130_fd_pr__res_high_po_0p69 l=2.2
X488 a_13868_205# a5 vss vss sky130_fd_pr__nfet_01v8 ad=0.1305 pd=1.48 as=0.1305 ps=1.48 w=0.45 l=0.18
X489 a_8819_12702# a_10409_12702# vdd vdd sky130_fd_pr__pfet_01v8_lvt ad=0.609 pd=4.78 as=0.609 ps=4.78 w=2.1 l=0.35
X490 vdd a_18719_6161# vdd vdd sky130_fd_pr__pfet_01v8 ad=0.2805 pd=2.03 as=0 ps=0 w=1.7 l=0.15
X491 a_7935_6210# a_11461_1934# a_11527_2855# vdd sky130_fd_pr__pfet_01v8_lvt ad=0.667 pd=5.18 as=0.3335 ps=2.59 w=2.3 l=0.35
X492 vss a_5993_1373# a_6063_1490# vss sky130_fd_pr__nfet_01v8_lvt ad=0.341 pd=2.82 as=0.1815 ps=1.43 w=1.1 l=0.15
X493 vss a_6063_1490# a_7935_1490# vss sky130_fd_pr__nfet_01v8_lvt ad=0.527 pd=4.02 as=0.2805 ps=2.03 w=1.7 l=0.15
X494 a_2903_9270# a_5214_9128# vss sky130_fd_pr__res_high_po_0p69 l=1.5
X495 vdd a_5993_3733# a_6063_3850# vdd sky130_fd_pr__pfet_01v8_lvt ad=0.3045 pd=2.39 as=0.3045 ps=2.39 w=2.1 l=0.35
X496 a_24993_3298# f6 vss vss sky130_fd_pr__nfet_01v8 ad=0.1305 pd=1.48 as=0.1305 ps=1.48 w=0.45 l=0.18
X497 a_22795_7929# a_22753_3298# a_16768_8794# vdd sky130_fd_pr__pfet_01v8_lvt ad=0.609 pd=4.78 as=0.609 ps=4.78 w=2.1 l=0.35
X498 vdd vss a_29702_7094# vdd sky130_fd_pr__pfet_01v8 ad=0.589 pd=4.42 as=0.3135 ps=2.23 w=1.9 l=0.15
X499 a_18719_10029# f1 a_13102_7094# vss sky130_fd_pr__nfet_01v8_lvt ad=0.1885 pd=1.88 as=0.1885 ps=1.88 w=0.65 l=0.15
X500 a_23199_10029# a_22753_1814# a_16602_7094# vss sky130_fd_pr__nfet_01v8_lvt ad=0.1885 pd=1.88 as=0.1885 ps=1.88 w=0.65 l=0.15
X501 a_11527_4275# a0 a_7935_6810# vss sky130_fd_pr__nfet_01v8_lvt ad=0.12375 pd=1.08 as=0.2325 ps=2.12 w=0.75 l=0.15
X502 vdd a_6063_1490# a_7935_1490# vdd sky130_fd_pr__pfet_01v8_lvt ad=0.3045 pd=2.39 as=0.3045 ps=2.39 w=2.1 l=0.35
X503 a_7935_1490# a_6063_1490# vss vss sky130_fd_pr__nfet_01v8_lvt ad=0.2805 pd=2.03 as=0.527 ps=4.02 w=1.7 l=0.15
X504 a_11461_1934# a0 vdd vdd sky130_fd_pr__pfet_01v8 ad=0.261 pd=2.38 as=0.261 ps=2.38 w=0.9 l=0.18
X505 a_22795_1641# a_22753_1814# a_13268_4274# vss sky130_fd_pr__nfet_01v8_lvt ad=0.1885 pd=1.88 as=0.1885 ps=1.88 w=0.65 l=0.15
X506 vdd a_29868_8794# a_29702_7094# vdd sky130_fd_pr__pfet_01v8 ad=0.4464 pd=3.5 as=0.2376 ps=1.77 w=1.44 l=0.15
X507 a_29868_4274# a_29868_2574# vss sky130_fd_pr__res_high_po_0p35 l=6.5
X508 a_22437_8740# a_20555_8261# vdd vdd sky130_fd_pr__pfet_01v8 ad=0.2805 pd=2.03 as=0.527 ps=4.02 w=1.7 l=0.15
X509 a_7935_6810# a_12237_1934# a_11527_2855# vdd sky130_fd_pr__pfet_01v8_lvt ad=0.667 pd=5.18 as=0.3335 ps=2.59 w=2.3 l=0.35
X510 a_7935_4450# a_6063_4450# vdd vdd sky130_fd_pr__pfet_01v8_lvt ad=0.3045 pd=2.39 as=0.3045 ps=2.39 w=2.1 l=0.35
X511 a_2903_9270# a_323_4520# vss vss sky130_fd_pr__nfet_01v8_lvt ad=0.319 pd=2.78 as=0.319 ps=2.78 w=1.1 l=0.15
X512 vdd a_20959_6161# vdd vdd sky130_fd_pr__pfet_01v8 ad=0.2805 pd=2.03 as=0 ps=0 w=1.7 l=0.15
X513 a_23199_6161# a_22753_1814# a_13268_8794# vdd sky130_fd_pr__pfet_01v8_lvt ad=0.609 pd=4.78 as=0.609 ps=4.78 w=2.1 l=0.35
X514 a_13208_205# a3 vdd vdd sky130_fd_pr__pfet_01v8 ad=0.261 pd=2.38 as=0.261 ps=2.38 w=0.9 l=0.18
X515 a_29868_4274# a_29868_2574# a_30217_2855# vss sky130_fd_pr__nfet_01v8_lvt ad=0.744 pd=5.42 as=0.396 ps=2.73 w=2.4 l=0.15
X516 a_30963_8465# vss vdd vdd sky130_fd_pr__pfet_01v8 ad=0.2607 pd=1.91 as=0.4898 ps=3.78 w=1.58 l=0.15
X517 en a_30963_3945# vdd vdd sky130_fd_pr__pfet_01v8 ad=0.495 pd=3.33 as=0.93 ps=6.62 w=3 l=0.15
X518 vss a_23615_11840# vss vss sky130_fd_pr__nfet_01v8_lvt ad=0.1218 pd=1.42 as=0 ps=0 w=0.42 l=0.15
X519 vss a_10175_11935# a_27857_13560# vss sky130_fd_pr__nfet_01v8_lvt ad=0.465 pd=3.62 as=0.2475 ps=1.83 w=1.5 l=0.15
X520 ep a_6157_11685# a_19667_11933# vdd sky130_fd_pr__pfet_01v8_lvt ad=0.32915 pd=2.56 as=0.32915 ps=2.56 w=2.27 l=0.35
X521 vss a_20959_10029# vss vss sky130_fd_pr__nfet_01v8_lvt ad=0.203 pd=1.98 as=0 ps=0 w=0.7 l=0.15
X522 a_11527_4275# a4 a_7935_6210# vss sky130_fd_pr__nfet_01v8_lvt ad=0.12375 pd=1.08 as=0.2325 ps=2.12 w=0.75 l=0.15
X523 a_2903_6910# a_5214_6768# vss sky130_fd_pr__res_high_po_0p69 l=1.5
X524 a_22795_10029# f5 a_13102_7094# vdd sky130_fd_pr__pfet_01v8_lvt ad=0.609 pd=4.78 as=0.609 ps=4.78 w=2.1 l=0.35
X525 a_13102_2574# a_13102_4274# vdd vdd sky130_fd_pr__pfet_01v8 ad=0.462 pd=3.13 as=0.868 ps=6.22 w=2.8 l=0.15
X526 a_13268_7094# a_11527_7375# sky130_fd_pr__cap_mim_m3_1 l=4.2 w=4.3
X527 a_18745_12784# a_21957_11030# vss vss sky130_fd_pr__nfet_01v8_lvt ad=0.3135 pd=2.23 as=0.589 ps=4.42 w=1.9 l=0.15
X528 vdd a_30963_2855# ep vdd sky130_fd_pr__pfet_01v8 ad=0.495 pd=3.33 as=0.495 ps=3.33 w=3 l=0.15
X529 vss a_23199_1641# vss vss sky130_fd_pr__nfet_01v8_lvt ad=0.203 pd=1.98 as=0 ps=0 w=0.7 l=0.15
X530 a_25035_3409# f6 a_13268_4274# vdd sky130_fd_pr__pfet_01v8_lvt ad=0.609 pd=4.78 as=0.609 ps=4.78 w=2.1 l=0.35
X531 a_8487_11686# a_13717_11105# vdd vdd sky130_fd_pr__pfet_01v8_lvt ad=1.015 pd=7.58 as=1.015 ps=7.58 w=3.5 l=0.35
X532 a_8425_11085# a_15237_11085# vdd vdd sky130_fd_pr__pfet_01v8_lvt ad=1.015 pd=7.58 as=1.015 ps=7.58 w=3.5 l=0.35
X533 vdd a_323_4520# a_2903_6910# vdd sky130_fd_pr__pfet_01v8_lvt ad=0.1595 pd=1.39 as=0.1595 ps=1.39 w=1.1 l=0.35
X534 a_12625_1934# a6 vdd vdd sky130_fd_pr__pfet_01v8 ad=0.261 pd=2.38 as=0.261 ps=2.38 w=0.9 l=0.18
X535 a_21137_13560# a_20590_13570# a_21477_13560# vss sky130_fd_pr__nfet_01v8_lvt ad=0.465 pd=3.62 as=0.2475 ps=1.83 w=1.5 l=0.15
X536 a_8487_11686# a_13717_11105# vdd vdd sky130_fd_pr__pfet_01v8 ad=0.5775 pd=3.83 as=1.085 ps=7.62 w=3.5 l=0.15
X537 vdd a_25439_6161# vdd vdd sky130_fd_pr__pfet_01v8 ad=0.2805 pd=2.03 as=0 ps=0 w=1.7 l=0.15
X538 a_7935_1490# a_11849_1934# a_11527_4275# vdd sky130_fd_pr__pfet_01v8_lvt ad=0.667 pd=5.18 as=0.3335 ps=2.59 w=2.3 l=0.35
X539 a_7935_3850# a_6063_3850# vss vss sky130_fd_pr__nfet_01v8_lvt ad=0.2805 pd=2.03 as=0.527 ps=4.02 w=1.7 l=0.15
X540 a_13268_4274# a_13268_2574# vss sky130_fd_pr__res_high_po_0p35 l=6.5
X541 vdd a_13268_2574# a_13268_4274# vdd sky130_fd_pr__pfet_01v8 ad=0.462 pd=3.13 as=0.462 ps=3.13 w=2.8 l=0.15
X542 vdd a_30963_3945# a_30963_2855# vdd sky130_fd_pr__pfet_01v8 ad=0.3906 pd=3.14 as=0.2079 ps=1.59 w=1.26 l=0.15
X543 a_23615_11840# a_21927_11686# a_21477_13560# vdd sky130_fd_pr__pfet_01v8_lvt ad=0.928 pd=6.98 as=0.928 ps=6.98 w=3.2 l=0.35
X544 a_22437_2120# a_20555_1641# vss vss sky130_fd_pr__nfet_01v8_lvt ad=0.203 pd=1.98 as=0.203 ps=1.98 w=0.7 l=0.15
X545 a_26387_11933# rst_n vdd vdd sky130_fd_pr__pfet_01v8 ad=0.464 pd=3.78 as=0.464 ps=3.78 w=1.6 l=0.18
X546 ep en vss vss sky130_fd_pr__nfet_01v8_lvt ad=0.261 pd=2.38 as=0.261 ps=2.38 w=0.9 l=0.15
X547 a_20959_3741# a_20513_3298# a_13102_2574# vdd sky130_fd_pr__pfet_01v8_lvt ad=0.609 pd=4.78 as=0.609 ps=4.78 w=2.1 l=0.35
X548 cke2 a_18745_12784# vdd vdd sky130_fd_pr__pfet_01v8 ad=0.93 pd=6.62 as=0.495 ps=3.33 w=3 l=0.15
X549 a_28197_13560# a_29097_13560# vdd vdd sky130_fd_pr__pfet_01v8_lvt ad=0.174 pd=1.78 as=0.174 ps=1.78 w=0.6 l=0.35
X550 a_5993_9144# a_5214_9128# sky130_fd_pr__cap_mim_m3_1 l=4.2 w=4.2
X551 ckd1 a_8425_11085# vdd vdd sky130_fd_pr__pfet_01v8 ad=0.495 pd=3.33 as=0.93 ps=6.62 w=3 l=0.15
X552 a_8517_11085# a_8487_11686# a_8425_11085# vdd sky130_fd_pr__pfet_01v8 ad=0.462 pd=3.13 as=0.868 ps=6.22 w=2.8 l=0.15
X553 vdd a_323_9240# a_2903_8670# vdd sky130_fd_pr__pfet_01v8_lvt ad=0.1595 pd=1.39 as=0.1595 ps=1.39 w=1.1 l=0.35
X554 vdd a_6063_6810# a_7935_6810# vdd sky130_fd_pr__pfet_01v8_lvt ad=0.3045 pd=2.39 as=0.3045 ps=2.39 w=2.1 l=0.35
X555 a_7935_9170# a_14961_1934# a_15027_4275# vdd sky130_fd_pr__pfet_01v8_lvt ad=0.667 pd=5.18 as=0.3335 ps=2.59 w=2.3 l=0.35
X556 a_10175_11935# a_15825_11602# vdd vdd sky130_fd_pr__pfet_01v8 ad=0.5775 pd=3.83 as=1.085 ps=7.62 w=3.5 l=0.15
X557 vss a_5993_8453# a_6063_8570# vss sky130_fd_pr__nfet_01v8_lvt ad=0.341 pd=2.82 as=0.1815 ps=1.43 w=1.1 l=0.15
X558 a_11461_1934# a0 vss vss sky130_fd_pr__nfet_01v8 ad=0.1305 pd=1.48 as=0.1305 ps=1.48 w=0.45 l=0.18
X559 cke2 a_18745_12784# vss vss sky130_fd_pr__nfet_01v8_lvt ad=0.2145 pd=1.63 as=0.403 ps=3.22 w=1.3 l=0.15
X560 a_7935_2090# a_12625_1934# a_11527_4275# vdd sky130_fd_pr__pfet_01v8_lvt ad=0.667 pd=5.18 as=0.3335 ps=2.59 w=2.3 l=0.35
X561 a_18315_3741# a_18273_3298# a_16602_2574# vdd sky130_fd_pr__pfet_01v8_lvt ad=0.609 pd=4.78 as=0.609 ps=4.78 w=2.1 l=0.35
X562 a_20959_8261# f2 a_13102_7094# vss sky130_fd_pr__nfet_01v8_lvt ad=0.1885 pd=1.88 as=0.1885 ps=1.88 w=0.65 l=0.15
X563 a_7935_8570# b5 a_15027_4275# vss sky130_fd_pr__nfet_01v8_lvt ad=0.2325 pd=2.12 as=0.12375 ps=1.08 w=0.75 l=0.15
X564 a_22753_3298# f4 vdd vdd sky130_fd_pr__pfet_01v8 ad=0.261 pd=2.38 as=0.261 ps=2.38 w=0.9 l=0.18
X565 vss vdd a_30817_3517# vss sky130_fd_pr__nfet_01v8 ad=0.17835 pd=1.52 as=0.17835 ps=1.52 w=1.23 l=0.2
X566 a_8487_11686# a_7595_11810# vdd vdd sky130_fd_pr__pfet_01v8_lvt ad=0.16675 pd=1.44 as=0.3335 ps=2.88 w=1.15 l=0.35
X567 a_12947_11933# a_6157_11685# dn vdd sky130_fd_pr__pfet_01v8_lvt ad=0.6583 pd=5.12 as=0.32915 ps=2.56 w=2.27 l=0.35
X568 a_3663_2190# a_5214_2048# vss sky130_fd_pr__res_high_po_0p69 l=1.5
X569 a_26917_2120# a_25035_1641# vss vss sky130_fd_pr__nfet_01v8_lvt ad=0.203 pd=1.98 as=0.203 ps=1.98 w=0.7 l=0.15
X570 a_18719_1641# a_18273_1814# a_13268_4274# vdd sky130_fd_pr__pfet_01v8_lvt ad=0.609 pd=4.78 as=0.609 ps=4.78 w=2.1 l=0.35
X571 a_23199_3409# f4 a_13268_4274# vss sky130_fd_pr__nfet_01v8_lvt ad=0.1885 pd=1.88 as=0.1885 ps=1.88 w=0.65 l=0.15
X572 vss a_16602_4274# a_16602_2574# vss sky130_fd_pr__nfet_01v8_lvt ad=0.527 pd=4.02 as=0.2805 ps=2.03 w=1.7 l=0.15
X573 a_25439_10029# f7 a_13102_7094# vss sky130_fd_pr__nfet_01v8_lvt ad=0.1885 pd=1.88 as=0.1885 ps=1.88 w=0.65 l=0.15
X574 vdd a_6063_8570# a_7935_8570# vdd sky130_fd_pr__pfet_01v8_lvt ad=0.3045 pd=2.39 as=0.3045 ps=2.39 w=2.1 l=0.35
X575 a_7935_8570# b3 a_15027_7375# vss sky130_fd_pr__nfet_01v8_lvt ad=0.2325 pd=2.12 as=0.12375 ps=1.08 w=0.75 l=0.15
X576 vdd vss a_30963_7375# vdd sky130_fd_pr__pfet_01v8 ad=0.2607 pd=1.91 as=0.2607 ps=1.91 w=1.58 l=0.15
X577 vdd a_18719_5509# vdd vdd sky130_fd_pr__pfet_01v8 ad=0.2805 pd=2.03 as=0 ps=0 w=1.7 l=0.15
X578 a_5993_6784# a_5214_6768# sky130_fd_pr__cap_mim_m3_1 l=4.2 w=4.2
X579 a_25439_3741# a_24993_3298# a_13102_2574# vdd sky130_fd_pr__pfet_01v8_lvt ad=0.609 pd=4.78 as=0.609 ps=4.78 w=2.1 l=0.35
X580 vdd a_25035_8261# a_26917_8740# vdd sky130_fd_pr__pfet_01v8 ad=0.527 pd=4.02 as=0.2805 ps=2.03 w=1.7 l=0.15
X581 a_20555_7929# a_20513_3298# a_13268_8794# vss sky130_fd_pr__nfet_01v8_lvt ad=0.1885 pd=1.88 as=0.1885 ps=1.88 w=0.65 l=0.15
X582 a_30817_8037# a_29702_7094# a_30963_8465# vss sky130_fd_pr__nfet_01v8_lvt ad=0.396 pd=2.73 as=0.396 ps=2.73 w=2.4 l=0.15
X583 a_13208_205# a3 vss vss sky130_fd_pr__nfet_01v8 ad=0.1305 pd=1.48 as=0.1305 ps=1.48 w=0.45 l=0.18
X584 a_7935_1490# a_6063_1490# vdd vdd sky130_fd_pr__pfet_01v8_lvt ad=0.3045 pd=2.39 as=0.609 ps=4.78 w=2.1 l=0.35
X585 vdd a_8517_11085# a_8819_12702# vdd sky130_fd_pr__pfet_01v8 ad=0.5775 pd=3.83 as=0.5775 ps=3.83 w=3.5 l=0.15
X586 a_13102_7094# a_13102_8794# vdd vdd sky130_fd_pr__pfet_01v8_lvt ad=0.406 pd=3.09 as=0.812 ps=6.18 w=2.8 l=0.35
X587 a_15027_7375# a_15349_1934# a_7935_8570# vdd sky130_fd_pr__pfet_01v8_lvt ad=0.3335 pd=2.59 as=0.667 ps=5.18 w=2.3 l=0.35
X588 vdd a_323_6880# a_3663_1590# vdd sky130_fd_pr__pfet_01v8_lvt ad=0.319 pd=2.78 as=0.1595 ps=1.39 w=1.1 l=0.35
X589 a_5993_8453# a_6063_8570# vss sky130_fd_pr__res_high_po_0p35 l=9.5
X590 a_20959_7929# a_20513_3298# a_16768_8794# vss sky130_fd_pr__nfet_01v8_lvt ad=0.1885 pd=1.88 as=0.1885 ps=1.88 w=0.65 l=0.15
X591 a_16768_8794# a_16768_7094# vdd vdd sky130_fd_pr__pfet_01v8_lvt ad=0.406 pd=3.09 as=0.812 ps=6.18 w=2.8 l=0.35
X592 a_323_4520# qp vdd vdd sky130_fd_pr__pfet_01v8_lvt ad=0.203 pd=1.69 as=0.406 ps=3.38 w=1.4 l=0.35
X593 a_7935_3850# b7 a_15027_2855# vss sky130_fd_pr__nfet_01v8_lvt ad=0.2325 pd=2.12 as=0.12375 ps=1.08 w=0.75 l=0.15
X594 a_18315_8261# f0 a_16602_7094# vss sky130_fd_pr__nfet_01v8_lvt ad=0.1885 pd=1.88 as=0.1885 ps=1.88 w=0.65 l=0.15
X595 a_20555_6161# f3 a_13268_8794# vdd sky130_fd_pr__pfet_01v8_lvt ad=0.609 pd=4.78 as=0.609 ps=4.78 w=2.1 l=0.35
X596 a_2903_1590# a_5214_1580# vss sky130_fd_pr__res_high_po_0p69 l=1.5
X597 vdd a_8425_11085# vdd vdd sky130_fd_pr__pfet_01v8_lvt ad=0.638 pd=4.98 as=0 ps=0 w=2.2 l=0.35
X598 vdd a_23199_3741# vdd vdd sky130_fd_pr__pfet_01v8 ad=0.2805 pd=2.03 as=0 ps=0 w=1.7 l=0.15
X599 a_20959_6161# f3 a_16768_8794# vdd sky130_fd_pr__pfet_01v8_lvt ad=0.609 pd=4.78 as=0.609 ps=4.78 w=2.1 l=0.35
X600 a_18719_6161# f1 a_13268_8794# vss sky130_fd_pr__nfet_01v8_lvt ad=0.1885 pd=1.88 as=0.1885 ps=1.88 w=0.65 l=0.15
X601 vdd a_5993_1373# a_6063_1490# vdd sky130_fd_pr__pfet_01v8_lvt ad=0.3045 pd=2.39 as=0.3045 ps=2.39 w=2.1 l=0.35
X602 a_21927_11686# a_21035_11810# vss vss sky130_fd_pr__nfet_01v8_lvt ad=0.1305 pd=1.48 as=0.1305 ps=1.48 w=0.45 l=0.15
X603 vss a_15237_11085# a_8425_11085# vss sky130_fd_pr__nfet_01v8_lvt ad=0.589 pd=4.42 as=0.3135 ps=2.23 w=1.9 l=0.15
X604 a_13102_7094# a_13102_8794# vdd vdd sky130_fd_pr__pfet_01v8 ad=0.462 pd=3.13 as=0.462 ps=3.13 w=2.8 l=0.15
X605 a_25439_8261# f6 a_13102_7094# vss sky130_fd_pr__nfet_01v8_lvt ad=0.1885 pd=1.88 as=0.1885 ps=1.88 w=0.65 l=0.15
X606 a_30817_8037# vdd vss vss sky130_fd_pr__nfet_01v8 ad=0.17835 pd=1.52 as=0.17835 ps=1.52 w=1.23 l=0.2
X607 a_12625_1934# a6 vss vss sky130_fd_pr__nfet_01v8 ad=0.1305 pd=1.48 as=0.1305 ps=1.48 w=0.45 l=0.18
X608 a_20555_3741# a_20513_3298# a_16602_2574# vdd sky130_fd_pr__pfet_01v8_lvt ad=0.609 pd=4.78 as=0.609 ps=4.78 w=2.1 l=0.35
X609 vdd a_30963_7375# a_30963_8465# vdd sky130_fd_pr__pfet_01v8 ad=0.2079 pd=1.59 as=0.2079 ps=1.59 w=1.26 l=0.15
X610 vss a_5993_6093# a_6063_6210# vss sky130_fd_pr__nfet_01v8_lvt ad=0.341 pd=2.82 as=0.1815 ps=1.43 w=1.1 l=0.15
X611 a_25035_1641# f7 a_16768_4274# vss sky130_fd_pr__nfet_01v8_lvt ad=0.1885 pd=1.88 as=0.1885 ps=1.88 w=0.65 l=0.15
X612 vdd a_23199_3409# vdd vdd sky130_fd_pr__pfet_01v8 ad=0.527 pd=4.02 as=0 ps=0 w=1.7 l=0.15
X613 a_10175_11935# a_8425_11085# vdd vdd sky130_fd_pr__pfet_01v8_lvt ad=0.609 pd=4.78 as=0.609 ps=4.78 w=2.1 l=0.35
X614 en a_6157_11685# a_26387_11933# vdd sky130_fd_pr__pfet_01v8_lvt ad=0.32915 pd=2.56 as=0.32915 ps=2.56 w=2.27 l=0.35
X615 a_6063_6210# a_5993_6093# vdd vdd sky130_fd_pr__pfet_01v8_lvt ad=0.3045 pd=2.39 as=0.3045 ps=2.39 w=2.1 l=0.35
X616 a_20959_7929# a_20513_3298# a_13268_8794# vdd sky130_fd_pr__pfet_01v8_lvt ad=0.609 pd=4.78 as=0.609 ps=4.78 w=2.1 l=0.35
X617 a_7935_6210# a6 a_11527_8795# vss sky130_fd_pr__nfet_01v8_lvt ad=0.2325 pd=2.12 as=0.12375 ps=1.08 w=0.75 l=0.15
X618 a_15027_7375# a_16125_1934# a_7935_9170# vdd sky130_fd_pr__pfet_01v8_lvt ad=0.3335 pd=2.59 as=0.667 ps=5.18 w=2.3 l=0.35
X619 a_11527_4275# a_11461_1934# a_7935_6810# vdd sky130_fd_pr__pfet_01v8_lvt ad=0.3335 pd=2.59 as=0.667 ps=5.18 w=2.3 l=0.35
X620 vdd a_20959_5509# vdd vdd sky130_fd_pr__pfet_01v8 ad=0.2805 pd=2.03 as=0 ps=0 w=1.7 l=0.15
X621 ckd2 ckd0 vss vss sky130_fd_pr__nfet_01v8_lvt ad=0.1305 pd=1.48 as=0.1305 ps=1.48 w=0.45 l=0.15
X622 dp a_30963_7375# vss vss sky130_fd_pr__nfet_01v8_lvt ad=0.3465 pd=2.43 as=0.651 ps=4.82 w=2.1 l=0.15
X623 a_23199_1641# f5 a_16768_4274# vdd sky130_fd_pr__pfet_01v8_lvt ad=0.609 pd=4.78 as=0.609 ps=4.78 w=2.1 l=0.35
X624 vdd a_7595_11810# a_8487_11686# vdd sky130_fd_pr__pfet_01v8_lvt ad=0.3335 pd=2.88 as=0.16675 ps=1.44 w=1.15 l=0.35
X625 vdd a_13268_7094# a_13268_8794# vdd sky130_fd_pr__pfet_01v8 ad=0.868 pd=6.22 as=0.462 ps=3.13 w=2.8 l=0.15
X626 vss a_8425_11085# a_28757_13560# vss sky130_fd_pr__nfet_01v8_lvt ad=0.465 pd=3.62 as=0.2475 ps=1.83 w=1.5 l=0.15
X627 a_21035_11810# a_20437_11105# vdd vdd sky130_fd_pr__pfet_01v8_lvt ad=1.015 pd=7.58 as=1.015 ps=7.58 w=3.5 l=0.35
X628 a_18745_12784# a_21957_11030# vdd vdd sky130_fd_pr__pfet_01v8_lvt ad=1.015 pd=7.58 as=1.015 ps=7.58 w=3.5 l=0.35
X629 a_20555_8261# f2 a_16602_7094# vss sky130_fd_pr__nfet_01v8_lvt ad=0.1885 pd=1.88 as=0.1885 ps=1.88 w=0.65 l=0.15
X630 a_30963_2855# vss vdd vdd sky130_fd_pr__pfet_01v8 ad=0.2607 pd=1.91 as=0.2607 ps=1.91 w=1.58 l=0.15
X631 vdd a_20555_3741# a_22437_4220# vdd sky130_fd_pr__pfet_01v8 ad=0.527 pd=4.02 as=0.2805 ps=2.03 w=1.7 l=0.15
X632 a_15237_11085# a_15825_11602# vss vss sky130_fd_pr__nfet_01v8 ad=0.174 pd=1.78 as=0.174 ps=1.78 w=0.6 l=0.28
X633 a_21957_11030# a_21927_11686# a_21865_11030# vdd sky130_fd_pr__pfet_01v8_lvt ad=0.928 pd=6.98 as=0.928 ps=6.98 w=3.2 l=0.35
X634 vdd a_21957_11030# a_18745_12784# vdd sky130_fd_pr__pfet_01v8 ad=0.5775 pd=3.83 as=0.5775 ps=3.83 w=3.5 l=0.15
X635 a_18315_7929# a_18273_3298# a_16768_8794# vdd sky130_fd_pr__pfet_01v8_lvt ad=0.609 pd=4.78 as=0.609 ps=4.78 w=2.1 l=0.35
X636 a_7935_2090# a_6063_2090# vdd vdd sky130_fd_pr__pfet_01v8_lvt ad=0.3045 pd=2.39 as=0.3045 ps=2.39 w=2.1 l=0.35
X637 a_30963_3945# a_29702_2574# a_30817_3517# vss sky130_fd_pr__nfet_01v8_lvt ad=0.396 pd=2.73 as=0.396 ps=2.73 w=2.4 l=0.15
X638 a_20197_2720# a_28514_1816# vss sky130_fd_pr__res_high_po_0p69 l=2.2
X639 a_22795_3409# f4 a_16768_4274# vss sky130_fd_pr__nfet_01v8_lvt ad=0.1885 pd=1.88 as=0.1885 ps=1.88 w=0.65 l=0.15
X640 a_2903_6910# a_323_4520# vss vss sky130_fd_pr__nfet_01v8_lvt ad=0.319 pd=2.78 as=0.319 ps=2.78 w=1.1 l=0.15
X641 a_25035_10029# a_24993_1814# a_16602_7094# vdd sky130_fd_pr__pfet_01v8_lvt ad=0.609 pd=4.78 as=0.609 ps=4.78 w=2.1 l=0.35
X642 vdd a_18719_8261# vdd vdd sky130_fd_pr__pfet_01v8 ad=0.527 pd=4.02 as=0 ps=0 w=1.7 l=0.15
X643 a_13717_11105# a_12947_11933# vdd vdd sky130_fd_pr__pfet_01v8 ad=0.5775 pd=3.83 as=1.085 ps=7.62 w=3.5 l=0.15
X644 a_18745_12784# a_21035_11810# a_29097_13560# vdd sky130_fd_pr__pfet_01v8_lvt ad=0.928 pd=6.98 as=0.928 ps=6.98 w=3.2 l=0.35
X645 a_25439_7929# a_24993_3298# a_13268_8794# vdd sky130_fd_pr__pfet_01v8_lvt ad=0.609 pd=4.78 as=0.609 ps=4.78 w=2.1 l=0.35
X646 a_30817_8037# a_29868_8794# a_30963_7375# vss sky130_fd_pr__nfet_01v8_lvt ad=0.396 pd=2.73 as=0.396 ps=2.73 w=2.4 l=0.15
X647 a_22753_3298# f4 vss vss sky130_fd_pr__nfet_01v8 ad=0.1305 pd=1.48 as=0.1305 ps=1.48 w=0.45 l=0.18
X648 a_18315_1641# a_18273_1814# a_13268_4274# vss sky130_fd_pr__nfet_01v8_lvt ad=0.1885 pd=1.88 as=0.1885 ps=1.88 w=0.65 l=0.15
X649 a_15027_7375# b1 a_7935_3850# vss sky130_fd_pr__nfet_01v8_lvt ad=0.12375 pd=1.08 as=0.2325 ps=2.12 w=0.75 l=0.15
X650 a_23199_6161# a_22753_1814# a_16768_8794# vss sky130_fd_pr__nfet_01v8_lvt ad=0.1885 pd=1.88 as=0.1885 ps=1.88 w=0.65 l=0.15
X651 vdd a_25439_5509# vdd vdd sky130_fd_pr__pfet_01v8 ad=0.2805 pd=2.03 as=0 ps=0 w=1.7 l=0.15
X652 cke2 cke0 vss vss sky130_fd_pr__nfet_01v8_lvt ad=0.1305 pd=1.48 as=0.1305 ps=1.48 w=0.45 l=0.15
X653 vdd a_323_4520# a_3663_6910# vdd sky130_fd_pr__pfet_01v8_lvt ad=0.319 pd=2.78 as=0.1595 ps=1.39 w=1.1 l=0.35
X654 a_7935_6810# a_6063_6810# vdd vdd sky130_fd_pr__pfet_01v8_lvt ad=0.3045 pd=2.39 as=0.609 ps=4.78 w=2.1 l=0.35
X655 a_15027_8795# a_15737_1934# a_7935_3850# vdd sky130_fd_pr__pfet_01v8_lvt ad=0.3335 pd=2.59 as=0.667 ps=5.18 w=2.3 l=0.35
X656 vdd a_18315_10029# a_20197_9340# vdd sky130_fd_pr__pfet_01v8 ad=0.527 pd=4.02 as=0.2805 ps=2.03 w=1.7 l=0.15
X657 a_18719_1641# a_18273_1814# a_16768_4274# vss sky130_fd_pr__nfet_01v8_lvt ad=0.1885 pd=1.88 as=0.1885 ps=1.88 w=0.65 l=0.15
X658 cke3 a_21865_11030# vss vss sky130_fd_pr__nfet_01v8_lvt ad=0.2145 pd=1.63 as=0.403 ps=3.22 w=1.3 l=0.15
X659 a_8425_11085# a_10175_11935# vss vss sky130_fd_pr__nfet_01v8_lvt ad=0.1885 pd=1.88 as=0.1885 ps=1.88 w=0.65 l=0.15
X660 a_6063_3850# a_5993_3733# vdd vdd sky130_fd_pr__pfet_01v8_lvt ad=0.3045 pd=2.39 as=0.3045 ps=2.39 w=2.1 l=0.35
X661 a_22795_5509# a_22753_1814# a_16602_2574# vdd sky130_fd_pr__pfet_01v8_lvt ad=0.609 pd=4.78 as=0.609 ps=4.78 w=2.1 l=0.35
X662 a_13268_2574# a_11527_2855# sky130_fd_pr__cap_mim_m3_1 l=4.2 w=4.3
X663 a_30963_3945# a_30963_2855# vdd vdd sky130_fd_pr__pfet_01v8 ad=0.2079 pd=1.59 as=0.2079 ps=1.59 w=1.26 l=0.15
X664 a_20555_10029# f3 a_16602_7094# vss sky130_fd_pr__nfet_01v8_lvt ad=0.1885 pd=1.88 as=0.1885 ps=1.88 w=0.65 l=0.15
X665 vdd a_323_2160# a_2903_4550# vdd sky130_fd_pr__pfet_01v8_lvt ad=0.1595 pd=1.39 as=0.1595 ps=1.39 w=1.1 l=0.35
X666 a_26917_2720# a_25035_3409# vdd vdd sky130_fd_pr__pfet_01v8 ad=0.2805 pd=2.03 as=0.527 ps=4.02 w=1.7 l=0.15
X667 a_18175_13625# a_18105_12784# vss vss sky130_fd_pr__nfet_01v8 ad=0.2465 pd=2.28 as=0.2465 ps=2.28 w=0.85 l=0.35
X668 a_10409_12702# a_8819_12702# vdd vdd sky130_fd_pr__pfet_01v8_lvt ad=0.609 pd=4.78 as=0.609 ps=4.78 w=2.1 l=0.35
X669 a_24677_8740# a_28514_8208# vss sky130_fd_pr__res_high_po_0p69 l=2.2
X670 a_3663_9270# a_5214_9128# vss sky130_fd_pr__res_high_po_0p69 l=1.5
X671 a_7935_2090# a_7935_1490# vss vss sky130_fd_pr__nfet_01v8_lvt ad=0.1305 pd=1.48 as=0.1305 ps=1.48 w=0.45 l=0.15
X672 dp a_6157_11685# a_6227_11933# vdd sky130_fd_pr__pfet_01v8_lvt ad=0.32915 pd=2.56 as=0.32915 ps=2.56 w=2.27 l=0.35
X673 a_29097_13560# a_28197_13560# vss vss sky130_fd_pr__nfet_01v8 ad=0.174 pd=1.78 as=0.174 ps=1.78 w=0.6 l=0.28
X674 a_18315_10029# f1 a_13102_7094# vdd sky130_fd_pr__pfet_01v8_lvt ad=0.609 pd=4.78 as=0.609 ps=4.78 w=2.1 l=0.35
X675 vdd a_20959_8261# vdd vdd sky130_fd_pr__pfet_01v8 ad=0.527 pd=4.02 as=0 ps=0 w=1.7 l=0.15
X676 a_20555_7929# a_20513_3298# a_16768_8794# vdd sky130_fd_pr__pfet_01v8_lvt ad=0.609 pd=4.78 as=0.609 ps=4.78 w=2.1 l=0.35
X677 a_16768_8794# a_16768_7094# vdd vdd sky130_fd_pr__pfet_01v8 ad=0.462 pd=3.13 as=0.868 ps=6.22 w=2.8 l=0.15
X678 vss a_30963_2855# ep vss sky130_fd_pr__nfet_01v8_lvt ad=0.651 pd=4.82 as=0.3465 ps=2.43 w=2.1 l=0.15
X679 a_20959_10029# f3 a_13102_7094# vss sky130_fd_pr__nfet_01v8_lvt ad=0.1885 pd=1.88 as=0.1885 ps=1.88 w=0.65 l=0.15
X680 vdd a_5993_6784# a_6063_6810# vdd sky130_fd_pr__pfet_01v8_lvt ad=0.3045 pd=2.39 as=0.3045 ps=2.39 w=2.1 l=0.35
X681 a_22795_5509# a_22753_1814# a_13102_2574# vss sky130_fd_pr__nfet_01v8_lvt ad=0.1885 pd=1.88 as=0.1885 ps=1.88 w=0.65 l=0.15
X682 vdd a_30963_3945# en vdd sky130_fd_pr__pfet_01v8_lvt ad=0.812 pd=6.18 as=0.406 ps=3.09 w=2.8 l=0.35
X683 a_7587_12850# a_7035_12870# vdd vdd sky130_fd_pr__pfet_01v8_lvt ad=0.522 pd=4.18 as=0.261 ps=2.09 w=1.8 l=0.35
X684 cke1 a_23615_11840# vss vss sky130_fd_pr__nfet_01v8_lvt ad=0.2145 pd=1.63 as=0.403 ps=3.22 w=1.3 l=0.15
X685 vdd a_323_2160# a_3663_8670# vdd sky130_fd_pr__pfet_01v8_lvt ad=0.319 pd=2.78 as=0.1595 ps=1.39 w=1.1 l=0.35
X686 a_7935_8570# a_6063_8570# vdd vdd sky130_fd_pr__pfet_01v8_lvt ad=0.3045 pd=2.39 as=0.609 ps=4.78 w=2.1 l=0.35
X687 a_15027_7375# b5 a_7935_4450# vss sky130_fd_pr__nfet_01v8_lvt ad=0.12375 pd=1.08 as=0.2325 ps=2.12 w=0.75 l=0.15
X688 a_28514_6336# vss sky130_fd_pr__cap_mim_m3_1 l=1.6 w=1.6
X689 a_27157_11105# a_26387_11933# vdd vdd sky130_fd_pr__pfet_01v8 ad=0.5775 pd=3.83 as=1.085 ps=7.62 w=3.5 l=0.15
X690 a_18719_10029# f1 a_16602_7094# vdd sky130_fd_pr__pfet_01v8_lvt ad=0.609 pd=4.78 as=0.609 ps=4.78 w=2.1 l=0.35
X691 vss a_18719_1641# vss vss sky130_fd_pr__nfet_01v8_lvt ad=0.203 pd=1.98 as=0 ps=0 w=0.7 l=0.15
X692 a_16602_4274# a_16602_2574# vss sky130_fd_pr__res_high_po_0p35 l=6.5
X693 a_28197_13560# a_21927_11686# a_18105_12784# vss sky130_fd_pr__nfet_01v8_lvt ad=0.33 pd=2.33 as=0.62 ps=4.62 w=2 l=0.15
X694 vdd a_22795_10029# a_24677_9340# vdd sky130_fd_pr__pfet_01v8 ad=0.527 pd=4.02 as=0.2805 ps=2.03 w=1.7 l=0.15
X695 vdd a_6063_4450# a_7935_4450# vdd sky130_fd_pr__pfet_01v8_lvt ad=0.3045 pd=2.39 as=0.3045 ps=2.39 w=2.1 l=0.35
X696 a_15018_205# b0 vdd vdd sky130_fd_pr__pfet_01v8 ad=0.261 pd=2.38 as=0.261 ps=2.38 w=0.9 l=0.18
X697 a_7935_2090# a4 a_11527_7375# vss sky130_fd_pr__nfet_01v8_lvt ad=0.2325 pd=2.12 as=0.12375 ps=1.08 w=0.75 l=0.15
X698 a_13102_7094# a_13102_8794# vss vss sky130_fd_pr__nfet_01v8_lvt ad=0.2805 pd=2.03 as=0.527 ps=4.02 w=1.7 l=0.15
X699 a_20197_8740# a_18315_8261# vdd vdd sky130_fd_pr__pfet_01v8 ad=0.2805 pd=2.03 as=0.527 ps=4.02 w=1.7 l=0.15
X700 a_30963_2855# a_29868_4274# a_30817_3517# vss sky130_fd_pr__nfet_01v8_lvt ad=0.396 pd=2.73 as=0.396 ps=2.73 w=2.4 l=0.15
X701 vdd a_5993_8453# a_6063_8570# vdd sky130_fd_pr__pfet_01v8_lvt ad=0.3045 pd=2.39 as=0.3045 ps=2.39 w=2.1 l=0.35
X702 vss a_21957_11030# a_18745_12784# vss sky130_fd_pr__nfet_01v8_lvt ad=0.589 pd=4.42 as=0.3135 ps=2.23 w=1.9 l=0.15
X703 a_30217_7375# vdd vss vss sky130_fd_pr__nfet_01v8 ad=0.16675 pd=1.44 as=0.3335 ps=2.88 w=1.15 l=0.2
X704 vdd a_25439_8261# vdd vdd sky130_fd_pr__pfet_01v8 ad=0.527 pd=4.02 as=0 ps=0 w=1.7 l=0.15
X705 dn a_30963_8465# vss vss sky130_fd_pr__nfet_01v8_lvt ad=0.3465 pd=2.43 as=0.651 ps=4.82 w=2.1 l=0.15
X706 a_6063_3850# a_5993_3733# vss vss sky130_fd_pr__nfet_01v8_lvt ad=0.1815 pd=1.43 as=0.341 ps=2.82 w=1.1 l=0.15
X707 a_18105_12784# a_18745_12784# vdd vdd sky130_fd_pr__pfet_01v8_lvt ad=0.609 pd=4.78 as=0.609 ps=4.78 w=2.1 l=0.35
X708 a_15349_1934# b3 vdd vdd sky130_fd_pr__pfet_01v8 ad=0.261 pd=2.38 as=0.261 ps=2.38 w=0.9 l=0.18
X709 vdd a_13717_11105# a_8487_11686# vdd sky130_fd_pr__pfet_01v8 ad=0.5775 pd=3.83 as=0.5775 ps=3.83 w=3.5 l=0.15
X710 a_18719_8261# a_18273_3298# a_13102_7094# vdd sky130_fd_pr__pfet_01v8_lvt ad=0.609 pd=4.78 as=0.609 ps=4.78 w=2.1 l=0.35
X711 vdd a_30963_8465# dn vdd sky130_fd_pr__pfet_01v8 ad=0.495 pd=3.33 as=0.495 ps=3.33 w=3 l=0.15
X712 a_25439_10029# a_24993_1814# a_16602_7094# vss sky130_fd_pr__nfet_01v8_lvt ad=0.1885 pd=1.88 as=0.1885 ps=1.88 w=0.65 l=0.15
X713 a_30963_8465# a_29702_7094# a_30817_8037# vss sky130_fd_pr__nfet_01v8_lvt ad=0.744 pd=5.42 as=0.396 ps=2.73 w=2.4 l=0.15
X714 a_323_2160# ip vdd vdd sky130_fd_pr__pfet_01v8_lvt ad=0.203 pd=1.69 as=0.406 ps=3.38 w=1.4 l=0.35
X715 a_5993_1373# a_5214_1580# sky130_fd_pr__cap_mim_m3_1 l=4.2 w=4.2
X716 a_21865_11030# a_28197_13560# vdd vdd sky130_fd_pr__pfet_01v8_lvt ad=1.015 pd=7.58 as=1.015 ps=7.58 w=3.5 l=0.35
X717 a_7935_9170# a_6063_9170# vdd vdd sky130_fd_pr__pfet_01v8_lvt ad=0.3045 pd=2.39 as=0.3045 ps=2.39 w=2.1 l=0.35
X718 a_24677_8740# a_22795_8261# vdd vdd sky130_fd_pr__pfet_01v8 ad=0.2805 pd=2.03 as=0.527 ps=4.02 w=1.7 l=0.15
X719 a_15027_7375# a_14961_1934# a_7935_3850# vdd sky130_fd_pr__pfet_01v8_lvt ad=0.3335 pd=2.59 as=0.667 ps=5.18 w=2.3 l=0.35
X720 ckd1 ckd3 vss vss sky130_fd_pr__nfet_01v8_lvt ad=0.1305 pd=1.48 as=0.1305 ps=1.48 w=0.45 l=0.15
X721 ckd1 a_8425_11085# vdd vdd sky130_fd_pr__pfet_01v8_lvt ad=0.87 pd=6.58 as=0.87 ps=6.58 w=3 l=0.35
X722 vdd a_28197_13560# a_21865_11030# vdd sky130_fd_pr__pfet_01v8 ad=0.5775 pd=3.83 as=0.5775 ps=3.83 w=3.5 l=0.15
X723 vdd a_16602_8794# a_16602_7094# vdd sky130_fd_pr__pfet_01v8 ad=0.462 pd=3.13 as=0.462 ps=3.13 w=2.8 l=0.15
X724 vdd a_8425_11085# ckd1 vdd sky130_fd_pr__pfet_01v8 ad=0.495 pd=3.33 as=0.495 ps=3.33 w=3 l=0.15
X725 a_8425_11085# a_8487_11686# a_8517_11085# vdd sky130_fd_pr__pfet_01v8 ad=0.868 pd=6.22 as=0.462 ps=3.13 w=2.8 l=0.15
X726 a_9105_11602# a_8517_11085# vss vss sky130_fd_pr__nfet_01v8 ad=0.174 pd=1.78 as=0.174 ps=1.78 w=0.6 l=0.28
X727 a_21957_11030# a_21477_13560# vss vss sky130_fd_pr__nfet_01v8 ad=0.174 pd=1.78 as=0.174 ps=1.78 w=0.6 l=0.28
X728 a_16998_205# b6 vdd vdd sky130_fd_pr__pfet_01v8 ad=0.261 pd=2.38 as=0.261 ps=2.38 w=0.9 l=0.18
X729 a_8517_11085# a_9105_11602# vss vss sky130_fd_pr__nfet_01v8 ad=0.174 pd=1.78 as=0.174 ps=1.78 w=0.6 l=0.28
X730 vdd a_23199_6161# vdd vdd sky130_fd_pr__pfet_01v8 ad=0.2805 pd=2.03 as=0 ps=0 w=1.7 l=0.15
X731 a_15027_2855# a_15737_1934# a_7935_9170# vdd sky130_fd_pr__pfet_01v8_lvt ad=0.3335 pd=2.59 as=0.667 ps=5.18 w=2.3 l=0.35
X732 a_26917_6640# a_28514_6336# vss sky130_fd_pr__res_high_po_0p69 l=2.2
X733 vdd a_15825_11602# a_10175_11935# vdd sky130_fd_pr__pfet_01v8 ad=0.5775 pd=3.83 as=0.5775 ps=3.83 w=3.5 l=0.15
X734 a_21865_11030# a_28197_13560# vdd vdd sky130_fd_pr__pfet_01v8 ad=0.5775 pd=3.83 as=1.085 ps=7.62 w=3.5 l=0.15
X735 vss a_18745_12784# cke2 vss sky130_fd_pr__nfet_01v8_lvt ad=0.403 pd=3.22 as=0.2145 ps=1.63 w=1.3 l=0.15
X736 a_28197_13560# a_21035_11810# a_18105_12784# vdd sky130_fd_pr__pfet_01v8 ad=0.5775 pd=3.83 as=1.085 ps=7.62 w=3.5 l=0.15
X737 a_25035_10029# f7 a_13102_7094# vdd sky130_fd_pr__pfet_01v8_lvt ad=0.609 pd=4.78 as=0.609 ps=4.78 w=2.1 l=0.35
X738 a_6063_2090# a_5993_2064# vss sky130_fd_pr__res_high_po_0p35 l=9.5
X739 a_8819_12702# a_7595_11810# a_15825_11602# vdd sky130_fd_pr__pfet_01v8 ad=0.462 pd=3.13 as=0.868 ps=6.22 w=2.8 l=0.15
X740 a_29868_8794# vss vdd vdd sky130_fd_pr__pfet_01v8 ad=0.3135 pd=2.23 as=0.589 ps=4.42 w=1.9 l=0.15
X741 a_18273_3298# f0 vdd vdd sky130_fd_pr__pfet_01v8 ad=0.261 pd=2.38 as=0.261 ps=2.38 w=0.9 l=0.18
X742 vss a_25439_1641# vss vss sky130_fd_pr__nfet_01v8_lvt ad=0.203 pd=1.98 as=0 ps=0 w=0.7 l=0.15
X743 a_23199_8261# f4 a_16602_7094# vdd sky130_fd_pr__pfet_01v8_lvt ad=0.609 pd=4.78 as=0.609 ps=4.78 w=2.1 l=0.35
X744 a_8819_12702# a_8517_11085# vdd vdd sky130_fd_pr__pfet_01v8 ad=1.085 pd=7.62 as=0.5775 ps=3.83 w=3.5 l=0.15
X745 a_7935_8570# a_6063_8570# vss vss sky130_fd_pr__nfet_01v8_lvt ad=0.2805 pd=2.03 as=0.527 ps=4.02 w=1.7 l=0.15
X746 a_15018_205# b0 vss vss sky130_fd_pr__nfet_01v8 ad=0.1305 pd=1.48 as=0.1305 ps=1.48 w=0.45 l=0.18
X747 vdd a_20555_6161# a_22437_6640# vdd sky130_fd_pr__pfet_01v8 ad=0.527 pd=4.02 as=0.2805 ps=2.03 w=1.7 l=0.15
X748 a_29702_7094# a_29702_8794# a_30217_7375# vss sky130_fd_pr__nfet_01v8_lvt ad=0.396 pd=2.73 as=0.744 ps=5.42 w=2.4 l=0.15
X749 a_2903_4550# a_323_2160# vss vss sky130_fd_pr__nfet_01v8_lvt ad=0.319 pd=2.78 as=0.319 ps=2.78 w=1.1 l=0.15
X750 a_30817_3517# vdd vss vss sky130_fd_pr__nfet_01v8 ad=0.17835 pd=1.52 as=0.17835 ps=1.52 w=1.23 l=0.2
X751 a_21137_13560# a_8819_12702# vss vss sky130_fd_pr__nfet_01v8_lvt ad=0.2475 pd=1.83 as=0.465 ps=3.62 w=1.5 l=0.15
X752 a_21927_11686# a_27157_11105# vdd vdd sky130_fd_pr__pfet_01v8 ad=0.5775 pd=3.83 as=1.085 ps=7.62 w=3.5 l=0.15
X753 vdd a_13268_2574# a_13268_4274# vdd sky130_fd_pr__pfet_01v8_lvt ad=0.812 pd=6.18 as=0.406 ps=3.09 w=2.8 l=0.35
X754 a_24677_2120# a_22795_1641# vss vss sky130_fd_pr__nfet_01v8_lvt ad=0.203 pd=1.98 as=0.203 ps=1.98 w=0.7 l=0.15
X755 a_20959_3409# f2 a_13268_4274# vss sky130_fd_pr__nfet_01v8_lvt ad=0.1885 pd=1.88 as=0.1885 ps=1.88 w=0.65 l=0.15
X756 a_7935_9170# b3 a_15027_8795# vss sky130_fd_pr__nfet_01v8_lvt ad=0.2325 pd=2.12 as=0.12375 ps=1.08 w=0.75 l=0.15
X757 a_23199_3741# a_22753_3298# a_13102_2574# vdd sky130_fd_pr__pfet_01v8_lvt ad=0.609 pd=4.78 as=0.609 ps=4.78 w=2.1 l=0.35
X758 vdd a_21865_11030# vdd vdd sky130_fd_pr__pfet_01v8_lvt ad=0.638 pd=4.98 as=0 ps=0 w=2.2 l=0.35
X759 a_16602_2574# a_16602_4274# vdd vdd sky130_fd_pr__pfet_01v8 ad=0.462 pd=3.13 as=0.462 ps=3.13 w=2.8 l=0.15
X760 vdd vss a_30963_8465# vdd sky130_fd_pr__pfet_01v8 ad=0.4898 pd=3.78 as=0.2607 ps=1.91 w=1.58 l=0.15
X761 a_30963_7375# a_29868_8794# a_30817_8037# vss sky130_fd_pr__nfet_01v8_lvt ad=0.744 pd=5.42 as=0.396 ps=2.73 w=2.4 l=0.15
X762 vdd a_323_4520# a_3663_4550# vdd sky130_fd_pr__pfet_01v8_lvt ad=0.319 pd=2.78 as=0.1595 ps=1.39 w=1.1 l=0.35
X763 a_7935_4450# a_6063_4450# vdd vdd sky130_fd_pr__pfet_01v8_lvt ad=0.3045 pd=2.39 as=0.609 ps=4.78 w=2.1 l=0.35
X764 a_15349_1934# b3 vss vss sky130_fd_pr__nfet_01v8 ad=0.1305 pd=1.48 as=0.1305 ps=1.48 w=0.45 l=0.18
X765 a_29868_4274# a_29702_2574# vdd vdd sky130_fd_pr__pfet_01v8 ad=0.2376 pd=1.77 as=0.4464 ps=3.5 w=1.44 l=0.15
X766 a_17855_12810# a_10409_12702# a_18367_12810# vdd sky130_fd_pr__pfet_01v8_lvt ad=0.638 pd=4.98 as=0.638 ps=4.98 w=2.2 l=0.35
X767 a_6063_1490# a_5993_1373# vdd vdd sky130_fd_pr__pfet_01v8_lvt ad=0.3045 pd=2.39 as=0.3045 ps=2.39 w=2.1 l=0.35
X768 a_18315_3409# f0 a_16768_4274# vss sky130_fd_pr__nfet_01v8_lvt ad=0.1885 pd=1.88 as=0.1885 ps=1.88 w=0.65 l=0.15
X769 a_25035_5509# f7 a_16602_2574# vss sky130_fd_pr__nfet_01v8_lvt ad=0.1885 pd=1.88 as=0.1885 ps=1.88 w=0.65 l=0.15
X770 vdd a_323_2160# a_2903_2190# vdd sky130_fd_pr__pfet_01v8_lvt ad=0.1595 pd=1.39 as=0.1595 ps=1.39 w=1.1 l=0.35
X771 vdd a_16768_2574# a_16768_4274# vdd sky130_fd_pr__pfet_01v8 ad=0.868 pd=6.22 as=0.462 ps=3.13 w=2.8 l=0.15
X772 a_8487_11686# a_13717_11105# vss vss sky130_fd_pr__nfet_01v8_lvt ad=0.28875 pd=2.08 as=0.5425 ps=4.12 w=1.75 l=0.15
X773 a_20959_5509# a_20513_1814# a_13102_2574# vdd sky130_fd_pr__pfet_01v8_lvt ad=0.609 pd=4.78 as=0.609 ps=4.78 w=2.1 l=0.35
X774 vdd vss a_29868_4274# vdd sky130_fd_pr__pfet_01v8 ad=0.589 pd=4.42 as=0.3135 ps=2.23 w=1.9 l=0.15
X775 ep a_30963_2855# vdd vdd sky130_fd_pr__pfet_01v8 ad=0.495 pd=3.33 as=0.495 ps=3.33 w=3 l=0.15
X776 a_23199_3741# f4 a_13102_2574# vss sky130_fd_pr__nfet_01v8_lvt ad=0.1885 pd=1.88 as=0.1885 ps=1.88 w=0.65 l=0.15
X777 vss a_28197_13560# a_21865_11030# vss sky130_fd_pr__nfet_01v8_lvt ad=0.589 pd=4.42 as=0.3135 ps=2.23 w=1.9 l=0.15
X778 vdd a_18719_7929# vdd vdd sky130_fd_pr__pfet_01v8 ad=0.2805 pd=2.03 as=0 ps=0 w=1.7 l=0.15
X779 a_25439_3409# f6 a_13268_4274# vss sky130_fd_pr__nfet_01v8_lvt ad=0.1885 pd=1.88 as=0.1885 ps=1.88 w=0.65 l=0.15
X780 vdd a_5993_4424# a_6063_4450# vdd sky130_fd_pr__pfet_01v8_lvt ad=0.3045 pd=2.39 as=0.3045 ps=2.39 w=2.1 l=0.35
X781 a_7935_6810# a_11461_1934# a_11527_4275# vdd sky130_fd_pr__pfet_01v8_lvt ad=0.667 pd=5.18 as=0.3335 ps=2.59 w=2.3 l=0.35
X782 a_16998_205# b6 vss vss sky130_fd_pr__nfet_01v8 ad=0.1305 pd=1.48 as=0.1305 ps=1.48 w=0.45 l=0.18
X783 a_18745_12784# a_21957_11030# vdd vdd sky130_fd_pr__pfet_01v8 ad=1.085 pd=7.62 as=0.5775 ps=3.83 w=3.5 l=0.15
X784 a_21865_11030# a_28197_13560# vss vss sky130_fd_pr__nfet_01v8_lvt ad=0.3135 pd=2.23 as=0.589 ps=4.42 w=1.9 l=0.15
X785 a_22795_7929# a_22753_3298# a_13268_8794# vss sky130_fd_pr__nfet_01v8_lvt ad=0.1885 pd=1.88 as=0.1885 ps=1.88 w=0.65 l=0.15
X786 vdd a_16602_4274# a_16602_2574# vdd sky130_fd_pr__pfet_01v8_lvt ad=0.812 pd=6.18 as=0.406 ps=3.09 w=2.8 l=0.35
X787 a_26917_9340# a_28514_8208# vss sky130_fd_pr__res_high_po_0p69 l=2.2
X788 a_30963_7375# vss vdd vdd sky130_fd_pr__pfet_01v8 ad=0.2607 pd=1.91 as=0.4898 ps=3.78 w=1.58 l=0.15
X789 a_7935_6810# a_7935_6210# vss vss sky130_fd_pr__nfet_01v8_lvt ad=0.1305 pd=1.48 as=0.1305 ps=1.48 w=0.45 l=0.15
X790 a_30963_3945# vss vdd vdd sky130_fd_pr__pfet_01v8 ad=0.2607 pd=1.91 as=0.2607 ps=1.91 w=1.58 l=0.15
X791 vdd a_12947_11933# a_13717_11105# vdd sky130_fd_pr__pfet_01v8 ad=1.085 pd=7.62 as=0.5775 ps=3.83 w=3.5 l=0.15
X792 a_323_9240# qn vdd vdd sky130_fd_pr__pfet_01v8_lvt ad=0.203 pd=1.69 as=0.406 ps=3.38 w=1.4 l=0.35
X793 a_30963_8465# a_29702_7094# a_30817_8037# vss sky130_fd_pr__nfet_01v8_lvt ad=0.396 pd=2.73 as=0.744 ps=5.42 w=2.4 l=0.15
X794 a_18315_5509# a_18273_1814# a_16602_2574# vdd sky130_fd_pr__pfet_01v8_lvt ad=0.609 pd=4.78 as=0.609 ps=4.78 w=2.1 l=0.35
X795 a_28514_1816# vss sky130_fd_pr__cap_mim_m3_1 l=1.6 w=1.6
X796 a_30217_2855# a_29702_4274# a_29702_2574# vss sky130_fd_pr__nfet_01v8_lvt ad=0.396 pd=2.73 as=0.396 ps=2.73 w=2.4 l=0.15
X797 a_2903_6310# a_5214_6300# vss sky130_fd_pr__res_high_po_0p69 l=1.5
X798 a_22795_6161# f5 a_13268_8794# vdd sky130_fd_pr__pfet_01v8_lvt ad=0.609 pd=4.78 as=0.609 ps=4.78 w=2.1 l=0.35
X799 vdd a_6063_2090# a_7935_2090# vdd sky130_fd_pr__pfet_01v8_lvt ad=0.3045 pd=2.39 as=0.3045 ps=2.39 w=2.1 l=0.35
X800 vdd a_18315_3741# a_20197_4220# vdd sky130_fd_pr__pfet_01v8 ad=0.527 pd=4.02 as=0.2805 ps=2.03 w=1.7 l=0.15
X801 a_22217_13560# a_10409_12702# vss vss sky130_fd_pr__nfet_01v8_lvt ad=0.2475 pd=1.83 as=0.465 ps=3.62 w=1.5 l=0.15
X802 vss a_13102_4274# a_13102_2574# vss sky130_fd_pr__nfet_01v8_lvt ad=0.527 pd=4.02 as=0.2805 ps=2.03 w=1.7 l=0.15
X803 a_18273_3298# f0 vss vss sky130_fd_pr__nfet_01v8 ad=0.1305 pd=1.48 as=0.1305 ps=1.48 w=0.45 l=0.18
X804 a_18719_3409# a_18273_3298# a_13268_4274# vdd sky130_fd_pr__pfet_01v8_lvt ad=0.609 pd=4.78 as=0.609 ps=4.78 w=2.1 l=0.35
X805 a_7595_11810# a_6997_11105# vdd vdd sky130_fd_pr__pfet_01v8 ad=0.5775 pd=3.83 as=1.085 ps=7.62 w=3.5 l=0.15
X806 a_15237_11085# a_7595_11810# a_10409_12702# vdd sky130_fd_pr__pfet_01v8 ad=0.462 pd=3.13 as=0.868 ps=6.22 w=2.8 l=0.15
X807 a_7935_6210# a2 a_11527_7375# vss sky130_fd_pr__nfet_01v8_lvt ad=0.2325 pd=2.12 as=0.12375 ps=1.08 w=0.75 l=0.15
X808 a_22437_9340# a_20555_10029# vdd vdd sky130_fd_pr__pfet_01v8 ad=0.2805 pd=2.03 as=0.527 ps=4.02 w=1.7 l=0.15
X809 a_29868_8794# a_29868_7094# a_30217_7375# vss sky130_fd_pr__nfet_01v8_lvt ad=0.396 pd=2.73 as=0.744 ps=5.42 w=2.4 l=0.15
X810 a_18315_5509# a_18273_1814# a_13102_2574# vss sky130_fd_pr__nfet_01v8_lvt ad=0.1885 pd=1.88 as=0.1885 ps=1.88 w=0.65 l=0.15
X811 a_6063_1490# a_5993_1373# vss sky130_fd_pr__res_high_po_0p35 l=9.5
X812 a_20555_3409# f2 a_16768_4274# vss sky130_fd_pr__nfet_01v8_lvt ad=0.1885 pd=1.88 as=0.1885 ps=1.88 w=0.65 l=0.15
X813 a_25439_5509# a_24993_1814# a_13102_2574# vdd sky130_fd_pr__pfet_01v8_lvt ad=0.609 pd=4.78 as=0.609 ps=4.78 w=2.1 l=0.35
X814 a_11527_7375# a_11849_1934# a_7935_6210# vdd sky130_fd_pr__pfet_01v8_lvt ad=0.3335 pd=2.59 as=0.667 ps=5.18 w=2.3 l=0.35
X815 a_3663_2190# a_323_2160# vss vss sky130_fd_pr__nfet_01v8_lvt ad=0.319 pd=2.78 as=0.319 ps=2.78 w=1.1 l=0.15
X816 a_7935_6210# a_12237_1934# a_11527_4275# vdd sky130_fd_pr__pfet_01v8_lvt ad=0.667 pd=5.18 as=0.3335 ps=2.59 w=2.3 l=0.35
X817 a_5993_2064# a_5214_2048# sky130_fd_pr__cap_mim_m3_1 l=4.2 w=4.2
X818 vss a_30963_3945# en vss sky130_fd_pr__nfet_01v8_lvt ad=0.651 pd=4.82 as=0.3465 ps=2.43 w=2.1 l=0.15
X819 vss a_21865_11030# cke3 vss sky130_fd_pr__nfet_01v8_lvt ad=0.403 pd=3.22 as=0.2145 ps=1.63 w=1.3 l=0.15
X820 vdd a_20959_7929# vdd vdd sky130_fd_pr__pfet_01v8 ad=0.2805 pd=2.03 as=0 ps=0 w=1.7 l=0.15
X821 a_23199_7929# a_22753_3298# a_13268_8794# vdd sky130_fd_pr__pfet_01v8_lvt ad=0.609 pd=4.78 as=0.609 ps=4.78 w=2.1 l=0.35
X822 a_18719_5509# a_18273_1814# a_16602_2574# vss sky130_fd_pr__nfet_01v8_lvt ad=0.1885 pd=1.88 as=0.1885 ps=1.88 w=0.65 l=0.15
X823 a_7935_1490# a6 a_11527_2855# vss sky130_fd_pr__nfet_01v8_lvt ad=0.2325 pd=2.12 as=0.12375 ps=1.08 w=0.75 l=0.15
X824 a_6063_1490# a_5993_1373# vss vss sky130_fd_pr__nfet_01v8_lvt ad=0.1815 pd=1.43 as=0.341 ps=2.82 w=1.1 l=0.15
X825 a_30963_7375# a_30963_8465# vdd vdd sky130_fd_pr__pfet_01v8 ad=0.2079 pd=1.59 as=0.2079 ps=1.59 w=1.26 l=0.15
X826 a_15027_8795# b1 a_7935_4450# vss sky130_fd_pr__nfet_01v8_lvt ad=0.12375 pd=1.08 as=0.2325 ps=2.12 w=0.75 l=0.15
X827 a_29702_7094# vss vdd vdd sky130_fd_pr__pfet_01v8 ad=0.3135 pd=2.23 as=0.589 ps=4.42 w=1.9 l=0.15
X828 a_30963_8465# a_30963_7375# vdd vdd sky130_fd_pr__pfet_01v8 ad=0.2079 pd=1.59 as=0.3906 ps=3.14 w=1.26 l=0.15
X829 vdd a_23199_5509# vdd vdd sky130_fd_pr__pfet_01v8 ad=0.2805 pd=2.03 as=0 ps=0 w=1.7 l=0.15
X830 a_7935_3850# b1 a_15027_7375# vss sky130_fd_pr__nfet_01v8_lvt ad=0.2325 pd=2.12 as=0.12375 ps=1.08 w=0.75 l=0.15
X831 a_25439_1641# f7 a_16768_4274# vdd sky130_fd_pr__pfet_01v8_lvt ad=0.609 pd=4.78 as=0.609 ps=4.78 w=2.1 l=0.35
X832 a_22795_3741# f4 a_16602_2574# vss sky130_fd_pr__nfet_01v8_lvt ad=0.1885 pd=1.88 as=0.1885 ps=1.88 w=0.65 l=0.15
X833 vss a_23615_11840# cke1 vss sky130_fd_pr__nfet_01v8_lvt ad=0.403 pd=3.22 as=0.2145 ps=1.63 w=1.3 l=0.15
X834 a_20555_5509# a_20513_1814# a_16602_2574# vdd sky130_fd_pr__pfet_01v8_lvt ad=0.609 pd=4.78 as=0.609 ps=4.78 w=2.1 l=0.35
X835 vdd a_22795_3741# a_24677_4220# vdd sky130_fd_pr__pfet_01v8 ad=0.527 pd=4.02 as=0.2805 ps=2.03 w=1.7 l=0.15
X836 vdd a_26387_11933# a_27157_11105# vdd sky130_fd_pr__pfet_01v8 ad=1.085 pd=7.62 as=0.5775 ps=3.83 w=3.5 l=0.15
X837 a_323_6880# in vdd vdd sky130_fd_pr__pfet_01v8_lvt ad=0.203 pd=1.69 as=0.406 ps=3.38 w=1.4 l=0.35
X838 a_6063_6810# a_5993_6784# vdd vdd sky130_fd_pr__pfet_01v8_lvt ad=0.3045 pd=2.39 as=0.3045 ps=2.39 w=2.1 l=0.35
X839 a_29702_7094# a_29868_8794# vdd vdd sky130_fd_pr__pfet_01v8 ad=0.2376 pd=1.77 as=0.4464 ps=3.5 w=1.44 l=0.15
X840 a_20555_3741# f2 a_13102_2574# vdd sky130_fd_pr__pfet_01v8_lvt ad=0.609 pd=4.78 as=0.609 ps=4.78 w=2.1 l=0.35
X841 a_18105_12784# a_21927_11686# a_28197_13560# vss sky130_fd_pr__nfet_01v8_lvt ad=0.62 pd=4.62 as=0.33 ps=2.33 w=2 l=0.15
X842 a_11527_7375# a_12625_1934# a_7935_6810# vdd sky130_fd_pr__pfet_01v8_lvt ad=0.3335 pd=2.59 as=0.667 ps=5.18 w=2.3 l=0.35
X843 a_22437_4220# a_28514_3688# vss sky130_fd_pr__res_high_po_0p69 l=2.2
X844 a_25035_1641# a_24993_1814# a_13268_4274# vss sky130_fd_pr__nfet_01v8_lvt ad=0.1885 pd=1.88 as=0.1885 ps=1.88 w=0.65 l=0.15
X845 a_6227_11933# a_6157_11685# dp vdd sky130_fd_pr__pfet_01v8_lvt ad=0.6583 pd=5.12 as=0.32915 ps=2.56 w=2.27 l=0.35
X846 a_7935_4450# b7 a_15027_4275# vss sky130_fd_pr__nfet_01v8_lvt ad=0.2325 pd=2.12 as=0.12375 ps=1.08 w=0.75 l=0.15
X847 a_20959_3741# f2 a_16602_2574# vdd sky130_fd_pr__pfet_01v8_lvt ad=0.609 pd=4.78 as=0.609 ps=4.78 w=2.1 l=0.35
X848 vss a_21865_11030# vss vss sky130_fd_pr__nfet_01v8_lvt ad=0.1218 pd=1.42 as=0 ps=0 w=0.42 l=0.15
X849 a_15027_8795# b5 a_7935_3850# vss sky130_fd_pr__nfet_01v8_lvt ad=0.12375 pd=1.08 as=0.2325 ps=2.12 w=0.75 l=0.15
X850 vdd a_25439_7929# vdd vdd sky130_fd_pr__pfet_01v8 ad=0.2805 pd=2.03 as=0 ps=0 w=1.7 l=0.15
X851 a_16125_1934# b7 vdd vdd sky130_fd_pr__pfet_01v8 ad=0.261 pd=2.38 as=0.261 ps=2.38 w=0.9 l=0.18
X852 a_25439_1641# a_24993_1814# a_16768_4274# vss sky130_fd_pr__nfet_01v8_lvt ad=0.1885 pd=1.88 as=0.1885 ps=1.88 w=0.65 l=0.15
X853 a_23199_3409# f4 a_16768_4274# vdd sky130_fd_pr__pfet_01v8_lvt ad=0.609 pd=4.78 as=0.609 ps=4.78 w=2.1 l=0.35
X854 a_15825_11602# a_15237_11085# vdd vdd sky130_fd_pr__pfet_01v8_lvt ad=0.174 pd=1.78 as=0.174 ps=1.78 w=0.6 l=0.35
X855 a_30963_7375# a_29868_8794# a_30817_8037# vss sky130_fd_pr__nfet_01v8_lvt ad=0.396 pd=2.73 as=0.744 ps=5.42 w=2.4 l=0.15
X856 vdd a_20555_5509# a_22437_4820# vdd sky130_fd_pr__pfet_01v8 ad=0.527 pd=4.02 as=0.2805 ps=2.03 w=1.7 l=0.15
X857 a_30217_2855# a_29868_2574# a_29868_4274# vss sky130_fd_pr__nfet_01v8_lvt ad=0.396 pd=2.73 as=0.396 ps=2.73 w=2.4 l=0.15
X858 a_12947_11933# rst_n vdd vdd sky130_fd_pr__pfet_01v8 ad=0.464 pd=3.78 as=0.464 ps=3.78 w=1.6 l=0.18
X859 a_6063_8570# a_5993_8453# vdd vdd sky130_fd_pr__pfet_01v8_lvt ad=0.3045 pd=2.39 as=0.3045 ps=2.39 w=2.1 l=0.35
X860 a_6063_6810# a_5993_6784# vss sky130_fd_pr__res_high_po_0p35 l=9.5
X861 a_20555_8261# a_20513_3298# a_13102_7094# vss sky130_fd_pr__nfet_01v8_lvt ad=0.1885 pd=1.88 as=0.1885 ps=1.88 w=0.65 l=0.15
X862 vdd a_323_4520# a_2903_9270# vdd sky130_fd_pr__pfet_01v8_lvt ad=0.1595 pd=1.39 as=0.1595 ps=1.39 w=1.1 l=0.35
X863 a_7935_1490# a4 a_11527_8795# vss sky130_fd_pr__nfet_01v8_lvt ad=0.2325 pd=2.12 as=0.12375 ps=1.08 w=0.75 l=0.15
X864 a_22795_10029# f5 a_16602_7094# vss sky130_fd_pr__nfet_01v8_lvt ad=0.1885 pd=1.88 as=0.1885 ps=1.88 w=0.65 l=0.15
X865 a_16768_8794# a_16768_7094# vss sky130_fd_pr__res_high_po_0p35 l=6.5
X866 a_20959_8261# a_20513_3298# a_16602_7094# vss sky130_fd_pr__nfet_01v8_lvt ad=0.1885 pd=1.88 as=0.1885 ps=1.88 w=0.65 l=0.15
X867 ep a_30963_2855# vdd vdd sky130_fd_pr__pfet_01v8 ad=0.495 pd=3.33 as=0.93 ps=6.62 w=3 l=0.15
X868 vdd a_23199_8261# vdd vdd sky130_fd_pr__pfet_01v8 ad=0.527 pd=4.02 as=0 ps=0 w=1.7 l=0.15
X869 a_21865_11030# a_28197_13560# vdd vdd sky130_fd_pr__pfet_01v8 ad=1.085 pd=7.62 as=0.5775 ps=3.83 w=3.5 l=0.15
X870 ckd1 a_8425_11085# vdd vdd sky130_fd_pr__pfet_01v8 ad=0.93 pd=6.62 as=0.495 ps=3.33 w=3 l=0.15
X871 a_23199_10029# f5 a_13102_7094# vss sky130_fd_pr__nfet_01v8_lvt ad=0.1885 pd=1.88 as=0.1885 ps=1.88 w=0.65 l=0.15
X872 vdd a_6063_9170# a_7935_9170# vdd sky130_fd_pr__pfet_01v8_lvt ad=0.3045 pd=2.39 as=0.3045 ps=2.39 w=2.1 l=0.35
X873 vdd a_25035_10029# a_26917_9340# vdd sky130_fd_pr__pfet_01v8 ad=0.527 pd=4.02 as=0.2805 ps=2.03 w=1.7 l=0.15
X874 dp dn vdd vdd sky130_fd_pr__pfet_01v8 ad=0.3135 pd=2.23 as=0.589 ps=4.42 w=1.9 l=0.15
X875 vdd a_6227_11933# a_6997_11105# vdd sky130_fd_pr__pfet_01v8 ad=1.085 pd=7.62 as=0.5775 ps=3.83 w=3.5 l=0.15
X876 a_10175_11935# a_15825_11602# vdd vdd sky130_fd_pr__pfet_01v8 ad=1.085 pd=7.62 as=0.5775 ps=3.83 w=3.5 l=0.15
X877 vdd a_323_2160# a_3663_2190# vdd sky130_fd_pr__pfet_01v8_lvt ad=0.319 pd=2.78 as=0.1595 ps=1.39 w=1.1 l=0.35
X878 a_7935_2090# a_6063_2090# vdd vdd sky130_fd_pr__pfet_01v8_lvt ad=0.3045 pd=2.39 as=0.609 ps=4.78 w=2.1 l=0.35
X879 a_18105_12784# a_21035_11810# a_28197_13560# vdd sky130_fd_pr__pfet_01v8 ad=1.085 pd=7.62 as=0.5775 ps=3.83 w=3.5 l=0.15
X880 vss a_20959_8261# vss vss sky130_fd_pr__nfet_01v8_lvt ad=0.203 pd=1.98 as=0 ps=0 w=0.7 l=0.15
X881 a_15825_11602# a_7595_11810# a_8819_12702# vdd sky130_fd_pr__pfet_01v8 ad=0.868 pd=6.22 as=0.462 ps=3.13 w=2.8 l=0.15
X882 a_15027_8795# a_15349_1934# a_7935_9170# vdd sky130_fd_pr__pfet_01v8_lvt ad=0.3335 pd=2.59 as=0.667 ps=5.18 w=2.3 l=0.35
X883 a_13268_8794# a_13268_7094# vdd vdd sky130_fd_pr__pfet_01v8 ad=0.462 pd=3.13 as=0.868 ps=6.22 w=2.8 l=0.15
X884 a_3663_9270# a_323_6880# vss vss sky130_fd_pr__nfet_01v8_lvt ad=0.319 pd=2.78 as=0.319 ps=2.78 w=1.1 l=0.15
X885 a_25035_7929# f6 a_16768_8794# vss sky130_fd_pr__nfet_01v8_lvt ad=0.1885 pd=1.88 as=0.1885 ps=1.88 w=0.65 l=0.15
X886 a_20555_7929# f2 a_13268_8794# vdd sky130_fd_pr__pfet_01v8_lvt ad=0.609 pd=4.78 as=0.609 ps=4.78 w=2.1 l=0.35
X887 cke0 a_18105_12784# vdd vdd sky130_fd_pr__pfet_01v8 ad=0.495 pd=3.33 as=0.93 ps=6.62 w=3 l=0.15
X888 a_6997_11105# a_6227_11933# vdd vdd sky130_fd_pr__pfet_01v8 ad=0.5775 pd=3.83 as=1.085 ps=7.62 w=3.5 l=0.15
X889 a_6063_8570# a_5993_8453# vss vss sky130_fd_pr__nfet_01v8_lvt ad=0.1815 pd=1.43 as=0.341 ps=2.82 w=1.1 l=0.15
X890 a_7935_6210# a_6063_6210# vdd vdd sky130_fd_pr__pfet_01v8_lvt ad=0.3045 pd=2.39 as=0.3045 ps=2.39 w=2.1 l=0.35
X891 a_21035_11810# a_21927_11686# vss vss sky130_fd_pr__nfet_01v8_lvt ad=0.1305 pd=1.48 as=0.1305 ps=1.48 w=0.45 l=0.15
X892 a_20959_7929# f2 a_16768_8794# vdd sky130_fd_pr__pfet_01v8_lvt ad=0.609 pd=4.78 as=0.609 ps=4.78 w=2.1 l=0.35
X893 ckd0 ckd2 vdd vdd sky130_fd_pr__pfet_01v8_lvt ad=0.406 pd=3.38 as=0.406 ps=3.38 w=1.4 l=0.35
X894 a_24677_6640# a_28514_6336# vss sky130_fd_pr__res_high_po_0p69 l=2.2
X895 vdd a_5993_2064# a_6063_2090# vdd sky130_fd_pr__pfet_01v8_lvt ad=0.3045 pd=2.39 as=0.3045 ps=2.39 w=2.1 l=0.35
X896 a_12947_11933# a_6157_11685# dn vdd sky130_fd_pr__pfet_01v8_lvt ad=0.32915 pd=2.56 as=0.6583 ps=5.12 w=2.27 l=0.35
X897 a_20197_8740# a_18315_8261# vss vss sky130_fd_pr__nfet_01v8_lvt ad=0.203 pd=1.98 as=0.203 ps=1.98 w=0.7 l=0.15
X898 a_7935_4450# a_15737_1934# a_15027_7375# vdd sky130_fd_pr__pfet_01v8_lvt ad=0.667 pd=5.18 as=0.3335 ps=2.59 w=2.3 l=0.35
X899 a_25035_6161# a_24993_1814# a_16768_8794# vdd sky130_fd_pr__pfet_01v8_lvt ad=0.609 pd=4.78 as=0.609 ps=4.78 w=2.1 l=0.35
X900 a_7935_4450# a_7935_3850# vss vss sky130_fd_pr__nfet_01v8_lvt ad=0.1305 pd=1.48 as=0.1305 ps=1.48 w=0.45 l=0.15
X901 vdd rst_n a_6157_11685# vdd sky130_fd_pr__pfet_01v8_lvt ad=0.29 pd=2.29 as=0.29 ps=2.29 w=2 l=0.35
X902 a_16602_2574# a_16602_4274# vss vss sky130_fd_pr__nfet_01v8_lvt ad=0.2805 pd=2.03 as=0.527 ps=4.02 w=1.7 l=0.15
X903 vss a_8819_12702# a_21137_13560# vss sky130_fd_pr__nfet_01v8_lvt ad=0.465 pd=3.62 as=0.2475 ps=1.83 w=1.5 l=0.15
X904 dn a_6157_11685# a_12947_11933# vdd sky130_fd_pr__pfet_01v8_lvt ad=0.32915 pd=2.56 as=0.32915 ps=2.56 w=2.27 l=0.35
X905 a_15825_11602# a_7035_12870# vdd vdd sky130_fd_pr__pfet_01v8 ad=0.522 pd=4.18 as=0.522 ps=4.18 w=1.8 l=0.18
X906 vdd a_27157_11105# a_21927_11686# vdd sky130_fd_pr__pfet_01v8 ad=0.5775 pd=3.83 as=0.5775 ps=3.83 w=3.5 l=0.15
X907 a_18745_12784# a_18105_12784# vss vss sky130_fd_pr__nfet_01v8_lvt ad=0.1885 pd=1.88 as=0.1885 ps=1.88 w=0.65 l=0.15
X908 a_15027_7375# b3 a_7935_8570# vss sky130_fd_pr__nfet_01v8_lvt ad=0.12375 pd=1.08 as=0.2325 ps=2.12 w=0.75 l=0.15
X909 a_16125_1934# b7 vss vss sky130_fd_pr__nfet_01v8 ad=0.1305 pd=1.48 as=0.1305 ps=1.48 w=0.45 l=0.18
X910 a_26917_8740# a_25035_8261# vdd vdd sky130_fd_pr__pfet_01v8 ad=0.2805 pd=2.03 as=0.527 ps=4.02 w=1.7 l=0.15
X911 a_2903_3950# a_5214_3940# vss sky130_fd_pr__res_high_po_0p69 l=1.5
X912 a_15027_8795# a_16125_1934# a_7935_8570# vdd sky130_fd_pr__pfet_01v8_lvt ad=0.3335 pd=2.59 as=0.667 ps=5.18 w=2.3 l=0.35
X913 a_29702_8794# a_29702_7094# vss sky130_fd_pr__res_high_po_0p35 l=6.5
X914 vss a_6063_4450# a_7935_4450# vss sky130_fd_pr__nfet_01v8_lvt ad=0.527 pd=4.02 as=0.2805 ps=2.03 w=1.7 l=0.15
X915 vdd a_18315_6161# a_20197_6640# vdd sky130_fd_pr__pfet_01v8 ad=0.527 pd=4.02 as=0.2805 ps=2.03 w=1.7 l=0.15
X916 a_20590_13570# a_17855_12810# vss vss sky130_fd_pr__nfet_01v8 ad=0.21 pd=1.7 as=0.413 ps=3.39 w=1.4 l=0.18
X917 vdd a_18719_10029# vdd vdd sky130_fd_pr__pfet_01v8 ad=0.527 pd=4.02 as=0 ps=0 w=1.7 l=0.15
X918 a_18315_7929# a_18273_3298# a_13268_8794# vss sky130_fd_pr__nfet_01v8_lvt ad=0.1885 pd=1.88 as=0.1885 ps=1.88 w=0.65 l=0.15
X919 a_6063_6210# a_5993_6093# vss sky130_fd_pr__res_high_po_0p35 l=9.5
X920 vdd a_18719_1641# vdd vdd sky130_fd_pr__pfet_01v8 ad=0.2805 pd=2.03 as=0 ps=0 w=1.7 l=0.15
X921 a_19667_11933# rst_n ep vss sky130_fd_pr__nfet_01v8_lvt ad=0.2145 pd=1.63 as=0.403 ps=3.22 w=1.3 l=0.15
X922 a_18719_7929# a_18273_3298# a_16768_8794# vss sky130_fd_pr__nfet_01v8_lvt ad=0.1885 pd=1.88 as=0.1885 ps=1.88 w=0.65 l=0.15
X923 a_24677_9340# a_22795_10029# vss vss sky130_fd_pr__nfet_01v8_lvt ad=0.203 pd=1.98 as=0.203 ps=1.98 w=0.7 l=0.15
X924 vdd a_13102_8794# a_13102_7094# vdd sky130_fd_pr__pfet_01v8 ad=0.462 pd=3.13 as=0.462 ps=3.13 w=2.8 l=0.15
X925 a_15027_7375# b7 a_7935_9170# vss sky130_fd_pr__nfet_01v8_lvt ad=0.12375 pd=1.08 as=0.2325 ps=2.12 w=0.75 l=0.15
X926 a_18315_6161# f1 a_13268_8794# vdd sky130_fd_pr__pfet_01v8_lvt ad=0.609 pd=4.78 as=0.609 ps=4.78 w=2.1 l=0.35
X927 a_7935_3850# a_6063_3850# vdd vdd sky130_fd_pr__pfet_01v8_lvt ad=0.3045 pd=2.39 as=0.3045 ps=2.39 w=2.1 l=0.35
X928 a_6063_6210# a_5993_6093# vss vss sky130_fd_pr__nfet_01v8_lvt ad=0.1815 pd=1.43 as=0.341 ps=2.82 w=1.1 l=0.15
X929 a_323_4520# qp vdd vdd sky130_fd_pr__pfet_01v8_lvt ad=0.203 pd=1.69 as=0.203 ps=1.69 w=1.4 l=0.35
X930 vdd vss a_29702_2574# vdd sky130_fd_pr__pfet_01v8 ad=0.589 pd=4.42 as=0.3135 ps=2.23 w=1.9 l=0.15
X931 a_21957_11030# a_20590_13570# a_22217_13560# vss sky130_fd_pr__nfet_01v8_lvt ad=0.2475 pd=1.83 as=0.465 ps=3.62 w=1.5 l=0.15
X932 a_26387_11933# a_6157_11685# en vdd sky130_fd_pr__pfet_01v8_lvt ad=0.32915 pd=2.56 as=0.6583 ps=5.12 w=2.27 l=0.35
X933 vss a_20959_5509# vss vss sky130_fd_pr__nfet_01v8_lvt ad=0.203 pd=1.98 as=0 ps=0 w=0.7 l=0.15
X934 a_25439_8261# f6 a_16602_7094# vdd sky130_fd_pr__pfet_01v8_lvt ad=0.609 pd=4.78 as=0.609 ps=4.78 w=2.1 l=0.35
X935 a_18719_6161# f1 a_16768_8794# vdd sky130_fd_pr__pfet_01v8_lvt ad=0.609 pd=4.78 as=0.609 ps=4.78 w=2.1 l=0.35
X936 a_7035_12870# a_6157_11685# vss vss sky130_fd_pr__nfet_01v8 ad=0.1885 pd=1.88 as=0.1885 ps=1.88 w=0.65 l=0.35
X937 a_8487_11686# a_7595_11810# vss vss sky130_fd_pr__nfet_01v8_lvt ad=0.1305 pd=1.48 as=0.1305 ps=1.48 w=0.45 l=0.15
X938 a_20959_3741# f2 a_13102_2574# vss sky130_fd_pr__nfet_01v8_lvt ad=0.1885 pd=1.88 as=0.1885 ps=1.88 w=0.65 l=0.15
X939 a_10409_12702# a_9105_11602# vdd vdd sky130_fd_pr__pfet_01v8 ad=0.5775 pd=3.83 as=1.085 ps=7.62 w=3.5 l=0.15
X940 vdd a_22795_6161# a_24677_6640# vdd sky130_fd_pr__pfet_01v8 ad=0.527 pd=4.02 as=0.2805 ps=2.03 w=1.7 l=0.15
X941 a_6063_4450# a_5993_4424# vdd vdd sky130_fd_pr__pfet_01v8_lvt ad=0.3045 pd=2.39 as=0.3045 ps=2.39 w=2.1 l=0.35
X942 a_23615_11840# a_21865_11030# vdd vdd sky130_fd_pr__pfet_01v8_lvt ad=0.609 pd=4.78 as=0.609 ps=4.78 w=2.1 l=0.35
X943 a_18315_10029# a_18273_1814# a_13102_7094# vss sky130_fd_pr__nfet_01v8_lvt ad=0.1885 pd=1.88 as=0.1885 ps=1.88 w=0.65 l=0.15
X944 a_7935_4450# b3 a_15027_2855# vss sky130_fd_pr__nfet_01v8_lvt ad=0.2325 pd=2.12 as=0.12375 ps=1.08 w=0.75 l=0.15
X945 vdd vss a_30963_2855# vdd sky130_fd_pr__pfet_01v8 ad=0.2607 pd=1.91 as=0.2607 ps=1.91 w=1.58 l=0.15
X946 a_13102_8794# a_13102_7094# vss sky130_fd_pr__res_high_po_0p35 l=6.5
X947 a_30817_3517# a_29702_2574# a_30963_3945# vss sky130_fd_pr__nfet_01v8_lvt ad=0.396 pd=2.73 as=0.396 ps=2.73 w=2.4 l=0.15
X948 a_22437_4220# a_20555_3741# vdd vdd sky130_fd_pr__pfet_01v8 ad=0.2805 pd=2.03 as=0.527 ps=4.02 w=1.7 l=0.15
X949 vss a_10409_12702# a_22217_13560# vss sky130_fd_pr__nfet_01v8_lvt ad=0.465 pd=3.62 as=0.2475 ps=1.83 w=1.5 l=0.15
X950 a_20197_4820# a_18315_5509# vss vss sky130_fd_pr__nfet_01v8_lvt ad=0.203 pd=1.98 as=0.203 ps=1.98 w=0.7 l=0.15
X951 vss a_6063_2090# a_7935_2090# vss sky130_fd_pr__nfet_01v8_lvt ad=0.527 pd=4.02 as=0.2805 ps=2.03 w=1.7 l=0.15
X952 a_15027_2855# a_15349_1934# a_7935_4450# vdd sky130_fd_pr__pfet_01v8_lvt ad=0.3335 pd=2.59 as=0.667 ps=5.18 w=2.3 l=0.35
X953 vdd a_6997_11105# a_7595_11810# vdd sky130_fd_pr__pfet_01v8 ad=0.5775 pd=3.83 as=0.5775 ps=3.83 w=3.5 l=0.15
X954 vdd a_20959_10029# vdd vdd sky130_fd_pr__pfet_01v8 ad=0.527 pd=4.02 as=0 ps=0 w=1.7 l=0.15
X955 a_13102_2574# a_13102_4274# vdd vdd sky130_fd_pr__pfet_01v8_lvt ad=0.406 pd=3.09 as=0.812 ps=6.18 w=2.8 l=0.35
X956 vdd a_20959_1641# vdd vdd sky130_fd_pr__pfet_01v8 ad=0.2805 pd=2.03 as=0 ps=0 w=1.7 l=0.15
X957 cke1 a_23615_11840# vdd vdd sky130_fd_pr__pfet_01v8_lvt ad=0.87 pd=6.58 as=0.87 ps=6.58 w=3 l=0.35
X958 cke3 cke1 vdd vdd sky130_fd_pr__pfet_01v8_lvt ad=0.406 pd=3.38 as=0.406 ps=3.38 w=1.4 l=0.35
X959 a_10409_12702# a_7595_11810# a_15237_11085# vdd sky130_fd_pr__pfet_01v8 ad=0.868 pd=6.22 as=0.462 ps=3.13 w=2.8 l=0.15
X960 a_27157_11105# a_26387_11933# vdd vdd sky130_fd_pr__pfet_01v8_lvt ad=1.015 pd=7.58 as=1.015 ps=7.58 w=3.5 l=0.35
X961 a_20959_10029# a_20513_1814# a_16602_7094# vss sky130_fd_pr__nfet_01v8_lvt ad=0.1885 pd=1.88 as=0.1885 ps=1.88 w=0.65 l=0.15
X962 a_7935_9170# a_6063_9170# vdd vdd sky130_fd_pr__pfet_01v8_lvt ad=0.3045 pd=2.39 as=0.609 ps=4.78 w=2.1 l=0.35
X963 a_16768_4274# a_16768_2574# vdd vdd sky130_fd_pr__pfet_01v8_lvt ad=0.406 pd=3.09 as=0.812 ps=6.18 w=2.8 l=0.35
X964 a_18315_3741# f0 a_16602_2574# vss sky130_fd_pr__nfet_01v8_lvt ad=0.1885 pd=1.88 as=0.1885 ps=1.88 w=0.65 l=0.15
X965 vdd a_323_6880# a_3663_9270# vdd sky130_fd_pr__pfet_01v8_lvt ad=0.319 pd=2.78 as=0.1595 ps=1.39 w=1.1 l=0.35
X966 a_5993_8453# a_5214_8660# sky130_fd_pr__cap_mim_m3_1 l=4.2 w=4.2
X967 a_23199_6161# f5 a_13268_8794# vss sky130_fd_pr__nfet_01v8_lvt ad=0.1885 pd=1.88 as=0.1885 ps=1.88 w=0.65 l=0.15
X968 a_8517_11085# a_7595_11810# a_8425_11085# vss sky130_fd_pr__nfet_01v8_lvt ad=0.23925 pd=1.78 as=0.4495 ps=3.52 w=1.45 l=0.15
X969 a_18719_1641# f1 a_13268_4274# vss sky130_fd_pr__nfet_01v8_lvt ad=0.1885 pd=1.88 as=0.1885 ps=1.88 w=0.65 l=0.15
X970 a_23199_5509# a_22753_1814# a_13102_2574# vdd sky130_fd_pr__pfet_01v8_lvt ad=0.609 pd=4.78 as=0.609 ps=4.78 w=2.1 l=0.35
X971 a_25439_3741# f6 a_13102_2574# vss sky130_fd_pr__nfet_01v8_lvt ad=0.1885 pd=1.88 as=0.1885 ps=1.88 w=0.65 l=0.15
X972 a_7935_6810# a2 a_11527_8795# vss sky130_fd_pr__nfet_01v8_lvt ad=0.2325 pd=2.12 as=0.12375 ps=1.08 w=0.75 l=0.15
X973 a_20197_9340# a_18315_10029# vdd vdd sky130_fd_pr__pfet_01v8 ad=0.2805 pd=2.03 as=0.527 ps=4.02 w=1.7 l=0.15
X974 a_13102_2574# a_13102_4274# vdd vdd sky130_fd_pr__pfet_01v8 ad=0.462 pd=3.13 as=0.462 ps=3.13 w=2.8 l=0.15
X975 a_30817_3517# vdd vss vss sky130_fd_pr__nfet_01v8 ad=0.17835 pd=1.52 as=0.17835 ps=1.52 w=1.23 l=0.2
X976 vdd a_30963_2855# a_30963_3945# vdd sky130_fd_pr__pfet_01v8 ad=0.2079 pd=1.59 as=0.2079 ps=1.59 w=1.26 l=0.15
X977 vdd a_5993_9144# a_6063_9170# vdd sky130_fd_pr__pfet_01v8_lvt ad=0.3045 pd=2.39 as=0.3045 ps=2.39 w=2.1 l=0.35
X978 vdd a_6063_6210# a_7935_6210# vdd sky130_fd_pr__pfet_01v8_lvt ad=0.3045 pd=2.39 as=0.3045 ps=2.39 w=2.1 l=0.35
X979 a_21927_11686# a_27157_11105# vss vss sky130_fd_pr__nfet_01v8_lvt ad=0.28875 pd=2.08 as=0.5425 ps=4.12 w=1.75 l=0.15
X980 a_15027_2855# a_16125_1934# a_7935_3850# vdd sky130_fd_pr__pfet_01v8_lvt ad=0.3335 pd=2.59 as=0.667 ps=5.18 w=2.3 l=0.35
X981 a_2903_6310# a_323_9240# vdd vdd sky130_fd_pr__pfet_01v8_lvt ad=0.1595 pd=1.39 as=0.1595 ps=1.39 w=1.1 l=0.35
X982 vdd a_25439_10029# vdd vdd sky130_fd_pr__pfet_01v8 ad=0.527 pd=4.02 as=0 ps=0 w=1.7 l=0.15
X983 ep a_30963_2855# vss vss sky130_fd_pr__nfet_01v8_lvt ad=0.3465 pd=2.43 as=0.651 ps=4.82 w=2.1 l=0.15
X984 vdd a_25439_1641# vdd vdd sky130_fd_pr__pfet_01v8 ad=0.2805 pd=2.03 as=0 ps=0 w=1.7 l=0.15
X985 a_6227_11933# a_6157_11685# dp vdd sky130_fd_pr__pfet_01v8_lvt ad=0.32915 pd=2.56 as=0.6583 ps=5.12 w=2.27 l=0.35
X986 a_21865_11030# a_23615_11840# vss vss sky130_fd_pr__nfet_01v8_lvt ad=0.1885 pd=1.88 as=0.1885 ps=1.88 w=0.65 l=0.15
X987 vdd a_13268_2574# a_13268_4274# vdd sky130_fd_pr__pfet_01v8 ad=0.868 pd=6.22 as=0.462 ps=3.13 w=2.8 l=0.15
X988 a_7935_4450# b1 a_15027_8795# vss sky130_fd_pr__nfet_01v8_lvt ad=0.2325 pd=2.12 as=0.12375 ps=1.08 w=0.75 l=0.15
X989 vss a_16768_7094# a_16768_8794# vss sky130_fd_pr__nfet_01v8_lvt ad=0.527 pd=4.02 as=0.2805 ps=2.03 w=1.7 l=0.15
X990 a_8819_12702# a_8517_11085# vss vss sky130_fd_pr__nfet_01v8_lvt ad=0.3135 pd=2.23 as=0.589 ps=4.42 w=1.9 l=0.15
X991 a_18719_10029# a_18273_1814# a_13102_7094# vdd sky130_fd_pr__pfet_01v8_lvt ad=0.609 pd=4.78 as=0.609 ps=4.78 w=2.1 l=0.35
X992 a_25035_6161# f7 a_13268_8794# vdd sky130_fd_pr__pfet_01v8_lvt ad=0.609 pd=4.78 as=0.609 ps=4.78 w=2.1 l=0.35
X993 a_25035_5509# a_24993_1814# a_13102_2574# vss sky130_fd_pr__nfet_01v8_lvt ad=0.1885 pd=1.88 as=0.1885 ps=1.88 w=0.65 l=0.15
X994 a_22795_1641# a_22753_1814# a_16768_4274# vdd sky130_fd_pr__pfet_01v8_lvt ad=0.609 pd=4.78 as=0.609 ps=4.78 w=2.1 l=0.35
X995 a_20555_3741# f2 a_16602_2574# vss sky130_fd_pr__nfet_01v8_lvt ad=0.1885 pd=1.88 as=0.1885 ps=1.88 w=0.65 l=0.15
X996 vdd a_7035_12870# a_7587_12850# vdd sky130_fd_pr__pfet_01v8_lvt ad=0.261 pd=2.09 as=0.261 ps=2.09 w=1.8 l=0.35
X997 a_25439_5509# a_24993_1814# a_16602_2574# vss sky130_fd_pr__nfet_01v8_lvt ad=0.1885 pd=1.88 as=0.1885 ps=1.88 w=0.65 l=0.15
X998 vdd a_30963_2855# ep vdd sky130_fd_pr__pfet_01v8_lvt ad=0.812 pd=6.18 as=0.406 ps=3.09 w=2.8 l=0.35
X999 a_3663_6910# a_323_4520# vss vss sky130_fd_pr__nfet_01v8_lvt ad=0.319 pd=2.78 as=0.319 ps=2.78 w=1.1 l=0.15
X1000 a_24677_9340# a_22795_10029# vdd vdd sky130_fd_pr__pfet_01v8 ad=0.2805 pd=2.03 as=0.527 ps=4.02 w=1.7 l=0.15
X1001 vss vdd a_30817_8037# vss sky130_fd_pr__nfet_01v8 ad=0.3567 pd=3.04 as=0.17835 ps=1.52 w=1.23 l=0.2
X1002 a_15027_8795# a_14961_1934# a_7935_4450# vdd sky130_fd_pr__pfet_01v8_lvt ad=0.3335 pd=2.59 as=0.667 ps=5.18 w=2.3 l=0.35
X1003 a_13102_8794# a_11527_8795# sky130_fd_pr__cap_mim_m3_1 l=4.2 w=4.3
X1004 a_30817_3517# a_29868_4274# a_30963_2855# vss sky130_fd_pr__nfet_01v8_lvt ad=0.396 pd=2.73 as=0.396 ps=2.73 w=2.4 l=0.15
X1005 a_20197_4220# a_28514_3688# vss sky130_fd_pr__res_high_po_0p69 l=2.2
X1006 ckd2 a_10409_12702# vdd vdd sky130_fd_pr__pfet_01v8 ad=0.495 pd=3.33 as=0.93 ps=6.62 w=3 l=0.15
X1007 vdd a_23199_7929# vdd vdd sky130_fd_pr__pfet_01v8 ad=0.2805 pd=2.03 as=0 ps=0 w=1.7 l=0.15
X1008 a_15027_2855# b1 a_7935_8570# vss sky130_fd_pr__nfet_01v8_lvt ad=0.12375 pd=1.08 as=0.2325 ps=2.12 w=0.75 l=0.15
X1009 a_23199_1641# a_22753_1814# a_16768_4274# vss sky130_fd_pr__nfet_01v8_lvt ad=0.1885 pd=1.88 as=0.1885 ps=1.88 w=0.65 l=0.15
X1010 a_17855_12810# a_10409_12702# a_18175_13625# vss sky130_fd_pr__nfet_01v8 ad=0.2465 pd=2.28 as=0.2465 ps=2.28 w=0.85 l=0.35
X1011 a_6997_11105# a_6227_11933# vdd vdd sky130_fd_pr__pfet_01v8_lvt ad=1.015 pd=7.58 as=1.015 ps=7.58 w=3.5 l=0.35
X1012 a_22795_6161# f5 a_16768_8794# vss sky130_fd_pr__nfet_01v8_lvt ad=0.1885 pd=1.88 as=0.1885 ps=1.88 w=0.65 l=0.15
X1013 a_15027_4275# a_15737_1934# a_7935_8570# vdd sky130_fd_pr__pfet_01v8_lvt ad=0.3335 pd=2.59 as=0.667 ps=5.18 w=2.3 l=0.35
X1014 a_323_4520# vss sky130_fd_pr__cap_mim_m3_1 l=1.75 w=1.75
X1015 a_15237_11085# a_15825_11602# vdd vdd sky130_fd_pr__pfet_01v8_lvt ad=0.174 pd=1.78 as=0.174 ps=1.78 w=0.6 l=0.35
X1016 a_3663_6310# a_323_9240# vdd vdd sky130_fd_pr__pfet_01v8_lvt ad=0.1595 pd=1.39 as=0.319 ps=2.78 w=1.1 l=0.35
X1017 vdd a_6063_3850# a_7935_3850# vdd sky130_fd_pr__pfet_01v8_lvt ad=0.3045 pd=2.39 as=0.3045 ps=2.39 w=2.1 l=0.35
X1018 vdd a_18315_5509# a_20197_4820# vdd sky130_fd_pr__pfet_01v8 ad=0.527 pd=4.02 as=0.2805 ps=2.03 w=1.7 l=0.15
X1019 a_24677_4220# a_28514_3688# vss sky130_fd_pr__res_high_po_0p69 l=2.2
X1020 a_26917_7240# a_28514_6336# vss sky130_fd_pr__res_high_po_0p69 l=2.2
X1021 dn a_30963_8465# vdd vdd sky130_fd_pr__pfet_01v8 ad=0.495 pd=3.33 as=0.495 ps=3.33 w=3 l=0.15
X1022 vdd vss a_30963_7375# vdd sky130_fd_pr__pfet_01v8 ad=0.4898 pd=3.78 as=0.2607 ps=1.91 w=1.58 l=0.15
X1023 a_2903_3950# a_323_6880# vdd vdd sky130_fd_pr__pfet_01v8_lvt ad=0.1595 pd=1.39 as=0.1595 ps=1.39 w=1.1 l=0.35
X1024 a_20555_3409# a_20513_3298# a_13268_4274# vss sky130_fd_pr__nfet_01v8_lvt ad=0.1885 pd=1.88 as=0.1885 ps=1.88 w=0.65 l=0.15
X1025 vdd a_25035_3741# a_26917_4220# vdd sky130_fd_pr__pfet_01v8 ad=0.527 pd=4.02 as=0.2805 ps=2.03 w=1.7 l=0.15
X1026 a_22795_3741# f4 a_13102_2574# vdd sky130_fd_pr__pfet_01v8_lvt ad=0.609 pd=4.78 as=0.609 ps=4.78 w=2.1 l=0.35
X1027 a_7595_11810# a_6997_11105# vss vss sky130_fd_pr__nfet_01v8_lvt ad=0.28875 pd=2.08 as=0.5425 ps=4.12 w=1.75 l=0.15
X1028 a_2903_8670# a_5214_8660# vss sky130_fd_pr__res_high_po_0p69 l=1.5
X1029 a_14528_205# a7 vdd vdd sky130_fd_pr__pfet_01v8 ad=0.261 pd=2.38 as=0.261 ps=2.38 w=0.9 l=0.18
X1030 a_16768_4274# a_16768_2574# vdd vdd sky130_fd_pr__pfet_01v8 ad=0.462 pd=3.13 as=0.868 ps=6.22 w=2.8 l=0.15
X1031 a_20959_3409# a_20513_3298# a_16768_4274# vss sky130_fd_pr__nfet_01v8_lvt ad=0.1885 pd=1.88 as=0.1885 ps=1.88 w=0.65 l=0.15
X1032 vss a_6063_9170# a_7935_9170# vss sky130_fd_pr__nfet_01v8_lvt ad=0.527 pd=4.02 as=0.2805 ps=2.03 w=1.7 l=0.15
X1033 a_23199_10029# f5 a_16602_7094# vdd sky130_fd_pr__pfet_01v8_lvt ad=0.609 pd=4.78 as=0.609 ps=4.78 w=2.1 l=0.35
X1034 a_15027_2855# b5 a_7935_9170# vss sky130_fd_pr__nfet_01v8_lvt ad=0.12375 pd=1.08 as=0.2325 ps=2.12 w=0.75 l=0.15
X1035 a_7935_1490# a0 a_11527_7375# vss sky130_fd_pr__nfet_01v8_lvt ad=0.2325 pd=2.12 as=0.12375 ps=1.08 w=0.75 l=0.15
X1036 vdd a_20555_7929# a_22437_7240# vdd sky130_fd_pr__pfet_01v8 ad=0.527 pd=4.02 as=0.2805 ps=2.03 w=1.7 l=0.15
X1037 vdd a_30963_7375# dp vdd sky130_fd_pr__pfet_01v8 ad=0.495 pd=3.33 as=0.495 ps=3.33 w=3 l=0.15
X1038 a_13717_11105# a_12947_11933# vss vss sky130_fd_pr__nfet_01v8_lvt ad=0.20625 pd=1.58 as=0.3875 ps=3.12 w=1.25 l=0.15
X1039 a_21477_13560# a_21957_11030# vss vss sky130_fd_pr__nfet_01v8 ad=0.174 pd=1.78 as=0.174 ps=1.78 w=0.6 l=0.28
X1040 a_25439_3409# f6 a_16768_4274# vdd sky130_fd_pr__pfet_01v8_lvt ad=0.609 pd=4.78 as=0.609 ps=4.78 w=2.1 l=0.35
X1041 cke0 cke2 vss vss sky130_fd_pr__nfet_01v8_lvt ad=0.1305 pd=1.48 as=0.1305 ps=1.48 w=0.45 l=0.15
X1042 ckd3 ckd1 vdd vdd sky130_fd_pr__pfet_01v8_lvt ad=0.406 pd=3.38 as=0.406 ps=3.38 w=1.4 l=0.35
X1043 vdd a_18105_12784# cke0 vdd sky130_fd_pr__pfet_01v8 ad=0.495 pd=3.33 as=0.495 ps=3.33 w=3 l=0.15
X1044 cke0 a_18105_12784# vdd vdd sky130_fd_pr__pfet_01v8_lvt ad=0.87 pd=6.58 as=0.87 ps=6.58 w=3 l=0.35
X1045 a_7935_1490# a_6063_1490# vdd vdd sky130_fd_pr__pfet_01v8_lvt ad=0.3045 pd=2.39 as=0.3045 ps=2.39 w=2.1 l=0.35
X1046 vdd a_22795_5509# a_24677_4820# vdd sky130_fd_pr__pfet_01v8 ad=0.527 pd=4.02 as=0.2805 ps=2.03 w=1.7 l=0.15
X1047 a_323_2160# ip vdd vdd sky130_fd_pr__pfet_01v8_lvt ad=0.203 pd=1.69 as=0.203 ps=1.69 w=1.4 l=0.35
X1048 a_7935_6810# a4 a_11527_2855# vss sky130_fd_pr__nfet_01v8_lvt ad=0.2325 pd=2.12 as=0.12375 ps=1.08 w=0.75 l=0.15
X1049 a_20555_5509# f3 a_13102_2574# vdd sky130_fd_pr__pfet_01v8_lvt ad=0.609 pd=4.78 as=0.609 ps=4.78 w=2.1 l=0.35
X1050 a_29097_13560# a_28197_13560# vdd vdd sky130_fd_pr__pfet_01v8_lvt ad=0.174 pd=1.78 as=0.174 ps=1.78 w=0.6 l=0.35
X1051 a_22795_8261# a_22753_3298# a_13102_7094# vss sky130_fd_pr__nfet_01v8_lvt ad=0.1885 pd=1.88 as=0.1885 ps=1.88 w=0.65 l=0.15
X1052 a_24677_9340# a_28514_8208# vss sky130_fd_pr__res_high_po_0p69 l=2.2
X1053 vdd a_30963_7375# a_30963_8465# vdd sky130_fd_pr__pfet_01v8 ad=0.3906 pd=3.14 as=0.2079 ps=1.59 w=1.26 l=0.15
X1054 a_10175_11935# a_15825_11602# vdd vdd sky130_fd_pr__pfet_01v8_lvt ad=1.015 pd=7.58 as=1.015 ps=7.58 w=3.5 l=0.35
X1055 vss a_20959_7929# vss vss sky130_fd_pr__nfet_01v8_lvt ad=0.203 pd=1.98 as=0 ps=0 w=0.7 l=0.15
X1056 vdd dn dp vdd sky130_fd_pr__pfet_01v8 ad=0.589 pd=4.42 as=0.3135 ps=2.23 w=1.9 l=0.15
X1057 a_7935_2090# a6 a_11527_4275# vss sky130_fd_pr__nfet_01v8_lvt ad=0.2325 pd=2.12 as=0.12375 ps=1.08 w=0.75 l=0.15
X1058 a_20959_5509# f3 a_16602_2574# vdd sky130_fd_pr__pfet_01v8_lvt ad=0.609 pd=4.78 as=0.609 ps=4.78 w=2.1 l=0.35
X1059 a_3663_6310# a_5214_6300# vss sky130_fd_pr__res_high_po_0p69 l=1.5
X1060 a_3663_3950# a_323_9240# vdd vdd sky130_fd_pr__pfet_01v8_lvt ad=0.1595 pd=1.39 as=0.319 ps=2.78 w=1.1 l=0.35
X1061 a_30217_2855# vdd vss vss sky130_fd_pr__nfet_01v8 ad=0.16675 pd=1.44 as=0.3335 ps=2.88 w=1.15 l=0.2
X1062 a_30817_8037# vdd vss vss sky130_fd_pr__nfet_01v8 ad=0.17835 pd=1.52 as=0.3567 ps=3.04 w=1.23 l=0.2
X1063 a_6063_2090# a_5993_2064# vdd vdd sky130_fd_pr__pfet_01v8_lvt ad=0.3045 pd=2.39 as=0.3045 ps=2.39 w=2.1 l=0.35
X1064 a_5993_6093# a_5214_6300# sky130_fd_pr__cap_mim_m3_1 l=4.2 w=4.2
X1065 vdd a_6063_6210# a_7935_6210# vdd sky130_fd_pr__pfet_01v8_lvt ad=0.609 pd=4.78 as=0.3045 ps=2.39 w=2.1 l=0.35
X1066 a_11527_7375# a_12237_1934# a_7935_2090# vdd sky130_fd_pr__pfet_01v8_lvt ad=0.3335 pd=2.59 as=0.667 ps=5.18 w=2.3 l=0.35
X1067 a_22437_6640# a_20555_6161# vdd vdd sky130_fd_pr__pfet_01v8 ad=0.2805 pd=2.03 as=0.527 ps=4.02 w=1.7 l=0.15
X1068 a_20197_7240# a_18315_7929# vss vss sky130_fd_pr__nfet_01v8_lvt ad=0.203 pd=1.98 as=0.203 ps=1.98 w=0.7 l=0.15
X1069 a_30963_3945# a_29702_2574# a_30817_3517# vss sky130_fd_pr__nfet_01v8_lvt ad=0.744 pd=5.42 as=0.396 ps=2.73 w=2.4 l=0.15
X1070 a_22437_2120# a_28514_1816# vss sky130_fd_pr__res_high_po_0p69 l=2.2
X1071 vdd a_18719_3741# vdd vdd sky130_fd_pr__pfet_01v8 ad=0.527 pd=4.02 as=0 ps=0 w=1.7 l=0.15
X1072 a_6157_11685# rst_n vdd vdd sky130_fd_pr__pfet_01v8_lvt ad=0.58 pd=4.58 as=0.29 ps=2.29 w=2 l=0.35
X1073 a_15027_2855# a_14961_1934# a_7935_8570# vdd sky130_fd_pr__pfet_01v8_lvt ad=0.3335 pd=2.59 as=0.667 ps=5.18 w=2.3 l=0.35
X1074 vss a_8425_11085# vss vss sky130_fd_pr__nfet_01v8 ad=0.2465 pd=2.28 as=0 ps=0 w=0.85 l=0.35
X1075 vss a_17855_12810# a_20590_13570# vss sky130_fd_pr__nfet_01v8 ad=0.413 pd=3.39 as=0.21 ps=1.7 w=1.4 l=0.18
X1076 a_27157_11105# a_26387_11933# vss vss sky130_fd_pr__nfet_01v8_lvt ad=0.20625 pd=1.58 as=0.3875 ps=3.12 w=1.25 l=0.15
X1077 a_15027_8795# b3 a_7935_9170# vss sky130_fd_pr__nfet_01v8_lvt ad=0.12375 pd=1.08 as=0.2325 ps=2.12 w=0.75 l=0.15
X1078 vdd a_16602_4274# a_16602_2574# vdd sky130_fd_pr__pfet_01v8 ad=0.462 pd=3.13 as=0.462 ps=3.13 w=2.8 l=0.15
X1079 ep rst_n a_19667_11933# vss sky130_fd_pr__nfet_01v8_lvt ad=0.403 pd=3.22 as=0.2145 ps=1.63 w=1.3 l=0.15
X1080 vss a_23199_8261# vss vss sky130_fd_pr__nfet_01v8_lvt ad=0.203 pd=1.98 as=0 ps=0 w=0.7 l=0.15
X1081 a_22795_7929# f4 a_13268_8794# vdd sky130_fd_pr__pfet_01v8_lvt ad=0.609 pd=4.78 as=0.609 ps=4.78 w=2.1 l=0.35
X1082 vss vdd a_30217_7375# vss sky130_fd_pr__nfet_01v8 ad=0.16675 pd=1.44 as=0.16675 ps=1.44 w=1.15 l=0.2
X1083 a_26917_2120# a_28514_1816# vss sky130_fd_pr__res_high_po_0p69 l=2.2
X1084 a_22217_13560# a_20590_13570# a_21957_11030# vss sky130_fd_pr__nfet_01v8_lvt ad=0.465 pd=3.62 as=0.2475 ps=1.83 w=1.5 l=0.15
X1085 a_20590_13570# a_17855_12810# vdd vdd sky130_fd_pr__pfet_01v8_lvt ad=0.58 pd=4.58 as=0.58 ps=4.58 w=2 l=0.35
X1086 a_29868_4274# vss vdd vdd sky130_fd_pr__pfet_01v8 ad=0.3135 pd=2.23 as=0.589 ps=4.42 w=1.9 l=0.15
X1087 a_7935_9170# a_7935_8570# vss vss sky130_fd_pr__nfet_01v8_lvt ad=0.1305 pd=1.48 as=0.1305 ps=1.48 w=0.45 l=0.15
X1088 a_22437_8740# a_20555_8261# vss vss sky130_fd_pr__nfet_01v8_lvt ad=0.203 pd=1.98 as=0.203 ps=1.98 w=0.7 l=0.15
X1089 a_3663_3950# a_5214_3940# vss sky130_fd_pr__res_high_po_0p69 l=1.5
X1090 a_14528_205# a7 vss vss sky130_fd_pr__nfet_01v8 ad=0.1305 pd=1.48 as=0.1305 ps=1.48 w=0.45 l=0.18
X1091 a_15027_8795# b7 a_7935_8570# vss sky130_fd_pr__nfet_01v8_lvt ad=0.12375 pd=1.08 as=0.2325 ps=2.12 w=0.75 l=0.15
X1092 a_30217_7375# vdd vss vss sky130_fd_pr__nfet_01v8 ad=0.16675 pd=1.44 as=0.16675 ps=1.44 w=1.15 l=0.2
X1093 vss a_5993_2064# a_6063_2090# vss sky130_fd_pr__nfet_01v8_lvt ad=0.341 pd=2.82 as=0.1815 ps=1.43 w=1.1 l=0.15
X1094 a_9105_11602# a_8517_11085# vdd vdd sky130_fd_pr__pfet_01v8_lvt ad=0.174 pd=1.78 as=0.174 ps=1.78 w=0.6 l=0.35
X1095 vdd a_9105_11602# a_10409_12702# vdd sky130_fd_pr__pfet_01v8 ad=0.5775 pd=3.83 as=0.5775 ps=3.83 w=3.5 l=0.15
X1096 a_21957_11030# a_21477_13560# vdd vdd sky130_fd_pr__pfet_01v8_lvt ad=0.174 pd=1.78 as=0.174 ps=1.78 w=0.6 l=0.35
X1097 vdd a_20959_3741# vdd vdd sky130_fd_pr__pfet_01v8 ad=0.527 pd=4.02 as=0 ps=0 w=1.7 l=0.15
X1098 a_8517_11085# a_9105_11602# vdd vdd sky130_fd_pr__pfet_01v8_lvt ad=0.174 pd=1.78 as=0.174 ps=1.78 w=0.6 l=0.35
X1099 a_11527_8795# a_11849_1934# a_7935_6810# vdd sky130_fd_pr__pfet_01v8_lvt ad=0.3335 pd=2.59 as=0.667 ps=5.18 w=2.3 l=0.35
X1100 a_29097_13560# a_7035_12870# vdd vdd sky130_fd_pr__pfet_01v8 ad=0.522 pd=4.18 as=0.522 ps=4.18 w=1.8 l=0.18
X1101 a_7935_6810# a_6063_6810# vdd vdd sky130_fd_pr__pfet_01v8_lvt ad=0.3045 pd=2.39 as=0.3045 ps=2.39 w=2.1 l=0.35
X1102 a_7935_6810# a_7935_6210# vdd vdd sky130_fd_pr__pfet_01v8_lvt ad=0.609 pd=4.78 as=0.609 ps=4.78 w=2.1 l=0.35
X1103 a_16768_8794# a_16768_7094# vdd vdd sky130_fd_pr__pfet_01v8 ad=0.462 pd=3.13 as=0.462 ps=3.13 w=2.8 l=0.15
X1104 vdd a_6063_3850# a_7935_3850# vdd sky130_fd_pr__pfet_01v8_lvt ad=0.609 pd=4.78 as=0.3045 ps=2.39 w=2.1 l=0.35
X1105 vdd vss a_30963_3945# vdd sky130_fd_pr__pfet_01v8 ad=0.2607 pd=1.91 as=0.2607 ps=1.91 w=1.58 l=0.15
X1106 a_22795_8261# a_22753_3298# a_16602_7094# vdd sky130_fd_pr__pfet_01v8_lvt ad=0.609 pd=4.78 as=0.609 ps=4.78 w=2.1 l=0.35
X1107 a_25035_7929# a_24993_3298# a_13268_8794# vss sky130_fd_pr__nfet_01v8_lvt ad=0.1885 pd=1.88 as=0.1885 ps=1.88 w=0.65 l=0.15
X1108 a_29702_2574# a_29702_4274# a_30217_2855# vss sky130_fd_pr__nfet_01v8_lvt ad=0.396 pd=2.73 as=0.744 ps=5.42 w=2.4 l=0.15
X1109 a_20959_1641# a_20513_1814# a_13268_4274# vdd sky130_fd_pr__pfet_01v8_lvt ad=0.609 pd=4.78 as=0.609 ps=4.78 w=2.1 l=0.35
X1110 vdd a_23615_11840# vdd vdd sky130_fd_pr__pfet_01v8_lvt ad=0.638 pd=4.98 as=0 ps=0 w=2.2 l=0.35
X1111 a_22437_7240# a_28514_6336# vss sky130_fd_pr__res_high_po_0p69 l=2.2
X1112 a_3663_4550# a_323_4520# vss vss sky130_fd_pr__nfet_01v8_lvt ad=0.319 pd=2.78 as=0.319 ps=2.78 w=1.1 l=0.15
X1113 a_18367_12810# a_18745_12784# vdd vdd sky130_fd_pr__pfet_01v8_lvt ad=0.638 pd=4.98 as=0.638 ps=4.98 w=2.2 l=0.35
X1114 a_25439_7929# a_24993_3298# a_16768_8794# vss sky130_fd_pr__nfet_01v8_lvt ad=0.1885 pd=1.88 as=0.1885 ps=1.88 w=0.65 l=0.15
X1115 a_13102_2574# a_13102_4274# vss vss sky130_fd_pr__nfet_01v8_lvt ad=0.2805 pd=2.03 as=0.527 ps=4.02 w=1.7 l=0.15
X1116 a_20197_4220# a_18315_3741# vdd vdd sky130_fd_pr__pfet_01v8 ad=0.2805 pd=2.03 as=0.527 ps=4.02 w=1.7 l=0.15
X1117 a_8425_11085# a_7595_11810# a_8517_11085# vss sky130_fd_pr__nfet_01v8_lvt ad=0.4495 pd=3.52 as=0.23925 ps=1.78 w=1.45 l=0.15
X1118 a_11527_7375# a2 a_7935_6210# vss sky130_fd_pr__nfet_01v8_lvt ad=0.12375 pd=1.08 as=0.2325 ps=2.12 w=0.75 l=0.15
X1119 cke1 cke3 vss vss sky130_fd_pr__nfet_01v8_lvt ad=0.1305 pd=1.48 as=0.1305 ps=1.48 w=0.45 l=0.15
X1120 a_26917_8740# a_25035_8261# vss vss sky130_fd_pr__nfet_01v8_lvt ad=0.203 pd=1.98 as=0.203 ps=1.98 w=0.7 l=0.15
X1121 a_20513_1814# f3 vdd vdd sky130_fd_pr__pfet_01v8 ad=0.261 pd=2.38 as=0.261 ps=2.38 w=0.9 l=0.18
X1122 a_13102_4274# a_11527_4275# sky130_fd_pr__cap_mim_m3_1 l=4.2 w=4.3
X1123 a_30963_2855# a_29868_4274# a_30817_3517# vss sky130_fd_pr__nfet_01v8_lvt ad=0.744 pd=5.42 as=0.396 ps=2.73 w=2.4 l=0.15
X1124 a_21035_11810# a_20437_11105# vdd vdd sky130_fd_pr__pfet_01v8 ad=0.5775 pd=3.83 as=1.085 ps=7.62 w=3.5 l=0.15
X1125 a_10175_11935# a_15825_11602# vss vss sky130_fd_pr__nfet_01v8_lvt ad=0.3135 pd=2.23 as=0.589 ps=4.42 w=1.9 l=0.15
X1126 a_11527_8795# a_12625_1934# a_7935_6210# vdd sky130_fd_pr__pfet_01v8_lvt ad=0.3335 pd=2.59 as=0.667 ps=5.18 w=2.3 l=0.35
X1127 a_7935_8570# a_6063_8570# vdd vdd sky130_fd_pr__pfet_01v8_lvt ad=0.3045 pd=2.39 as=0.3045 ps=2.39 w=2.1 l=0.35
X1128 vdd a_10175_11935# vdd vdd sky130_fd_pr__pfet_01v8_lvt ad=0.638 pd=4.98 as=0 ps=0 w=2.2 l=0.35
X1129 a_323_9240# qn vdd vdd sky130_fd_pr__pfet_01v8_lvt ad=0.203 pd=1.69 as=0.203 ps=1.69 w=1.4 l=0.35
X1130 a_18719_5509# f1 a_13102_2574# vss sky130_fd_pr__nfet_01v8_lvt ad=0.1885 pd=1.88 as=0.1885 ps=1.88 w=0.65 l=0.15
X1131 en a_30963_3945# vss vss sky130_fd_pr__nfet_01v8_lvt ad=0.3465 pd=2.43 as=0.651 ps=4.82 w=2.1 l=0.15
X1132 vdd a_6063_1490# a_7935_1490# vdd sky130_fd_pr__pfet_01v8_lvt ad=0.3045 pd=2.39 as=0.3045 ps=2.39 w=2.1 l=0.35
X1133 a_18315_1641# a_18273_1814# a_16768_4274# vdd sky130_fd_pr__pfet_01v8_lvt ad=0.609 pd=4.78 as=0.609 ps=4.78 w=2.1 l=0.35
X1134 a_25035_3741# a_24993_3298# a_16602_2574# vdd sky130_fd_pr__pfet_01v8_lvt ad=0.609 pd=4.78 as=0.609 ps=4.78 w=2.1 l=0.35
X1135 vdd a_25439_3741# vdd vdd sky130_fd_pr__pfet_01v8 ad=0.527 pd=4.02 as=0 ps=0 w=1.7 l=0.15
X1136 vdd a_13102_8794# a_13102_7094# vdd sky130_fd_pr__pfet_01v8_lvt ad=0.812 pd=6.18 as=0.406 ps=3.09 w=2.8 l=0.35
X1137 a_7935_8570# a_15349_1934# a_15027_7375# vdd sky130_fd_pr__pfet_01v8_lvt ad=0.667 pd=5.18 as=0.3335 ps=2.59 w=2.3 l=0.35
X1138 a_20959_6161# f3 a_13268_8794# vss sky130_fd_pr__nfet_01v8_lvt ad=0.1885 pd=1.88 as=0.1885 ps=1.88 w=0.65 l=0.15
X1139 vdd a_30963_8465# a_30963_7375# vdd sky130_fd_pr__pfet_01v8 ad=0.2079 pd=1.59 as=0.2079 ps=1.59 w=1.26 l=0.15
X1140 vss a_23199_5509# vss vss sky130_fd_pr__nfet_01v8_lvt ad=0.203 pd=1.98 as=0 ps=0 w=0.7 l=0.15
X1141 a_8819_12702# a_8487_11686# a_15825_11602# vss sky130_fd_pr__nfet_01v8_lvt ad=0.23925 pd=1.78 as=0.4495 ps=3.52 w=1.45 l=0.15
X1142 a_26917_9340# a_25035_10029# vss vss sky130_fd_pr__nfet_01v8_lvt ad=0.203 pd=1.98 as=0.203 ps=1.98 w=0.7 l=0.15
X1143 vdd a_16768_7094# a_16768_8794# vdd sky130_fd_pr__pfet_01v8_lvt ad=0.812 pd=6.18 as=0.406 ps=3.09 w=2.8 l=0.35
X1144 vdd qp a_323_4520# vdd sky130_fd_pr__pfet_01v8_lvt ad=0.203 pd=1.69 as=0.203 ps=1.69 w=1.4 l=0.35
X1145 a_2903_1590# a_323_6880# vdd vdd sky130_fd_pr__pfet_01v8_lvt ad=0.1595 pd=1.39 as=0.1595 ps=1.39 w=1.1 l=0.35
X1146 a_25439_1641# a_24993_1814# a_13268_4274# vdd sky130_fd_pr__pfet_01v8_lvt ad=0.609 pd=4.78 as=0.609 ps=4.78 w=2.1 l=0.35
X1147 a_6063_9170# a_5993_9144# vdd vdd sky130_fd_pr__pfet_01v8_lvt ad=0.3045 pd=2.39 as=0.3045 ps=2.39 w=2.1 l=0.35
X1148 vdd a_25035_6161# a_26917_6640# vdd sky130_fd_pr__pfet_01v8 ad=0.527 pd=4.02 as=0.2805 ps=2.03 w=1.7 l=0.15
X1149 vdd a_30963_3945# en vdd sky130_fd_pr__pfet_01v8 ad=0.495 pd=3.33 as=0.495 ps=3.33 w=3 l=0.15
X1150 vdd a_18719_3409# vdd vdd sky130_fd_pr__pfet_01v8 ad=0.2805 pd=2.03 as=0 ps=0 w=1.7 l=0.15
X1151 vdd a_30963_8465# dn vdd sky130_fd_pr__pfet_01v8 ad=0.93 pd=6.62 as=0.495 ps=3.33 w=3 l=0.15
X1152 vss a_8517_11085# a_8819_12702# vss sky130_fd_pr__nfet_01v8_lvt ad=0.589 pd=4.42 as=0.3135 ps=2.23 w=1.9 l=0.15
X1153 vss a_6063_6810# a_7935_6810# vss sky130_fd_pr__nfet_01v8_lvt ad=0.527 pd=4.02 as=0.2805 ps=2.03 w=1.7 l=0.15
X1154 a_11527_7375# a6 a_7935_6810# vss sky130_fd_pr__nfet_01v8_lvt ad=0.12375 pd=1.08 as=0.2325 ps=2.12 w=0.75 l=0.15
X1155 a_7935_4450# a_7935_3850# vdd vdd sky130_fd_pr__pfet_01v8_lvt ad=0.609 pd=4.78 as=0.609 ps=4.78 w=2.1 l=0.35
X1156 a_24677_4220# a_22795_3741# vdd vdd sky130_fd_pr__pfet_01v8 ad=0.2805 pd=2.03 as=0.527 ps=4.02 w=1.7 l=0.15
X1157 a_18105_12784# a_21477_13560# vdd vdd sky130_fd_pr__pfet_01v8 ad=0.5775 pd=3.83 as=1.085 ps=7.62 w=3.5 l=0.15
X1158 a_18315_6161# f1 a_16768_8794# vss sky130_fd_pr__nfet_01v8_lvt ad=0.1885 pd=1.88 as=0.1885 ps=1.88 w=0.65 l=0.15
X1159 dn a_30963_8465# vdd vdd sky130_fd_pr__pfet_01v8_lvt ad=0.406 pd=3.09 as=0.812 ps=6.18 w=2.8 l=0.35
X1160 a_22437_4820# a_20555_5509# vss vss sky130_fd_pr__nfet_01v8_lvt ad=0.203 pd=1.98 as=0.203 ps=1.98 w=0.7 l=0.15
X1161 vdd a_16602_8794# a_16602_7094# vdd sky130_fd_pr__pfet_01v8 ad=0.868 pd=6.22 as=0.462 ps=3.13 w=2.8 l=0.15
X1162 vdd a_23199_10029# vdd vdd sky130_fd_pr__pfet_01v8 ad=0.527 pd=4.02 as=0 ps=0 w=1.7 l=0.15
X1163 a_25035_8261# f6 a_16602_7094# vss sky130_fd_pr__nfet_01v8_lvt ad=0.1885 pd=1.88 as=0.1885 ps=1.88 w=0.65 l=0.15
X1164 a_30963_2855# vss vdd vdd sky130_fd_pr__pfet_01v8 ad=0.2607 pd=1.91 as=0.4898 ps=3.78 w=1.58 l=0.15
X1165 vdd a_5993_6093# a_6063_6210# vdd sky130_fd_pr__pfet_01v8_lvt ad=0.609 pd=4.78 as=0.3045 ps=2.39 w=2.1 l=0.35
X1166 a_30963_3945# a_29702_2574# a_30817_3517# vss sky130_fd_pr__nfet_01v8_lvt ad=0.396 pd=2.73 as=0.744 ps=5.42 w=2.4 l=0.15
X1167 vdd a_23199_1641# vdd vdd sky130_fd_pr__pfet_01v8 ad=0.2805 pd=2.03 as=0 ps=0 w=1.7 l=0.15
X1168 ckd2 a_10409_12702# vdd vdd sky130_fd_pr__pfet_01v8_lvt ad=0.87 pd=6.58 as=0.87 ps=6.58 w=3 l=0.35
X1169 a_9105_11602# a_7035_12870# vdd vdd sky130_fd_pr__pfet_01v8 ad=0.522 pd=4.18 as=0.522 ps=4.18 w=1.8 l=0.18
X1170 vss a_18719_10029# vss vss sky130_fd_pr__nfet_01v8_lvt ad=0.203 pd=1.98 as=0 ps=0 w=0.7 l=0.15
X1171 vdd a_323_9240# a_2903_6310# vdd sky130_fd_pr__pfet_01v8_lvt ad=0.319 pd=2.78 as=0.1595 ps=1.39 w=1.1 l=0.35
X1172 a_7935_9170# a_16125_1934# a_15027_7375# vdd sky130_fd_pr__pfet_01v8_lvt ad=0.667 pd=5.18 as=0.3335 ps=2.59 w=2.3 l=0.35
X1173 vdd a_10409_12702# ckd2 vdd sky130_fd_pr__pfet_01v8 ad=0.495 pd=3.33 as=0.495 ps=3.33 w=3 l=0.15
X1174 a_25439_6161# f7 a_13268_8794# vss sky130_fd_pr__nfet_01v8_lvt ad=0.1885 pd=1.88 as=0.1885 ps=1.88 w=0.65 l=0.15
X1175 a_20555_1641# a_20513_1814# a_16768_4274# vdd sky130_fd_pr__pfet_01v8_lvt ad=0.609 pd=4.78 as=0.609 ps=4.78 w=2.1 l=0.35
X1176 a_7935_2090# a2 a_11527_2855# vss sky130_fd_pr__nfet_01v8_lvt ad=0.2325 pd=2.12 as=0.12375 ps=1.08 w=0.75 l=0.15
X1177 a_29868_4274# a_29868_2574# a_30217_2855# vss sky130_fd_pr__nfet_01v8_lvt ad=0.396 pd=2.73 as=0.744 ps=5.42 w=2.4 l=0.15
X1178 a_18315_3741# f0 a_13102_2574# vdd sky130_fd_pr__pfet_01v8_lvt ad=0.609 pd=4.78 as=0.609 ps=4.78 w=2.1 l=0.35
X1179 a_22437_4820# a_20555_5509# vdd vdd sky130_fd_pr__pfet_01v8 ad=0.2805 pd=2.03 as=0.527 ps=4.02 w=1.7 l=0.15
X1180 a_323_6880# in vdd vdd sky130_fd_pr__pfet_01v8_lvt ad=0.203 pd=1.69 as=0.203 ps=1.69 w=1.4 l=0.35
X1181 a_23199_5509# a_22753_1814# a_16602_2574# vss sky130_fd_pr__nfet_01v8_lvt ad=0.1885 pd=1.88 as=0.1885 ps=1.88 w=0.65 l=0.15
X1182 a_3663_1590# a_323_6880# vdd vdd sky130_fd_pr__pfet_01v8_lvt ad=0.1595 pd=1.39 as=0.319 ps=2.78 w=1.1 l=0.35
X1183 a_18719_3741# f0 a_16602_2574# vdd sky130_fd_pr__pfet_01v8_lvt ad=0.609 pd=4.78 as=0.609 ps=4.78 w=2.1 l=0.35
X1184 a_2903_3950# a_323_6880# vss vss sky130_fd_pr__nfet_01v8_lvt ad=0.319 pd=2.78 as=0.319 ps=2.78 w=1.1 l=0.15
X1185 a_11527_2855# a_11849_1934# a_7935_2090# vdd sky130_fd_pr__pfet_01v8_lvt ad=0.3335 pd=2.59 as=0.667 ps=5.18 w=2.3 l=0.35
X1186 vdd a_20959_3409# vdd vdd sky130_fd_pr__pfet_01v8 ad=0.2805 pd=2.03 as=0 ps=0 w=1.7 l=0.15
X1187 a_26917_4820# a_25035_5509# vss vss sky130_fd_pr__nfet_01v8_lvt ad=0.203 pd=1.98 as=0.203 ps=1.98 w=0.7 l=0.15
X1188 a_30963_3945# a_30963_2855# vdd vdd sky130_fd_pr__pfet_01v8 ad=0.2079 pd=1.59 as=0.3906 ps=3.14 w=1.26 l=0.15
X1189 vss a_5993_9144# a_6063_9170# vss sky130_fd_pr__nfet_01v8_lvt ad=0.341 pd=2.82 as=0.1815 ps=1.43 w=1.1 l=0.15
X1190 a_14961_1934# b1 vdd vdd sky130_fd_pr__pfet_01v8 ad=0.261 pd=2.38 as=0.261 ps=2.38 w=0.9 l=0.18
X1191 a_18315_8261# a_18273_3298# a_13102_7094# vss sky130_fd_pr__nfet_01v8_lvt ad=0.1885 pd=1.88 as=0.1885 ps=1.88 w=0.65 l=0.15
X1192 a_20555_6161# f3 a_16768_8794# vss sky130_fd_pr__nfet_01v8_lvt ad=0.1885 pd=1.88 as=0.1885 ps=1.88 w=0.65 l=0.15
X1193 a_7935_8570# b1 a_15027_2855# vss sky130_fd_pr__nfet_01v8_lvt ad=0.2325 pd=2.12 as=0.12375 ps=1.08 w=0.75 l=0.15
X1194 vdd a_20555_1641# a_22437_2120# vdd sky130_fd_pr__pfet_01v8 ad=0.527 pd=4.02 as=0.2805 ps=2.03 w=1.7 l=0.15
X1195 a_25035_7929# a_24993_3298# a_16768_8794# vdd sky130_fd_pr__pfet_01v8_lvt ad=0.609 pd=4.78 as=0.609 ps=4.78 w=2.1 l=0.35
X1196 vdd a_18719_6161# vdd vdd sky130_fd_pr__pfet_01v8 ad=0.527 pd=4.02 as=0 ps=0 w=1.7 l=0.15
X1197 a_20513_1814# f3 vss vss sky130_fd_pr__nfet_01v8 ad=0.1305 pd=1.48 as=0.1305 ps=1.48 w=0.45 l=0.18
X1198 vdd a_323_9240# a_3663_6310# vdd sky130_fd_pr__pfet_01v8_lvt ad=0.1595 pd=1.39 as=0.1595 ps=1.39 w=1.1 l=0.35
X1199 a_7935_3850# b3 a_15027_4275# vss sky130_fd_pr__nfet_01v8_lvt ad=0.2325 pd=2.12 as=0.12375 ps=1.08 w=0.75 l=0.15
X1200 a_17855_12810# a_8819_12702# a_17727_12810# vdd sky130_fd_pr__pfet_01v8_lvt ad=0.638 pd=4.98 as=0.638 ps=4.98 w=2.2 l=0.35
X1201 vss a_12947_11933# a_13717_11105# vss sky130_fd_pr__nfet_01v8_lvt ad=0.3875 pd=3.12 as=0.20625 ps=1.58 w=1.25 l=0.15
X1202 a_15237_11085# a_7587_12850# vss vss sky130_fd_pr__nfet_01v8 ad=0.29 pd=2.58 as=0.29 ps=2.58 w=1 l=0.18
X1203 vdd a_6063_6810# a_7935_6810# vdd sky130_fd_pr__pfet_01v8_lvt ad=0.3045 pd=2.39 as=0.3045 ps=2.39 w=2.1 l=0.35
X1204 a_7935_3850# a_15737_1934# a_15027_8795# vdd sky130_fd_pr__pfet_01v8_lvt ad=0.667 pd=5.18 as=0.3335 ps=2.59 w=2.3 l=0.35
X1205 a_18719_8261# a_18273_3298# a_16602_7094# vss sky130_fd_pr__nfet_01v8_lvt ad=0.1885 pd=1.88 as=0.1885 ps=1.88 w=0.65 l=0.15
X1206 a_8819_12702# a_10409_12702# vss vss sky130_fd_pr__nfet_01v8_lvt ad=0.1885 pd=1.88 as=0.1885 ps=1.88 w=0.65 l=0.15
X1207 vdd a_5993_3733# a_6063_3850# vdd sky130_fd_pr__pfet_01v8_lvt ad=0.609 pd=4.78 as=0.3045 ps=2.39 w=2.1 l=0.35
X1208 a_11527_2855# a_12625_1934# a_7935_1490# vdd sky130_fd_pr__pfet_01v8_lvt ad=0.3335 pd=2.59 as=0.667 ps=5.18 w=2.3 l=0.35
X1209 a_26917_9340# a_25035_10029# vdd vdd sky130_fd_pr__pfet_01v8 ad=0.2805 pd=2.03 as=0.527 ps=4.02 w=1.7 l=0.15
X1210 a_26917_4220# a_28514_3688# vss sky130_fd_pr__res_high_po_0p69 l=2.2
X1211 cke0 a_18105_12784# vdd vdd sky130_fd_pr__pfet_01v8 ad=0.93 pd=6.62 as=0.495 ps=3.33 w=3 l=0.15
X1212 a_2903_6910# a_323_4520# vdd vdd sky130_fd_pr__pfet_01v8_lvt ad=0.1595 pd=1.39 as=0.1595 ps=1.39 w=1.1 l=0.35
X1213 dp a_30963_7375# vdd vdd sky130_fd_pr__pfet_01v8_lvt ad=0.406 pd=3.09 as=0.812 ps=6.18 w=2.8 l=0.35
X1214 vdd a_323_6880# a_2903_3950# vdd sky130_fd_pr__pfet_01v8_lvt ad=0.319 pd=2.78 as=0.1595 ps=1.39 w=1.1 l=0.35
X1215 a_16338_205# b4 vdd vdd sky130_fd_pr__pfet_01v8 ad=0.261 pd=2.38 as=0.261 ps=2.38 w=0.9 l=0.18
X1216 vdd a_25439_3409# vdd vdd sky130_fd_pr__pfet_01v8 ad=0.2805 pd=2.03 as=0 ps=0 w=1.7 l=0.15
X1217 a_15237_11085# a_8487_11686# a_10409_12702# vss sky130_fd_pr__nfet_01v8_lvt ad=0.23925 pd=1.78 as=0.4495 ps=3.52 w=1.45 l=0.15
X1218 a_21865_11030# a_21035_11810# a_21957_11030# vss sky130_fd_pr__nfet_01v8_lvt ad=0.62 pd=4.62 as=0.33 ps=2.33 w=2 l=0.15
X1219 a_7935_2090# a0 a_11527_8795# vss sky130_fd_pr__nfet_01v8_lvt ad=0.2325 pd=2.12 as=0.12375 ps=1.08 w=0.75 l=0.15
X1220 vss a_13268_7094# a_13268_8794# vss sky130_fd_pr__nfet_01v8_lvt ad=0.527 pd=4.02 as=0.2805 ps=2.03 w=1.7 l=0.15
X1221 vdd a_18315_7929# a_20197_7240# vdd sky130_fd_pr__pfet_01v8 ad=0.527 pd=4.02 as=0.2805 ps=2.03 w=1.7 l=0.15
X1222 a_3663_1590# a_5214_1580# vss sky130_fd_pr__res_high_po_0p69 l=1.5
X1223 a_30963_2855# a_29868_4274# a_30817_3517# vss sky130_fd_pr__nfet_01v8_lvt ad=0.396 pd=2.73 as=0.744 ps=5.42 w=2.4 l=0.15
X1224 a_22795_3409# a_22753_3298# a_16768_4274# vdd sky130_fd_pr__pfet_01v8_lvt ad=0.609 pd=4.78 as=0.609 ps=4.78 w=2.1 l=0.35
X1225 a_18105_12784# a_21477_13560# vss vss sky130_fd_pr__nfet_01v8_lvt ad=0.3135 pd=2.23 as=0.589 ps=4.42 w=1.9 l=0.15
X1226 vdd a_6063_8570# a_7935_8570# vdd sky130_fd_pr__pfet_01v8_lvt ad=0.3045 pd=2.39 as=0.3045 ps=2.39 w=2.1 l=0.35
X1227 a_20437_11105# a_19667_11933# vdd vdd sky130_fd_pr__pfet_01v8 ad=0.5775 pd=3.83 as=1.085 ps=7.62 w=3.5 l=0.15
X1228 vss a_18719_8261# vss vss sky130_fd_pr__nfet_01v8_lvt ad=0.203 pd=1.98 as=0 ps=0 w=0.7 l=0.15
X1229 a_20555_3741# a_20513_3298# a_13102_2574# vss sky130_fd_pr__nfet_01v8_lvt ad=0.1885 pd=1.88 as=0.1885 ps=1.88 w=0.65 l=0.15
X1230 a_21957_11030# a_21035_11810# a_21865_11030# vss sky130_fd_pr__nfet_01v8_lvt ad=0.33 pd=2.33 as=0.62 ps=4.62 w=2 l=0.15
X1231 vdd a_20959_6161# vdd vdd sky130_fd_pr__pfet_01v8 ad=0.527 pd=4.02 as=0 ps=0 w=1.7 l=0.15
X1232 a_22437_9340# a_20555_10029# vss vss sky130_fd_pr__nfet_01v8_lvt ad=0.203 pd=1.98 as=0.203 ps=1.98 w=0.7 l=0.15
X1233 a_2903_8670# a_323_9240# vdd vdd sky130_fd_pr__pfet_01v8_lvt ad=0.1595 pd=1.39 as=0.1595 ps=1.39 w=1.1 l=0.35
X1234 a_18315_7929# f0 a_13268_8794# vdd sky130_fd_pr__pfet_01v8_lvt ad=0.609 pd=4.78 as=0.609 ps=4.78 w=2.1 l=0.35
X1235 a_7935_4450# a_6063_4450# vdd vdd sky130_fd_pr__pfet_01v8_lvt ad=0.3045 pd=2.39 as=0.3045 ps=2.39 w=2.1 l=0.35
X1236 vdd a_6063_1490# a_7935_1490# vdd sky130_fd_pr__pfet_01v8_lvt ad=0.609 pd=4.78 as=0.3045 ps=2.39 w=2.1 l=0.35
X1237 a_22795_3409# a_22753_3298# a_13268_4274# vss sky130_fd_pr__nfet_01v8_lvt ad=0.1885 pd=1.88 as=0.1885 ps=1.88 w=0.65 l=0.15
X1238 a_20959_3741# a_20513_3298# a_16602_2574# vss sky130_fd_pr__nfet_01v8_lvt ad=0.1885 pd=1.88 as=0.1885 ps=1.88 w=0.65 l=0.15
X1239 a_7595_11810# a_8487_11686# vss vss sky130_fd_pr__nfet_01v8_lvt ad=0.1305 pd=1.48 as=0.1305 ps=1.48 w=0.45 l=0.15
X1240 a_8487_11686# a_13717_11105# vdd vdd sky130_fd_pr__pfet_01v8 ad=0.5775 pd=3.83 as=0.5775 ps=3.83 w=3.5 l=0.15
X1241 vdd a_29868_4274# a_29702_2574# vdd sky130_fd_pr__pfet_01v8 ad=0.4464 pd=3.5 as=0.2376 ps=1.77 w=1.44 l=0.15
X1242 a_26917_4820# a_28514_3688# vss sky130_fd_pr__res_high_po_0p69 l=2.2
X1243 a_25035_3741# f6 a_13102_2574# vdd sky130_fd_pr__pfet_01v8_lvt ad=0.609 pd=4.78 as=0.609 ps=4.78 w=2.1 l=0.35
X1244 a_6157_11685# rst_n vdd vdd sky130_fd_pr__pfet_01v8_lvt ad=0.29 pd=2.29 as=0.58 ps=4.58 w=2 l=0.35
X1245 a_18719_7929# f0 a_16768_8794# vdd sky130_fd_pr__pfet_01v8_lvt ad=0.609 pd=4.78 as=0.609 ps=4.78 w=2.1 l=0.35
X1246 a_22437_9340# a_28514_8208# vss sky130_fd_pr__res_high_po_0p69 l=2.2
X1247 vss a_26387_11933# a_27157_11105# vss sky130_fd_pr__nfet_01v8_lvt ad=0.3875 pd=3.12 as=0.20625 ps=1.58 w=1.25 l=0.15
X1248 a_25439_10029# f7 a_16602_7094# vdd sky130_fd_pr__pfet_01v8_lvt ad=0.609 pd=4.78 as=0.609 ps=4.78 w=2.1 l=0.35
X1249 a_20959_8261# a_20513_3298# a_13102_7094# vdd sky130_fd_pr__pfet_01v8_lvt ad=0.609 pd=4.78 as=0.609 ps=4.78 w=2.1 l=0.35
X1250 vdd a_30963_8465# dn vdd sky130_fd_pr__pfet_01v8 ad=0.495 pd=3.33 as=0.495 ps=3.33 w=3 l=0.15
X1251 vdd a_323_9240# a_3663_3950# vdd sky130_fd_pr__pfet_01v8_lvt ad=0.1595 pd=1.39 as=0.1595 ps=1.39 w=1.1 l=0.35
X1252 a_23615_11840# a_29097_13560# vdd vdd sky130_fd_pr__pfet_01v8 ad=0.5775 pd=3.83 as=1.085 ps=7.62 w=3.5 l=0.15
X1253 a_3663_6910# a_323_4520# vdd vdd sky130_fd_pr__pfet_01v8_lvt ad=0.1595 pd=1.39 as=0.319 ps=2.78 w=1.1 l=0.35
X1254 a_7935_4450# a_6063_4450# vss vss sky130_fd_pr__nfet_01v8_lvt ad=0.2805 pd=2.03 as=0.527 ps=4.02 w=1.7 l=0.15
X1255 a_16768_7094# a_15027_7375# sky130_fd_pr__cap_mim_m3_1 l=4.2 w=4.3
X1256 vss a_21865_11030# vss vss sky130_fd_pr__nfet_01v8 ad=0.2465 pd=2.28 as=0 ps=0 w=0.85 l=0.35
X1257 vdd a_22795_7929# a_24677_7240# vdd sky130_fd_pr__pfet_01v8 ad=0.527 pd=4.02 as=0.2805 ps=2.03 w=1.7 l=0.15
X1258 a_20197_6640# a_18315_6161# vdd vdd sky130_fd_pr__pfet_01v8 ad=0.2805 pd=2.03 as=0.527 ps=4.02 w=1.7 l=0.15
X1259 a_6063_6210# a_5993_6093# vdd vdd sky130_fd_pr__pfet_01v8_lvt ad=0.3045 pd=2.39 as=0.609 ps=4.78 w=2.1 l=0.35
X1260 vdd a_25035_5509# a_26917_4820# vdd sky130_fd_pr__pfet_01v8 ad=0.527 pd=4.02 as=0.2805 ps=2.03 w=1.7 l=0.15
X1261 a_2903_6310# a_323_9240# vdd vdd sky130_fd_pr__pfet_01v8_lvt ad=0.1595 pd=1.39 as=0.319 ps=2.78 w=1.1 l=0.35
X1262 a_22795_5509# f5 a_13102_2574# vdd sky130_fd_pr__pfet_01v8_lvt ad=0.609 pd=4.78 as=0.609 ps=4.78 w=2.1 l=0.35
X1263 a_18315_8261# a_18273_3298# a_16602_7094# vdd sky130_fd_pr__pfet_01v8_lvt ad=0.609 pd=4.78 as=0.609 ps=4.78 w=2.1 l=0.35
X1264 a_18719_7929# f0 a_13268_8794# vss sky130_fd_pr__nfet_01v8_lvt ad=0.1885 pd=1.88 as=0.1885 ps=1.88 w=0.65 l=0.15
X1265 vdd a_25439_6161# vdd vdd sky130_fd_pr__pfet_01v8 ad=0.527 pd=4.02 as=0 ps=0 w=1.7 l=0.15
X1266 a_13268_4274# a_13268_2574# vdd vdd sky130_fd_pr__pfet_01v8 ad=0.462 pd=3.13 as=0.868 ps=6.22 w=2.8 l=0.15
X1267 a_14961_1934# b1 vss vss sky130_fd_pr__nfet_01v8 ad=0.1305 pd=1.48 as=0.1305 ps=1.48 w=0.45 l=0.18
X1268 vss a_20959_3741# vss vss sky130_fd_pr__nfet_01v8_lvt ad=0.203 pd=1.98 as=0 ps=0 w=0.7 l=0.15
X1269 a_13717_11105# a_12947_11933# vdd vdd sky130_fd_pr__pfet_01v8_lvt ad=1.015 pd=7.58 as=1.015 ps=7.58 w=3.5 l=0.35
X1270 vss a_23199_7929# vss vss sky130_fd_pr__nfet_01v8_lvt ad=0.203 pd=1.98 as=0 ps=0 w=0.7 l=0.15
X1271 vdd ip a_323_2160# vdd sky130_fd_pr__pfet_01v8_lvt ad=0.203 pd=1.69 as=0.203 ps=1.69 w=1.4 l=0.35
X1272 a_15027_4275# a_15349_1934# a_7935_3850# vdd sky130_fd_pr__pfet_01v8_lvt ad=0.3335 pd=2.59 as=0.667 ps=5.18 w=2.3 l=0.35
X1273 a_30963_2855# a_30963_3945# vdd vdd sky130_fd_pr__pfet_01v8 ad=0.2079 pd=1.59 as=0.2079 ps=1.59 w=1.26 l=0.15
X1274 a_3663_8670# a_323_2160# vdd vdd sky130_fd_pr__pfet_01v8_lvt ad=0.1595 pd=1.39 as=0.319 ps=2.78 w=1.1 l=0.35
X1275 a_15027_4275# b1 a_7935_9170# vss sky130_fd_pr__nfet_01v8_lvt ad=0.12375 pd=1.08 as=0.2325 ps=2.12 w=0.75 l=0.15
X1276 a_29702_2574# vss vdd vdd sky130_fd_pr__pfet_01v8 ad=0.3135 pd=2.23 as=0.589 ps=4.42 w=1.9 l=0.15
X1277 a_10409_12702# a_9105_11602# vdd vdd sky130_fd_pr__pfet_01v8 ad=1.085 pd=7.62 as=0.5775 ps=3.83 w=3.5 l=0.15
X1278 a_18719_6161# a_18273_1814# a_13268_8794# vdd sky130_fd_pr__pfet_01v8_lvt ad=0.609 pd=4.78 as=0.609 ps=4.78 w=2.1 l=0.35
X1279 a_21865_11030# a_21927_11686# a_21957_11030# vdd sky130_fd_pr__pfet_01v8 ad=1.085 pd=7.62 as=0.5775 ps=3.83 w=3.5 l=0.15
X1280 a_25439_8261# a_24993_3298# a_13102_7094# vdd sky130_fd_pr__pfet_01v8_lvt ad=0.609 pd=4.78 as=0.609 ps=4.78 w=2.1 l=0.35
X1281 a_29868_7094# a_28514_6336# sky130_fd_pr__cap_mim_m3_1 l=4.8 w=4.8
X1282 a_28514_3688# vss sky130_fd_pr__cap_mim_m3_1 l=1.6 w=1.6
X1283 a_7935_2090# a_7935_1490# vdd vdd sky130_fd_pr__pfet_01v8_lvt ad=0.609 pd=4.78 as=0.609 ps=4.78 w=2.1 l=0.35
X1284 a_7935_9170# a_15737_1934# a_15027_2855# vdd sky130_fd_pr__pfet_01v8_lvt ad=0.667 pd=5.18 as=0.3335 ps=2.59 w=2.3 l=0.35
X1285 a_20197_4220# a_18315_3741# vss vss sky130_fd_pr__nfet_01v8_lvt ad=0.203 pd=1.98 as=0.203 ps=1.98 w=0.7 l=0.15
X1286 a_24677_6640# a_22795_6161# vdd vdd sky130_fd_pr__pfet_01v8 ad=0.2805 pd=2.03 as=0.527 ps=4.02 w=1.7 l=0.15
X1287 a_21957_11030# a_21927_11686# a_21865_11030# vdd sky130_fd_pr__pfet_01v8 ad=0.5775 pd=3.83 as=1.085 ps=7.62 w=3.5 l=0.15
X1288 a_22437_7240# a_20555_7929# vss vss sky130_fd_pr__nfet_01v8_lvt ad=0.203 pd=1.98 as=0.203 ps=1.98 w=0.7 l=0.15
X1289 a_16338_205# b4 vss vss sky130_fd_pr__nfet_01v8 ad=0.1305 pd=1.48 as=0.1305 ps=1.48 w=0.45 l=0.18
X1290 a_10175_11935# a_8487_11686# a_9105_11602# vdd sky130_fd_pr__pfet_01v8 ad=0.462 pd=3.13 as=0.868 ps=6.22 w=2.8 l=0.15
X1291 vss vdd a_30817_8037# vss sky130_fd_pr__nfet_01v8 ad=0.17835 pd=1.52 as=0.17835 ps=1.52 w=1.23 l=0.2
X1292 vss a_18719_5509# vss vss sky130_fd_pr__nfet_01v8_lvt ad=0.203 pd=1.98 as=0 ps=0 w=0.7 l=0.15
X1293 a_15027_2855# b3 a_7935_4450# vss sky130_fd_pr__nfet_01v8_lvt ad=0.12375 pd=1.08 as=0.2325 ps=2.12 w=0.75 l=0.15
X1294 a_17855_12810# a_7587_12850# vss vss sky130_fd_pr__nfet_01v8 ad=0.29 pd=2.58 as=0.29 ps=2.58 w=1 l=0.18
X1295 a_7935_2090# a_6063_2090# vss vss sky130_fd_pr__nfet_01v8_lvt ad=0.2805 pd=2.03 as=0.527 ps=4.02 w=1.7 l=0.15
X1296 a_15027_4275# a_16125_1934# a_7935_4450# vdd sky130_fd_pr__pfet_01v8_lvt ad=0.3335 pd=2.59 as=0.667 ps=5.18 w=2.3 l=0.35
X1297 a_15027_4275# b5 a_7935_8570# vss sky130_fd_pr__nfet_01v8_lvt ad=0.12375 pd=1.08 as=0.2325 ps=2.12 w=0.75 l=0.15
X1298 vss a_25439_8261# vss vss sky130_fd_pr__nfet_01v8_lvt ad=0.203 pd=1.98 as=0 ps=0 w=0.7 l=0.15
X1299 vss a_6227_11933# a_6997_11105# vss sky130_fd_pr__nfet_01v8_lvt ad=0.3875 pd=3.12 as=0.20625 ps=1.58 w=1.25 l=0.15
X1300 vdd a_20437_11105# a_21035_11810# vdd sky130_fd_pr__pfet_01v8 ad=0.5775 pd=3.83 as=0.5775 ps=3.83 w=3.5 l=0.15
X1301 vss a_15825_11602# a_10175_11935# vss sky130_fd_pr__nfet_01v8_lvt ad=0.589 pd=4.42 as=0.3135 ps=2.23 w=1.9 l=0.15
X1302 a_20555_8261# a_20513_3298# a_16602_7094# vdd sky130_fd_pr__pfet_01v8_lvt ad=0.609 pd=4.78 as=0.609 ps=4.78 w=2.1 l=0.35
X1303 a_25035_7929# f6 a_13268_8794# vdd sky130_fd_pr__pfet_01v8_lvt ad=0.609 pd=4.78 as=0.609 ps=4.78 w=2.1 l=0.35
X1304 dn dp vdd vdd sky130_fd_pr__pfet_01v8 ad=0.3135 pd=2.23 as=0.589 ps=4.42 w=1.9 l=0.15
X1305 vss qp a_323_4520# vss sky130_fd_pr__nfet_01v8_lvt ad=0.217 pd=2.02 as=0.1155 ps=1.03 w=0.7 l=0.15
X1306 a_6063_3850# a_5993_3733# vdd vdd sky130_fd_pr__pfet_01v8_lvt ad=0.3045 pd=2.39 as=0.609 ps=4.78 w=2.1 l=0.35
X1307 vdd a_6063_6810# a_7935_6810# vdd sky130_fd_pr__pfet_01v8_lvt ad=0.609 pd=4.78 as=0.3045 ps=2.39 w=2.1 l=0.35
X1308 a_30817_8037# vdd vss vss sky130_fd_pr__nfet_01v8 ad=0.17835 pd=1.52 as=0.17835 ps=1.52 w=1.23 l=0.2
X1309 a_2903_3950# a_323_6880# vdd vdd sky130_fd_pr__pfet_01v8_lvt ad=0.1595 pd=1.39 as=0.319 ps=2.78 w=1.1 l=0.35
X1310 a_23199_7929# a_22753_3298# a_16768_8794# vss sky130_fd_pr__nfet_01v8_lvt ad=0.1885 pd=1.88 as=0.1885 ps=1.88 w=0.65 l=0.15
X1311 a_24677_7240# a_28514_6336# vss sky130_fd_pr__res_high_po_0p69 l=2.2
X1312 vdd a_18719_5509# vdd vdd sky130_fd_pr__pfet_01v8 ad=0.527 pd=4.02 as=0 ps=0 w=1.7 l=0.15
X1313 a_2903_1590# a_323_6880# vss vss sky130_fd_pr__nfet_01v8_lvt ad=0.319 pd=2.78 as=0.319 ps=2.78 w=1.1 l=0.15
X1314 a_15825_11602# a_8487_11686# a_8819_12702# vss sky130_fd_pr__nfet_01v8_lvt ad=0.4495 pd=3.52 as=0.23925 ps=1.78 w=1.45 l=0.15
X1315 a_7935_6210# a4 a_11527_4275# vss sky130_fd_pr__nfet_01v8_lvt ad=0.2325 pd=2.12 as=0.12375 ps=1.08 w=0.75 l=0.15
X1316 a_6997_11105# a_6227_11933# vss vss sky130_fd_pr__nfet_01v8_lvt ad=0.20625 pd=1.58 as=0.3875 ps=3.12 w=1.25 l=0.15
X1317 a_3663_8670# a_5214_8660# vss sky130_fd_pr__res_high_po_0p69 l=1.5
X1318 a_11527_8795# a2 a_7935_6810# vss sky130_fd_pr__nfet_01v8_lvt ad=0.12375 pd=1.08 as=0.2325 ps=2.12 w=0.75 l=0.15
X1319 vdd a_13102_4274# a_13102_2574# vdd sky130_fd_pr__pfet_01v8 ad=0.462 pd=3.13 as=0.462 ps=3.13 w=2.8 l=0.15
X1320 a_15027_2855# b7 a_7935_3850# vss sky130_fd_pr__nfet_01v8_lvt ad=0.12375 pd=1.08 as=0.2325 ps=2.12 w=0.75 l=0.15
X1321 vss a_13717_11105# a_8487_11686# vss sky130_fd_pr__nfet_01v8_lvt ad=0.5425 pd=4.12 as=0.28875 ps=2.08 w=1.75 l=0.15
X1322 a_23615_11840# a_29097_13560# vss vss sky130_fd_pr__nfet_01v8_lvt ad=0.3135 pd=2.23 as=0.589 ps=4.42 w=1.9 l=0.15
X1323 vss a_5993_6784# a_6063_6810# vss sky130_fd_pr__nfet_01v8_lvt ad=0.341 pd=2.82 as=0.1815 ps=1.43 w=1.1 l=0.15
X1324 a_24677_8740# a_22795_8261# vss vss sky130_fd_pr__nfet_01v8_lvt ad=0.203 pd=1.98 as=0.203 ps=1.98 w=0.7 l=0.15
X1325 a_26917_7240# a_25035_7929# vss vss sky130_fd_pr__nfet_01v8_lvt ad=0.203 pd=1.98 as=0.203 ps=1.98 w=0.7 l=0.15
X1326 a_23199_6161# f5 a_16768_8794# vdd sky130_fd_pr__pfet_01v8_lvt ad=0.609 pd=4.78 as=0.609 ps=4.78 w=2.1 l=0.35
X1327 a_16768_4274# a_16768_2574# vss sky130_fd_pr__res_high_po_0p35 l=6.5
X1328 cke3 a_21865_11030# vdd vdd sky130_fd_pr__pfet_01v8 ad=0.495 pd=3.33 as=0.93 ps=6.62 w=3 l=0.15
X1329 vdd a_23199_3741# vdd vdd sky130_fd_pr__pfet_01v8 ad=0.527 pd=4.02 as=0 ps=0 w=1.7 l=0.15
X1330 a_18105_12784# a_21477_13560# vdd vdd sky130_fd_pr__pfet_01v8_lvt ad=1.015 pd=7.58 as=1.015 ps=7.58 w=3.5 l=0.35
X1331 vdd a_6063_8570# a_7935_8570# vdd sky130_fd_pr__pfet_01v8_lvt ad=0.609 pd=4.78 as=0.3045 ps=2.39 w=2.1 l=0.35
X1332 vdd a_21477_13560# a_18105_12784# vdd sky130_fd_pr__pfet_01v8 ad=0.5775 pd=3.83 as=0.5775 ps=3.83 w=3.5 l=0.15
X1333 a_21035_11810# a_20437_11105# vdd vdd sky130_fd_pr__pfet_01v8 ad=0.5775 pd=3.83 as=0.5775 ps=3.83 w=3.5 l=0.15
X1334 a_13268_8794# a_13268_7094# vdd vdd sky130_fd_pr__pfet_01v8_lvt ad=0.406 pd=3.09 as=0.812 ps=6.18 w=2.8 l=0.35
X1335 vdd a_6063_4450# a_7935_4450# vdd sky130_fd_pr__pfet_01v8_lvt ad=0.3045 pd=2.39 as=0.3045 ps=2.39 w=2.1 l=0.35
X1336 a_16768_8794# a_16768_7094# vss vss sky130_fd_pr__nfet_01v8_lvt ad=0.2805 pd=2.03 as=0.527 ps=4.02 w=1.7 l=0.15
X1337 vdd a_5993_1373# a_6063_1490# vdd sky130_fd_pr__pfet_01v8_lvt ad=0.609 pd=4.78 as=0.3045 ps=2.39 w=2.1 l=0.35
X1338 a_23199_1641# a_22753_1814# a_13268_4274# vdd sky130_fd_pr__pfet_01v8_lvt ad=0.609 pd=4.78 as=0.609 ps=4.78 w=2.1 l=0.35
X1339 a_28197_13560# a_20590_13570# a_27857_13560# vss sky130_fd_pr__nfet_01v8_lvt ad=0.2475 pd=1.83 as=0.465 ps=3.62 w=1.5 l=0.15
X1340 cke1 a_23615_11840# vdd vdd sky130_fd_pr__pfet_01v8 ad=0.495 pd=3.33 as=0.93 ps=6.62 w=3 l=0.15
X1341 ep en vdd vdd sky130_fd_pr__pfet_01v8 ad=0.3135 pd=2.23 as=0.589 ps=4.42 w=1.9 l=0.15
X1342 a_30963_3945# vss vdd vdd sky130_fd_pr__pfet_01v8 ad=0.2607 pd=1.91 as=0.4898 ps=3.78 w=1.58 l=0.15
X1343 ckd2 a_10409_12702# vdd vdd sky130_fd_pr__pfet_01v8 ad=0.93 pd=6.62 as=0.495 ps=3.33 w=3 l=0.15
X1344 a_2903_4550# a_323_2160# vdd vdd sky130_fd_pr__pfet_01v8_lvt ad=0.1595 pd=1.39 as=0.1595 ps=1.39 w=1.1 l=0.35
X1345 vdd a_323_6880# a_2903_1590# vdd sky130_fd_pr__pfet_01v8_lvt ad=0.319 pd=2.78 as=0.1595 ps=1.39 w=1.1 l=0.35
X1346 a_7587_12850# a_7035_12870# vdd vdd sky130_fd_pr__pfet_01v8_lvt ad=0.261 pd=2.09 as=0.522 ps=4.18 w=1.8 l=0.35
X1347 a_11527_8795# a6 a_7935_6210# vss sky130_fd_pr__nfet_01v8_lvt ad=0.12375 pd=1.08 as=0.2325 ps=2.12 w=0.75 l=0.15
X1348 vdd a_20959_5509# vdd vdd sky130_fd_pr__pfet_01v8 ad=0.527 pd=4.02 as=0 ps=0 w=1.7 l=0.15
X1349 a_10175_11935# a_8425_11085# vss vss sky130_fd_pr__nfet_01v8_lvt ad=0.1885 pd=1.88 as=0.1885 ps=1.88 w=0.65 l=0.15
X1350 vss ip a_323_2160# vss sky130_fd_pr__nfet_01v8_lvt ad=0.217 pd=2.02 as=0.1155 ps=1.03 w=0.7 l=0.15
X1351 a_7935_6210# a_7935_6810# vdd vdd sky130_fd_pr__pfet_01v8_lvt ad=0.609 pd=4.78 as=0.609 ps=4.78 w=2.1 l=0.35
X1352 a_13268_8794# a_13268_7094# vdd vdd sky130_fd_pr__pfet_01v8 ad=0.462 pd=3.13 as=0.462 ps=3.13 w=2.8 l=0.15
X1353 a_25035_3409# f6 a_16768_4274# vss sky130_fd_pr__nfet_01v8_lvt ad=0.1885 pd=1.88 as=0.1885 ps=1.88 w=0.65 l=0.15
X1354 a_23199_1641# f5 a_13268_4274# vss sky130_fd_pr__nfet_01v8_lvt ad=0.1885 pd=1.88 as=0.1885 ps=1.88 w=0.65 l=0.15
X1355 a_20959_3409# a_20513_3298# a_13268_4274# vdd sky130_fd_pr__pfet_01v8_lvt ad=0.609 pd=4.78 as=0.609 ps=4.78 w=2.1 l=0.35
X1356 ckd2 a_10409_12702# vss vss sky130_fd_pr__nfet_01v8_lvt ad=0.2145 pd=1.63 as=0.403 ps=3.22 w=1.3 l=0.15
X1357 vss a_25439_5509# vss vss sky130_fd_pr__nfet_01v8_lvt ad=0.203 pd=1.98 as=0 ps=0 w=0.7 l=0.15
X1358 vdd qn a_323_9240# vdd sky130_fd_pr__pfet_01v8_lvt ad=0.203 pd=1.69 as=0.203 ps=1.69 w=1.4 l=0.35
X1359 a_24677_2120# a_28514_1816# vss sky130_fd_pr__res_high_po_0p69 l=2.2
X1360 a_7935_2090# a_6063_2090# vdd vdd sky130_fd_pr__pfet_01v8_lvt ad=0.3045 pd=2.39 as=0.3045 ps=2.39 w=2.1 l=0.35
X1361 a_20197_4820# a_18315_5509# vdd vdd sky130_fd_pr__pfet_01v8 ad=0.2805 pd=2.03 as=0.527 ps=4.02 w=1.7 l=0.15
X1362 a_30963_7375# a_30963_8465# vdd vdd sky130_fd_pr__pfet_01v8 ad=0.2079 pd=1.59 as=0.3906 ps=3.14 w=1.26 l=0.15
X1363 a_22753_1814# f5 vdd vdd sky130_fd_pr__pfet_01v8 ad=0.261 pd=2.38 as=0.261 ps=2.38 w=0.9 l=0.18
X1364 a_16602_7094# a_16602_8794# vdd vdd sky130_fd_pr__pfet_01v8_lvt ad=0.406 pd=3.09 as=0.812 ps=6.18 w=2.8 l=0.35
X1365 a_7935_9170# a_7935_8570# vdd vdd sky130_fd_pr__pfet_01v8_lvt ad=0.609 pd=4.78 as=0.609 ps=4.78 w=2.1 l=0.35
X1366 vdd a_323_6880# a_3663_1590# vdd sky130_fd_pr__pfet_01v8_lvt ad=0.1595 pd=1.39 as=0.1595 ps=1.39 w=1.1 l=0.35
X1367 a_26917_4220# a_25035_3741# vdd vdd sky130_fd_pr__pfet_01v8 ad=0.2805 pd=2.03 as=0.527 ps=4.02 w=1.7 l=0.15
X1368 ckd0 a_8819_12702# vdd vdd sky130_fd_pr__pfet_01v8_lvt ad=0.87 pd=6.58 as=0.87 ps=6.58 w=3 l=0.35
X1369 ckd2 ckd0 vdd vdd sky130_fd_pr__pfet_01v8_lvt ad=0.406 pd=3.38 as=0.406 ps=3.38 w=1.4 l=0.35
X1370 a_24677_4820# a_22795_5509# vss vss sky130_fd_pr__nfet_01v8_lvt ad=0.203 pd=1.98 as=0.203 ps=1.98 w=0.7 l=0.15
X1371 a_3663_4550# a_323_4520# vdd vdd sky130_fd_pr__pfet_01v8_lvt ad=0.1595 pd=1.39 as=0.319 ps=2.78 w=1.1 l=0.35
X1372 a_29702_4274# a_29702_2574# vss sky130_fd_pr__res_high_po_0p35 l=6.5
X1373 a_18315_3409# a_18273_3298# a_16768_4274# vdd sky130_fd_pr__pfet_01v8_lvt ad=0.609 pd=4.78 as=0.609 ps=4.78 w=2.1 l=0.35
X1374 a_25035_5509# a_24993_1814# a_16602_2574# vdd sky130_fd_pr__pfet_01v8_lvt ad=0.609 pd=4.78 as=0.609 ps=4.78 w=2.1 l=0.35
X1375 vdd a_25439_5509# vdd vdd sky130_fd_pr__pfet_01v8 ad=0.527 pd=4.02 as=0 ps=0 w=1.7 l=0.15
X1376 a_7935_6210# a_11849_1934# a_11527_7375# vdd sky130_fd_pr__pfet_01v8_lvt ad=0.667 pd=5.18 as=0.3335 ps=2.59 w=2.3 l=0.35
X1377 cke1 cke3 vdd vdd sky130_fd_pr__pfet_01v8_lvt ad=0.406 pd=3.38 as=0.406 ps=3.38 w=1.4 l=0.35
X1378 a_21035_11810# a_20437_11105# vss vss sky130_fd_pr__nfet_01v8_lvt ad=0.28875 pd=2.08 as=0.5425 ps=4.12 w=1.75 l=0.15
X1379 a_3663_6310# a_323_9240# vdd vdd sky130_fd_pr__pfet_01v8_lvt ad=0.1595 pd=1.39 as=0.1595 ps=1.39 w=1.1 l=0.35
X1380 a_16768_2574# a_15027_2855# sky130_fd_pr__cap_mim_m3_1 l=4.2 w=4.3
X1381 vdd a_18315_1641# a_20197_2120# vdd sky130_fd_pr__pfet_01v8 ad=0.527 pd=4.02 as=0.2805 ps=2.03 w=1.7 l=0.15
X1382 vss a_16768_2574# a_16768_4274# vss sky130_fd_pr__nfet_01v8_lvt ad=0.527 pd=4.02 as=0.2805 ps=2.03 w=1.7 l=0.15
X1383 a_8425_11085# a_15237_11085# vdd vdd sky130_fd_pr__pfet_01v8 ad=0.5775 pd=3.83 as=1.085 ps=7.62 w=3.5 l=0.15
X1384 a_7935_9170# a_6063_9170# vss vss sky130_fd_pr__nfet_01v8_lvt ad=0.2805 pd=2.03 as=0.527 ps=4.02 w=1.7 l=0.15
X1385 dp a_30963_7375# vdd vdd sky130_fd_pr__pfet_01v8 ad=0.495 pd=3.33 as=0.495 ps=3.33 w=3 l=0.15
X1386 a_25439_3409# a_24993_3298# a_13268_4274# vdd sky130_fd_pr__pfet_01v8_lvt ad=0.609 pd=4.78 as=0.609 ps=4.78 w=2.1 l=0.35
X1387 a_11527_7375# a0 a_7935_1490# vss sky130_fd_pr__nfet_01v8_lvt ad=0.12375 pd=1.08 as=0.2325 ps=2.12 w=0.75 l=0.15
X1388 a_22437_7240# a_20555_7929# vdd vdd sky130_fd_pr__pfet_01v8 ad=0.2805 pd=2.03 as=0.527 ps=4.02 w=1.7 l=0.15
X1389 a_18315_3409# a_18273_3298# a_13268_4274# vss sky130_fd_pr__nfet_01v8_lvt ad=0.1885 pd=1.88 as=0.1885 ps=1.88 w=0.65 l=0.15
X1390 ckd0 a_8819_12702# vdd vdd sky130_fd_pr__pfet_01v8 ad=0.495 pd=3.33 as=0.93 ps=6.62 w=3 l=0.15
X1391 a_17727_13625# a_18745_12784# vss vss sky130_fd_pr__nfet_01v8 ad=0.2465 pd=2.28 as=0.2465 ps=2.28 w=0.85 l=0.35
X1392 a_10409_12702# a_8487_11686# a_15237_11085# vss sky130_fd_pr__nfet_01v8_lvt ad=0.4495 pd=3.52 as=0.23925 ps=1.78 w=1.45 l=0.15
X1393 a_11527_8795# a_12237_1934# a_7935_1490# vdd sky130_fd_pr__pfet_01v8_lvt ad=0.3335 pd=2.59 as=0.667 ps=5.18 w=2.3 l=0.35
X1394 vss vdd a_30817_3517# vss sky130_fd_pr__nfet_01v8 ad=0.3567 pd=3.04 as=0.17835 ps=1.52 w=1.23 l=0.2
X1395 a_18719_3409# a_18273_3298# a_16768_4274# vss sky130_fd_pr__nfet_01v8_lvt ad=0.1885 pd=1.88 as=0.1885 ps=1.88 w=0.65 l=0.15
X1396 a_24677_4820# a_22795_5509# vdd vdd sky130_fd_pr__pfet_01v8 ad=0.2805 pd=2.03 as=0.527 ps=4.02 w=1.7 l=0.15
X1397 vss a_21477_13560# a_18105_12784# vss sky130_fd_pr__nfet_01v8_lvt ad=0.589 pd=4.42 as=0.3135 ps=2.23 w=1.9 l=0.15
X1398 a_15027_4275# a_14961_1934# a_7935_9170# vdd sky130_fd_pr__pfet_01v8_lvt ad=0.3335 pd=2.59 as=0.667 ps=5.18 w=2.3 l=0.35
X1399 vdd a_19667_11933# a_20437_11105# vdd sky130_fd_pr__pfet_01v8 ad=1.085 pd=7.62 as=0.5775 ps=3.83 w=3.5 l=0.15
X1400 a_2903_8670# a_323_9240# vss vss sky130_fd_pr__nfet_01v8_lvt ad=0.319 pd=2.78 as=0.319 ps=2.78 w=1.1 l=0.15
X1401 vdd a_13102_8794# a_13102_7094# vdd sky130_fd_pr__pfet_01v8 ad=0.868 pd=6.22 as=0.462 ps=3.13 w=2.8 l=0.15
X1402 a_7935_3850# a_14961_1934# a_15027_7375# vdd sky130_fd_pr__pfet_01v8_lvt ad=0.667 pd=5.18 as=0.3335 ps=2.59 w=2.3 l=0.35
X1403 vdd in a_323_6880# vdd sky130_fd_pr__pfet_01v8_lvt ad=0.203 pd=1.69 as=0.203 ps=1.69 w=1.4 l=0.35
X1404 vdd a_5993_6784# a_6063_6810# vdd sky130_fd_pr__pfet_01v8_lvt ad=0.609 pd=4.78 as=0.3045 ps=2.39 w=2.1 l=0.35
X1405 a_12548_205# a1 vdd vdd sky130_fd_pr__pfet_01v8 ad=0.261 pd=2.38 as=0.261 ps=2.38 w=0.9 l=0.18
X1406 vdd a_23199_3409# vdd vdd sky130_fd_pr__pfet_01v8 ad=0.2805 pd=2.03 as=0 ps=0 w=1.7 l=0.15
X1407 cke2 cke0 vdd vdd sky130_fd_pr__pfet_01v8_lvt ad=0.406 pd=3.38 as=0.406 ps=3.38 w=1.4 l=0.35
X1408 vdd a_323_4520# a_2903_6910# vdd sky130_fd_pr__pfet_01v8_lvt ad=0.319 pd=2.78 as=0.1595 ps=1.39 w=1.1 l=0.35
X1409 a_7935_6810# a_12625_1934# a_11527_7375# vdd sky130_fd_pr__pfet_01v8_lvt ad=0.667 pd=5.18 as=0.3335 ps=2.59 w=2.3 l=0.35
X1410 a_25035_8261# a_24993_3298# a_13102_7094# vss sky130_fd_pr__nfet_01v8_lvt ad=0.1885 pd=1.88 as=0.1885 ps=1.88 w=0.65 l=0.15
X1411 a_29868_2574# a_28514_1816# sky130_fd_pr__cap_mim_m3_1 l=4.8 w=4.8
X1412 ckd1 a_8425_11085# vss vss sky130_fd_pr__nfet_01v8_lvt ad=0.2145 pd=1.63 as=0.403 ps=3.22 w=1.3 l=0.15
X1413 vdd a_13717_11105# a_8487_11686# vdd sky130_fd_pr__pfet_01v8 ad=1.085 pd=7.62 as=0.5775 ps=3.83 w=3.5 l=0.15
X1414 a_22795_1641# f5 a_16768_4274# vss sky130_fd_pr__nfet_01v8_lvt ad=0.1885 pd=1.88 as=0.1885 ps=1.88 w=0.65 l=0.15
X1415 a_20555_3409# a_20513_3298# a_16768_4274# vdd sky130_fd_pr__pfet_01v8_lvt ad=0.609 pd=4.78 as=0.609 ps=4.78 w=2.1 l=0.35
X1416 ckd3 a_10175_11935# vdd vdd sky130_fd_pr__pfet_01v8 ad=0.495 pd=3.33 as=0.93 ps=6.62 w=3 l=0.15
X1417 vss a_20437_11105# a_21035_11810# vss sky130_fd_pr__nfet_01v8_lvt ad=0.5425 pd=4.12 as=0.28875 ps=2.08 w=1.75 l=0.15
X1418 a_11527_7375# a4 a_7935_2090# vss sky130_fd_pr__nfet_01v8_lvt ad=0.12375 pd=1.08 as=0.2325 ps=2.12 w=0.75 l=0.15
X1419 a_25439_8261# a_24993_3298# a_16602_7094# vss sky130_fd_pr__nfet_01v8_lvt ad=0.1885 pd=1.88 as=0.1885 ps=1.88 w=0.65 l=0.15
X1420 a_18315_5509# f1 a_13102_2574# vdd sky130_fd_pr__pfet_01v8_lvt ad=0.609 pd=4.78 as=0.609 ps=4.78 w=2.1 l=0.35
X1421 vdd a_22795_1641# a_24677_2120# vdd sky130_fd_pr__pfet_01v8 ad=0.527 pd=4.02 as=0.2805 ps=2.03 w=1.7 l=0.15
X1422 a_20555_1641# f3 a_13268_4274# vdd sky130_fd_pr__pfet_01v8_lvt ad=0.609 pd=4.78 as=0.609 ps=4.78 w=2.1 l=0.35
X1423 a_23615_11840# a_29097_13560# vdd vdd sky130_fd_pr__pfet_01v8_lvt ad=1.015 pd=7.58 as=1.015 ps=7.58 w=3.5 l=0.35
X1424 vss a_18719_7929# vss vss sky130_fd_pr__nfet_01v8_lvt ad=0.203 pd=1.98 as=0 ps=0 w=0.7 l=0.15
X1425 a_13102_4274# a_13102_2574# vss sky130_fd_pr__res_high_po_0p35 l=6.5
X1426 a_18719_5509# f1 a_16602_2574# vdd sky130_fd_pr__pfet_01v8_lvt ad=0.609 pd=4.78 as=0.609 ps=4.78 w=2.1 l=0.35
X1427 vdd a_29097_13560# a_23615_11840# vdd sky130_fd_pr__pfet_01v8 ad=0.5775 pd=3.83 as=0.5775 ps=3.83 w=3.5 l=0.15
X1428 vdd vss a_30963_2855# vdd sky130_fd_pr__pfet_01v8 ad=0.4898 pd=3.78 as=0.2607 ps=1.91 w=1.58 l=0.15
X1429 a_12237_1934# a4 vdd vdd sky130_fd_pr__pfet_01v8 ad=0.261 pd=2.38 as=0.261 ps=2.38 w=0.9 l=0.18
X1430 vdd a_5993_8453# a_6063_8570# vdd sky130_fd_pr__pfet_01v8_lvt ad=0.609 pd=4.78 as=0.3045 ps=2.39 w=2.1 l=0.35
X1431 vdd a_18719_8261# vdd vdd sky130_fd_pr__pfet_01v8 ad=0.2805 pd=2.03 as=0 ps=0 w=1.7 l=0.15
X1432 a_20959_1641# f3 a_16768_4274# vdd sky130_fd_pr__pfet_01v8_lvt ad=0.609 pd=4.78 as=0.609 ps=4.78 w=2.1 l=0.35
X1433 a_28197_13560# a_7587_12850# vss vss sky130_fd_pr__nfet_01v8 ad=0.29 pd=2.58 as=0.29 ps=2.58 w=1 l=0.18
X1434 vdd a_323_9240# a_2903_8670# vdd sky130_fd_pr__pfet_01v8_lvt ad=0.319 pd=2.78 as=0.1595 ps=1.39 w=1.1 l=0.35
X1435 a_3663_3950# a_323_9240# vdd vdd sky130_fd_pr__pfet_01v8_lvt ad=0.1595 pd=1.39 as=0.1595 ps=1.39 w=1.1 l=0.35
X1436 a_6063_1490# a_5993_1373# vdd vdd sky130_fd_pr__pfet_01v8_lvt ad=0.3045 pd=2.39 as=0.609 ps=4.78 w=2.1 l=0.35
X1437 vdd a_6063_4450# a_7935_4450# vdd sky130_fd_pr__pfet_01v8_lvt ad=0.609 pd=4.78 as=0.3045 ps=2.39 w=2.1 l=0.35
X1438 a_2903_1590# a_323_6880# vdd vdd sky130_fd_pr__pfet_01v8_lvt ad=0.1595 pd=1.39 as=0.319 ps=2.78 w=1.1 l=0.35
X1439 a_22795_10029# a_22753_1814# a_16602_7094# vdd sky130_fd_pr__pfet_01v8_lvt ad=0.609 pd=4.78 as=0.609 ps=4.78 w=2.1 l=0.35
X1440 a_7935_6210# a0 a_11527_2855# vss sky130_fd_pr__nfet_01v8_lvt ad=0.2325 pd=2.12 as=0.12375 ps=1.08 w=0.75 l=0.15
X1441 vdd a_20555_3409# a_22437_2720# vdd sky130_fd_pr__pfet_01v8 ad=0.527 pd=4.02 as=0.2805 ps=2.03 w=1.7 l=0.15
X1442 a_18105_12784# a_18745_12784# vss vss sky130_fd_pr__nfet_01v8_lvt ad=0.1885 pd=1.88 as=0.1885 ps=1.88 w=0.65 l=0.15
X1443 vss qn a_323_9240# vss sky130_fd_pr__nfet_01v8_lvt ad=0.217 pd=2.02 as=0.1155 ps=1.03 w=0.7 l=0.15
X1444 a_22753_1814# f5 vss vss sky130_fd_pr__nfet_01v8 ad=0.1305 pd=1.48 as=0.1305 ps=1.48 w=0.45 l=0.18
X1445 a_8425_11085# a_10175_11935# vdd vdd sky130_fd_pr__pfet_01v8_lvt ad=0.609 pd=4.78 as=0.609 ps=4.78 w=2.1 l=0.35
X1446 vss a_25439_10029# vss vss sky130_fd_pr__nfet_01v8_lvt ad=0.203 pd=1.98 as=0 ps=0 w=0.7 l=0.15
X1447 vdd a_323_4520# a_3663_6910# vdd sky130_fd_pr__pfet_01v8_lvt ad=0.1595 pd=1.39 as=0.1595 ps=1.39 w=1.1 l=0.35
X1448 a_20555_6161# a_20513_1814# a_13268_8794# vss sky130_fd_pr__nfet_01v8_lvt ad=0.1885 pd=1.88 as=0.1885 ps=1.88 w=0.65 l=0.15
X1449 a_30817_8037# a_29702_7094# a_30963_8465# vss sky130_fd_pr__nfet_01v8_lvt ad=0.396 pd=2.73 as=0.396 ps=2.73 w=2.4 l=0.15
X1450 a_2903_6310# a_323_9240# vss vss sky130_fd_pr__nfet_01v8_lvt ad=0.319 pd=2.78 as=0.319 ps=2.78 w=1.1 l=0.15
X1451 vss a_5993_4424# a_6063_4450# vss sky130_fd_pr__nfet_01v8_lvt ad=0.341 pd=2.82 as=0.1815 ps=1.43 w=1.1 l=0.15
X1452 a_7935_1490# a2 a_11527_4275# vss sky130_fd_pr__nfet_01v8_lvt ad=0.2325 pd=2.12 as=0.12375 ps=1.08 w=0.75 l=0.15
X1453 a_29097_13560# a_20590_13570# a_28757_13560# vss sky130_fd_pr__nfet_01v8_lvt ad=0.2475 pd=1.83 as=0.465 ps=3.62 w=1.5 l=0.15
X1454 a_16602_7094# a_16602_8794# vdd vdd sky130_fd_pr__pfet_01v8 ad=0.462 pd=3.13 as=0.868 ps=6.22 w=2.8 l=0.15
X1455 a_20959_6161# a_20513_1814# a_16768_8794# vss sky130_fd_pr__nfet_01v8_lvt ad=0.1885 pd=1.88 as=0.1885 ps=1.88 w=0.65 l=0.15
X1456 a_22795_3741# a_22753_3298# a_13102_2574# vss sky130_fd_pr__nfet_01v8_lvt ad=0.1885 pd=1.88 as=0.1885 ps=1.88 w=0.65 l=0.15
X1457 vdd a_27157_11105# a_21927_11686# vdd sky130_fd_pr__pfet_01v8 ad=1.085 pd=7.62 as=0.5775 ps=3.83 w=3.5 l=0.15
X1458 vdd a_30963_2855# a_30963_3945# vdd sky130_fd_pr__pfet_01v8 ad=0.3906 pd=3.14 as=0.2079 ps=1.59 w=1.26 l=0.15
X1459 a_7935_9170# a_6063_9170# vdd vdd sky130_fd_pr__pfet_01v8_lvt ad=0.3045 pd=2.39 as=0.3045 ps=2.39 w=2.1 l=0.35
X1460 vdd a_23199_6161# vdd vdd sky130_fd_pr__pfet_01v8 ad=0.527 pd=4.02 as=0 ps=0 w=1.7 l=0.15
X1461 a_11527_7375# a_11461_1934# a_7935_1490# vdd sky130_fd_pr__pfet_01v8_lvt ad=0.3335 pd=2.59 as=0.667 ps=5.18 w=2.3 l=0.35
X1462 a_6063_2090# a_5993_2064# vss vss sky130_fd_pr__nfet_01v8_lvt ad=0.1815 pd=1.43 as=0.341 ps=2.82 w=1.1 l=0.15
X1463 vdd a_6063_2090# a_7935_2090# vdd sky130_fd_pr__pfet_01v8_lvt ad=0.3045 pd=2.39 as=0.3045 ps=2.39 w=2.1 l=0.35
X1464 a_30817_3517# vdd vss vss sky130_fd_pr__nfet_01v8 ad=0.17835 pd=1.52 as=0.3567 ps=3.04 w=1.23 l=0.2
X1465 a_21477_13560# a_21957_11030# vdd vdd sky130_fd_pr__pfet_01v8_lvt ad=0.174 pd=1.78 as=0.174 ps=1.78 w=0.6 l=0.35
X1466 a_9105_11602# a_8487_11686# a_10175_11935# vdd sky130_fd_pr__pfet_01v8 ad=0.868 pd=6.22 as=0.462 ps=3.13 w=2.8 l=0.15
X1467 a_21927_11686# a_27157_11105# vdd vdd sky130_fd_pr__pfet_01v8 ad=0.5775 pd=3.83 as=0.5775 ps=3.83 w=3.5 l=0.15
X1468 vdd a_323_2160# a_3663_8670# vdd sky130_fd_pr__pfet_01v8_lvt ad=0.1595 pd=1.39 as=0.1595 ps=1.39 w=1.1 l=0.35
X1469 a_7935_9170# a_15349_1934# a_15027_8795# vdd sky130_fd_pr__pfet_01v8_lvt ad=0.667 pd=5.18 as=0.3335 ps=2.59 w=2.3 l=0.35
X1470 vdd a_20959_8261# vdd vdd sky130_fd_pr__pfet_01v8 ad=0.2805 pd=2.03 as=0 ps=0 w=1.7 l=0.15
X1471 a_23199_8261# a_22753_3298# a_13102_7094# vdd sky130_fd_pr__pfet_01v8_lvt ad=0.609 pd=4.78 as=0.609 ps=4.78 w=2.1 l=0.35
X1472 vdd a_16768_7094# a_16768_8794# vdd sky130_fd_pr__pfet_01v8 ad=0.462 pd=3.13 as=0.462 ps=3.13 w=2.8 l=0.15
X1473 a_7935_9170# b1 a_15027_4275# vss sky130_fd_pr__nfet_01v8_lvt ad=0.2325 pd=2.12 as=0.12375 ps=1.08 w=0.75 l=0.15
X1474 a_7935_4450# b5 a_15027_7375# vss sky130_fd_pr__nfet_01v8_lvt ad=0.2325 pd=2.12 as=0.12375 ps=1.08 w=0.75 l=0.15
X1475 a_2903_2190# a_323_2160# vdd vdd sky130_fd_pr__pfet_01v8_lvt ad=0.1595 pd=1.39 as=0.1595 ps=1.39 w=1.1 l=0.35
X1476 vdd a_25035_7929# a_26917_7240# vdd sky130_fd_pr__pfet_01v8 ad=0.527 pd=4.02 as=0.2805 ps=2.03 w=1.7 l=0.15
X1477 a_11527_2855# a_12237_1934# a_7935_6810# vdd sky130_fd_pr__pfet_01v8_lvt ad=0.3335 pd=2.59 as=0.667 ps=5.18 w=2.3 l=0.35
X1478 a_17855_12810# a_8819_12702# a_17727_13625# vss sky130_fd_pr__nfet_01v8 ad=0.2465 pd=2.28 as=0.2465 ps=2.28 w=0.85 l=0.35
X1479 ckd1 ckd3 vdd vdd sky130_fd_pr__pfet_01v8_lvt ad=0.406 pd=3.38 as=0.406 ps=3.38 w=1.4 l=0.35
X1480 vss a_20959_6161# vss vss sky130_fd_pr__nfet_01v8_lvt ad=0.203 pd=1.98 as=0 ps=0 w=0.7 l=0.15
X1481 a_7935_3850# a_7935_4450# vdd vdd sky130_fd_pr__pfet_01v8_lvt ad=0.609 pd=4.78 as=0.609 ps=4.78 w=2.1 l=0.35
X1482 a_12548_205# a1 vss vss sky130_fd_pr__nfet_01v8 ad=0.1305 pd=1.48 as=0.1305 ps=1.48 w=0.45 l=0.18
X1483 a_25035_5509# f7 a_13102_2574# vdd sky130_fd_pr__pfet_01v8_lvt ad=0.609 pd=4.78 as=0.609 ps=4.78 w=2.1 l=0.35
X1484 a_20513_3298# f2 vdd vdd sky130_fd_pr__pfet_01v8 ad=0.261 pd=2.38 as=0.261 ps=2.38 w=0.9 l=0.18
X1485 vss a_23199_3741# vss vss sky130_fd_pr__nfet_01v8_lvt ad=0.203 pd=1.98 as=0 ps=0 w=0.7 l=0.15
X1486 a_8517_11085# a_7587_12850# vss vss sky130_fd_pr__nfet_01v8 ad=0.29 pd=2.58 as=0.29 ps=2.58 w=1 l=0.18
X1487 vss vdd a_30217_2855# vss sky130_fd_pr__nfet_01v8 ad=0.16675 pd=1.44 as=0.16675 ps=1.44 w=1.15 l=0.2
X1488 cke3 a_21865_11030# vdd vdd sky130_fd_pr__pfet_01v8_lvt ad=0.87 pd=6.58 as=0.87 ps=6.58 w=3 l=0.35
X1489 vss a_29097_13560# a_23615_11840# vss sky130_fd_pr__nfet_01v8_lvt ad=0.589 pd=4.42 as=0.3135 ps=2.23 w=1.9 l=0.15
X1490 vss a_25439_7929# vss vss sky130_fd_pr__nfet_01v8_lvt ad=0.203 pd=1.98 as=0 ps=0 w=0.7 l=0.15
X1491 vdd a_21865_11030# cke3 vdd sky130_fd_pr__pfet_01v8 ad=0.495 pd=3.33 as=0.495 ps=3.33 w=3 l=0.15
X1492 a_7935_8570# a_16125_1934# a_15027_8795# vdd sky130_fd_pr__pfet_01v8_lvt ad=0.667 pd=5.18 as=0.3335 ps=2.59 w=2.3 l=0.35
X1493 a_20197_6640# a_18315_6161# vss vss sky130_fd_pr__nfet_01v8_lvt ad=0.203 pd=1.98 as=0.203 ps=1.98 w=0.7 l=0.15
X1494 vss vdd a_30817_8037# vss sky130_fd_pr__nfet_01v8 ad=0.17835 pd=1.52 as=0.17835 ps=1.52 w=1.23 l=0.2
X1495 vdd a_25439_8261# vdd vdd sky130_fd_pr__pfet_01v8 ad=0.2805 pd=2.03 as=0 ps=0 w=1.7 l=0.15
X1496 vdd dp dn vdd sky130_fd_pr__pfet_01v8 ad=0.589 pd=4.42 as=0.3135 ps=2.23 w=1.9 l=0.15
X1497 a_12237_1934# a4 vss vss sky130_fd_pr__nfet_01v8 ad=0.1305 pd=1.48 as=0.1305 ps=1.48 w=0.45 l=0.18
X1498 dn rst_n a_12947_11933# vss sky130_fd_pr__nfet_01v8_lvt ad=0.403 pd=3.22 as=0.2145 ps=1.63 w=1.3 l=0.15
X1499 a_18105_12784# a_21477_13560# vdd vdd sky130_fd_pr__pfet_01v8 ad=1.085 pd=7.62 as=0.5775 ps=3.83 w=3.5 l=0.15
X1500 a_6063_6810# a_5993_6784# vdd vdd sky130_fd_pr__pfet_01v8_lvt ad=0.3045 pd=2.39 as=0.609 ps=4.78 w=2.1 l=0.35
.ends
