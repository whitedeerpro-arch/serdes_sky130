* NGSPICE file created from serdes_rx_cmos_pi_8ph_5g_pdk.ext - technology: sky130A

.subckt serdes_rx_cmos_pi_8ph_5g_pdk c0 c1 c2 c3 c4 c5 c6 c7 a0 a1 a2 a3 a4 a5 a6
+ a7 b0 b1 b2 b3 b4 b5 b6 b7 f0 f1 f2 f3 f4 f5 f6 f7 rst_n dp dn ep en ckd0 ckd1 ckd2
+ ckd3 cke0 cke1 cke2 cke3 vdd vss
X0 vdd a_9351_6170# vdd vdd sky130_fd_pr__pfet_01v8 ad=0.667 pd=5.18 as=186.767 ps=1.4249k w=2.3 l=0.15
X1 a_16191_3430# a_15733_3298# a_7971_1984# vss sky130_fd_pr__nfet_01v8_lvt ad=0.145 pd=1.58 as=0.145 ps=1.58 w=0.5 l=0.15
X2 a_363_6446# a4 a_3087_8796# vss sky130_fd_pr__nfet_01v8_lvt ad=0.248 pd=2.22 as=0.132 ps=1.13 w=0.8 l=0.15
X3 a_6247_7364# b7 a_363_4894# vss sky130_fd_pr__nfet_01v8_lvt ad=0.132 pd=1.13 as=0.248 ps=2.22 w=0.8 l=0.15
X4 a_11173_1814# f3 vdd vdd sky130_fd_pr__pfet_01v8 ad=0.261 pd=2.38 as=0.261 ps=2.38 w=0.9 l=0.18
X5 vdd a_13911_5530# vdd vdd sky130_fd_pr__pfet_01v8 ad=0.667 pd=5.18 as=0 ps=0 w=2.3 l=0.15
X6 vss a_24971_12720# cke3 vss sky130_fd_pr__nfet_01v8_lvt ad=0.372 pd=3.02 as=0.198 ps=1.53 w=1.2 l=0.15
X7 vdd a_4027_11933# ckd1 vdd sky130_fd_pr__pfet_01v8 ad=0.4158 pd=2.85 as=0.4158 ps=2.85 w=2.52 l=0.15
X8 a_10891_1645# a_8935_1650# vdd vdd sky130_fd_pr__pfet_01v8 ad=0.667 pd=5.18 as=0.667 ps=5.18 w=2.3 l=0.15
X9 a_13495_7950# a_13453_3298# a_7971_6504# vdd sky130_fd_pr__pfet_01v8_lvt ad=0.261 pd=2.38 as=0.261 ps=2.38 w=0.9 l=0.35
X10 a_9351_1650# a_8893_1814# a_4811_1984# vdd sky130_fd_pr__pfet_01v8_lvt ad=0.261 pd=2.38 as=0.261 ps=2.38 w=0.9 l=0.35
X11 vdd c0 a_363_2286# vdd sky130_fd_pr__pfet_01v8_lvt ad=0.493 pd=3.98 as=0.2465 ps=1.99 w=1.7 l=0.35
X12 a_8935_10050# a_8893_1814# a_4811_9376# vss sky130_fd_pr__nfet_01v8_lvt ad=0.145 pd=1.58 as=0.145 ps=1.58 w=0.5 l=0.15
X13 vss a_6247_8796# a_7971_9376# vss sky130_fd_pr__nfet_01v8_lvt ad=0.31 pd=2.62 as=0.165 ps=1.33 w=1 l=0.15
X14 vss a_21768_9194# dp vss sky130_fd_pr__nfet_01v8_lvt ad=0.434 pd=3.42 as=0.231 ps=1.73 w=1.4 l=0.15
X15 a_15981_11939# a_16649_11686# vss vss sky130_fd_pr__nfet_01v8_lvt ad=0.1305 pd=1.48 as=0.1305 ps=1.48 w=0.45 l=0.15
X16 a_363_9054# c7 vdd vdd sky130_fd_pr__pfet_01v8_lvt ad=0.2465 pd=1.99 as=0.493 ps=3.98 w=1.7 l=0.35
X17 vdd a_21602_2174# en vdd sky130_fd_pr__pfet_01v8_lvt ad=0.406 pd=3.09 as=0.406 ps=3.09 w=2.8 l=0.35
X18 a_363_8526# a0 a_3087_2844# vss sky130_fd_pr__nfet_01v8_lvt ad=0.248 pd=2.22 as=0.132 ps=1.13 w=0.8 l=0.15
X19 a_18971_12720# a_17221_12720# vss vss sky130_fd_pr__nfet_01v8_lvt ad=0.1218 pd=1.42 as=0.1218 ps=1.42 w=0.42 l=0.15
X20 a_13911_7950# f4 a_7971_6504# vdd sky130_fd_pr__pfet_01v8_lvt ad=0.261 pd=2.38 as=0.261 ps=2.38 w=0.9 l=0.35
X21 a_17731_3745# a_20664_3688# vss sky130_fd_pr__res_high_po_0p69 l=7.2
X22 vdd a_5719_11933# ckd3 vdd sky130_fd_pr__pfet_01v8 ad=0.7812 pd=5.66 as=0.4158 ps=2.85 w=2.52 l=0.15
X23 a_11631_8270# a_11173_3298# a_4811_9376# vdd sky130_fd_pr__pfet_01v8_lvt ad=0.261 pd=2.38 as=0.261 ps=2.38 w=0.9 l=0.35
X24 a_6247_2844# a_6621_1968# a_363_2814# vdd sky130_fd_pr__pfet_01v8_lvt ad=0.3045 pd=2.39 as=0.609 ps=4.78 w=2.1 l=0.35
X25 a_2901_12720# a_4651_12720# vss vss sky130_fd_pr__nfet_01v8_lvt ad=0.1218 pd=1.42 as=0.1218 ps=1.42 w=0.42 l=0.15
X26 a_4811_9376# a_3087_8796# vdd vdd sky130_fd_pr__pfet_01v8 ad=0.363 pd=2.53 as=0.682 ps=5.02 w=2.2 l=0.15
X27 ckd0 a_2901_12720# vdd vdd sky130_fd_pr__pfet_01v8 ad=0.4158 pd=2.85 as=0.7812 ps=5.66 w=2.52 l=0.15
X28 vdd a_15469_11950# a_15981_11939# vdd sky130_fd_pr__pfet_01v8 ad=0.36465 pd=2.54 as=0.36465 ps=2.54 w=2.21 l=0.15
X29 a_363_2814# c1 vdd vdd sky130_fd_pr__pfet_01v8_lvt ad=0.2465 pd=1.99 as=0.493 ps=3.98 w=1.7 l=0.35
X30 a_4622_11162# a_4089_11686# a_5719_11933# vdd sky130_fd_pr__pfet_01v8 ad=0.37455 pd=2.6 as=0.37455 ps=2.6 w=2.27 l=0.15
X31 a_15451_3745# a_13495_3750# vss vss sky130_fd_pr__nfet_01v8_lvt ad=0.1595 pd=1.68 as=0.1595 ps=1.68 w=0.55 l=0.15
X32 cke3 cke1 vdd vdd sky130_fd_pr__pfet_01v8 ad=0.5481 pd=4.36 as=0.5481 ps=4.36 w=1.89 l=0.15
X33 a_15451_2690# a_13495_3430# vdd vdd sky130_fd_pr__pfet_01v8 ad=0.667 pd=5.18 as=0.667 ps=5.18 w=2.3 l=0.15
X34 a_17731_3745# a_15775_3750# vdd vdd sky130_fd_pr__pfet_01v8 ad=0.667 pd=5.18 as=0.667 ps=5.18 w=2.3 l=0.15
X35 a_16191_1650# f7 a_4811_1984# vss sky130_fd_pr__nfet_01v8_lvt ad=0.145 pd=1.58 as=0.145 ps=1.58 w=0.5 l=0.15
X36 a_4651_12720# a_4622_11162# vss vss sky130_fd_pr__nfet_01v8_lvt ad=0.2805 pd=2.03 as=0.527 ps=4.02 w=1.7 l=0.15
X37 a_17731_4790# a_20664_3688# vss sky130_fd_pr__res_high_po_0p69 l=7.2
X38 a_13171_1645# a_11215_1650# vdd vdd sky130_fd_pr__pfet_01v8 ad=0.667 pd=5.18 as=0.667 ps=5.18 w=2.3 l=0.15
X39 a_16191_3750# a_15733_3298# a_4811_4856# vdd sky130_fd_pr__pfet_01v8_lvt ad=0.261 pd=2.38 as=0.261 ps=2.38 w=0.9 l=0.35
X40 ckd0 a_2901_12720# vdd vdd sky130_fd_pr__pfet_01v8 ad=0.4158 pd=2.85 as=0.4158 ps=2.85 w=2.52 l=0.15
X41 cke0 a_17221_12720# vdd vdd sky130_fd_pr__pfet_01v8 ad=0.4158 pd=2.85 as=0.7812 ps=5.66 w=2.52 l=0.15
X42 a_363_9054# b3 a_6247_7364# vss sky130_fd_pr__nfet_01v8_lvt ad=0.248 pd=2.22 as=0.132 ps=1.13 w=0.8 l=0.15
X43 a_363_6974# b7 a_6247_2844# vss sky130_fd_pr__nfet_01v8_lvt ad=0.248 pd=2.22 as=0.132 ps=1.13 w=0.8 l=0.15
X44 ckd2 a_4651_12720# vdd vdd sky130_fd_pr__pfet_01v8 ad=0.4158 pd=2.85 as=0.7812 ps=5.66 w=2.52 l=0.15
X45 a_1987_11933# a_411_11960# dp vdd sky130_fd_pr__pfet_01v8_lvt ad=0.32915 pd=2.56 as=0.6583 ps=5.12 w=2.27 l=0.35
X46 a_13171_9310# a_20664_8208# vss sky130_fd_pr__res_high_po_0p69 l=7.2
X47 a_8935_7950# f0 a_4811_6504# vdd sky130_fd_pr__pfet_01v8_lvt ad=0.261 pd=2.38 as=0.261 ps=2.38 w=0.9 l=0.35
X48 a_11631_3430# a_11173_3298# a_7971_1984# vss sky130_fd_pr__nfet_01v8_lvt ad=0.145 pd=1.58 as=0.145 ps=1.58 w=0.5 l=0.15
X49 vdd a_2901_12720# ckd0 vdd sky130_fd_pr__pfet_01v8 ad=0.4158 pd=2.85 as=0.4158 ps=2.85 w=2.52 l=0.15
X50 a_15451_8265# a_13495_8270# vdd vdd sky130_fd_pr__pfet_01v8 ad=0.667 pd=5.18 as=0.667 ps=5.18 w=2.3 l=0.15
X51 a_16191_7950# f6 a_7971_6504# vdd sky130_fd_pr__pfet_01v8_lvt ad=0.261 pd=2.38 as=0.261 ps=2.38 w=0.9 l=0.35
X52 a_6247_4276# b3 a_363_6974# vss sky130_fd_pr__nfet_01v8_lvt ad=0.132 pd=1.13 as=0.248 ps=2.22 w=0.8 l=0.15
X53 a_8935_7950# f0 a_7971_6504# vss sky130_fd_pr__nfet_01v8_lvt ad=0.145 pd=1.58 as=0.145 ps=1.58 w=0.5 l=0.15
X54 a_13911_8270# a_13453_3298# a_4811_9376# vdd sky130_fd_pr__pfet_01v8_lvt ad=0.261 pd=2.38 as=0.261 ps=2.38 w=0.9 l=0.35
X55 a_11215_8270# a_11173_3298# a_4811_9376# vss sky130_fd_pr__nfet_01v8_lvt ad=0.145 pd=1.58 as=0.145 ps=1.58 w=0.5 l=0.15
X56 a_11173_1814# f3 vss vss sky130_fd_pr__nfet_01v8 ad=0.1305 pd=1.48 as=0.1305 ps=1.48 w=0.45 l=0.18
X57 vdd a_11631_1650# vdd vdd sky130_fd_pr__pfet_01v8 ad=0.667 pd=5.18 as=0 ps=0 w=2.3 l=0.15
X58 a_8267_11933# rst_n dn vss sky130_fd_pr__nfet_01v8_lvt ad=0.2145 pd=1.63 as=0.403 ps=3.22 w=1.3 l=0.15
X59 a_16679_11933# a_16649_11686# a_4651_12720# vdd sky130_fd_pr__pfet_01v8 ad=0.7037 pd=5.16 as=0.37455 ps=2.6 w=2.27 l=0.15
X60 a_13171_9310# a_11215_10050# vss vss sky130_fd_pr__nfet_01v8_lvt ad=0.1595 pd=1.68 as=0.1595 ps=1.68 w=0.55 l=0.15
X61 vdd a_21602_9194# a_21602_6694# vdd sky130_fd_pr__pfet_01v8_lvt ad=0.5365 pd=4.28 as=0.26825 ps=2.14 w=1.85 l=0.35
X62 a_15775_1650# a_15733_1814# a_4811_1984# vss sky130_fd_pr__nfet_01v8_lvt ad=0.145 pd=1.58 as=0.145 ps=1.58 w=0.5 l=0.15
X63 a_15775_3750# f6 a_4811_4856# vdd sky130_fd_pr__pfet_01v8_lvt ad=0.261 pd=2.38 as=0.261 ps=2.38 w=0.9 l=0.35
X64 ep a_411_11960# a_14547_11933# vdd sky130_fd_pr__pfet_01v8_lvt ad=0.32915 pd=2.56 as=0.32915 ps=2.56 w=2.27 l=0.35
X65 a_16649_11686# a_20335_12811# vss vss sky130_fd_pr__nfet_01v8_lvt ad=0.17325 pd=1.38 as=0.3255 ps=2.72 w=1.05 l=0.15
X66 a_3087_8796# a6 a_363_8526# vss sky130_fd_pr__nfet_01v8_lvt ad=0.132 pd=1.13 as=0.248 ps=2.22 w=0.8 l=0.15
X67 a_7971_6504# a_6247_7364# vdd vdd sky130_fd_pr__pfet_01v8 ad=0.363 pd=2.53 as=0.363 ps=2.53 w=2.2 l=0.15
X68 a_11215_1650# f3 a_4811_1984# vdd sky130_fd_pr__pfet_01v8_lvt ad=0.261 pd=2.38 as=0.261 ps=2.38 w=0.9 l=0.35
X69 vss a_21602_6694# dn vss sky130_fd_pr__nfet_01v8_lvt ad=0.434 pd=3.42 as=0.231 ps=1.73 w=1.4 l=0.15
X70 a_24971_12720# a_23462_11162# vdd vdd sky130_fd_pr__pfet_01v8 ad=0.6293 pd=4.68 as=0.33495 ps=2.36 w=2.03 l=0.15
X71 a_10891_8265# a_8935_8270# vss vss sky130_fd_pr__nfet_01v8_lvt ad=0.1595 pd=1.68 as=0.1595 ps=1.68 w=0.55 l=0.15
X72 vss a_4119_11933# a_2901_12720# vss sky130_fd_pr__nfet_01v8_lvt ad=0.527 pd=4.02 as=0.2805 ps=2.03 w=1.7 l=0.15
X73 a_13495_8270# f4 a_4811_9376# vdd sky130_fd_pr__pfet_01v8_lvt ad=0.261 pd=2.38 as=0.261 ps=2.38 w=0.9 l=0.35
X74 a_3087_2844# a2 a_363_2286# vss sky130_fd_pr__nfet_01v8_lvt ad=0.132 pd=1.13 as=0.248 ps=2.22 w=0.8 l=0.15
X75 a_11631_6170# f3 a_4811_6504# vss sky130_fd_pr__nfet_01v8_lvt ad=0.145 pd=1.58 as=0.145 ps=1.58 w=0.5 l=0.15
X76 vdd a_6247_2844# a_7971_1984# vdd sky130_fd_pr__pfet_01v8 ad=0.682 pd=5.02 as=0.363 ps=2.53 w=2.2 l=0.15
X77 vdd a_16191_3430# vdd vdd sky130_fd_pr__pfet_01v8 ad=0.667 pd=5.18 as=0 ps=0 w=2.3 l=0.15
X78 vss a_16191_3750# vss vss sky130_fd_pr__nfet_01v8_lvt ad=0.1595 pd=1.68 as=55.9628 ps=516.59998 w=0.55 l=0.15
X79 a_4027_11933# a_16649_11686# a_23462_11162# vss sky130_fd_pr__nfet_01v8_lvt ad=0.231 pd=1.73 as=0.434 ps=3.42 w=1.4 l=0.15
X80 a_15451_7210# a_20664_6336# vss sky130_fd_pr__res_high_po_0p69 l=7.2
X81 vdd a_13911_1650# vdd vdd sky130_fd_pr__pfet_01v8 ad=0.667 pd=5.18 as=0 ps=0 w=2.3 l=0.15
X82 a_9351_3430# a_8893_3298# a_4811_1984# vdd sky130_fd_pr__pfet_01v8_lvt ad=0.261 pd=2.38 as=0.261 ps=2.38 w=0.9 l=0.35
X83 a_18971_12720# a_17221_12720# vdd vdd sky130_fd_pr__pfet_01v8 ad=0.5104 pd=4.1 as=0.5104 ps=4.1 w=1.76 l=0.15
X84 a_9351_8270# f0 a_7971_9376# vdd sky130_fd_pr__pfet_01v8_lvt ad=0.261 pd=2.38 as=0.261 ps=2.38 w=0.9 l=0.35
X85 a_21602_4674# a_21602_2174# vss sky130_fd_pr__res_high_po_0p35 l=10.5
X86 a_6621_1968# b3 vdd vdd sky130_fd_pr__pfet_01v8 ad=0.261 pd=2.38 as=0.261 ps=2.38 w=0.9 l=0.18
X87 a_2901_12720# a_4651_12720# vdd vdd sky130_fd_pr__pfet_01v8 ad=0.5104 pd=4.1 as=0.5104 ps=4.1 w=1.76 l=0.15
X88 a_13495_10050# f5 a_7971_9376# vss sky130_fd_pr__nfet_01v8_lvt ad=0.145 pd=1.58 as=0.145 ps=1.58 w=0.5 l=0.15
X89 a_363_4366# a2 a_3087_8796# vss sky130_fd_pr__nfet_01v8_lvt ad=0.248 pd=2.22 as=0.132 ps=1.13 w=0.8 l=0.15
X90 vdd a_16191_8270# vdd vdd sky130_fd_pr__pfet_01v8 ad=0.667 pd=5.18 as=0 ps=0 w=2.3 l=0.15
X91 a_8935_10050# f1 a_7971_9376# vss sky130_fd_pr__nfet_01v8_lvt ad=0.145 pd=1.58 as=0.145 ps=1.58 w=0.5 l=0.15
X92 a_363_2286# c0 vss vss sky130_fd_pr__nfet_01v8_lvt ad=0.493 pd=3.98 as=0.493 ps=3.98 w=1.7 l=0.15
X93 a_13495_10050# a_13453_1814# a_4811_9376# vss sky130_fd_pr__nfet_01v8_lvt ad=0.145 pd=1.58 as=0.145 ps=1.58 w=0.5 l=0.15
X94 a_13171_8265# a_11215_8270# vss vss sky130_fd_pr__nfet_01v8_lvt ad=0.1595 pd=1.68 as=0.1595 ps=1.68 w=0.55 l=0.15
X95 a_3087_7364# a_3461_1968# a_363_8526# vdd sky130_fd_pr__pfet_01v8_lvt ad=0.3045 pd=2.39 as=0.609 ps=4.78 w=2.1 l=0.35
X96 a_13911_6170# f5 a_4811_6504# vss sky130_fd_pr__nfet_01v8_lvt ad=0.145 pd=1.58 as=0.145 ps=1.58 w=0.5 l=0.15
X97 a_17731_1645# a_15775_1650# vss vss sky130_fd_pr__nfet_01v8_lvt ad=0.1595 pd=1.68 as=0.1595 ps=1.68 w=0.55 l=0.15
X98 a_7718_205# b6 vdd vdd sky130_fd_pr__pfet_01v8 ad=0.261 pd=2.38 as=0.261 ps=2.38 w=0.9 l=0.18
X99 vdd a_21768_6694# a_21768_9194# vdd sky130_fd_pr__pfet_01v8_lvt ad=0.26825 pd=2.14 as=0.26825 ps=2.14 w=1.85 l=0.35
X100 a_11631_5530# f3 a_4811_4856# vss sky130_fd_pr__nfet_01v8_lvt ad=0.145 pd=1.58 as=0.145 ps=1.58 w=0.5 l=0.15
X101 a_7971_9376# a_6247_8796# vdd vdd sky130_fd_pr__pfet_01v8 ad=0.363 pd=2.53 as=0.363 ps=2.53 w=2.2 l=0.15
X102 a_16191_5530# a_15733_1814# a_4811_4856# vdd sky130_fd_pr__pfet_01v8_lvt ad=0.261 pd=2.38 as=0.261 ps=2.38 w=0.9 l=0.35
X103 a_363_9054# a_7061_1968# a_6247_4276# vdd sky130_fd_pr__pfet_01v8_lvt ad=0.609 pd=4.78 as=0.3045 ps=2.39 w=2.1 l=0.35
X104 a_363_4894# a_6068_205# a_6247_4276# vdd sky130_fd_pr__pfet_01v8_lvt ad=0.609 pd=4.78 as=0.3045 ps=2.39 w=2.1 l=0.35
X105 vdd c3 a_363_4894# vdd sky130_fd_pr__pfet_01v8_lvt ad=0.493 pd=3.98 as=0.2465 ps=1.99 w=1.7 l=0.35
X106 a_8893_3298# f0 vdd vdd sky130_fd_pr__pfet_01v8 ad=0.261 pd=2.38 as=0.261 ps=2.38 w=0.9 l=0.18
X107 a_21602_9194# a_20664_8208# sky130_fd_pr__cap_mim_m3_1 l=4.1 w=4.1
X108 a_363_6446# c4 vdd vdd sky130_fd_pr__pfet_01v8_lvt ad=0.2465 pd=1.99 as=0.2465 ps=1.99 w=1.7 l=0.35
X109 a_363_8526# c6 vdd vdd sky130_fd_pr__pfet_01v8_lvt ad=0.2465 pd=1.99 as=0.493 ps=3.98 w=1.7 l=0.35
X110 vss a_11631_8270# vss vss sky130_fd_pr__nfet_01v8_lvt ad=0.1595 pd=1.68 as=0 ps=0 w=0.55 l=0.15
X111 a_17731_6165# a_15775_6170# vdd vdd sky130_fd_pr__pfet_01v8 ad=0.667 pd=5.18 as=0.667 ps=5.18 w=2.3 l=0.15
X112 a_15451_1645# a_20664_1816# vss sky130_fd_pr__res_high_po_0p69 l=7.2
X113 ckd1 a_4027_11933# vdd vdd sky130_fd_pr__pfet_01v8 ad=0.4158 pd=2.85 as=0.4158 ps=2.85 w=2.52 l=0.15
X114 a_16191_6170# a_15733_1814# a_4811_6504# vdd sky130_fd_pr__pfet_01v8_lvt ad=0.261 pd=2.38 as=0.261 ps=2.38 w=0.9 l=0.35
X115 a_13495_6170# a_13453_1814# a_4811_6504# vss sky130_fd_pr__nfet_01v8_lvt ad=0.145 pd=1.58 as=0.145 ps=1.58 w=0.5 l=0.15
X116 a_15775_3750# f6 a_7971_4856# vss sky130_fd_pr__nfet_01v8_lvt ad=0.145 pd=1.58 as=0.145 ps=1.58 w=0.5 l=0.15
X117 vdd a_9351_7950# vdd vdd sky130_fd_pr__pfet_01v8 ad=0.667 pd=5.18 as=0 ps=0 w=2.3 l=0.15
X118 vdd a_21602_4674# a_21602_2174# vdd sky130_fd_pr__pfet_01v8_lvt ad=0.26825 pd=2.14 as=0.26825 ps=2.14 w=1.85 l=0.35
X119 a_15775_5530# f7 a_4811_4856# vdd sky130_fd_pr__pfet_01v8_lvt ad=0.261 pd=2.38 as=0.261 ps=2.38 w=0.9 l=0.35
X120 a_363_2286# a_3901_1968# a_3087_7364# vdd sky130_fd_pr__pfet_01v8_lvt ad=0.609 pd=4.78 as=0.3045 ps=2.39 w=2.1 l=0.35
X121 a_11215_1650# f3 a_7971_1984# vss sky130_fd_pr__nfet_01v8_lvt ad=0.145 pd=1.58 as=0.145 ps=1.58 w=0.5 l=0.15
X122 a_13911_5530# f5 a_4811_4856# vss sky130_fd_pr__nfet_01v8_lvt ad=0.145 pd=1.58 as=0.145 ps=1.58 w=0.5 l=0.15
X123 a_11215_3430# f2 a_4811_1984# vdd sky130_fd_pr__pfet_01v8_lvt ad=0.261 pd=2.38 as=0.261 ps=2.38 w=0.9 l=0.35
X124 a_11215_3750# a_11173_3298# a_7971_4856# vdd sky130_fd_pr__pfet_01v8_lvt ad=0.261 pd=2.38 as=0.261 ps=2.38 w=0.9 l=0.35
X125 a_21768_4674# a_21768_2174# vss vss sky130_fd_pr__nfet_01v8_lvt ad=0.5365 pd=4.28 as=0.5365 ps=4.28 w=1.85 l=0.15
X126 a_6621_1968# b3 vss vss sky130_fd_pr__nfet_01v8 ad=0.1305 pd=1.48 as=0.1305 ps=1.48 w=0.45 l=0.18
X127 a_15981_11939# a_15469_11950# vdd vdd sky130_fd_pr__pfet_01v8 ad=0.36465 pd=2.54 as=0.36465 ps=2.54 w=2.21 l=0.15
X128 a_9351_6170# f1 a_4811_6504# vss sky130_fd_pr__nfet_01v8_lvt ad=0.145 pd=1.58 as=0.145 ps=1.58 w=0.5 l=0.15
X129 en a_21602_2174# vdd vdd sky130_fd_pr__pfet_01v8_lvt ad=0.406 pd=3.09 as=0.406 ps=3.09 w=2.8 l=0.35
X130 ckd2 ckd0 vss vss sky130_fd_pr__nfet_01v8_lvt ad=0.1305 pd=1.48 as=0.1305 ps=1.48 w=0.45 l=0.15
X131 a_5719_11933# a_4089_11686# a_4622_11162# vdd sky130_fd_pr__pfet_01v8 ad=0.7037 pd=5.16 as=0.37455 ps=2.6 w=2.27 l=0.15
X132 a_9351_6170# a_8893_1814# a_7971_6504# vss sky130_fd_pr__nfet_01v8_lvt ad=0.145 pd=1.58 as=0.145 ps=1.58 w=0.5 l=0.15
X133 a_363_2814# a_6621_1968# a_6247_2844# vdd sky130_fd_pr__pfet_01v8_lvt ad=0.609 pd=4.78 as=0.3045 ps=2.39 w=2.1 l=0.35
X134 a_11631_3750# f2 a_7971_4856# vdd sky130_fd_pr__pfet_01v8_lvt ad=0.261 pd=2.38 as=0.261 ps=2.38 w=0.9 l=0.35
X135 a_3087_8796# a_3461_1968# a_363_4366# vdd sky130_fd_pr__pfet_01v8_lvt ad=0.3045 pd=2.39 as=0.609 ps=4.78 w=2.1 l=0.35
X136 a_3087_4276# a_4341_1968# a_363_2286# vdd sky130_fd_pr__pfet_01v8_lvt ad=0.3045 pd=2.39 as=0.609 ps=4.78 w=2.1 l=0.35
X137 vss a_13911_8270# vss vss sky130_fd_pr__nfet_01v8_lvt ad=0.1595 pd=1.68 as=0 ps=0 w=0.55 l=0.15
X138 a_15775_6170# f7 a_4811_6504# vdd sky130_fd_pr__pfet_01v8_lvt ad=0.261 pd=2.38 as=0.261 ps=2.38 w=0.9 l=0.35
X139 a_363_2286# a6 a_3087_4276# vss sky130_fd_pr__nfet_01v8_lvt ad=0.248 pd=2.22 as=0.132 ps=1.13 w=0.8 l=0.15
X140 vdd c7 a_363_9054# vdd sky130_fd_pr__pfet_01v8_lvt ad=0.2465 pd=1.99 as=0.2465 ps=1.99 w=1.7 l=0.35
X141 a_11631_10050# a_11173_1814# a_4811_9376# vdd sky130_fd_pr__pfet_01v8_lvt ad=0.261 pd=2.38 as=0.261 ps=2.38 w=0.9 l=0.35
X142 a_21602_4674# a_20664_3688# sky130_fd_pr__cap_mim_m3_1 l=4.1 w=4.1
X143 vss a_4622_11162# a_4651_12720# vss sky130_fd_pr__nfet_01v8_lvt ad=0.527 pd=4.02 as=0.2805 ps=2.03 w=1.7 l=0.15
X144 a_8935_8270# a_8893_3298# a_7971_9376# vdd sky130_fd_pr__pfet_01v8_lvt ad=0.261 pd=2.38 as=0.261 ps=2.38 w=0.9 l=0.35
X145 a_16679_11933# a_17182_11162# vdd vdd sky130_fd_pr__pfet_01v8 ad=0.1218 pd=1.42 as=0.1218 ps=1.42 w=0.42 l=0.28
X146 a_7718_205# b6 vss vss sky130_fd_pr__nfet_01v8 ad=0.1305 pd=1.48 as=0.1305 ps=1.48 w=0.45 l=0.18
X147 vdd a_3087_7364# a_4811_6504# vdd sky130_fd_pr__pfet_01v8 ad=0.682 pd=5.02 as=0.363 ps=2.53 w=2.2 l=0.15
X148 vdd c1 a_363_2814# vdd sky130_fd_pr__pfet_01v8_lvt ad=0.2465 pd=1.99 as=0.2465 ps=1.99 w=1.7 l=0.35
X149 a_13495_5530# a_13453_1814# a_4811_4856# vss sky130_fd_pr__nfet_01v8_lvt ad=0.145 pd=1.58 as=0.145 ps=1.58 w=0.5 l=0.15
X150 vdd a_23221_12720# cke1 vdd sky130_fd_pr__pfet_01v8 ad=0.7812 pd=5.66 as=0.4158 ps=2.85 w=2.52 l=0.15
X151 vss a_9351_3430# vss vss sky130_fd_pr__nfet_01v8_lvt ad=0.1595 pd=1.68 as=0 ps=0 w=0.55 l=0.15
X152 a_8893_3298# f0 vss vss sky130_fd_pr__nfet_01v8 ad=0.1305 pd=1.48 as=0.1305 ps=1.48 w=0.45 l=0.18
X153 a_22959_11933# a_1418_11110# vss vss sky130_fd_pr__nfet_01v8 ad=0.29 pd=2.58 as=0.29 ps=2.58 w=1 l=0.18
X154 dn rst_n a_8267_11933# vss sky130_fd_pr__nfet_01v8_lvt ad=0.403 pd=3.22 as=0.2145 ps=1.63 w=1.3 l=0.15
X155 a_4027_11933# a_10399_11933# vdd vdd sky130_fd_pr__pfet_01v8 ad=0.58905 pd=3.9 as=1.1067 ps=7.76 w=3.57 l=0.15
X156 a_15451_6165# a_13495_6170# vss vss sky130_fd_pr__nfet_01v8_lvt ad=0.1595 pd=1.68 as=0.1595 ps=1.68 w=0.55 l=0.15
X157 a_9351_5530# f1 a_4811_4856# vss sky130_fd_pr__nfet_01v8_lvt ad=0.145 pd=1.58 as=0.145 ps=1.58 w=0.5 l=0.15
X158 cke2 a_18971_12720# vdd vdd sky130_fd_pr__pfet_01v8 ad=0.4158 pd=2.85 as=0.7812 ps=5.66 w=2.52 l=0.15
X159 vdd a_24971_12720# cke3 vdd sky130_fd_pr__pfet_01v8 ad=0.7812 pd=5.66 as=0.4158 ps=2.85 w=2.52 l=0.15
X160 a_2901_12720# a_16649_11686# a_17182_11162# vdd sky130_fd_pr__pfet_01v8 ad=0.37455 pd=2.6 as=0.7037 ps=5.16 w=2.27 l=0.15
X161 a_15451_9310# a_13495_10050# vdd vdd sky130_fd_pr__pfet_01v8 ad=0.667 pd=5.18 as=0.667 ps=5.18 w=2.3 l=0.15
X162 a_9351_5530# a_8893_1814# a_7971_4856# vss sky130_fd_pr__nfet_01v8_lvt ad=0.145 pd=1.58 as=0.145 ps=1.58 w=0.5 l=0.15
X163 a_3087_2844# a_3901_1968# a_363_4366# vdd sky130_fd_pr__pfet_01v8_lvt ad=0.3045 pd=2.39 as=0.609 ps=4.78 w=2.1 l=0.35
X164 a_20335_12811# a_20827_11933# vdd vdd sky130_fd_pr__pfet_01v8 ad=0.3465 pd=2.43 as=0.651 ps=4.82 w=2.1 l=0.15
X165 vss a_20335_12811# a_16649_11686# vss sky130_fd_pr__nfet_01v8_lvt ad=0.3255 pd=2.72 as=0.17325 ps=1.38 w=1.05 l=0.15
X166 a_363_6446# a_3901_1968# a_3087_8796# vdd sky130_fd_pr__pfet_01v8_lvt ad=0.609 pd=4.78 as=0.3045 ps=2.39 w=2.1 l=0.35
X167 a_13911_10050# a_13453_1814# a_4811_9376# vdd sky130_fd_pr__pfet_01v8_lvt ad=0.261 pd=2.38 as=0.261 ps=2.38 w=0.9 l=0.35
X168 cke1 cke3 vss vss sky130_fd_pr__nfet_01v8_lvt ad=0.1305 pd=1.48 as=0.1305 ps=1.48 w=0.45 l=0.15
X169 ckd1 ckd3 vdd vdd sky130_fd_pr__pfet_01v8 ad=0.5481 pd=4.36 as=0.5481 ps=4.36 w=1.89 l=0.15
X170 a_18971_12720# a_17182_11162# vss vss sky130_fd_pr__nfet_01v8_lvt ad=0.4205 pd=3.48 as=0.4205 ps=3.48 w=1.45 l=0.15
X171 a_16649_11686# a_20335_12811# vdd vdd sky130_fd_pr__pfet_01v8 ad=0.36465 pd=2.54 as=0.6851 ps=5.04 w=2.21 l=0.15
X172 a_23221_12720# a_22959_11933# vss vss sky130_fd_pr__nfet_01v8_lvt ad=0.4205 pd=3.48 as=0.4205 ps=3.48 w=1.45 l=0.15
X173 a_363_6974# c5 vss vss sky130_fd_pr__nfet_01v8_lvt ad=0.493 pd=3.98 as=0.493 ps=3.98 w=1.7 l=0.15
X174 vss a_9351_10050# vss vss sky130_fd_pr__nfet_01v8_lvt ad=0.1595 pd=1.68 as=0 ps=0 w=0.55 l=0.15
X175 a_11631_7950# f2 a_4811_6504# vss sky130_fd_pr__nfet_01v8_lvt ad=0.145 pd=1.58 as=0.145 ps=1.58 w=0.5 l=0.15
X176 a_13495_8270# f4 a_7971_9376# vss sky130_fd_pr__nfet_01v8_lvt ad=0.145 pd=1.58 as=0.145 ps=1.58 w=0.5 l=0.15
X177 a_4027_11933# a_5719_11933# vss vss sky130_fd_pr__nfet_01v8_lvt ad=0.1218 pd=1.42 as=0.1218 ps=1.42 w=0.42 l=0.15
X178 a_23462_11162# a_16649_11686# a_4027_11933# vss sky130_fd_pr__nfet_01v8_lvt ad=0.434 pd=3.42 as=0.231 ps=1.73 w=1.4 l=0.15
X179 vdd a_3087_8796# a_4811_9376# vdd sky130_fd_pr__pfet_01v8 ad=0.682 pd=5.02 as=0.363 ps=2.53 w=2.2 l=0.15
X180 a_13495_10050# f5 a_4811_9376# vdd sky130_fd_pr__pfet_01v8_lvt ad=0.261 pd=2.38 as=0.261 ps=2.38 w=0.9 l=0.35
X181 a_8935_1650# f1 a_7971_1984# vss sky130_fd_pr__nfet_01v8_lvt ad=0.145 pd=1.58 as=0.145 ps=1.58 w=0.5 l=0.15
X182 a_3087_4276# a4 a_363_8526# vss sky130_fd_pr__nfet_01v8_lvt ad=0.132 pd=1.13 as=0.248 ps=2.22 w=0.8 l=0.15
X183 a_10902_11162# a_3421_11939# a_2901_12720# vdd sky130_fd_pr__pfet_01v8 ad=0.37455 pd=2.6 as=0.37455 ps=2.6 w=2.27 l=0.15
X184 a_15451_4790# a_13495_5530# vss vss sky130_fd_pr__nfet_01v8_lvt ad=0.1595 pd=1.68 as=0.1595 ps=1.68 w=0.55 l=0.15
X185 a_13911_8270# a_13453_3298# a_7971_9376# vss sky130_fd_pr__nfet_01v8_lvt ad=0.145 pd=1.58 as=0.145 ps=1.58 w=0.5 l=0.15
X186 a_6247_2844# a_7061_1968# a_363_4894# vdd sky130_fd_pr__pfet_01v8_lvt ad=0.3045 pd=2.39 as=0.609 ps=4.78 w=2.1 l=0.35
X187 a_13495_1650# a_13453_1814# a_7971_1984# vdd sky130_fd_pr__pfet_01v8_lvt ad=0.261 pd=2.38 as=0.261 ps=2.38 w=0.9 l=0.35
X188 a_16191_3430# f6 a_4811_1984# vss sky130_fd_pr__nfet_01v8_lvt ad=0.145 pd=1.58 as=0.145 ps=1.58 w=0.5 l=0.15
X189 a_11215_5530# a_11173_1814# a_7971_4856# vdd sky130_fd_pr__pfet_01v8_lvt ad=0.261 pd=2.38 as=0.261 ps=2.38 w=0.9 l=0.35
X190 vdd rst_n a_411_11960# vdd sky130_fd_pr__pfet_01v8 ad=0.33 pd=2.33 as=0.33 ps=2.33 w=2 l=0.15
X191 a_2901_12720# a_3421_11939# a_10902_11162# vdd sky130_fd_pr__pfet_01v8 ad=0.37455 pd=2.6 as=0.7037 ps=5.16 w=2.27 l=0.15
X192 a_4089_11686# a_3421_11939# vss vss sky130_fd_pr__nfet_01v8_lvt ad=0.1305 pd=1.48 as=0.1305 ps=1.48 w=0.45 l=0.15
X193 a_17731_2690# a_20664_1816# vss sky130_fd_pr__res_high_po_0p69 l=7.2
X194 a_13911_1650# f5 a_7971_1984# vdd sky130_fd_pr__pfet_01v8_lvt ad=0.261 pd=2.38 as=0.261 ps=2.38 w=0.9 l=0.35
X195 a_11631_5530# f3 a_7971_4856# vdd sky130_fd_pr__pfet_01v8_lvt ad=0.261 pd=2.38 as=0.261 ps=2.38 w=0.9 l=0.35
X196 vss a_11631_10050# vss vss sky130_fd_pr__nfet_01v8_lvt ad=0.1595 pd=1.68 as=0 ps=0 w=0.55 l=0.15
X197 a_9351_10050# f1 a_7971_9376# vdd sky130_fd_pr__pfet_01v8_lvt ad=0.261 pd=2.38 as=0.261 ps=2.38 w=0.9 l=0.35
X198 a_15775_8270# a_15733_3298# a_7971_9376# vdd sky130_fd_pr__pfet_01v8_lvt ad=0.261 pd=2.38 as=0.261 ps=2.38 w=0.9 l=0.35
X199 vdd a_21602_6694# dn vdd sky130_fd_pr__pfet_01v8_lvt ad=0.812 pd=6.18 as=0.406 ps=3.09 w=2.8 l=0.35
X200 a_1987_11933# a_411_11960# vss vss sky130_fd_pr__nfet_01v8 ad=0.232 pd=2.18 as=0.232 ps=2.18 w=0.8 l=0.18
X201 a_363_8526# a_3461_1968# a_3087_7364# vdd sky130_fd_pr__pfet_01v8_lvt ad=0.609 pd=4.78 as=0.3045 ps=2.39 w=2.1 l=0.35
X202 vss a_16191_6170# vss vss sky130_fd_pr__nfet_01v8_lvt ad=0.1595 pd=1.68 as=0 ps=0 w=0.55 l=0.15
X203 vdd a_16191_10050# vdd vdd sky130_fd_pr__pfet_01v8 ad=0.667 pd=5.18 as=0 ps=0 w=2.3 l=0.15
X204 a_13911_7950# f4 a_4811_6504# vss sky130_fd_pr__nfet_01v8_lvt ad=0.145 pd=1.58 as=0.145 ps=1.58 w=0.5 l=0.15
X205 a_363_6974# b1 a_6247_7364# vss sky130_fd_pr__nfet_01v8_lvt ad=0.248 pd=2.22 as=0.132 ps=1.13 w=0.8 l=0.15
X206 a_363_2814# b5 a_6247_7364# vss sky130_fd_pr__nfet_01v8_lvt ad=0.248 pd=2.22 as=0.132 ps=1.13 w=0.8 l=0.15
X207 a_11215_6170# a_11173_1814# a_7971_6504# vdd sky130_fd_pr__pfet_01v8_lvt ad=0.261 pd=2.38 as=0.261 ps=2.38 w=0.9 l=0.35
X208 a_21768_4674# a_21768_2174# vdd vdd sky130_fd_pr__pfet_01v8_lvt ad=0.26825 pd=2.14 as=0.26825 ps=2.14 w=1.85 l=0.35
X209 ckd3 ckd1 vss vss sky130_fd_pr__nfet_01v8_lvt ad=0.1305 pd=1.48 as=0.1305 ps=1.48 w=0.45 l=0.15
X210 a_8935_3750# a_8893_3298# a_4811_4856# vss sky130_fd_pr__nfet_01v8_lvt ad=0.145 pd=1.58 as=0.145 ps=1.58 w=0.5 l=0.15
X211 ckd1 a_4027_11933# vss vss sky130_fd_pr__nfet_01v8_lvt ad=0.198 pd=1.53 as=0.372 ps=3.02 w=1.2 l=0.15
X212 a_4622_11162# a_1058_11170# vdd vdd sky130_fd_pr__pfet_01v8 ad=0.522 pd=4.18 as=0.522 ps=4.18 w=1.8 l=0.18
X213 a_15775_3430# a_15733_3298# a_4811_1984# vss sky130_fd_pr__nfet_01v8_lvt ad=0.145 pd=1.58 as=0.145 ps=1.58 w=0.5 l=0.15
X214 a_6247_4276# b1 a_363_4894# vss sky130_fd_pr__nfet_01v8_lvt ad=0.132 pd=1.13 as=0.248 ps=2.22 w=0.8 l=0.15
X215 a_11631_6170# f3 a_7971_6504# vdd sky130_fd_pr__pfet_01v8_lvt ad=0.261 pd=2.38 as=0.261 ps=2.38 w=0.9 l=0.35
X216 a_3928_205# a3 vdd vdd sky130_fd_pr__pfet_01v8 ad=0.261 pd=2.38 as=0.261 ps=2.38 w=0.9 l=0.18
X217 a_6247_4276# b5 a_363_9054# vss sky130_fd_pr__nfet_01v8_lvt ad=0.132 pd=1.13 as=0.248 ps=2.22 w=0.8 l=0.15
X218 a_16191_8270# a_15733_3298# a_7971_9376# vss sky130_fd_pr__nfet_01v8_lvt ad=0.145 pd=1.58 as=0.145 ps=1.58 w=0.5 l=0.15
X219 a_10891_9310# a_20664_8208# vss sky130_fd_pr__res_high_po_0p69 l=7.2
X220 a_4811_1984# a_3087_2844# vss vss sky130_fd_pr__nfet_01v8_lvt ad=0.165 pd=1.33 as=0.31 ps=2.62 w=1 l=0.15
X221 a_15451_9310# a_13495_10050# vss vss sky130_fd_pr__nfet_01v8_lvt ad=0.1595 pd=1.68 as=0.1595 ps=1.68 w=0.55 l=0.15
X222 a_8935_1650# f1 a_4811_1984# vdd sky130_fd_pr__pfet_01v8_lvt ad=0.261 pd=2.38 as=0.261 ps=2.38 w=0.9 l=0.35
X223 a_16679_11933# a_17182_11162# vss vss sky130_fd_pr__nfet_01v8 ad=0.1218 pd=1.42 as=0.1218 ps=1.42 w=0.42 l=0.28
X224 en a_411_11960# a_20827_11933# vdd sky130_fd_pr__pfet_01v8_lvt ad=0.32915 pd=2.56 as=0.32915 ps=2.56 w=2.27 l=0.35
X225 a_13495_7950# a_13453_3298# a_4811_6504# vss sky130_fd_pr__nfet_01v8_lvt ad=0.145 pd=1.58 as=0.145 ps=1.58 w=0.5 l=0.15
X226 a_16191_1650# f7 a_7971_1984# vdd sky130_fd_pr__pfet_01v8_lvt ad=0.261 pd=2.38 as=0.261 ps=2.38 w=0.9 l=0.35
X227 a_20827_11933# a_411_11960# en vdd sky130_fd_pr__pfet_01v8_lvt ad=0.6583 pd=5.12 as=0.32915 ps=2.56 w=2.27 l=0.35
X228 a_17731_7210# a_15775_7950# vdd vdd sky130_fd_pr__pfet_01v8 ad=0.667 pd=5.18 as=0.667 ps=5.18 w=2.3 l=0.15
X229 a_21602_2174# a_21602_4674# vss vss sky130_fd_pr__nfet_01v8_lvt ad=0.5365 pd=4.28 as=0.5365 ps=4.28 w=1.85 l=0.15
X230 a_4341_1968# a6 vdd vdd sky130_fd_pr__pfet_01v8 ad=0.261 pd=2.38 as=0.261 ps=2.38 w=0.9 l=0.18
X231 vdd c6 a_363_8526# vdd sky130_fd_pr__pfet_01v8_lvt ad=0.2465 pd=1.99 as=0.2465 ps=1.99 w=1.7 l=0.35
X232 a_5719_11933# a_10902_11162# vdd vdd sky130_fd_pr__pfet_01v8 ad=0.58905 pd=3.9 as=1.1067 ps=7.76 w=3.57 l=0.15
X233 a_16191_7950# a_15733_3298# a_4811_6504# vdd sky130_fd_pr__pfet_01v8_lvt ad=0.261 pd=2.38 as=0.261 ps=2.38 w=0.9 l=0.35
X234 vdd a_9351_5530# vdd vdd sky130_fd_pr__pfet_01v8 ad=0.667 pd=5.18 as=0 ps=0 w=2.3 l=0.15
X235 vss a_16191_5530# vss vss sky130_fd_pr__nfet_01v8_lvt ad=0.1595 pd=1.68 as=0 ps=0 w=0.55 l=0.15
X236 a_7971_9376# a_6247_8796# vss vss sky130_fd_pr__nfet_01v8_lvt ad=0.165 pd=1.33 as=0.31 ps=2.62 w=1 l=0.15
X237 a_4027_11933# a_10399_11933# vss vss sky130_fd_pr__nfet_01v8_lvt ad=0.2805 pd=2.03 as=0.527 ps=4.02 w=1.7 l=0.15
X238 dp a_21768_9194# vss vss sky130_fd_pr__nfet_01v8_lvt ad=0.231 pd=1.73 as=0.434 ps=3.42 w=1.4 l=0.15
X239 a_3087_2844# a0 a_363_8526# vss sky130_fd_pr__nfet_01v8_lvt ad=0.132 pd=1.13 as=0.248 ps=2.22 w=0.8 l=0.15
X240 a_20335_12811# a_20827_11933# vss vss sky130_fd_pr__nfet_01v8_lvt ad=0.435 pd=3.58 as=0.435 ps=3.58 w=1.5 l=0.15
X241 vss a_3087_8796# a_4811_9376# vss sky130_fd_pr__nfet_01v8_lvt ad=0.31 pd=2.62 as=0.165 ps=1.33 w=1 l=0.15
X242 vdd a_21768_9194# dp vdd sky130_fd_pr__pfet_01v8_lvt ad=0.812 pd=6.18 as=0.406 ps=3.09 w=2.8 l=0.35
X243 vss a_2901_12720# ckd0 vss sky130_fd_pr__nfet_01v8_lvt ad=0.372 pd=3.02 as=0.198 ps=1.53 w=1.2 l=0.15
X244 a_4119_11933# a_4622_11162# vdd vdd sky130_fd_pr__pfet_01v8 ad=0.1218 pd=1.42 as=0.1218 ps=1.42 w=0.42 l=0.28
X245 a_4119_11933# a_3421_11939# a_4027_11933# vss sky130_fd_pr__nfet_01v8_lvt ad=0.231 pd=1.73 as=0.434 ps=3.42 w=1.4 l=0.15
X246 vdd a_4119_11933# a_2901_12720# vdd sky130_fd_pr__pfet_01v8 ad=0.58905 pd=3.9 as=0.58905 ps=3.9 w=3.57 l=0.15
X247 a_5719_11933# a_10902_11162# vdd vdd sky130_fd_pr__pfet_01v8 ad=0.58905 pd=3.9 as=0.58905 ps=3.9 w=3.57 l=0.15
X248 a_9351_7950# f0 a_4811_6504# vss sky130_fd_pr__nfet_01v8_lvt ad=0.145 pd=1.58 as=0.145 ps=1.58 w=0.5 l=0.15
X249 a_6247_4276# a_6068_205# a_363_4894# vdd sky130_fd_pr__pfet_01v8_lvt ad=0.3045 pd=2.39 as=0.609 ps=4.78 w=2.1 l=0.35
X250 a_9351_7950# a_8893_3298# a_7971_6504# vss sky130_fd_pr__nfet_01v8_lvt ad=0.145 pd=1.58 as=0.145 ps=1.58 w=0.5 l=0.15
X251 vdd a_21768_4674# ep vdd sky130_fd_pr__pfet_01v8_lvt ad=0.406 pd=3.09 as=0.406 ps=3.09 w=2.8 l=0.35
X252 vdd a_2909_11950# a_3421_11939# vdd sky130_fd_pr__pfet_01v8 ad=0.6851 pd=5.04 as=0.36465 ps=2.54 w=2.21 l=0.15
X253 a_363_4366# a_3461_1968# a_3087_8796# vdd sky130_fd_pr__pfet_01v8_lvt ad=0.609 pd=4.78 as=0.3045 ps=2.39 w=2.1 l=0.35
X254 vdd c2 a_363_4366# vdd sky130_fd_pr__pfet_01v8_lvt ad=0.493 pd=3.98 as=0.2465 ps=1.99 w=1.7 l=0.35
X255 a_363_2286# a_4341_1968# a_3087_4276# vdd sky130_fd_pr__pfet_01v8_lvt ad=0.609 pd=4.78 as=0.3045 ps=2.39 w=2.1 l=0.35
X256 ckd0 a_2901_12720# vss vss sky130_fd_pr__nfet_01v8_lvt ad=0.198 pd=1.53 as=0.372 ps=3.02 w=1.2 l=0.15
X257 a_4027_11933# a_5719_11933# vdd vdd sky130_fd_pr__pfet_01v8 ad=0.5104 pd=4.1 as=0.5104 ps=4.1 w=1.76 l=0.15
X258 a_24971_12720# a_23462_11162# vss vss sky130_fd_pr__nfet_01v8_lvt ad=0.4205 pd=3.48 as=0.4205 ps=3.48 w=1.45 l=0.15
X259 a_9351_10050# a_8893_1814# a_7971_9376# vss sky130_fd_pr__nfet_01v8_lvt ad=0.145 pd=1.58 as=0.145 ps=1.58 w=0.5 l=0.15
X260 vdd a_10902_11162# a_5719_11933# vdd sky130_fd_pr__pfet_01v8 ad=0.58905 pd=3.9 as=0.58905 ps=3.9 w=3.57 l=0.15
X261 a_363_9054# c7 vdd vdd sky130_fd_pr__pfet_01v8_lvt ad=0.2465 pd=1.99 as=0.2465 ps=1.99 w=1.7 l=0.35
X262 a_11631_8270# a_11173_3298# a_7971_9376# vss sky130_fd_pr__nfet_01v8_lvt ad=0.145 pd=1.58 as=0.145 ps=1.58 w=0.5 l=0.15
X263 a_15775_6170# f7 a_7971_6504# vss sky130_fd_pr__nfet_01v8_lvt ad=0.145 pd=1.58 as=0.145 ps=1.58 w=0.5 l=0.15
X264 a_15775_7950# f6 a_4811_6504# vdd sky130_fd_pr__pfet_01v8_lvt ad=0.261 pd=2.38 as=0.261 ps=2.38 w=0.9 l=0.35
X265 cke2 cke0 vss vss sky130_fd_pr__nfet_01v8_lvt ad=0.1305 pd=1.48 as=0.1305 ps=1.48 w=0.45 l=0.15
X266 a_16679_11933# a_15981_11939# a_4651_12720# vss sky130_fd_pr__nfet_01v8_lvt ad=0.231 pd=1.73 as=0.434 ps=3.42 w=1.4 l=0.15
X267 a_15775_10050# f7 a_7971_9376# vss sky130_fd_pr__nfet_01v8_lvt ad=0.145 pd=1.58 as=0.145 ps=1.58 w=0.5 l=0.15
X268 a_6247_2844# b7 a_363_6974# vss sky130_fd_pr__nfet_01v8_lvt ad=0.132 pd=1.13 as=0.248 ps=2.22 w=0.8 l=0.15
X269 a_17731_2690# a_15775_3430# vss vss sky130_fd_pr__nfet_01v8_lvt ad=0.1595 pd=1.68 as=0.1595 ps=1.68 w=0.55 l=0.15
X270 vss a_13911_10050# vss vss sky130_fd_pr__nfet_01v8_lvt ad=0.1595 pd=1.68 as=0 ps=0 w=0.55 l=0.15
X271 a_8935_10050# a_8893_1814# a_7971_9376# vdd sky130_fd_pr__pfet_01v8_lvt ad=0.261 pd=2.38 as=0.261 ps=2.38 w=0.9 l=0.35
X272 a_363_2286# a0 a_3087_8796# vss sky130_fd_pr__nfet_01v8_lvt ad=0.248 pd=2.22 as=0.132 ps=1.13 w=0.8 l=0.15
X273 a_6247_7364# b3 a_363_9054# vss sky130_fd_pr__nfet_01v8_lvt ad=0.132 pd=1.13 as=0.248 ps=2.22 w=0.8 l=0.15
X274 a_363_2814# c1 vdd vdd sky130_fd_pr__pfet_01v8_lvt ad=0.2465 pd=1.99 as=0.2465 ps=1.99 w=1.7 l=0.35
X275 a_3928_205# a3 vss vss sky130_fd_pr__nfet_01v8 ad=0.1305 pd=1.48 as=0.1305 ps=1.48 w=0.45 l=0.18
X276 a_15775_10050# a_15733_1814# a_4811_9376# vss sky130_fd_pr__nfet_01v8_lvt ad=0.145 pd=1.58 as=0.145 ps=1.58 w=0.5 l=0.15
X277 a_3087_7364# a_2938_205# a_363_6446# vdd sky130_fd_pr__pfet_01v8_lvt ad=0.3045 pd=2.39 as=0.609 ps=4.78 w=2.1 l=0.35
X278 a_10891_6165# a_20664_6336# vss sky130_fd_pr__res_high_po_0p69 l=7.2
X279 a_21768_9194# a_21768_6694# vss sky130_fd_pr__res_high_po_0p35 l=10.5
X280 a_13495_3430# a_13453_3298# a_7971_1984# vdd sky130_fd_pr__pfet_01v8_lvt ad=0.261 pd=2.38 as=0.261 ps=2.38 w=0.9 l=0.35
X281 a_17182_11162# a_16649_11686# a_2901_12720# vdd sky130_fd_pr__pfet_01v8 ad=0.37455 pd=2.6 as=0.37455 ps=2.6 w=2.27 l=0.15
X282 a_13911_3430# f4 a_7971_1984# vdd sky130_fd_pr__pfet_01v8_lvt ad=0.261 pd=2.38 as=0.261 ps=2.38 w=0.9 l=0.35
X283 vdd a_20827_11933# a_20335_12811# vdd sky130_fd_pr__pfet_01v8 ad=0.3465 pd=2.43 as=0.3465 ps=2.43 w=2.1 l=0.15
X284 a_15451_7210# a_13495_7950# vss vss sky130_fd_pr__nfet_01v8_lvt ad=0.1595 pd=1.68 as=0.1595 ps=1.68 w=0.55 l=0.15
X285 a_4341_1968# a6 vss vss sky130_fd_pr__nfet_01v8 ad=0.1305 pd=1.48 as=0.1305 ps=1.48 w=0.45 l=0.18
X286 a_4811_4856# a_3087_4276# vdd vdd sky130_fd_pr__pfet_01v8 ad=0.363 pd=2.53 as=0.682 ps=5.02 w=2.2 l=0.15
X287 a_363_9054# b7 a_6247_8796# vss sky130_fd_pr__nfet_01v8_lvt ad=0.248 pd=2.22 as=0.132 ps=1.13 w=0.8 l=0.15
X288 vdd a_6247_7364# a_7971_6504# vdd sky130_fd_pr__pfet_01v8 ad=0.363 pd=2.53 as=0.363 ps=2.53 w=2.2 l=0.15
X289 a_15775_5530# f7 a_7971_4856# vss sky130_fd_pr__nfet_01v8_lvt ad=0.145 pd=1.58 as=0.145 ps=1.58 w=0.5 l=0.15
X290 a_6247_7364# a_7501_1968# a_363_4894# vdd sky130_fd_pr__pfet_01v8_lvt ad=0.3045 pd=2.39 as=0.609 ps=4.78 w=2.1 l=0.35
X291 a_4811_6504# a_3087_7364# vdd vdd sky130_fd_pr__pfet_01v8 ad=0.363 pd=2.53 as=0.363 ps=2.53 w=2.2 l=0.15
X292 dn a_21602_6694# vss vss sky130_fd_pr__nfet_01v8_lvt ad=0.231 pd=1.73 as=0.434 ps=3.42 w=1.4 l=0.15
X293 a_11215_3430# f2 a_7971_1984# vss sky130_fd_pr__nfet_01v8_lvt ad=0.145 pd=1.58 as=0.145 ps=1.58 w=0.5 l=0.15
X294 a_13171_4790# a_20664_3688# vss sky130_fd_pr__res_high_po_0p69 l=7.2
X295 a_363_2814# b3 a_6247_2844# vss sky130_fd_pr__nfet_01v8_lvt ad=0.248 pd=2.22 as=0.132 ps=1.13 w=0.8 l=0.15
X296 a_8935_3430# f0 a_4811_1984# vdd sky130_fd_pr__pfet_01v8_lvt ad=0.261 pd=2.38 as=0.261 ps=2.38 w=0.9 l=0.35
X297 a_2901_12720# a_3421_11939# a_10902_11162# vdd sky130_fd_pr__pfet_01v8 ad=0.7037 pd=5.16 as=0.37455 ps=2.6 w=2.27 l=0.15
X298 a_16191_3430# f6 a_7971_1984# vdd sky130_fd_pr__pfet_01v8_lvt ad=0.261 pd=2.38 as=0.261 ps=2.38 w=0.9 l=0.35
X299 a_11215_3750# a_11173_3298# a_4811_4856# vss sky130_fd_pr__nfet_01v8_lvt ad=0.145 pd=1.58 as=0.145 ps=1.58 w=0.5 l=0.15
X300 a_411_11960# rst_n vdd vdd sky130_fd_pr__pfet_01v8 ad=0.33 pd=2.33 as=0.33 ps=2.33 w=2 l=0.15
X301 a_363_9054# a_6068_205# a_6247_2844# vdd sky130_fd_pr__pfet_01v8_lvt ad=0.609 pd=4.78 as=0.3045 ps=2.39 w=2.1 l=0.35
X302 a_363_4894# a_7061_1968# a_6247_2844# vdd sky130_fd_pr__pfet_01v8_lvt ad=0.609 pd=4.78 as=0.3045 ps=2.39 w=2.1 l=0.35
X303 a_3087_8796# a_2938_205# a_363_2286# vdd sky130_fd_pr__pfet_01v8_lvt ad=0.3045 pd=2.39 as=0.609 ps=4.78 w=2.1 l=0.35
X304 vdd a_9351_1650# vdd vdd sky130_fd_pr__pfet_01v8 ad=0.667 pd=5.18 as=0 ps=0 w=2.3 l=0.15
X305 a_363_8526# a4 a_3087_4276# vss sky130_fd_pr__nfet_01v8_lvt ad=0.248 pd=2.22 as=0.132 ps=1.13 w=0.8 l=0.15
X306 a_6055_12811# a_2909_11950# vdd vdd sky130_fd_pr__pfet_01v8 ad=0.5481 pd=4.36 as=0.5481 ps=4.36 w=1.89 l=0.15
X307 a_3087_8796# a2 a_363_4366# vss sky130_fd_pr__nfet_01v8_lvt ad=0.132 pd=1.13 as=0.248 ps=2.22 w=0.8 l=0.15
X308 a_3421_11939# a_2909_11950# vss vss sky130_fd_pr__nfet_01v8_lvt ad=0.17325 pd=1.38 as=0.3255 ps=2.72 w=1.05 l=0.15
X309 vss a_6247_4276# a_7971_4856# vss sky130_fd_pr__nfet_01v8_lvt ad=0.31 pd=2.62 as=0.165 ps=1.33 w=1 l=0.15
X310 ckd3 a_5719_11933# vdd vdd sky130_fd_pr__pfet_01v8 ad=0.4158 pd=2.85 as=0.7812 ps=5.66 w=2.52 l=0.15
X311 vdd a_4622_11162# a_4651_12720# vdd sky130_fd_pr__pfet_01v8 ad=0.58905 pd=3.9 as=0.58905 ps=3.9 w=3.57 l=0.15
X312 vss a_16191_7950# vss vss sky130_fd_pr__nfet_01v8_lvt ad=0.1595 pd=1.68 as=0 ps=0 w=0.55 l=0.15
X313 a_3421_11939# a_4089_11686# vdd vdd sky130_fd_pr__pfet_01v8 ad=0.5481 pd=4.36 as=0.5481 ps=4.36 w=1.89 l=0.15
X314 a_1987_11933# rst_n dp vss sky130_fd_pr__nfet_01v8_lvt ad=0.2145 pd=1.63 as=0.403 ps=3.22 w=1.3 l=0.15
X315 a_10891_2690# a_8935_3430# vdd vdd sky130_fd_pr__pfet_01v8 ad=0.667 pd=5.18 as=0.667 ps=5.18 w=2.3 l=0.15
X316 a_10891_3745# a_8935_3750# vss vss sky130_fd_pr__nfet_01v8_lvt ad=0.1595 pd=1.68 as=0.1595 ps=1.68 w=0.55 l=0.15
X317 vss a_4027_11933# ckd1 vss sky130_fd_pr__nfet_01v8_lvt ad=0.372 pd=3.02 as=0.198 ps=1.53 w=1.2 l=0.15
X318 a_11631_1650# f3 a_4811_1984# vss sky130_fd_pr__nfet_01v8_lvt ad=0.145 pd=1.58 as=0.145 ps=1.58 w=0.5 l=0.15
X319 a_15775_10050# a_15733_1814# a_7971_9376# vdd sky130_fd_pr__pfet_01v8_lvt ad=0.261 pd=2.38 as=0.261 ps=2.38 w=0.9 l=0.35
X320 a_11631_3750# a_11173_3298# a_4811_4856# vdd sky130_fd_pr__pfet_01v8_lvt ad=0.261 pd=2.38 as=0.261 ps=2.38 w=0.9 l=0.35
X321 a_4119_11933# a_4622_11162# vss vss sky130_fd_pr__nfet_01v8 ad=0.1218 pd=1.42 as=0.1218 ps=1.42 w=0.42 l=0.28
X322 vdd a_6247_8796# a_7971_9376# vdd sky130_fd_pr__pfet_01v8 ad=0.363 pd=2.53 as=0.363 ps=2.53 w=2.2 l=0.15
X323 a_4811_9376# a_3087_8796# vdd vdd sky130_fd_pr__pfet_01v8 ad=0.363 pd=2.53 as=0.363 ps=2.53 w=2.2 l=0.15
X324 a_6247_8796# a_7501_1968# a_363_9054# vdd sky130_fd_pr__pfet_01v8_lvt ad=0.3045 pd=2.39 as=0.609 ps=4.78 w=2.1 l=0.35
X325 a_11215_7950# a_11173_3298# a_7971_6504# vdd sky130_fd_pr__pfet_01v8_lvt ad=0.261 pd=2.38 as=0.261 ps=2.38 w=0.9 l=0.35
X326 vdd a_6055_12811# a_4089_11686# vdd sky130_fd_pr__pfet_01v8 ad=0.6851 pd=5.04 as=0.36465 ps=2.54 w=2.21 l=0.15
X327 a_363_4366# c2 vss vss sky130_fd_pr__nfet_01v8_lvt ad=0.493 pd=3.98 as=0.493 ps=3.98 w=1.7 l=0.15
X328 cke1 a_23221_12720# vdd vdd sky130_fd_pr__pfet_01v8 ad=0.4158 pd=2.85 as=0.7812 ps=5.66 w=2.52 l=0.15
X329 a_14547_11933# rst_n ep vss sky130_fd_pr__nfet_01v8_lvt ad=0.2145 pd=1.63 as=0.403 ps=3.22 w=1.3 l=0.15
X330 a_10891_8265# a_8935_8270# vdd vdd sky130_fd_pr__pfet_01v8 ad=0.667 pd=5.18 as=0.667 ps=5.18 w=2.3 l=0.15
X331 a_5738_205# b0 vdd vdd sky130_fd_pr__pfet_01v8 ad=0.261 pd=2.38 as=0.261 ps=2.38 w=0.9 l=0.18
X332 a_11631_7950# f2 a_7971_6504# vdd sky130_fd_pr__pfet_01v8_lvt ad=0.261 pd=2.38 as=0.261 ps=2.38 w=0.9 l=0.35
X333 vdd a_21768_6694# a_21768_9194# vdd sky130_fd_pr__pfet_01v8_lvt ad=0.5365 pd=4.28 as=0.26825 ps=2.14 w=1.85 l=0.35
X334 a_9351_8270# a_8893_3298# a_4811_9376# vdd sky130_fd_pr__pfet_01v8_lvt ad=0.261 pd=2.38 as=0.261 ps=2.38 w=0.9 l=0.35
X335 a_3087_2844# a_4341_1968# a_363_6446# vdd sky130_fd_pr__pfet_01v8_lvt ad=0.3045 pd=2.39 as=0.609 ps=4.78 w=2.1 l=0.35
X336 vdd c5 a_363_6974# vdd sky130_fd_pr__pfet_01v8_lvt ad=0.493 pd=3.98 as=0.2465 ps=1.99 w=1.7 l=0.35
X337 a_17731_4790# a_15775_5530# vdd vdd sky130_fd_pr__pfet_01v8 ad=0.667 pd=5.18 as=0.667 ps=5.18 w=2.3 l=0.15
X338 a_5719_11933# a_15981_11939# a_22959_11933# vdd sky130_fd_pr__pfet_01v8 ad=0.37455 pd=2.6 as=0.37455 ps=2.6 w=2.27 l=0.15
X339 a_363_8526# c6 vdd vdd sky130_fd_pr__pfet_01v8_lvt ad=0.2465 pd=1.99 as=0.2465 ps=1.99 w=1.7 l=0.35
X340 a_8935_6170# a_8893_1814# a_4811_6504# vss sky130_fd_pr__nfet_01v8_lvt ad=0.145 pd=1.58 as=0.145 ps=1.58 w=0.5 l=0.15
X341 a_13171_3745# a_11215_3750# vss vss sky130_fd_pr__nfet_01v8_lvt ad=0.1595 pd=1.68 as=0.1595 ps=1.68 w=0.55 l=0.15
X342 vss a_10399_11933# a_4027_11933# vss sky130_fd_pr__nfet_01v8_lvt ad=0.527 pd=4.02 as=0.2805 ps=2.03 w=1.7 l=0.15
X343 a_13171_2690# a_11215_3430# vdd vdd sky130_fd_pr__pfet_01v8 ad=0.667 pd=5.18 as=0.667 ps=5.18 w=2.3 l=0.15
X344 a_15451_3745# a_13495_3750# vdd vdd sky130_fd_pr__pfet_01v8 ad=0.667 pd=5.18 as=0.667 ps=5.18 w=2.3 l=0.15
X345 a_13911_1650# f5 a_4811_1984# vss sky130_fd_pr__nfet_01v8_lvt ad=0.145 pd=1.58 as=0.145 ps=1.58 w=0.5 l=0.15
X346 a_8935_3430# f0 a_7971_1984# vss sky130_fd_pr__nfet_01v8_lvt ad=0.145 pd=1.58 as=0.145 ps=1.58 w=0.5 l=0.15
X347 a_20335_12811# a_15469_11950# vss vss sky130_fd_pr__nfet_01v8_lvt ad=0.1305 pd=1.48 as=0.1305 ps=1.48 w=0.45 l=0.15
X348 a_4027_11933# a_3421_11939# a_4119_11933# vss sky130_fd_pr__nfet_01v8_lvt ad=0.434 pd=3.42 as=0.231 ps=1.73 w=1.4 l=0.15
X349 a_10891_8265# a_20664_8208# vss sky130_fd_pr__res_high_po_0p69 l=7.2
X350 dn a_21602_6694# vdd vdd sky130_fd_pr__pfet_01v8_lvt ad=0.406 pd=3.09 as=0.812 ps=6.18 w=2.8 l=0.35
X351 a_13911_3750# a_13453_3298# a_4811_4856# vdd sky130_fd_pr__pfet_01v8_lvt ad=0.261 pd=2.38 as=0.261 ps=2.38 w=0.9 l=0.35
X352 a_2901_12720# a_4119_11933# vdd vdd sky130_fd_pr__pfet_01v8 ad=0.58905 pd=3.9 as=0.58905 ps=3.9 w=3.57 l=0.15
X353 a_22959_11933# a_15981_11939# a_5719_11933# vdd sky130_fd_pr__pfet_01v8 ad=0.37455 pd=2.6 as=0.7037 ps=5.16 w=2.27 l=0.15
X354 a_363_4366# a6 a_3087_7364# vss sky130_fd_pr__nfet_01v8_lvt ad=0.248 pd=2.22 as=0.132 ps=1.13 w=0.8 l=0.15
X355 vdd a_21768_2174# a_21768_4674# vdd sky130_fd_pr__pfet_01v8_lvt ad=0.26825 pd=2.14 as=0.26825 ps=2.14 w=1.85 l=0.35
X356 a_7971_4856# a_6247_4276# vdd vdd sky130_fd_pr__pfet_01v8 ad=0.363 pd=2.53 as=0.363 ps=2.53 w=2.2 l=0.15
X357 vdd a_21602_4674# a_21602_2174# vdd sky130_fd_pr__pfet_01v8_lvt ad=0.5365 pd=4.28 as=0.26825 ps=2.14 w=1.85 l=0.35
X358 cke0 cke2 vdd vdd sky130_fd_pr__pfet_01v8 ad=0.5481 pd=4.36 as=0.5481 ps=4.36 w=1.89 l=0.15
X359 a_13171_8265# a_11215_8270# vdd vdd sky130_fd_pr__pfet_01v8 ad=0.667 pd=5.18 as=0.667 ps=5.18 w=2.3 l=0.15
X360 ep a_21768_4674# vdd vdd sky130_fd_pr__pfet_01v8_lvt ad=0.406 pd=3.09 as=0.406 ps=3.09 w=2.8 l=0.35
X361 a_3087_4276# a6 a_363_2286# vss sky130_fd_pr__nfet_01v8_lvt ad=0.132 pd=1.13 as=0.248 ps=2.22 w=0.8 l=0.15
X362 vss a_11631_3750# vss vss sky130_fd_pr__nfet_01v8_lvt ad=0.1595 pd=1.68 as=0 ps=0 w=0.55 l=0.15
X363 a_4651_12720# a_15981_11939# a_16679_11933# vss sky130_fd_pr__nfet_01v8_lvt ad=0.434 pd=3.42 as=0.231 ps=1.73 w=1.4 l=0.15
X364 vss a_9351_8270# vss vss sky130_fd_pr__nfet_01v8_lvt ad=0.1595 pd=1.68 as=0 ps=0 w=0.55 l=0.15
X365 a_15775_7950# f6 a_7971_6504# vss sky130_fd_pr__nfet_01v8_lvt ad=0.145 pd=1.58 as=0.145 ps=1.58 w=0.5 l=0.15
X366 vdd a_11631_3430# vdd vdd sky130_fd_pr__pfet_01v8 ad=0.667 pd=5.18 as=0 ps=0 w=2.3 l=0.15
X367 vss a_21602_2174# en vss sky130_fd_pr__nfet_01v8_lvt ad=0.434 pd=3.42 as=0.231 ps=1.73 w=1.4 l=0.15
X368 a_13495_1650# a_13453_1814# a_4811_1984# vss sky130_fd_pr__nfet_01v8_lvt ad=0.145 pd=1.58 as=0.145 ps=1.58 w=0.5 l=0.15
X369 a_13495_3750# f4 a_4811_4856# vdd sky130_fd_pr__pfet_01v8_lvt ad=0.261 pd=2.38 as=0.261 ps=2.38 w=0.9 l=0.35
X370 a_8935_5530# a_8893_1814# a_4811_4856# vss sky130_fd_pr__nfet_01v8_lvt ad=0.145 pd=1.58 as=0.145 ps=1.58 w=0.5 l=0.15
X371 a_2901_12720# a_16649_11686# a_17182_11162# vdd sky130_fd_pr__pfet_01v8 ad=0.7037 pd=5.16 as=0.37455 ps=2.6 w=2.27 l=0.15
X372 a_10902_11162# a_1058_11170# vdd vdd sky130_fd_pr__pfet_01v8 ad=0.522 pd=4.18 as=0.522 ps=4.18 w=1.8 l=0.18
X373 vdd a_11631_8270# vdd vdd sky130_fd_pr__pfet_01v8 ad=0.667 pd=5.18 as=0 ps=0 w=2.3 l=0.15
X374 a_363_6446# a_2938_205# a_3087_7364# vdd sky130_fd_pr__pfet_01v8_lvt ad=0.609 pd=4.78 as=0.3045 ps=2.39 w=2.1 l=0.35
X375 a_5738_205# b0 vss vss sky130_fd_pr__nfet_01v8 ad=0.1305 pd=1.48 as=0.1305 ps=1.48 w=0.45 l=0.18
X376 a_20335_12811# a_20827_11933# vdd vdd sky130_fd_pr__pfet_01v8 ad=0.651 pd=4.82 as=0.3465 ps=2.43 w=2.1 l=0.15
X377 a_15451_2690# a_20664_1816# vss sky130_fd_pr__res_high_po_0p69 l=7.2
X378 a_11215_8270# f2 a_4811_9376# vdd sky130_fd_pr__pfet_01v8_lvt ad=0.261 pd=2.38 as=0.261 ps=2.38 w=0.9 l=0.35
X379 a_10891_7210# a_20664_6336# vss sky130_fd_pr__res_high_po_0p69 l=7.2
X380 a_9351_1650# f1 a_4811_1984# vss sky130_fd_pr__nfet_01v8_lvt ad=0.145 pd=1.58 as=0.145 ps=1.58 w=0.5 l=0.15
X381 a_16649_11686# a_15981_11939# vss vss sky130_fd_pr__nfet_01v8_lvt ad=0.1305 pd=1.48 as=0.1305 ps=1.48 w=0.45 l=0.15
X382 a_6055_12811# a_8267_11933# vdd vdd sky130_fd_pr__pfet_01v8 ad=0.3465 pd=2.43 as=0.651 ps=4.82 w=2.1 l=0.15
X383 a_9351_1650# a_8893_1814# a_7971_1984# vss sky130_fd_pr__nfet_01v8_lvt ad=0.145 pd=1.58 as=0.145 ps=1.58 w=0.5 l=0.15
X384 a_9351_3750# f0 a_7971_4856# vdd sky130_fd_pr__pfet_01v8_lvt ad=0.261 pd=2.38 as=0.261 ps=2.38 w=0.9 l=0.35
X385 dp a_21768_9194# vdd vdd sky130_fd_pr__pfet_01v8_lvt ad=0.406 pd=3.09 as=0.812 ps=6.18 w=2.8 l=0.35
X386 a_3087_4276# a_3461_1968# a_363_6446# vdd sky130_fd_pr__pfet_01v8_lvt ad=0.3045 pd=2.39 as=0.609 ps=4.78 w=2.1 l=0.35
X387 vdd a_13911_3430# vdd vdd sky130_fd_pr__pfet_01v8 ad=0.667 pd=5.18 as=0 ps=0 w=2.3 l=0.15
X388 vss a_13911_3750# vss vss sky130_fd_pr__nfet_01v8_lvt ad=0.1595 pd=1.68 as=0 ps=0 w=0.55 l=0.15
X389 vdd a_16191_3750# vdd vdd sky130_fd_pr__pfet_01v8 ad=0.667 pd=5.18 as=0 ps=0 w=2.3 l=0.15
X390 a_363_6446# a2 a_3087_4276# vss sky130_fd_pr__nfet_01v8_lvt ad=0.248 pd=2.22 as=0.132 ps=1.13 w=0.8 l=0.15
X391 a_17221_12720# a_16679_11933# vdd vdd sky130_fd_pr__pfet_01v8 ad=0.33495 pd=2.36 as=0.6293 ps=4.68 w=2.03 l=0.15
X392 a_11631_5530# a_11173_1814# a_4811_4856# vdd sky130_fd_pr__pfet_01v8_lvt ad=0.261 pd=2.38 as=0.261 ps=2.38 w=0.9 l=0.35
X393 a_4089_11686# a_6055_12811# vss vss sky130_fd_pr__nfet_01v8_lvt ad=0.17325 pd=1.38 as=0.3255 ps=2.72 w=1.05 l=0.15
X394 a_17731_9310# a_15775_10050# vss vss sky130_fd_pr__nfet_01v8_lvt ad=0.1595 pd=1.68 as=0.1595 ps=1.68 w=0.55 l=0.15
X395 vdd a_17221_12720# cke0 vdd sky130_fd_pr__pfet_01v8 ad=0.4158 pd=2.85 as=0.4158 ps=2.85 w=2.52 l=0.15
X396 a_13171_6165# a_20664_6336# vss sky130_fd_pr__res_high_po_0p69 l=7.2
X397 vdd a_2901_12720# ckd0 vdd sky130_fd_pr__pfet_01v8 ad=0.7812 pd=5.66 as=0.4158 ps=2.85 w=2.52 l=0.15
X398 a_363_4894# a_7501_1968# a_6247_7364# vdd sky130_fd_pr__pfet_01v8_lvt ad=0.609 pd=4.78 as=0.3045 ps=2.39 w=2.1 l=0.35
X399 vdd a_4651_12720# ckd2 vdd sky130_fd_pr__pfet_01v8 ad=0.4158 pd=2.85 as=0.4158 ps=2.85 w=2.52 l=0.15
X400 vdd a_13911_8270# vdd vdd sky130_fd_pr__pfet_01v8 ad=0.667 pd=5.18 as=0 ps=0 w=2.3 l=0.15
X401 a_3087_7364# a4 a_363_2286# vss sky130_fd_pr__nfet_01v8_lvt ad=0.132 pd=1.13 as=0.248 ps=2.22 w=0.8 l=0.15
X402 a_11631_6170# a_11173_1814# a_4811_6504# vdd sky130_fd_pr__pfet_01v8_lvt ad=0.261 pd=2.38 as=0.261 ps=2.38 w=0.9 l=0.35
X403 a_16191_8270# f6 a_4811_9376# vss sky130_fd_pr__nfet_01v8_lvt ad=0.145 pd=1.58 as=0.145 ps=1.58 w=0.5 l=0.15
X404 vdd a_18971_12720# cke2 vdd sky130_fd_pr__pfet_01v8 ad=0.4158 pd=2.85 as=0.4158 ps=2.85 w=2.52 l=0.15
X405 a_363_2286# c0 vdd vdd sky130_fd_pr__pfet_01v8_lvt ad=0.2465 pd=1.99 as=0.493 ps=3.98 w=1.7 l=0.35
X406 a_4119_11933# a_1418_11110# vss vss sky130_fd_pr__nfet_01v8 ad=0.29 pd=2.58 as=0.29 ps=2.58 w=1 l=0.18
X407 a_363_9054# c7 vss vss sky130_fd_pr__nfet_01v8_lvt ad=0.493 pd=3.98 as=0.493 ps=3.98 w=1.7 l=0.15
X408 a_15451_1645# a_13495_1650# vss vss sky130_fd_pr__nfet_01v8_lvt ad=0.1595 pd=1.68 as=0.1595 ps=1.68 w=0.55 l=0.15
X409 a_17731_1645# a_15775_1650# vdd vdd sky130_fd_pr__pfet_01v8 ad=0.667 pd=5.18 as=0.667 ps=5.18 w=2.3 l=0.15
X410 ckd0 ckd2 vss vss sky130_fd_pr__nfet_01v8_lvt ad=0.1305 pd=1.48 as=0.1305 ps=1.48 w=0.45 l=0.15
X411 a_24971_12720# a_23221_12720# vss vss sky130_fd_pr__nfet_01v8_lvt ad=0.1218 pd=1.42 as=0.1218 ps=1.42 w=0.42 l=0.15
X412 a_6068_205# b1 vdd vdd sky130_fd_pr__pfet_01v8 ad=0.261 pd=2.38 as=0.261 ps=2.38 w=0.9 l=0.18
X413 a_16191_1650# a_15733_1814# a_4811_1984# vdd sky130_fd_pr__pfet_01v8_lvt ad=0.261 pd=2.38 as=0.261 ps=2.38 w=0.9 l=0.35
X414 a_13911_5530# a_13453_1814# a_4811_4856# vdd sky130_fd_pr__pfet_01v8_lvt ad=0.261 pd=2.38 as=0.261 ps=2.38 w=0.9 l=0.35
X415 a_363_2286# a_2938_205# a_3087_8796# vdd sky130_fd_pr__pfet_01v8_lvt ad=0.609 pd=4.78 as=0.3045 ps=2.39 w=2.1 l=0.35
X416 a_13453_1814# f5 vdd vdd sky130_fd_pr__pfet_01v8 ad=0.261 pd=2.38 as=0.261 ps=2.38 w=0.9 l=0.18
X417 a_363_8526# a_3901_1968# a_3087_4276# vdd sky130_fd_pr__pfet_01v8_lvt ad=0.609 pd=4.78 as=0.3045 ps=2.39 w=2.1 l=0.35
X418 a_2909_11950# a_1987_11933# vdd vdd sky130_fd_pr__pfet_01v8 ad=0.3465 pd=2.43 as=0.651 ps=4.82 w=2.1 l=0.15
X419 vss a_2909_11950# a_3421_11939# vss sky130_fd_pr__nfet_01v8_lvt ad=0.3255 pd=2.72 as=0.17325 ps=1.38 w=1.05 l=0.15
X420 a_4651_12720# a_4622_11162# vdd vdd sky130_fd_pr__pfet_01v8 ad=0.58905 pd=3.9 as=0.58905 ps=3.9 w=3.57 l=0.15
X421 a_7971_6504# a_6247_7364# vdd vdd sky130_fd_pr__pfet_01v8 ad=0.363 pd=2.53 as=0.682 ps=5.02 w=2.2 l=0.15
X422 dp rst_n a_1987_11933# vss sky130_fd_pr__nfet_01v8_lvt ad=0.403 pd=3.22 as=0.2145 ps=1.63 w=1.3 l=0.15
X423 a_15451_6165# a_13495_6170# vdd vdd sky130_fd_pr__pfet_01v8 ad=0.667 pd=5.18 as=0.667 ps=5.18 w=2.3 l=0.15
X424 vss a_16191_10050# vss vss sky130_fd_pr__nfet_01v8_lvt ad=0.1595 pd=1.68 as=0 ps=0 w=0.55 l=0.15
X425 a_15775_8270# a_15733_3298# a_4811_9376# vss sky130_fd_pr__nfet_01v8_lvt ad=0.145 pd=1.58 as=0.145 ps=1.58 w=0.5 l=0.15
X426 a_6247_7364# b1 a_363_6974# vss sky130_fd_pr__nfet_01v8_lvt ad=0.132 pd=1.13 as=0.248 ps=2.22 w=0.8 l=0.15
X427 a_3421_11939# a_2909_11950# vdd vdd sky130_fd_pr__pfet_01v8 ad=0.36465 pd=2.54 as=0.6851 ps=5.04 w=2.21 l=0.15
X428 a_6247_7364# b5 a_363_2814# vss sky130_fd_pr__nfet_01v8_lvt ad=0.132 pd=1.13 as=0.248 ps=2.22 w=0.8 l=0.15
X429 a_13911_6170# a_13453_1814# a_4811_6504# vdd sky130_fd_pr__pfet_01v8_lvt ad=0.261 pd=2.38 as=0.261 ps=2.38 w=0.9 l=0.35
X430 a_7058_205# b4 vdd vdd sky130_fd_pr__pfet_01v8 ad=0.261 pd=2.38 as=0.261 ps=2.38 w=0.9 l=0.18
X431 a_11215_6170# a_11173_1814# a_4811_6504# vss sky130_fd_pr__nfet_01v8_lvt ad=0.145 pd=1.58 as=0.145 ps=1.58 w=0.5 l=0.15
X432 a_23221_12720# a_24971_12720# vss vss sky130_fd_pr__nfet_01v8_lvt ad=0.1218 pd=1.42 as=0.1218 ps=1.42 w=0.42 l=0.15
X433 a_13495_3750# f4 a_7971_4856# vss sky130_fd_pr__nfet_01v8_lvt ad=0.145 pd=1.58 as=0.145 ps=1.58 w=0.5 l=0.15
X434 vdd a_3087_4276# a_4811_4856# vdd sky130_fd_pr__pfet_01v8 ad=0.682 pd=5.02 as=0.363 ps=2.53 w=2.2 l=0.15
X435 ep rst_n a_14547_11933# vss sky130_fd_pr__nfet_01v8_lvt ad=0.403 pd=3.22 as=0.2145 ps=1.63 w=1.3 l=0.15
X436 a_363_9054# a_7501_1968# a_6247_8796# vdd sky130_fd_pr__pfet_01v8_lvt ad=0.609 pd=4.78 as=0.3045 ps=2.39 w=2.1 l=0.35
X437 a_15775_1650# f7 a_4811_1984# vdd sky130_fd_pr__pfet_01v8_lvt ad=0.261 pd=2.38 as=0.261 ps=2.38 w=0.9 l=0.35
X438 a_13495_5530# f5 a_4811_4856# vdd sky130_fd_pr__pfet_01v8_lvt ad=0.261 pd=2.38 as=0.261 ps=2.38 w=0.9 l=0.35
X439 a_7501_1968# b7 vdd vdd sky130_fd_pr__pfet_01v8 ad=0.261 pd=2.38 as=0.261 ps=2.38 w=0.9 l=0.18
X440 a_6247_2844# a_6068_205# a_363_9054# vdd sky130_fd_pr__pfet_01v8_lvt ad=0.3045 pd=2.39 as=0.609 ps=4.78 w=2.1 l=0.35
X441 a_13911_3750# a_13453_3298# a_7971_4856# vss sky130_fd_pr__nfet_01v8_lvt ad=0.145 pd=1.58 as=0.145 ps=1.58 w=0.5 l=0.15
X442 a_8935_3750# a_8893_3298# a_7971_4856# vdd sky130_fd_pr__pfet_01v8_lvt ad=0.261 pd=2.38 as=0.261 ps=2.38 w=0.9 l=0.35
X443 a_13911_10050# a_13453_1814# a_7971_9376# vss sky130_fd_pr__nfet_01v8_lvt ad=0.145 pd=1.58 as=0.145 ps=1.58 w=0.5 l=0.15
X444 a_1058_11170# a_411_11960# vdd vdd sky130_fd_pr__pfet_01v8 ad=0.435 pd=3.58 as=0.435 ps=3.58 w=1.5 l=0.18
X445 a_14547_11933# a_411_11960# vss vss sky130_fd_pr__nfet_01v8 ad=0.232 pd=2.18 as=0.232 ps=2.18 w=0.8 l=0.18
X446 a_20827_11933# a_411_11960# en vdd sky130_fd_pr__pfet_01v8_lvt ad=0.32915 pd=2.56 as=0.6583 ps=5.12 w=2.27 l=0.35
X447 a_363_6446# a_4341_1968# a_3087_2844# vdd sky130_fd_pr__pfet_01v8_lvt ad=0.609 pd=4.78 as=0.3045 ps=2.39 w=2.1 l=0.35
X448 a_10891_9310# a_8935_10050# vdd vdd sky130_fd_pr__pfet_01v8 ad=0.667 pd=5.18 as=0.667 ps=5.18 w=2.3 l=0.15
X449 a_10891_6165# a_8935_6170# vss vss sky130_fd_pr__nfet_01v8_lvt ad=0.1595 pd=1.68 as=0.1595 ps=1.68 w=0.55 l=0.15
X450 a_22959_11933# a_15981_11939# a_5719_11933# vdd sky130_fd_pr__pfet_01v8 ad=0.7037 pd=5.16 as=0.37455 ps=2.6 w=2.27 l=0.15
X451 a_13495_6170# f5 a_4811_6504# vdd sky130_fd_pr__pfet_01v8_lvt ad=0.261 pd=2.38 as=0.261 ps=2.38 w=0.9 l=0.35
X452 a_13171_2690# a_20664_1816# vss sky130_fd_pr__res_high_po_0p69 l=7.2
X453 a_9351_10050# a_8893_1814# a_4811_9376# vdd sky130_fd_pr__pfet_01v8_lvt ad=0.261 pd=2.38 as=0.261 ps=2.38 w=0.9 l=0.35
X454 a_8935_7950# a_8893_3298# a_4811_6504# vss sky130_fd_pr__nfet_01v8_lvt ad=0.145 pd=1.58 as=0.145 ps=1.58 w=0.5 l=0.15
X455 a_9351_5530# f1 a_7971_4856# vdd sky130_fd_pr__pfet_01v8_lvt ad=0.261 pd=2.38 as=0.261 ps=2.38 w=0.9 l=0.35
X456 a_17182_11162# a_1058_11170# vdd vdd sky130_fd_pr__pfet_01v8 ad=0.522 pd=4.18 as=0.522 ps=4.18 w=1.8 l=0.18
X457 a_21602_6694# a_21602_9194# vdd vdd sky130_fd_pr__pfet_01v8_lvt ad=0.26825 pd=2.14 as=0.5365 ps=4.28 w=1.85 l=0.35
X458 vss a_16191_1650# vss vss sky130_fd_pr__nfet_01v8_lvt ad=0.1595 pd=1.68 as=0 ps=0 w=0.55 l=0.15
X459 cke3 a_24971_12720# vdd vdd sky130_fd_pr__pfet_01v8 ad=0.4158 pd=2.85 as=0.7812 ps=5.66 w=2.52 l=0.15
X460 a_15451_4790# a_20664_3688# vss sky130_fd_pr__res_high_po_0p69 l=7.2
X461 a_363_9054# b1 a_6247_2844# vss sky130_fd_pr__nfet_01v8_lvt ad=0.248 pd=2.22 as=0.132 ps=1.13 w=0.8 l=0.15
X462 a_6055_12811# a_8267_11933# vss vss sky130_fd_pr__nfet_01v8_lvt ad=0.435 pd=3.58 as=0.435 ps=3.58 w=1.5 l=0.15
X463 a_4811_9376# a_3087_8796# vss vss sky130_fd_pr__nfet_01v8_lvt ad=0.165 pd=1.33 as=0.31 ps=2.62 w=1 l=0.15
X464 a_363_4894# b5 a_6247_2844# vss sky130_fd_pr__nfet_01v8_lvt ad=0.248 pd=2.22 as=0.132 ps=1.13 w=0.8 l=0.15
X465 a_11215_5530# a_11173_1814# a_4811_4856# vss sky130_fd_pr__nfet_01v8_lvt ad=0.145 pd=1.58 as=0.145 ps=1.58 w=0.5 l=0.15
X466 a_6068_205# b1 vss vss sky130_fd_pr__nfet_01v8 ad=0.1305 pd=1.48 as=0.1305 ps=1.48 w=0.45 l=0.18
X467 a_7971_9376# a_6247_8796# vdd vdd sky130_fd_pr__pfet_01v8 ad=0.363 pd=2.53 as=0.682 ps=5.02 w=2.2 l=0.15
X468 a_2938_205# a0 vdd vdd sky130_fd_pr__pfet_01v8 ad=0.261 pd=2.38 as=0.261 ps=2.38 w=0.9 l=0.18
X469 a_13453_1814# f5 vss vss sky130_fd_pr__nfet_01v8 ad=0.1305 pd=1.48 as=0.1305 ps=1.48 w=0.45 l=0.18
X470 a_2909_11950# a_6055_12811# vss vss sky130_fd_pr__nfet_01v8_lvt ad=0.1305 pd=1.48 as=0.1305 ps=1.48 w=0.45 l=0.15
X471 a_9351_6170# f1 a_7971_6504# vdd sky130_fd_pr__pfet_01v8_lvt ad=0.261 pd=2.38 as=0.261 ps=2.38 w=0.9 l=0.35
X472 a_15469_11950# a_20335_12811# vdd vdd sky130_fd_pr__pfet_01v8 ad=0.5481 pd=4.36 as=0.5481 ps=4.36 w=1.89 l=0.15
X473 a_10891_4790# a_20664_3688# vss sky130_fd_pr__res_high_po_0p69 l=7.2
X474 a_16191_3750# a_15733_3298# a_7971_4856# vss sky130_fd_pr__nfet_01v8_lvt ad=0.145 pd=1.58 as=0.145 ps=1.58 w=0.5 l=0.15
X475 a_17731_8265# a_15775_8270# vss vss sky130_fd_pr__nfet_01v8_lvt ad=0.1595 pd=1.68 as=0.1595 ps=1.68 w=0.55 l=0.15
X476 vdd a_16191_6170# vdd vdd sky130_fd_pr__pfet_01v8 ad=0.667 pd=5.18 as=0 ps=0 w=2.3 l=0.15
X477 a_13171_8265# a_20664_8208# vss sky130_fd_pr__res_high_po_0p69 l=7.2
X478 a_363_2814# c1 vss vss sky130_fd_pr__nfet_01v8_lvt ad=0.493 pd=3.98 as=0.493 ps=3.98 w=1.7 l=0.15
X479 a_4811_1984# a_3087_2844# vdd vdd sky130_fd_pr__pfet_01v8 ad=0.363 pd=2.53 as=0.682 ps=5.02 w=2.2 l=0.15
X480 vdd a_4027_11933# ckd1 vdd sky130_fd_pr__pfet_01v8 ad=0.7812 pd=5.66 as=0.4158 ps=2.85 w=2.52 l=0.15
X481 a_13171_6165# a_11215_6170# vss vss sky130_fd_pr__nfet_01v8_lvt ad=0.1595 pd=1.68 as=0.1595 ps=1.68 w=0.55 l=0.15
X482 a_7058_205# b4 vss vss sky130_fd_pr__nfet_01v8 ad=0.1305 pd=1.48 as=0.1305 ps=1.48 w=0.45 l=0.18
X483 a_13171_9310# a_11215_10050# vdd vdd sky130_fd_pr__pfet_01v8 ad=0.667 pd=5.18 as=0.667 ps=5.18 w=2.3 l=0.15
X484 a_10891_4790# a_8935_5530# vss vss sky130_fd_pr__nfet_01v8_lvt ad=0.1595 pd=1.68 as=0.1595 ps=1.68 w=0.55 l=0.15
X485 a_24971_12720# a_23221_12720# vdd vdd sky130_fd_pr__pfet_01v8 ad=0.5104 pd=4.1 as=0.5104 ps=4.1 w=1.76 l=0.15
X486 a_3087_8796# a0 a_363_2286# vss sky130_fd_pr__nfet_01v8_lvt ad=0.132 pd=1.13 as=0.248 ps=2.22 w=0.8 l=0.15
X487 a_11631_3430# f2 a_4811_1984# vss sky130_fd_pr__nfet_01v8_lvt ad=0.145 pd=1.58 as=0.145 ps=1.58 w=0.5 l=0.15
X488 vdd c4 a_363_6446# vdd sky130_fd_pr__pfet_01v8_lvt ad=0.493 pd=3.98 as=0.2465 ps=1.99 w=1.7 l=0.35
X489 a_1987_11933# a_411_11960# dp vdd sky130_fd_pr__pfet_01v8_lvt ad=0.6583 pd=5.12 as=0.32915 ps=2.56 w=2.27 l=0.35
X490 a_16191_3430# a_15733_3298# a_4811_1984# vdd sky130_fd_pr__pfet_01v8_lvt ad=0.261 pd=2.38 as=0.261 ps=2.38 w=0.9 l=0.35
X491 a_7501_1968# b7 vss vss sky130_fd_pr__nfet_01v8 ad=0.1305 pd=1.48 as=0.1305 ps=1.48 w=0.45 l=0.18
X492 vdd a_15469_11950# a_15981_11939# vdd sky130_fd_pr__pfet_01v8 ad=0.6851 pd=5.04 as=0.36465 ps=2.54 w=2.21 l=0.15
X493 a_11173_3298# f2 vdd vdd sky130_fd_pr__pfet_01v8 ad=0.261 pd=2.38 as=0.261 ps=2.38 w=0.9 l=0.18
X494 a_17221_12720# a_16679_11933# vdd vdd sky130_fd_pr__pfet_01v8 ad=0.6293 pd=4.68 as=0.33495 ps=2.36 w=2.03 l=0.15
X495 a_4119_11933# a_4089_11686# a_4027_11933# vdd sky130_fd_pr__pfet_01v8 ad=0.37455 pd=2.6 as=0.7037 ps=5.16 w=2.27 l=0.15
X496 vdd a_8267_11933# a_6055_12811# vdd sky130_fd_pr__pfet_01v8 ad=0.3465 pd=2.43 as=0.3465 ps=2.43 w=2.1 l=0.15
X497 vss a_11631_6170# vss vss sky130_fd_pr__nfet_01v8_lvt ad=0.1595 pd=1.68 as=0 ps=0 w=0.55 l=0.15
X498 a_4622_11162# a_4119_11933# vdd vdd sky130_fd_pr__pfet_01v8 ad=0.1218 pd=1.42 as=0.1218 ps=1.42 w=0.42 l=0.28
X499 a_2909_11950# a_1987_11933# vss vss sky130_fd_pr__nfet_01v8_lvt ad=0.435 pd=3.58 as=0.435 ps=3.58 w=1.5 l=0.15
X500 vdd a_11631_10050# vdd vdd sky130_fd_pr__pfet_01v8 ad=0.667 pd=5.18 as=0 ps=0 w=2.3 l=0.15
X501 vdd a_16679_11933# a_17221_12720# vdd sky130_fd_pr__pfet_01v8 ad=0.33495 pd=2.36 as=0.33495 ps=2.36 w=2.03 l=0.15
X502 a_23221_12720# a_24971_12720# vdd vdd sky130_fd_pr__pfet_01v8 ad=0.5104 pd=4.1 as=0.5104 ps=4.1 w=1.76 l=0.15
X503 vss a_6055_12811# a_4089_11686# vss sky130_fd_pr__nfet_01v8_lvt ad=0.3255 pd=2.72 as=0.17325 ps=1.38 w=1.05 l=0.15
X504 a_16191_10050# a_15733_1814# a_7971_9376# vss sky130_fd_pr__nfet_01v8_lvt ad=0.145 pd=1.58 as=0.145 ps=1.58 w=0.5 l=0.15
X505 a_6247_8796# b7 a_363_9054# vss sky130_fd_pr__nfet_01v8_lvt ad=0.132 pd=1.13 as=0.248 ps=2.22 w=0.8 l=0.15
X506 a_11215_8270# f2 a_7971_9376# vss sky130_fd_pr__nfet_01v8_lvt ad=0.145 pd=1.58 as=0.145 ps=1.58 w=0.5 l=0.15
X507 a_363_6446# a_3461_1968# a_3087_4276# vdd sky130_fd_pr__pfet_01v8_lvt ad=0.609 pd=4.78 as=0.3045 ps=2.39 w=2.1 l=0.35
X508 a_11215_10050# f3 a_4811_9376# vdd sky130_fd_pr__pfet_01v8_lvt ad=0.261 pd=2.38 as=0.261 ps=2.38 w=0.9 l=0.35
X509 cke0 a_17221_12720# vdd vdd sky130_fd_pr__pfet_01v8 ad=0.4158 pd=2.85 as=0.4158 ps=2.85 w=2.52 l=0.15
X510 a_15981_11939# a_16649_11686# vdd vdd sky130_fd_pr__pfet_01v8 ad=0.5481 pd=4.36 as=0.5481 ps=4.36 w=1.89 l=0.15
X511 a_15775_1650# f7 a_7971_1984# vss sky130_fd_pr__nfet_01v8_lvt ad=0.145 pd=1.58 as=0.145 ps=1.58 w=0.5 l=0.15
X512 a_363_4894# c3 vdd vdd sky130_fd_pr__pfet_01v8_lvt ad=0.2465 pd=1.99 as=0.493 ps=3.98 w=1.7 l=0.35
X513 ckd2 a_4651_12720# vdd vdd sky130_fd_pr__pfet_01v8 ad=0.4158 pd=2.85 as=0.4158 ps=2.85 w=2.52 l=0.15
X514 vdd a_21602_2174# en vdd sky130_fd_pr__pfet_01v8_lvt ad=0.812 pd=6.18 as=0.406 ps=3.09 w=2.8 l=0.35
X515 a_15775_3430# f6 a_4811_1984# vdd sky130_fd_pr__pfet_01v8_lvt ad=0.261 pd=2.38 as=0.261 ps=2.38 w=0.9 l=0.35
X516 a_11631_3750# a_11173_3298# a_7971_4856# vss sky130_fd_pr__nfet_01v8_lvt ad=0.145 pd=1.58 as=0.145 ps=1.58 w=0.5 l=0.15
X517 a_15775_3750# a_15733_3298# a_7971_4856# vdd sky130_fd_pr__pfet_01v8_lvt ad=0.261 pd=2.38 as=0.261 ps=2.38 w=0.9 l=0.35
X518 a_13171_4790# a_11215_5530# vss vss sky130_fd_pr__nfet_01v8_lvt ad=0.1595 pd=1.68 as=0.1595 ps=1.68 w=0.55 l=0.15
X519 vdd a_3087_7364# a_4811_6504# vdd sky130_fd_pr__pfet_01v8 ad=0.363 pd=2.53 as=0.363 ps=2.53 w=2.2 l=0.15
X520 vss a_21768_4674# ep vss sky130_fd_pr__nfet_01v8_lvt ad=0.434 pd=3.42 as=0.231 ps=1.73 w=1.4 l=0.15
X521 a_4089_11686# a_6055_12811# vdd vdd sky130_fd_pr__pfet_01v8 ad=0.36465 pd=2.54 as=0.6851 ps=5.04 w=2.21 l=0.15
X522 a_17182_11162# a_16679_11933# vdd vdd sky130_fd_pr__pfet_01v8 ad=0.1218 pd=1.42 as=0.1218 ps=1.42 w=0.42 l=0.28
X523 a_2938_205# a0 vss vss sky130_fd_pr__nfet_01v8 ad=0.1305 pd=1.48 as=0.1305 ps=1.48 w=0.45 l=0.18
X524 a_11215_1650# a_11173_1814# a_7971_1984# vdd sky130_fd_pr__pfet_01v8_lvt ad=0.261 pd=2.38 as=0.261 ps=2.38 w=0.9 l=0.35
X525 a_6247_2844# b3 a_363_2814# vss sky130_fd_pr__nfet_01v8_lvt ad=0.132 pd=1.13 as=0.248 ps=2.22 w=0.8 l=0.15
X526 a_13911_3430# f4 a_4811_1984# vss sky130_fd_pr__nfet_01v8_lvt ad=0.145 pd=1.58 as=0.145 ps=1.58 w=0.5 l=0.15
X527 a_8935_5530# a_8893_1814# a_7971_4856# vdd sky130_fd_pr__pfet_01v8_lvt ad=0.261 pd=2.38 as=0.261 ps=2.38 w=0.9 l=0.35
X528 a_21768_4674# a_21768_2174# vss sky130_fd_pr__res_high_po_0p35 l=10.5
X529 cke2 a_18971_12720# vdd vdd sky130_fd_pr__pfet_01v8 ad=0.4158 pd=2.85 as=0.4158 ps=2.85 w=2.52 l=0.15
X530 a_10891_1645# a_20664_1816# vss sky130_fd_pr__res_high_po_0p69 l=7.2
X531 a_11631_1650# f3 a_7971_1984# vdd sky130_fd_pr__pfet_01v8_lvt ad=0.261 pd=2.38 as=0.261 ps=2.38 w=0.9 l=0.35
X532 a_10399_11933# a_10902_11162# vdd vdd sky130_fd_pr__pfet_01v8 ad=0.1218 pd=1.42 as=0.1218 ps=1.42 w=0.42 l=0.28
X533 a_10399_11933# a_4089_11686# a_4651_12720# vss sky130_fd_pr__nfet_01v8_lvt ad=0.231 pd=1.73 as=0.434 ps=3.42 w=1.4 l=0.15
X534 a_11631_10050# f3 a_4811_9376# vss sky130_fd_pr__nfet_01v8_lvt ad=0.145 pd=1.58 as=0.145 ps=1.58 w=0.5 l=0.15
X535 a_13495_8270# a_13453_3298# a_7971_9376# vdd sky130_fd_pr__pfet_01v8_lvt ad=0.261 pd=2.38 as=0.261 ps=2.38 w=0.9 l=0.35
X536 a_2909_11950# a_1987_11933# vdd vdd sky130_fd_pr__pfet_01v8 ad=0.651 pd=4.82 as=0.3465 ps=2.43 w=2.1 l=0.15
X537 vdd a_10399_11933# a_4027_11933# vdd sky130_fd_pr__pfet_01v8 ad=0.58905 pd=3.9 as=0.58905 ps=3.9 w=3.57 l=0.15
X538 vss a_13911_6170# vss vss sky130_fd_pr__nfet_01v8_lvt ad=0.1595 pd=1.68 as=0 ps=0 w=0.55 l=0.15
X539 vdd a_13911_10050# vdd vdd sky130_fd_pr__pfet_01v8 ad=0.667 pd=5.18 as=0 ps=0 w=2.3 l=0.15
X540 a_363_2286# a4 a_3087_7364# vss sky130_fd_pr__nfet_01v8_lvt ad=0.248 pd=2.22 as=0.132 ps=1.13 w=0.8 l=0.15
X541 a_11631_7950# a_11173_3298# a_4811_6504# vdd sky130_fd_pr__pfet_01v8_lvt ad=0.261 pd=2.38 as=0.261 ps=2.38 w=0.9 l=0.35
X542 a_8935_6170# a_8893_1814# a_7971_6504# vdd sky130_fd_pr__pfet_01v8_lvt ad=0.261 pd=2.38 as=0.261 ps=2.38 w=0.9 l=0.35
X543 vss a_11631_5530# vss vss sky130_fd_pr__nfet_01v8_lvt ad=0.1595 pd=1.68 as=0 ps=0 w=0.55 l=0.15
X544 a_13911_8270# f4 a_7971_9376# vdd sky130_fd_pr__pfet_01v8_lvt ad=0.261 pd=2.38 as=0.261 ps=2.38 w=0.9 l=0.35
X545 vdd a_1987_11933# a_2909_11950# vdd sky130_fd_pr__pfet_01v8 ad=0.3465 pd=2.43 as=0.3465 ps=2.43 w=2.1 l=0.15
X546 a_1058_11170# a_411_11960# vss vss sky130_fd_pr__nfet_01v8 ad=0.174 pd=1.78 as=0.174 ps=1.78 w=0.6 l=0.18
X547 a_363_4894# b3 a_6247_8796# vss sky130_fd_pr__nfet_01v8_lvt ad=0.248 pd=2.22 as=0.132 ps=1.13 w=0.8 l=0.15
X548 vss a_6247_7364# a_7971_6504# vss sky130_fd_pr__nfet_01v8_lvt ad=0.31 pd=2.62 as=0.165 ps=1.33 w=1 l=0.15
X549 a_13495_3430# a_13453_3298# a_4811_1984# vss sky130_fd_pr__nfet_01v8_lvt ad=0.145 pd=1.58 as=0.145 ps=1.58 w=0.5 l=0.15
X550 a_17731_8265# a_20664_8208# vss sky130_fd_pr__res_high_po_0p69 l=7.2
X551 vdd c0 a_363_2286# vdd sky130_fd_pr__pfet_01v8_lvt ad=0.2465 pd=1.99 as=0.2465 ps=1.99 w=1.7 l=0.35
X552 vdd a_20335_12811# a_16649_11686# vdd sky130_fd_pr__pfet_01v8 ad=0.36465 pd=2.54 as=0.36465 ps=2.54 w=2.21 l=0.15
X553 a_6247_7364# a_6621_1968# a_363_9054# vdd sky130_fd_pr__pfet_01v8_lvt ad=0.3045 pd=2.39 as=0.609 ps=4.78 w=2.1 l=0.35
X554 a_11173_3298# f2 vss vss sky130_fd_pr__nfet_01v8 ad=0.1305 pd=1.48 as=0.1305 ps=1.48 w=0.45 l=0.18
X555 a_7971_4856# a_6247_4276# vss vss sky130_fd_pr__nfet_01v8_lvt ad=0.165 pd=1.33 as=0.31 ps=2.62 w=1 l=0.15
X556 vss a_3087_4276# a_4811_4856# vss sky130_fd_pr__nfet_01v8_lvt ad=0.31 pd=2.62 as=0.165 ps=1.33 w=1 l=0.15
X557 a_11215_7950# a_11173_3298# a_4811_6504# vss sky130_fd_pr__nfet_01v8_lvt ad=0.145 pd=1.58 as=0.145 ps=1.58 w=0.5 l=0.15
X558 a_15451_7210# a_13495_7950# vdd vdd sky130_fd_pr__pfet_01v8 ad=0.667 pd=5.18 as=0.667 ps=5.18 w=2.3 l=0.15
X559 a_9351_3430# f0 a_4811_1984# vss sky130_fd_pr__nfet_01v8_lvt ad=0.145 pd=1.58 as=0.145 ps=1.58 w=0.5 l=0.15
X560 a_8935_8270# f0 a_4811_9376# vdd sky130_fd_pr__pfet_01v8_lvt ad=0.261 pd=2.38 as=0.261 ps=2.38 w=0.9 l=0.35
X561 a_9351_3430# a_8893_3298# a_7971_1984# vss sky130_fd_pr__nfet_01v8_lvt ad=0.145 pd=1.58 as=0.145 ps=1.58 w=0.5 l=0.15
X562 vdd a_3087_8796# a_4811_9376# vdd sky130_fd_pr__pfet_01v8 ad=0.363 pd=2.53 as=0.363 ps=2.53 w=2.2 l=0.15
X563 a_13911_7950# a_13453_3298# a_4811_6504# vdd sky130_fd_pr__pfet_01v8_lvt ad=0.261 pd=2.38 as=0.261 ps=2.38 w=0.9 l=0.35
X564 a_3268_205# a1 vdd vdd sky130_fd_pr__pfet_01v8 ad=0.261 pd=2.38 as=0.261 ps=2.38 w=0.9 l=0.18
X565 vss a_13911_5530# vss vss sky130_fd_pr__nfet_01v8_lvt ad=0.1595 pd=1.68 as=0 ps=0 w=0.55 l=0.15
X566 cke3 cke1 vss vss sky130_fd_pr__nfet_01v8_lvt ad=0.1305 pd=1.48 as=0.1305 ps=1.48 w=0.45 l=0.15
X567 a_16191_8270# f6 a_7971_9376# vdd sky130_fd_pr__pfet_01v8_lvt ad=0.261 pd=2.38 as=0.261 ps=2.38 w=0.9 l=0.35
X568 a_7971_1984# a_6247_2844# vdd vdd sky130_fd_pr__pfet_01v8 ad=0.363 pd=2.53 as=0.363 ps=2.53 w=2.2 l=0.15
X569 a_15981_11939# a_15469_11950# vss vss sky130_fd_pr__nfet_01v8_lvt ad=0.17325 pd=1.38 as=0.3255 ps=2.72 w=1.05 l=0.15
X570 a_3087_4276# a_2938_205# a_363_4366# vdd sky130_fd_pr__pfet_01v8_lvt ad=0.3045 pd=2.39 as=0.609 ps=4.78 w=2.1 l=0.35
X571 a_10891_7210# a_8935_7950# vss vss sky130_fd_pr__nfet_01v8_lvt ad=0.1595 pd=1.68 as=0.1595 ps=1.68 w=0.55 l=0.15
X572 a_363_4366# a0 a_3087_4276# vss sky130_fd_pr__nfet_01v8_lvt ad=0.248 pd=2.22 as=0.132 ps=1.13 w=0.8 l=0.15
X573 vdd a_5719_11933# ckd3 vdd sky130_fd_pr__pfet_01v8 ad=0.4158 pd=2.85 as=0.4158 ps=2.85 w=2.52 l=0.15
X574 a_8935_8270# f0 a_7971_9376# vss sky130_fd_pr__nfet_01v8_lvt ad=0.145 pd=1.58 as=0.145 ps=1.58 w=0.5 l=0.15
X575 a_3901_1968# a4 vdd vdd sky130_fd_pr__pfet_01v8 ad=0.261 pd=2.38 as=0.261 ps=2.38 w=0.9 l=0.18
X576 a_8267_11933# a_411_11960# dn vdd sky130_fd_pr__pfet_01v8_lvt ad=0.6583 pd=5.12 as=0.32915 ps=2.56 w=2.27 l=0.35
X577 a_363_6446# c4 vss vss sky130_fd_pr__nfet_01v8_lvt ad=0.493 pd=3.98 as=0.493 ps=3.98 w=1.7 l=0.15
X578 a_20827_11933# rst_n vdd vdd sky130_fd_pr__pfet_01v8 ad=0.464 pd=3.78 as=0.464 ps=3.78 w=1.6 l=0.18
X579 a_13495_6170# f5 a_7971_6504# vss sky130_fd_pr__nfet_01v8_lvt ad=0.145 pd=1.58 as=0.145 ps=1.58 w=0.5 l=0.15
X580 a_15733_1814# f7 vdd vdd sky130_fd_pr__pfet_01v8 ad=0.261 pd=2.38 as=0.261 ps=2.38 w=0.9 l=0.18
X581 a_13495_7950# f4 a_4811_6504# vdd sky130_fd_pr__pfet_01v8_lvt ad=0.261 pd=2.38 as=0.261 ps=2.38 w=0.9 l=0.35
X582 a_15451_2690# a_13495_3430# vss vss sky130_fd_pr__nfet_01v8_lvt ad=0.1595 pd=1.68 as=0.1595 ps=1.68 w=0.55 l=0.15
X583 a_15775_5530# a_15733_1814# a_7971_4856# vdd sky130_fd_pr__pfet_01v8_lvt ad=0.261 pd=2.38 as=0.261 ps=2.38 w=0.9 l=0.35
X584 a_3087_7364# a6 a_363_4366# vss sky130_fd_pr__nfet_01v8_lvt ad=0.132 pd=1.13 as=0.248 ps=2.22 w=0.8 l=0.15
X585 a_13911_6170# a_13453_1814# a_7971_6504# vss sky130_fd_pr__nfet_01v8_lvt ad=0.145 pd=1.58 as=0.145 ps=1.58 w=0.5 l=0.15
X586 a_5248_205# a7 vdd vdd sky130_fd_pr__pfet_01v8 ad=0.261 pd=2.38 as=0.261 ps=2.38 w=0.9 l=0.18
X587 vdd a_6247_4276# a_7971_4856# vdd sky130_fd_pr__pfet_01v8 ad=0.363 pd=2.53 as=0.363 ps=2.53 w=2.2 l=0.15
X588 a_10399_11933# a_1418_11110# vss vss sky130_fd_pr__nfet_01v8 ad=0.29 pd=2.58 as=0.29 ps=2.58 w=1 l=0.18
X589 a_13911_10050# f5 a_4811_9376# vss sky130_fd_pr__nfet_01v8_lvt ad=0.145 pd=1.58 as=0.145 ps=1.58 w=0.5 l=0.15
X590 a_6247_8796# a_6621_1968# a_363_4894# vdd sky130_fd_pr__pfet_01v8_lvt ad=0.3045 pd=2.39 as=0.609 ps=4.78 w=2.1 l=0.35
X591 a_6247_4276# a_7501_1968# a_363_2814# vdd sky130_fd_pr__pfet_01v8_lvt ad=0.3045 pd=2.39 as=0.609 ps=4.78 w=2.1 l=0.35
X592 a_4622_11162# a_4119_11933# vss vss sky130_fd_pr__nfet_01v8 ad=0.1218 pd=1.42 as=0.1218 ps=1.42 w=0.42 l=0.28
X593 a_2901_12720# a_15981_11939# a_17182_11162# vss sky130_fd_pr__nfet_01v8_lvt ad=0.231 pd=1.73 as=0.434 ps=3.42 w=1.4 l=0.15
X594 a_11215_3430# a_11173_3298# a_7971_1984# vdd sky130_fd_pr__pfet_01v8_lvt ad=0.261 pd=2.38 as=0.261 ps=2.38 w=0.9 l=0.35
X595 a_4811_4856# a_3087_4276# vdd vdd sky130_fd_pr__pfet_01v8 ad=0.363 pd=2.53 as=0.363 ps=2.53 w=2.2 l=0.15
X596 a_363_2814# b7 a_6247_4276# vss sky130_fd_pr__nfet_01v8_lvt ad=0.248 pd=2.22 as=0.132 ps=1.13 w=0.8 l=0.15
X597 vdd a_21768_2174# a_21768_4674# vdd sky130_fd_pr__pfet_01v8_lvt ad=0.5365 pd=4.28 as=0.26825 ps=2.14 w=1.85 l=0.35
X598 a_11631_3430# f2 a_7971_1984# vdd sky130_fd_pr__pfet_01v8_lvt ad=0.261 pd=2.38 as=0.261 ps=2.38 w=0.9 l=0.35
X599 a_13171_7210# a_11215_7950# vss vss sky130_fd_pr__nfet_01v8_lvt ad=0.1595 pd=1.68 as=0.1595 ps=1.68 w=0.55 l=0.15
X600 a_9351_7950# f0 a_7971_6504# vdd sky130_fd_pr__pfet_01v8_lvt ad=0.261 pd=2.38 as=0.261 ps=2.38 w=0.9 l=0.35
X601 vdd a_6247_7364# a_7971_6504# vdd sky130_fd_pr__pfet_01v8 ad=0.682 pd=5.02 as=0.363 ps=2.53 w=2.2 l=0.15
X602 a_15775_6170# a_15733_1814# a_7971_6504# vdd sky130_fd_pr__pfet_01v8_lvt ad=0.261 pd=2.38 as=0.261 ps=2.38 w=0.9 l=0.35
X603 a_3087_2844# a_3461_1968# a_363_2286# vdd sky130_fd_pr__pfet_01v8_lvt ad=0.3045 pd=2.39 as=0.609 ps=4.78 w=2.1 l=0.35
X604 en a_21602_2174# vss vss sky130_fd_pr__nfet_01v8_lvt ad=0.231 pd=1.73 as=0.434 ps=3.42 w=1.4 l=0.15
X605 vdd a_16191_7950# vdd vdd sky130_fd_pr__pfet_01v8 ad=0.667 pd=5.18 as=0 ps=0 w=2.3 l=0.15
X606 a_17182_11162# a_16679_11933# vss vss sky130_fd_pr__nfet_01v8 ad=0.1218 pd=1.42 as=0.1218 ps=1.42 w=0.42 l=0.28
X607 a_3268_205# a1 vss vss sky130_fd_pr__nfet_01v8 ad=0.1305 pd=1.48 as=0.1305 ps=1.48 w=0.45 l=0.18
X608 a_8935_1650# a_8893_1814# a_4811_1984# vss sky130_fd_pr__nfet_01v8_lvt ad=0.145 pd=1.58 as=0.145 ps=1.58 w=0.5 l=0.15
X609 a_13495_5530# f5 a_7971_4856# vss sky130_fd_pr__nfet_01v8_lvt ad=0.145 pd=1.58 as=0.145 ps=1.58 w=0.5 l=0.15
X610 a_4027_11933# a_4089_11686# a_4119_11933# vdd sky130_fd_pr__pfet_01v8 ad=0.37455 pd=2.6 as=0.37455 ps=2.6 w=2.27 l=0.15
X611 a_6055_12811# a_8267_11933# vdd vdd sky130_fd_pr__pfet_01v8 ad=0.651 pd=4.82 as=0.3465 ps=2.43 w=2.1 l=0.15
X612 cke0 a_17221_12720# vss vss sky130_fd_pr__nfet_01v8_lvt ad=0.198 pd=1.53 as=0.372 ps=3.02 w=1.2 l=0.15
X613 a_10399_11933# a_10902_11162# vss vss sky130_fd_pr__nfet_01v8 ad=0.1218 pd=1.42 as=0.1218 ps=1.42 w=0.42 l=0.28
X614 a_16191_6170# a_15733_1814# a_7971_6504# vss sky130_fd_pr__nfet_01v8_lvt ad=0.145 pd=1.58 as=0.145 ps=1.58 w=0.5 l=0.15
X615 ckd2 a_4651_12720# vss vss sky130_fd_pr__nfet_01v8_lvt ad=0.198 pd=1.53 as=0.372 ps=3.02 w=1.2 l=0.15
X616 vdd a_10902_11162# a_5719_11933# vdd sky130_fd_pr__pfet_01v8 ad=1.1067 pd=7.76 as=0.58905 ps=3.9 w=3.57 l=0.15
X617 vss a_11631_7950# vss vss sky130_fd_pr__nfet_01v8_lvt ad=0.1595 pd=1.68 as=0 ps=0 w=0.55 l=0.15
X618 a_363_8526# a2 a_3087_7364# vss sky130_fd_pr__nfet_01v8_lvt ad=0.248 pd=2.22 as=0.132 ps=1.13 w=0.8 l=0.15
X619 a_363_6446# a6 a_3087_2844# vss sky130_fd_pr__nfet_01v8_lvt ad=0.248 pd=2.22 as=0.132 ps=1.13 w=0.8 l=0.15
X620 a_13911_5530# a_13453_1814# a_7971_4856# vss sky130_fd_pr__nfet_01v8_lvt ad=0.145 pd=1.58 as=0.145 ps=1.58 w=0.5 l=0.15
X621 a_3901_1968# a4 vss vss sky130_fd_pr__nfet_01v8 ad=0.1305 pd=1.48 as=0.1305 ps=1.48 w=0.45 l=0.18
X622 a_3087_4276# a2 a_363_6446# vss sky130_fd_pr__nfet_01v8_lvt ad=0.132 pd=1.13 as=0.248 ps=2.22 w=0.8 l=0.15
X623 cke2 a_18971_12720# vss vss sky130_fd_pr__nfet_01v8_lvt ad=0.198 pd=1.53 as=0.372 ps=3.02 w=1.2 l=0.15
X624 a_15733_1814# f7 vss vss sky130_fd_pr__nfet_01v8 ad=0.1305 pd=1.48 as=0.1305 ps=1.48 w=0.45 l=0.18
X625 vss a_9351_3750# vss vss sky130_fd_pr__nfet_01v8_lvt ad=0.1595 pd=1.68 as=0 ps=0 w=0.55 l=0.15
X626 a_11631_10050# a_11173_1814# a_7971_9376# vss sky130_fd_pr__nfet_01v8_lvt ad=0.145 pd=1.58 as=0.145 ps=1.58 w=0.5 l=0.15
X627 vdd a_9351_3430# vdd vdd sky130_fd_pr__pfet_01v8 ad=0.667 pd=5.18 as=0 ps=0 w=2.3 l=0.15
X628 ckd2 ckd0 vdd vdd sky130_fd_pr__pfet_01v8 ad=0.5481 pd=4.36 as=0.5481 ps=4.36 w=1.89 l=0.15
X629 a_363_4366# a_3901_1968# a_3087_2844# vdd sky130_fd_pr__pfet_01v8_lvt ad=0.609 pd=4.78 as=0.3045 ps=2.39 w=2.1 l=0.35
X630 vss a_16191_3430# vss vss sky130_fd_pr__nfet_01v8_lvt ad=0.1595 pd=1.68 as=0 ps=0 w=0.55 l=0.15
X631 a_5248_205# a7 vss vss sky130_fd_pr__nfet_01v8 ad=0.1305 pd=1.48 as=0.1305 ps=1.48 w=0.45 l=0.18
X632 a_4651_12720# a_4089_11686# a_10399_11933# vss sky130_fd_pr__nfet_01v8_lvt ad=0.434 pd=3.42 as=0.231 ps=1.73 w=1.4 l=0.15
X633 vdd c7 a_363_9054# vdd sky130_fd_pr__pfet_01v8_lvt ad=0.493 pd=3.98 as=0.2465 ps=1.99 w=1.7 l=0.35
X634 vdd c3 a_363_4894# vdd sky130_fd_pr__pfet_01v8_lvt ad=0.2465 pd=1.99 as=0.2465 ps=1.99 w=1.7 l=0.35
X635 a_4027_11933# a_10399_11933# vdd vdd sky130_fd_pr__pfet_01v8 ad=0.58905 pd=3.9 as=0.58905 ps=3.9 w=3.57 l=0.15
X636 vdd a_6247_8796# a_7971_9376# vdd sky130_fd_pr__pfet_01v8 ad=0.682 pd=5.02 as=0.363 ps=2.53 w=2.2 l=0.15
X637 vdd a_9351_8270# vdd vdd sky130_fd_pr__pfet_01v8 ad=0.667 pd=5.18 as=0 ps=0 w=2.3 l=0.15
X638 a_16191_5530# a_15733_1814# a_7971_4856# vss sky130_fd_pr__nfet_01v8_lvt ad=0.145 pd=1.58 as=0.145 ps=1.58 w=0.5 l=0.15
X639 vss a_13911_7950# vss vss sky130_fd_pr__nfet_01v8_lvt ad=0.1595 pd=1.68 as=0 ps=0 w=0.55 l=0.15
X640 a_10891_2690# a_20664_1816# vss sky130_fd_pr__res_high_po_0p69 l=7.2
X641 vdd c1 a_363_2814# vdd sky130_fd_pr__pfet_01v8_lvt ad=0.493 pd=3.98 as=0.2465 ps=1.99 w=1.7 l=0.35
X642 a_10891_3745# a_8935_3750# vdd vdd sky130_fd_pr__pfet_01v8 ad=0.667 pd=5.18 as=0.667 ps=5.18 w=2.3 l=0.15
X643 a_13495_10050# a_13453_1814# a_7971_9376# vdd sky130_fd_pr__pfet_01v8_lvt ad=0.261 pd=2.38 as=0.261 ps=2.38 w=0.9 l=0.35
X644 a_11631_6170# a_11173_1814# a_7971_6504# vss sky130_fd_pr__nfet_01v8_lvt ad=0.145 pd=1.58 as=0.145 ps=1.58 w=0.5 l=0.15
X645 vdd a_3087_2844# a_4811_1984# vdd sky130_fd_pr__pfet_01v8 ad=0.682 pd=5.02 as=0.363 ps=2.53 w=2.2 l=0.15
X646 a_9351_3750# a_8893_3298# a_4811_4856# vdd sky130_fd_pr__pfet_01v8_lvt ad=0.261 pd=2.38 as=0.261 ps=2.38 w=0.9 l=0.35
X647 a_13453_3298# f4 vdd vdd sky130_fd_pr__pfet_01v8 ad=0.261 pd=2.38 as=0.261 ps=2.38 w=0.9 l=0.18
X648 a_20664_6336# vss sky130_fd_pr__cap_mim_m3_1 l=3.1 w=3.1
X649 a_1418_11110# a_1058_11170# vss vss sky130_fd_pr__nfet_01v8 ad=0.348 pd=2.98 as=0.348 ps=2.98 w=1.2 l=0.18
X650 a_16649_11686# a_20335_12811# vdd vdd sky130_fd_pr__pfet_01v8 ad=0.36465 pd=2.54 as=0.36465 ps=2.54 w=2.21 l=0.15
X651 a_8935_7950# a_8893_3298# a_7971_6504# vdd sky130_fd_pr__pfet_01v8_lvt ad=0.261 pd=2.38 as=0.261 ps=2.38 w=0.9 l=0.35
X652 a_13911_10050# f5 a_7971_9376# vdd sky130_fd_pr__pfet_01v8_lvt ad=0.261 pd=2.38 as=0.261 ps=2.38 w=0.9 l=0.35
X653 a_363_2286# c0 vdd vdd sky130_fd_pr__pfet_01v8_lvt ad=0.2465 pd=1.99 as=0.2465 ps=1.99 w=1.7 l=0.35
X654 a_363_9054# a_6621_1968# a_6247_7364# vdd sky130_fd_pr__pfet_01v8_lvt ad=0.609 pd=4.78 as=0.3045 ps=2.39 w=2.1 l=0.35
X655 a_363_4366# c2 vdd vdd sky130_fd_pr__pfet_01v8_lvt ad=0.2465 pd=1.99 as=0.493 ps=3.98 w=1.7 l=0.35
X656 en a_21602_2174# vdd vdd sky130_fd_pr__pfet_01v8_lvt ad=0.406 pd=3.09 as=0.812 ps=6.18 w=2.8 l=0.35
X657 a_22959_11933# a_23462_11162# vdd vdd sky130_fd_pr__pfet_01v8 ad=0.1218 pd=1.42 as=0.1218 ps=1.42 w=0.42 l=0.28
X658 a_15451_8265# a_20664_8208# vss sky130_fd_pr__res_high_po_0p69 l=7.2
X659 a_3087_2844# a4 a_363_4366# vss sky130_fd_pr__nfet_01v8_lvt ad=0.132 pd=1.13 as=0.248 ps=2.22 w=0.8 l=0.15
X660 cke1 cke3 vdd vdd sky130_fd_pr__pfet_01v8 ad=0.5481 pd=4.36 as=0.5481 ps=4.36 w=1.89 l=0.15
X661 a_16679_11933# a_1418_11110# vss vss sky130_fd_pr__nfet_01v8 ad=0.29 pd=2.58 as=0.29 ps=2.58 w=1 l=0.18
X662 a_15451_4790# a_13495_5530# vdd vdd sky130_fd_pr__pfet_01v8 ad=0.667 pd=5.18 as=0.667 ps=5.18 w=2.3 l=0.15
X663 ckd1 a_4027_11933# vdd vdd sky130_fd_pr__pfet_01v8 ad=0.4158 pd=2.85 as=0.7812 ps=5.66 w=2.52 l=0.15
X664 a_16191_3750# f6 a_4811_4856# vss sky130_fd_pr__nfet_01v8_lvt ad=0.145 pd=1.58 as=0.145 ps=1.58 w=0.5 l=0.15
X665 vdd rst_n a_411_11960# vdd sky130_fd_pr__pfet_01v8 ad=0.62 pd=4.62 as=0.33 ps=2.33 w=2 l=0.15
X666 a_13171_3745# a_11215_3750# vdd vdd sky130_fd_pr__pfet_01v8 ad=0.667 pd=5.18 as=0.667 ps=5.18 w=2.3 l=0.15
X667 a_15469_11950# a_14547_11933# vdd vdd sky130_fd_pr__pfet_01v8 ad=0.3465 pd=2.43 as=0.651 ps=4.82 w=2.1 l=0.15
X668 vss a_15469_11950# a_15981_11939# vss sky130_fd_pr__nfet_01v8_lvt ad=0.3255 pd=2.72 as=0.17325 ps=1.38 w=1.05 l=0.15
X669 a_11631_5530# a_11173_1814# a_7971_4856# vss sky130_fd_pr__nfet_01v8_lvt ad=0.145 pd=1.58 as=0.145 ps=1.58 w=0.5 l=0.15
X670 a_15775_3430# f6 a_7971_1984# vss sky130_fd_pr__nfet_01v8_lvt ad=0.145 pd=1.58 as=0.145 ps=1.58 w=0.5 l=0.15
X671 a_8935_10050# f1 a_4811_9376# vdd sky130_fd_pr__pfet_01v8_lvt ad=0.261 pd=2.38 as=0.261 ps=2.38 w=0.9 l=0.35
X672 ckd3 a_5719_11933# vdd vdd sky130_fd_pr__pfet_01v8 ad=0.4158 pd=2.85 as=0.4158 ps=2.85 w=2.52 l=0.15
X673 a_8267_11933# a_411_11960# dn vdd sky130_fd_pr__pfet_01v8_lvt ad=0.32915 pd=2.56 as=0.6583 ps=5.12 w=2.27 l=0.35
X674 a_363_4366# a_2938_205# a_3087_4276# vdd sky130_fd_pr__pfet_01v8_lvt ad=0.609 pd=4.78 as=0.3045 ps=2.39 w=2.1 l=0.35
X675 a_4651_12720# a_2901_12720# vss vss sky130_fd_pr__nfet_01v8_lvt ad=0.1218 pd=1.42 as=0.1218 ps=1.42 w=0.42 l=0.15
X676 a_16191_10050# f7 a_7971_9376# vdd sky130_fd_pr__pfet_01v8_lvt ad=0.261 pd=2.38 as=0.261 ps=2.38 w=0.9 l=0.35
X677 a_20664_1816# vss sky130_fd_pr__cap_mim_m3_1 l=3.1 w=3.1
X678 a_4027_11933# a_15981_11939# a_23462_11162# vdd sky130_fd_pr__pfet_01v8 ad=0.37455 pd=2.6 as=0.7037 ps=5.16 w=2.27 l=0.15
X679 a_5719_11933# a_3421_11939# a_4622_11162# vss sky130_fd_pr__nfet_01v8_lvt ad=0.231 pd=1.73 as=0.434 ps=3.42 w=1.4 l=0.15
X680 a_13495_7950# f4 a_7971_6504# vss sky130_fd_pr__nfet_01v8_lvt ad=0.145 pd=1.58 as=0.145 ps=1.58 w=0.5 l=0.15
X681 a_3087_7364# a_3901_1968# a_363_2286# vdd sky130_fd_pr__pfet_01v8_lvt ad=0.3045 pd=2.39 as=0.609 ps=4.78 w=2.1 l=0.35
X682 a_6247_2844# b1 a_363_9054# vss sky130_fd_pr__nfet_01v8_lvt ad=0.132 pd=1.13 as=0.248 ps=2.22 w=0.8 l=0.15
X683 a_15775_3750# a_15733_3298# a_4811_4856# vss sky130_fd_pr__nfet_01v8_lvt ad=0.145 pd=1.58 as=0.145 ps=1.58 w=0.5 l=0.15
X684 vdd a_11631_3750# vdd vdd sky130_fd_pr__pfet_01v8 ad=0.667 pd=5.18 as=0 ps=0 w=2.3 l=0.15
X685 a_6247_2844# b5 a_363_4894# vss sky130_fd_pr__nfet_01v8_lvt ad=0.132 pd=1.13 as=0.248 ps=2.22 w=0.8 l=0.15
X686 a_4089_11686# a_3421_11939# vdd vdd sky130_fd_pr__pfet_01v8 ad=0.5481 pd=4.36 as=0.5481 ps=4.36 w=1.89 l=0.15
X687 a_17182_11162# a_15981_11939# a_2901_12720# vss sky130_fd_pr__nfet_01v8_lvt ad=0.434 pd=3.42 as=0.231 ps=1.73 w=1.4 l=0.15
X688 a_13911_7950# a_13453_3298# a_7971_6504# vss sky130_fd_pr__nfet_01v8_lvt ad=0.145 pd=1.58 as=0.145 ps=1.58 w=0.5 l=0.15
X689 a_13453_3298# f4 vss vss sky130_fd_pr__nfet_01v8 ad=0.1305 pd=1.48 as=0.1305 ps=1.48 w=0.45 l=0.18
X690 a_11215_1650# a_11173_1814# a_4811_1984# vss sky130_fd_pr__nfet_01v8_lvt ad=0.145 pd=1.58 as=0.145 ps=1.58 w=0.5 l=0.15
X691 a_11215_3750# f2 a_4811_4856# vdd sky130_fd_pr__pfet_01v8_lvt ad=0.261 pd=2.38 as=0.261 ps=2.38 w=0.9 l=0.35
X692 a_21602_6694# a_21602_9194# vdd vdd sky130_fd_pr__pfet_01v8_lvt ad=0.26825 pd=2.14 as=0.26825 ps=2.14 w=1.85 l=0.35
X693 a_363_2814# a_7501_1968# a_6247_4276# vdd sky130_fd_pr__pfet_01v8_lvt ad=0.609 pd=4.78 as=0.3045 ps=2.39 w=2.1 l=0.35
X694 a_363_4894# a_6621_1968# a_6247_8796# vdd sky130_fd_pr__pfet_01v8_lvt ad=0.609 pd=4.78 as=0.3045 ps=2.39 w=2.1 l=0.35
X695 ckd1 ckd3 vss vss sky130_fd_pr__nfet_01v8_lvt ad=0.1305 pd=1.48 as=0.1305 ps=1.48 w=0.45 l=0.15
X696 vdd a_23221_12720# cke1 vdd sky130_fd_pr__pfet_01v8 ad=0.4158 pd=2.85 as=0.4158 ps=2.85 w=2.52 l=0.15
X697 a_9351_10050# f1 a_4811_9376# vss sky130_fd_pr__nfet_01v8_lvt ad=0.145 pd=1.58 as=0.145 ps=1.58 w=0.5 l=0.15
X698 a_11631_8270# f2 a_4811_9376# vss sky130_fd_pr__nfet_01v8_lvt ad=0.145 pd=1.58 as=0.145 ps=1.58 w=0.5 l=0.15
X699 ckd3 ckd1 vdd vdd sky130_fd_pr__pfet_01v8 ad=0.5481 pd=4.36 as=0.5481 ps=4.36 w=1.89 l=0.15
X700 a_17731_6165# a_20664_6336# vss sky130_fd_pr__res_high_po_0p69 l=7.2
X701 a_411_11960# rst_n vss vss sky130_fd_pr__nfet_01v8_lvt ad=0.165 pd=1.33 as=0.31 ps=2.62 w=1 l=0.15
X702 a_363_2814# b1 a_6247_8796# vss sky130_fd_pr__nfet_01v8_lvt ad=0.248 pd=2.22 as=0.132 ps=1.13 w=0.8 l=0.15
X703 a_10891_1645# a_8935_1650# vss vss sky130_fd_pr__nfet_01v8_lvt ad=0.1595 pd=1.68 as=0.1595 ps=1.68 w=0.55 l=0.15
X704 a_363_2286# a_3461_1968# a_3087_2844# vdd sky130_fd_pr__pfet_01v8_lvt ad=0.609 pd=4.78 as=0.3045 ps=2.39 w=2.1 l=0.35
X705 vdd a_16191_5530# vdd vdd sky130_fd_pr__pfet_01v8 ad=0.667 pd=5.18 as=0 ps=0 w=2.3 l=0.15
X706 a_363_6974# b5 a_6247_8796# vss sky130_fd_pr__nfet_01v8_lvt ad=0.248 pd=2.22 as=0.132 ps=1.13 w=0.8 l=0.15
X707 vdd a_24971_12720# cke3 vdd sky130_fd_pr__pfet_01v8 ad=0.4158 pd=2.85 as=0.4158 ps=2.85 w=2.52 l=0.15
X708 a_15775_7950# a_15733_3298# a_7971_6504# vdd sky130_fd_pr__pfet_01v8_lvt ad=0.261 pd=2.38 as=0.261 ps=2.38 w=0.9 l=0.35
X709 a_11631_1650# a_11173_1814# a_4811_1984# vdd sky130_fd_pr__pfet_01v8_lvt ad=0.261 pd=2.38 as=0.261 ps=2.38 w=0.9 l=0.35
X710 vdd a_13911_3750# vdd vdd sky130_fd_pr__pfet_01v8 ad=0.667 pd=5.18 as=0 ps=0 w=2.3 l=0.15
X711 a_4119_11933# a_4089_11686# a_4027_11933# vdd sky130_fd_pr__pfet_01v8 ad=0.7037 pd=5.16 as=0.37455 ps=2.6 w=2.27 l=0.15
X712 a_6247_7364# a_7061_1968# a_363_2814# vdd sky130_fd_pr__pfet_01v8_lvt ad=0.3045 pd=2.39 as=0.609 ps=4.78 w=2.1 l=0.35
X713 a_9351_5530# a_8893_1814# a_4811_4856# vdd sky130_fd_pr__pfet_01v8_lvt ad=0.261 pd=2.38 as=0.261 ps=2.38 w=0.9 l=0.35
X714 vss a_17221_12720# cke0 vss sky130_fd_pr__nfet_01v8_lvt ad=0.372 pd=3.02 as=0.198 ps=1.53 w=1.2 l=0.15
X715 dp a_411_11960# a_1987_11933# vdd sky130_fd_pr__pfet_01v8_lvt ad=0.32915 pd=2.56 as=0.32915 ps=2.56 w=2.27 l=0.35
X716 a_363_4894# c3 vss vss sky130_fd_pr__nfet_01v8_lvt ad=0.493 pd=3.98 as=0.493 ps=3.98 w=1.7 l=0.15
X717 vss a_4651_12720# ckd2 vss sky130_fd_pr__nfet_01v8_lvt ad=0.372 pd=3.02 as=0.198 ps=1.53 w=1.2 l=0.15
X718 vdd a_4119_11933# a_2901_12720# vdd sky130_fd_pr__pfet_01v8 ad=1.1067 pd=7.76 as=0.58905 ps=3.9 w=3.57 l=0.15
X719 a_16191_7950# a_15733_3298# a_7971_6504# vss sky130_fd_pr__nfet_01v8_lvt ad=0.145 pd=1.58 as=0.145 ps=1.58 w=0.5 l=0.15
X720 a_10891_6165# a_8935_6170# vdd vdd sky130_fd_pr__pfet_01v8 ad=0.667 pd=5.18 as=0.667 ps=5.18 w=2.3 l=0.15
X721 a_7971_4856# a_6247_4276# vdd vdd sky130_fd_pr__pfet_01v8 ad=0.363 pd=2.53 as=0.682 ps=5.02 w=2.2 l=0.15
X722 vdd c6 a_363_8526# vdd sky130_fd_pr__pfet_01v8_lvt ad=0.493 pd=3.98 as=0.2465 ps=1.99 w=1.7 l=0.35
X723 a_9351_6170# a_8893_1814# a_4811_6504# vdd sky130_fd_pr__pfet_01v8_lvt ad=0.261 pd=2.38 as=0.261 ps=2.38 w=0.9 l=0.35
X724 a_3087_8796# a_3901_1968# a_363_6446# vdd sky130_fd_pr__pfet_01v8_lvt ad=0.3045 pd=2.39 as=0.609 ps=4.78 w=2.1 l=0.35
X725 vss a_18971_12720# cke2 vss sky130_fd_pr__nfet_01v8_lvt ad=0.372 pd=3.02 as=0.198 ps=1.53 w=1.2 l=0.15
X726 a_13911_8270# f4 a_4811_9376# vss sky130_fd_pr__nfet_01v8_lvt ad=0.145 pd=1.58 as=0.145 ps=1.58 w=0.5 l=0.15
X727 a_17731_3745# a_15775_3750# vss vss sky130_fd_pr__nfet_01v8_lvt ad=0.1595 pd=1.68 as=0.1595 ps=1.68 w=0.55 l=0.15
X728 vdd a_21602_6694# dn vdd sky130_fd_pr__pfet_01v8_lvt ad=0.406 pd=3.09 as=0.406 ps=3.09 w=2.8 l=0.35
X729 a_17731_2690# a_15775_3430# vdd vdd sky130_fd_pr__pfet_01v8 ad=0.667 pd=5.18 as=0.667 ps=5.18 w=2.3 l=0.15
X730 a_13171_1645# a_11215_1650# vss vss sky130_fd_pr__nfet_01v8_lvt ad=0.1595 pd=1.68 as=0.1595 ps=1.68 w=0.55 l=0.15
X731 a_15451_1645# a_13495_1650# vdd vdd sky130_fd_pr__pfet_01v8 ad=0.667 pd=5.18 as=0.667 ps=5.18 w=2.3 l=0.15
X732 ep a_21768_4674# vss vss sky130_fd_pr__nfet_01v8_lvt ad=0.231 pd=1.73 as=0.434 ps=3.42 w=1.4 l=0.15
X733 a_13911_1650# a_13453_1814# a_4811_1984# vdd sky130_fd_pr__pfet_01v8_lvt ad=0.261 pd=2.38 as=0.261 ps=2.38 w=0.9 l=0.35
X734 a_4651_12720# a_2901_12720# vdd vdd sky130_fd_pr__pfet_01v8 ad=0.5104 pd=4.1 as=0.5104 ps=4.1 w=1.76 l=0.15
X735 a_21768_9194# a_21768_6694# vdd vdd sky130_fd_pr__pfet_01v8_lvt ad=0.26825 pd=2.14 as=0.5365 ps=4.28 w=1.85 l=0.35
X736 vdd a_21768_4674# ep vdd sky130_fd_pr__pfet_01v8_lvt ad=0.812 pd=6.18 as=0.406 ps=3.09 w=2.8 l=0.35
X737 a_22959_11933# a_23462_11162# vss vss sky130_fd_pr__nfet_01v8 ad=0.1218 pd=1.42 as=0.1218 ps=1.42 w=0.42 l=0.28
X738 a_15469_11950# a_14547_11933# vss vss sky130_fd_pr__nfet_01v8_lvt ad=0.435 pd=3.58 as=0.435 ps=3.58 w=1.5 l=0.15
X739 a_17731_8265# a_15775_8270# vdd vdd sky130_fd_pr__pfet_01v8 ad=0.667 pd=5.18 as=0.667 ps=5.18 w=2.3 l=0.15
X740 a_363_4894# c3 vdd vdd sky130_fd_pr__pfet_01v8_lvt ad=0.2465 pd=1.99 as=0.2465 ps=1.99 w=1.7 l=0.35
X741 a_363_6974# c5 vdd vdd sky130_fd_pr__pfet_01v8_lvt ad=0.2465 pd=1.99 as=0.493 ps=3.98 w=1.7 l=0.35
X742 cke2 cke0 vdd vdd sky130_fd_pr__pfet_01v8 ad=0.5481 pd=4.36 as=0.5481 ps=4.36 w=1.89 l=0.15
X743 a_16191_8270# a_15733_3298# a_4811_9376# vdd sky130_fd_pr__pfet_01v8_lvt ad=0.261 pd=2.38 as=0.261 ps=2.38 w=0.9 l=0.35
X744 a_13171_6165# a_11215_6170# vdd vdd sky130_fd_pr__pfet_01v8 ad=0.667 pd=5.18 as=0.667 ps=5.18 w=2.3 l=0.15
X745 a_17731_9310# a_20664_8208# vss sky130_fd_pr__res_high_po_0p69 l=7.2
X746 a_13495_8270# a_13453_3298# a_4811_9376# vss sky130_fd_pr__nfet_01v8_lvt ad=0.145 pd=1.58 as=0.145 ps=1.58 w=0.5 l=0.15
X747 a_16191_10050# f7 a_4811_9376# vss sky130_fd_pr__nfet_01v8_lvt ad=0.145 pd=1.58 as=0.145 ps=1.58 w=0.5 l=0.15
X748 vss a_9351_6170# vss vss sky130_fd_pr__nfet_01v8_lvt ad=0.1595 pd=1.68 as=0 ps=0 w=0.55 l=0.15
X749 vss a_11631_1650# vss vss sky130_fd_pr__nfet_01v8_lvt ad=0.1595 pd=1.68 as=0 ps=0 w=0.55 l=0.15
X750 vdd a_9351_10050# vdd vdd sky130_fd_pr__pfet_01v8 ad=0.667 pd=5.18 as=0 ps=0 w=2.3 l=0.15
X751 a_11631_7950# a_11173_3298# a_7971_6504# vss sky130_fd_pr__nfet_01v8_lvt ad=0.145 pd=1.58 as=0.145 ps=1.58 w=0.5 l=0.15
X752 a_6247_8796# a_7061_1968# a_363_6974# vdd sky130_fd_pr__pfet_01v8_lvt ad=0.3045 pd=2.39 as=0.609 ps=4.78 w=2.1 l=0.35
X753 a_6247_8796# b3 a_363_4894# vss sky130_fd_pr__nfet_01v8_lvt ad=0.132 pd=1.13 as=0.248 ps=2.22 w=0.8 l=0.15
X754 a_7971_6504# a_6247_7364# vss vss sky130_fd_pr__nfet_01v8_lvt ad=0.165 pd=1.33 as=0.31 ps=2.62 w=1 l=0.15
X755 a_11215_3750# f2 a_7971_4856# vss sky130_fd_pr__nfet_01v8_lvt ad=0.145 pd=1.58 as=0.145 ps=1.58 w=0.5 l=0.15
X756 a_1418_11110# a_1058_11170# vdd vdd sky130_fd_pr__pfet_01v8 ad=0.87 pd=6.58 as=0.87 ps=6.58 w=3 l=0.18
X757 vss a_3087_7364# a_4811_6504# vss sky130_fd_pr__nfet_01v8_lvt ad=0.31 pd=2.62 as=0.165 ps=1.33 w=1 l=0.15
X758 a_13495_1650# f5 a_4811_1984# vdd sky130_fd_pr__pfet_01v8_lvt ad=0.261 pd=2.38 as=0.261 ps=2.38 w=0.9 l=0.35
X759 a_11215_5530# f3 a_4811_4856# vdd sky130_fd_pr__pfet_01v8_lvt ad=0.261 pd=2.38 as=0.261 ps=2.38 w=0.9 l=0.35
X760 a_6398_205# b2 vdd vdd sky130_fd_pr__pfet_01v8 ad=0.261 pd=2.38 as=0.261 ps=2.38 w=0.9 l=0.18
X761 a_8935_3430# a_8893_3298# a_4811_1984# vss sky130_fd_pr__nfet_01v8_lvt ad=0.145 pd=1.58 as=0.145 ps=1.58 w=0.5 l=0.15
X762 a_9351_8270# f0 a_4811_9376# vss sky130_fd_pr__nfet_01v8_lvt ad=0.145 pd=1.58 as=0.145 ps=1.58 w=0.5 l=0.15
X763 a_21602_2174# a_21602_4674# vdd vdd sky130_fd_pr__pfet_01v8_lvt ad=0.26825 pd=2.14 as=0.5365 ps=4.28 w=1.85 l=0.35
X764 a_3087_2844# a_2938_205# a_363_8526# vdd sky130_fd_pr__pfet_01v8_lvt ad=0.3045 pd=2.39 as=0.609 ps=4.78 w=2.1 l=0.35
X765 a_5719_11933# a_16649_11686# a_22959_11933# vss sky130_fd_pr__nfet_01v8_lvt ad=0.434 pd=3.42 as=0.231 ps=1.73 w=1.4 l=0.15
X766 a_9351_8270# a_8893_3298# a_7971_9376# vss sky130_fd_pr__nfet_01v8_lvt ad=0.145 pd=1.58 as=0.145 ps=1.58 w=0.5 l=0.15
X767 vdd a_11631_6170# vdd vdd sky130_fd_pr__pfet_01v8 ad=0.667 pd=5.18 as=0 ps=0 w=2.3 l=0.15
X768 a_15775_8270# f6 a_4811_9376# vdd sky130_fd_pr__pfet_01v8_lvt ad=0.261 pd=2.38 as=0.261 ps=2.38 w=0.9 l=0.35
X769 vdd a_21768_9194# dp vdd sky130_fd_pr__pfet_01v8_lvt ad=0.406 pd=3.09 as=0.406 ps=3.09 w=2.8 l=0.35
X770 a_4811_4856# a_3087_4276# vss vss sky130_fd_pr__nfet_01v8_lvt ad=0.165 pd=1.33 as=0.31 ps=2.62 w=1 l=0.15
X771 ckd3 a_5719_11933# vss vss sky130_fd_pr__nfet_01v8_lvt ad=0.198 pd=1.53 as=0.372 ps=3.02 w=1.2 l=0.15
X772 a_22959_11933# a_16649_11686# a_5719_11933# vss sky130_fd_pr__nfet_01v8_lvt ad=0.231 pd=1.73 as=0.434 ps=3.42 w=1.4 l=0.15
X773 a_11215_6170# f3 a_4811_6504# vdd sky130_fd_pr__pfet_01v8_lvt ad=0.261 pd=2.38 as=0.261 ps=2.38 w=0.9 l=0.35
X774 a_7061_1968# b5 vdd vdd sky130_fd_pr__pfet_01v8 ad=0.261 pd=2.38 as=0.261 ps=2.38 w=0.9 l=0.18
X775 a_10399_11933# a_3421_11939# a_4651_12720# vdd sky130_fd_pr__pfet_01v8 ad=0.37455 pd=2.6 as=0.7037 ps=5.16 w=2.27 l=0.15
X776 vdd a_14547_11933# a_15469_11950# vdd sky130_fd_pr__pfet_01v8 ad=0.3465 pd=2.43 as=0.3465 ps=2.43 w=2.1 l=0.15
X777 a_9351_1650# f1 a_7971_1984# vdd sky130_fd_pr__pfet_01v8_lvt ad=0.261 pd=2.38 as=0.261 ps=2.38 w=0.9 l=0.35
X778 vdd c2 a_363_4366# vdd sky130_fd_pr__pfet_01v8_lvt ad=0.2465 pd=1.99 as=0.2465 ps=1.99 w=1.7 l=0.35
X779 a_10902_11162# a_10399_11933# vdd vdd sky130_fd_pr__pfet_01v8 ad=0.1218 pd=1.42 as=0.1218 ps=1.42 w=0.42 l=0.28
X780 vss a_13911_1650# vss vss sky130_fd_pr__nfet_01v8_lvt ad=0.1595 pd=1.68 as=0 ps=0 w=0.55 l=0.15
X781 a_363_6446# a0 a_3087_7364# vss sky130_fd_pr__nfet_01v8_lvt ad=0.248 pd=2.22 as=0.132 ps=1.13 w=0.8 l=0.15
X782 a_13171_3745# a_20664_3688# vss sky130_fd_pr__res_high_po_0p69 l=7.2
X783 vdd a_16191_1650# vdd vdd sky130_fd_pr__pfet_01v8 ad=0.667 pd=5.18 as=0 ps=0 w=2.3 l=0.15
X784 a_11631_3430# a_11173_3298# a_4811_1984# vdd sky130_fd_pr__pfet_01v8_lvt ad=0.261 pd=2.38 as=0.261 ps=2.38 w=0.9 l=0.35
X785 a_363_4366# a4 a_3087_2844# vss sky130_fd_pr__nfet_01v8_lvt ad=0.248 pd=2.22 as=0.132 ps=1.13 w=0.8 l=0.15
X786 vss a_9351_5530# vss vss sky130_fd_pr__nfet_01v8_lvt ad=0.1595 pd=1.68 as=0 ps=0 w=0.55 l=0.15
X787 vdd a_6247_2844# a_7971_1984# vdd sky130_fd_pr__pfet_01v8 ad=0.363 pd=2.53 as=0.363 ps=2.53 w=2.2 l=0.15
X788 a_6247_2844# a_7501_1968# a_363_6974# vdd sky130_fd_pr__pfet_01v8_lvt ad=0.3045 pd=2.39 as=0.609 ps=4.78 w=2.1 l=0.35
X789 a_23462_11162# a_15981_11939# a_4027_11933# vdd sky130_fd_pr__pfet_01v8 ad=0.37455 pd=2.6 as=0.37455 ps=2.6 w=2.27 l=0.15
X790 a_4811_1984# a_3087_2844# vdd vdd sky130_fd_pr__pfet_01v8 ad=0.363 pd=2.53 as=0.363 ps=2.53 w=2.2 l=0.15
X791 a_18971_12720# a_17182_11162# vdd vdd sky130_fd_pr__pfet_01v8 ad=0.33495 pd=2.36 as=0.6293 ps=4.68 w=2.03 l=0.15
X792 vss a_6247_2844# a_7971_1984# vss sky130_fd_pr__nfet_01v8_lvt ad=0.31 pd=2.62 as=0.165 ps=1.33 w=1 l=0.15
X793 a_3087_4276# a0 a_363_4366# vss sky130_fd_pr__nfet_01v8_lvt ad=0.132 pd=1.13 as=0.248 ps=2.22 w=0.8 l=0.15
X794 vdd a_4622_11162# a_4651_12720# vdd sky130_fd_pr__pfet_01v8 ad=1.1067 pd=7.76 as=0.58905 ps=3.9 w=3.57 l=0.15
X795 a_4622_11162# a_3421_11939# a_5719_11933# vss sky130_fd_pr__nfet_01v8_lvt ad=0.434 pd=3.42 as=0.231 ps=1.73 w=1.4 l=0.15
X796 a_15981_11939# a_15469_11950# vdd vdd sky130_fd_pr__pfet_01v8 ad=0.36465 pd=2.54 as=0.6851 ps=5.04 w=2.21 l=0.15
X797 a_15451_8265# a_13495_8270# vss vss sky130_fd_pr__nfet_01v8_lvt ad=0.1595 pd=1.68 as=0.1595 ps=1.68 w=0.55 l=0.15
X798 vdd a_13911_6170# vdd vdd sky130_fd_pr__pfet_01v8 ad=0.667 pd=5.18 as=0 ps=0 w=2.3 l=0.15
X799 dn a_411_11960# a_8267_11933# vdd sky130_fd_pr__pfet_01v8_lvt ad=0.32915 pd=2.56 as=0.32915 ps=2.56 w=2.27 l=0.35
X800 a_17221_12720# a_16679_11933# vss vss sky130_fd_pr__nfet_01v8_lvt ad=0.4205 pd=3.48 as=0.4205 ps=3.48 w=1.45 l=0.15
X801 a_23221_12720# a_22959_11933# vdd vdd sky130_fd_pr__pfet_01v8 ad=0.33495 pd=2.36 as=0.6293 ps=4.68 w=2.03 l=0.15
X802 a_15733_3298# f6 vdd vdd sky130_fd_pr__pfet_01v8 ad=0.261 pd=2.38 as=0.261 ps=2.38 w=0.9 l=0.18
X803 vdd a_2909_11950# a_3421_11939# vdd sky130_fd_pr__pfet_01v8 ad=0.36465 pd=2.54 as=0.36465 ps=2.54 w=2.21 l=0.15
X804 a_16191_6170# f7 a_4811_6504# vss sky130_fd_pr__nfet_01v8_lvt ad=0.145 pd=1.58 as=0.145 ps=1.58 w=0.5 l=0.15
X805 a_21768_6694# a_20664_6336# sky130_fd_pr__cap_mim_m3_1 l=4.1 w=4.1
X806 a_363_4894# b7 a_6247_7364# vss sky130_fd_pr__nfet_01v8_lvt ad=0.248 pd=2.22 as=0.132 ps=1.13 w=0.8 l=0.15
X807 cke1 a_23221_12720# vdd vdd sky130_fd_pr__pfet_01v8 ad=0.4158 pd=2.85 as=0.4158 ps=2.85 w=2.52 l=0.15
X808 vdd a_3087_4276# a_4811_4856# vdd sky130_fd_pr__pfet_01v8 ad=0.363 pd=2.53 as=0.363 ps=2.53 w=2.2 l=0.15
X809 a_6398_205# b2 vss vss sky130_fd_pr__nfet_01v8 ad=0.1305 pd=1.48 as=0.1305 ps=1.48 w=0.45 l=0.18
X810 a_13911_3430# a_13453_3298# a_4811_1984# vdd sky130_fd_pr__pfet_01v8_lvt ad=0.261 pd=2.38 as=0.261 ps=2.38 w=0.9 l=0.35
X811 a_6247_4276# b7 a_363_2814# vss sky130_fd_pr__nfet_01v8_lvt ad=0.132 pd=1.13 as=0.248 ps=2.22 w=0.8 l=0.15
X812 vss rst_n a_411_11960# vss sky130_fd_pr__nfet_01v8_lvt ad=0.31 pd=2.62 as=0.165 ps=1.33 w=1 l=0.15
X813 cke3 a_24971_12720# vdd vdd sky130_fd_pr__pfet_01v8 ad=0.4158 pd=2.85 as=0.4158 ps=2.85 w=2.52 l=0.15
X814 a_15775_6170# a_15733_1814# a_4811_6504# vss sky130_fd_pr__nfet_01v8_lvt ad=0.145 pd=1.58 as=0.145 ps=1.58 w=0.5 l=0.15
X815 a_7061_1968# b5 vss vss sky130_fd_pr__nfet_01v8 ad=0.1305 pd=1.48 as=0.1305 ps=1.48 w=0.45 l=0.18
X816 a_8935_3750# f0 a_7971_4856# vss sky130_fd_pr__nfet_01v8_lvt ad=0.145 pd=1.58 as=0.145 ps=1.58 w=0.5 l=0.15
X817 a_363_6974# a_6068_205# a_6247_7364# vdd sky130_fd_pr__pfet_01v8_lvt ad=0.609 pd=4.78 as=0.3045 ps=2.39 w=2.1 l=0.35
X818 a_15451_6165# a_20664_6336# vss sky130_fd_pr__res_high_po_0p69 l=7.2
X819 a_13495_1650# f5 a_7971_1984# vss sky130_fd_pr__nfet_01v8_lvt ad=0.145 pd=1.58 as=0.145 ps=1.58 w=0.5 l=0.15
X820 a_16191_5530# f7 a_4811_4856# vss sky130_fd_pr__nfet_01v8_lvt ad=0.145 pd=1.58 as=0.145 ps=1.58 w=0.5 l=0.15
X821 a_363_2814# a_7061_1968# a_6247_7364# vdd sky130_fd_pr__pfet_01v8_lvt ad=0.609 pd=4.78 as=0.3045 ps=2.39 w=2.1 l=0.35
X822 a_13495_3430# f4 a_4811_1984# vdd sky130_fd_pr__pfet_01v8_lvt ad=0.261 pd=2.38 as=0.261 ps=2.38 w=0.9 l=0.35
X823 a_13495_3750# a_13453_3298# a_7971_4856# vdd sky130_fd_pr__pfet_01v8_lvt ad=0.261 pd=2.38 as=0.261 ps=2.38 w=0.9 l=0.35
X824 a_21768_2174# a_20664_1816# sky130_fd_pr__cap_mim_m3_1 l=4.1 w=4.1
X825 a_3087_7364# a2 a_363_8526# vss sky130_fd_pr__nfet_01v8_lvt ad=0.132 pd=1.13 as=0.248 ps=2.22 w=0.8 l=0.15
X826 a_8935_1650# a_8893_1814# a_7971_1984# vdd sky130_fd_pr__pfet_01v8_lvt ad=0.261 pd=2.38 as=0.261 ps=2.38 w=0.9 l=0.35
X827 a_3087_2844# a6 a_363_6446# vss sky130_fd_pr__nfet_01v8_lvt ad=0.132 pd=1.13 as=0.248 ps=2.22 w=0.8 l=0.15
X828 a_13911_1650# a_13453_1814# a_7971_1984# vss sky130_fd_pr__nfet_01v8_lvt ad=0.145 pd=1.58 as=0.145 ps=1.58 w=0.5 l=0.15
X829 a_13911_3750# f4 a_7971_4856# vdd sky130_fd_pr__pfet_01v8_lvt ad=0.261 pd=2.38 as=0.261 ps=2.38 w=0.9 l=0.35
X830 a_6247_4276# a_6621_1968# a_363_6974# vdd sky130_fd_pr__pfet_01v8_lvt ad=0.3045 pd=2.39 as=0.609 ps=4.78 w=2.1 l=0.35
X831 vss a_16191_8270# vss vss sky130_fd_pr__nfet_01v8_lvt ad=0.1595 pd=1.68 as=0 ps=0 w=0.55 l=0.15
X832 vdd a_21602_9194# a_21602_6694# vdd sky130_fd_pr__pfet_01v8_lvt ad=0.26825 pd=2.14 as=0.26825 ps=2.14 w=1.85 l=0.35
X833 a_363_6974# b3 a_6247_4276# vss sky130_fd_pr__nfet_01v8_lvt ad=0.248 pd=2.22 as=0.132 ps=1.13 w=0.8 l=0.15
X834 a_6055_12811# a_2909_11950# vss vss sky130_fd_pr__nfet_01v8_lvt ad=0.1305 pd=1.48 as=0.1305 ps=1.48 w=0.45 l=0.15
X835 a_11215_8270# a_11173_3298# a_7971_9376# vdd sky130_fd_pr__pfet_01v8_lvt ad=0.261 pd=2.38 as=0.261 ps=2.38 w=0.9 l=0.35
X836 a_10891_7210# a_8935_7950# vdd vdd sky130_fd_pr__pfet_01v8 ad=0.667 pd=5.18 as=0.667 ps=5.18 w=2.3 l=0.15
X837 a_15733_3298# f6 vss vss sky130_fd_pr__nfet_01v8 ad=0.1305 pd=1.48 as=0.1305 ps=1.48 w=0.45 l=0.18
X838 a_20335_12811# a_15469_11950# vdd vdd sky130_fd_pr__pfet_01v8 ad=0.5481 pd=4.36 as=0.5481 ps=4.36 w=1.89 l=0.15
X839 a_9351_3430# f0 a_7971_1984# vdd sky130_fd_pr__pfet_01v8_lvt ad=0.261 pd=2.38 as=0.261 ps=2.38 w=0.9 l=0.35
X840 a_9351_7950# a_8893_3298# a_4811_6504# vdd sky130_fd_pr__pfet_01v8_lvt ad=0.261 pd=2.38 as=0.261 ps=2.38 w=0.9 l=0.35
X841 dn a_21602_6694# vdd vdd sky130_fd_pr__pfet_01v8_lvt ad=0.406 pd=3.09 as=0.406 ps=3.09 w=2.8 l=0.35
X842 a_3421_11939# a_4089_11686# vss vss sky130_fd_pr__nfet_01v8_lvt ad=0.1305 pd=1.48 as=0.1305 ps=1.48 w=0.45 l=0.15
X843 a_2901_12720# a_4089_11686# a_10902_11162# vss sky130_fd_pr__nfet_01v8_lvt ad=0.231 pd=1.73 as=0.434 ps=3.42 w=1.4 l=0.15
X844 a_11631_8270# f2 a_7971_9376# vdd sky130_fd_pr__pfet_01v8_lvt ad=0.261 pd=2.38 as=0.261 ps=2.38 w=0.9 l=0.35
X845 a_21602_9194# a_21602_6694# vss sky130_fd_pr__res_high_po_0p35 l=10.5
X846 a_15775_5530# a_15733_1814# a_4811_4856# vss sky130_fd_pr__nfet_01v8_lvt ad=0.145 pd=1.58 as=0.145 ps=1.58 w=0.5 l=0.15
X847 a_14547_11933# a_411_11960# ep vdd sky130_fd_pr__pfet_01v8_lvt ad=0.6583 pd=5.12 as=0.32915 ps=2.56 w=2.27 l=0.35
X848 a_20827_11933# rst_n en vss sky130_fd_pr__nfet_01v8_lvt ad=0.2145 pd=1.63 as=0.403 ps=3.22 w=1.3 l=0.15
X849 a_411_11960# rst_n vdd vdd sky130_fd_pr__pfet_01v8 ad=0.33 pd=2.33 as=0.62 ps=4.62 w=2 l=0.15
X850 a_363_8526# a6 a_3087_8796# vss sky130_fd_pr__nfet_01v8_lvt ad=0.248 pd=2.22 as=0.132 ps=1.13 w=0.8 l=0.15
X851 a_11215_3430# a_11173_3298# a_4811_1984# vss sky130_fd_pr__nfet_01v8_lvt ad=0.145 pd=1.58 as=0.145 ps=1.58 w=0.5 l=0.15
X852 a_8935_3750# f0 a_4811_4856# vdd sky130_fd_pr__pfet_01v8_lvt ad=0.261 pd=2.38 as=0.261 ps=2.38 w=0.9 l=0.35
X853 a_16679_11933# a_16649_11686# a_4651_12720# vdd sky130_fd_pr__pfet_01v8 ad=0.37455 pd=2.6 as=0.7037 ps=5.16 w=2.27 l=0.15
X854 a_363_8526# c6 vss vss sky130_fd_pr__nfet_01v8_lvt ad=0.493 pd=3.98 as=0.493 ps=3.98 w=1.7 l=0.15
X855 a_3087_7364# a_4341_1968# a_363_4366# vdd sky130_fd_pr__pfet_01v8_lvt ad=0.3045 pd=2.39 as=0.609 ps=4.78 w=2.1 l=0.35
X856 a_16191_1650# a_15733_1814# a_7971_1984# vss sky130_fd_pr__nfet_01v8_lvt ad=0.145 pd=1.58 as=0.145 ps=1.58 w=0.5 l=0.15
X857 a_10902_11162# a_10399_11933# vss vss sky130_fd_pr__nfet_01v8 ad=0.1218 pd=1.42 as=0.1218 ps=1.42 w=0.42 l=0.28
X858 a_17731_6165# a_15775_6170# vss vss sky130_fd_pr__nfet_01v8_lvt ad=0.1595 pd=1.68 as=0.1595 ps=1.68 w=0.55 l=0.15
X859 a_363_2286# a2 a_3087_2844# vss sky130_fd_pr__nfet_01v8_lvt ad=0.248 pd=2.22 as=0.132 ps=1.13 w=0.8 l=0.15
X860 a_16191_3750# f6 a_7971_4856# vdd sky130_fd_pr__pfet_01v8_lvt ad=0.261 pd=2.38 as=0.261 ps=2.38 w=0.9 l=0.35
X861 a_17731_9310# a_15775_10050# vdd vdd sky130_fd_pr__pfet_01v8 ad=0.667 pd=5.18 as=0.667 ps=5.18 w=2.3 l=0.15
X862 vss a_9351_7950# vss vss sky130_fd_pr__nfet_01v8_lvt ad=0.1595 pd=1.68 as=0 ps=0 w=0.55 l=0.15
X863 a_24971_12720# a_23462_11162# vdd vdd sky130_fd_pr__pfet_01v8 ad=0.33495 pd=2.36 as=0.6293 ps=4.68 w=2.03 l=0.15
X864 a_363_2814# a_6068_205# a_6247_8796# vdd sky130_fd_pr__pfet_01v8_lvt ad=0.609 pd=4.78 as=0.3045 ps=2.39 w=2.1 l=0.35
X865 a_16191_10050# a_15733_1814# a_4811_9376# vdd sky130_fd_pr__pfet_01v8_lvt ad=0.261 pd=2.38 as=0.261 ps=2.38 w=0.9 l=0.35
X866 vdd c5 a_363_6974# vdd sky130_fd_pr__pfet_01v8_lvt ad=0.2465 pd=1.99 as=0.2465 ps=1.99 w=1.7 l=0.35
X867 a_13171_7210# a_11215_7950# vdd vdd sky130_fd_pr__pfet_01v8 ad=0.667 pd=5.18 as=0.667 ps=5.18 w=2.3 l=0.15
X868 vdd a_17221_12720# cke0 vdd sky130_fd_pr__pfet_01v8 ad=0.7812 pd=5.66 as=0.4158 ps=2.85 w=2.52 l=0.15
X869 a_363_6974# a_7061_1968# a_6247_8796# vdd sky130_fd_pr__pfet_01v8_lvt ad=0.609 pd=4.78 as=0.3045 ps=2.39 w=2.1 l=0.35
X870 a_10891_2690# a_8935_3430# vss vss sky130_fd_pr__nfet_01v8_lvt ad=0.1595 pd=1.68 as=0.1595 ps=1.68 w=0.55 l=0.15
X871 vdd a_4651_12720# ckd2 vdd sky130_fd_pr__pfet_01v8 ad=0.7812 pd=5.66 as=0.4158 ps=2.85 w=2.52 l=0.15
X872 a_8893_1814# f1 vdd vdd sky130_fd_pr__pfet_01v8 ad=0.261 pd=2.38 as=0.261 ps=2.38 w=0.9 l=0.18
X873 a_16649_11686# a_15981_11939# vdd vdd sky130_fd_pr__pfet_01v8 ad=0.5481 pd=4.36 as=0.5481 ps=4.36 w=1.89 l=0.15
X874 vdd a_6055_12811# a_4089_11686# vdd sky130_fd_pr__pfet_01v8 ad=0.36465 pd=2.54 as=0.36465 ps=2.54 w=2.21 l=0.15
X875 a_363_8526# a_2938_205# a_3087_2844# vdd sky130_fd_pr__pfet_01v8_lvt ad=0.609 pd=4.78 as=0.3045 ps=2.39 w=2.1 l=0.35
X876 vss a_5719_11933# ckd3 vss sky130_fd_pr__nfet_01v8_lvt ad=0.372 pd=3.02 as=0.198 ps=1.53 w=1.2 l=0.15
X877 dp a_21768_9194# vdd vdd sky130_fd_pr__pfet_01v8_lvt ad=0.406 pd=3.09 as=0.406 ps=3.09 w=2.8 l=0.35
X878 vdd a_18971_12720# cke2 vdd sky130_fd_pr__pfet_01v8 ad=0.7812 pd=5.66 as=0.4158 ps=2.85 w=2.52 l=0.15
X879 a_15469_11950# a_14547_11933# vdd vdd sky130_fd_pr__pfet_01v8 ad=0.651 pd=4.82 as=0.3465 ps=2.43 w=2.1 l=0.15
X880 a_4651_12720# a_3421_11939# a_10399_11933# vdd sky130_fd_pr__pfet_01v8 ad=0.37455 pd=2.6 as=0.37455 ps=2.6 w=2.27 l=0.15
X881 a_15775_8270# f6 a_7971_9376# vss sky130_fd_pr__nfet_01v8_lvt ad=0.145 pd=1.58 as=0.145 ps=1.58 w=0.5 l=0.15
X882 vdd a_11631_7950# vdd vdd sky130_fd_pr__pfet_01v8 ad=0.667 pd=5.18 as=0 ps=0 w=2.3 l=0.15
X883 vdd a_6247_4276# a_7971_4856# vdd sky130_fd_pr__pfet_01v8 ad=0.682 pd=5.02 as=0.363 ps=2.53 w=2.2 l=0.15
X884 a_15775_10050# f7 a_4811_9376# vdd sky130_fd_pr__pfet_01v8_lvt ad=0.261 pd=2.38 as=0.261 ps=2.38 w=0.9 l=0.35
X885 ep a_21768_4674# vdd vdd sky130_fd_pr__pfet_01v8_lvt ad=0.406 pd=3.09 as=0.812 ps=6.18 w=2.8 l=0.35
X886 cke0 cke2 vss vss sky130_fd_pr__nfet_01v8_lvt ad=0.1305 pd=1.48 as=0.1305 ps=1.48 w=0.45 l=0.15
X887 a_363_4366# c2 vdd vdd sky130_fd_pr__pfet_01v8_lvt ad=0.2465 pd=1.99 as=0.2465 ps=1.99 w=1.7 l=0.35
X888 a_363_6446# c4 vdd vdd sky130_fd_pr__pfet_01v8_lvt ad=0.2465 pd=1.99 as=0.493 ps=3.98 w=1.7 l=0.35
X889 a_11215_6170# f3 a_7971_6504# vss sky130_fd_pr__nfet_01v8_lvt ad=0.145 pd=1.58 as=0.145 ps=1.58 w=0.5 l=0.15
X890 a_17731_4790# a_15775_5530# vss vss sky130_fd_pr__nfet_01v8_lvt ad=0.1595 pd=1.68 as=0.1595 ps=1.68 w=0.55 l=0.15
X891 a_11215_7950# f2 a_4811_6504# vdd sky130_fd_pr__pfet_01v8_lvt ad=0.261 pd=2.38 as=0.261 ps=2.38 w=0.9 l=0.35
X892 vdd a_17182_11162# a_18971_12720# vdd sky130_fd_pr__pfet_01v8 ad=0.33495 pd=2.36 as=0.33495 ps=2.36 w=2.03 l=0.15
X893 a_4027_11933# a_15981_11939# a_23462_11162# vdd sky130_fd_pr__pfet_01v8 ad=0.7037 pd=5.16 as=0.37455 ps=2.6 w=2.27 l=0.15
X894 a_21768_9194# a_21768_6694# vss vss sky130_fd_pr__nfet_01v8_lvt ad=0.5365 pd=4.28 as=0.5365 ps=4.28 w=1.85 l=0.15
X895 a_3461_1968# a2 vdd vdd sky130_fd_pr__pfet_01v8 ad=0.261 pd=2.38 as=0.261 ps=2.38 w=0.9 l=0.18
X896 a_11631_1650# a_11173_1814# a_7971_1984# vss sky130_fd_pr__nfet_01v8_lvt ad=0.145 pd=1.58 as=0.145 ps=1.58 w=0.5 l=0.15
X897 a_15775_1650# a_15733_1814# a_7971_1984# vdd sky130_fd_pr__pfet_01v8_lvt ad=0.261 pd=2.38 as=0.261 ps=2.38 w=0.9 l=0.35
X898 a_13171_2690# a_11215_3430# vss vss sky130_fd_pr__nfet_01v8_lvt ad=0.1595 pd=1.68 as=0.1595 ps=1.68 w=0.55 l=0.15
X899 a_13495_5530# a_13453_1814# a_7971_4856# vdd sky130_fd_pr__pfet_01v8_lvt ad=0.261 pd=2.38 as=0.261 ps=2.38 w=0.9 l=0.35
X900 a_363_6974# a_7501_1968# a_6247_2844# vdd sky130_fd_pr__pfet_01v8_lvt ad=0.609 pd=4.78 as=0.3045 ps=2.39 w=2.1 l=0.35
X901 a_3087_8796# a_4341_1968# a_363_8526# vdd sky130_fd_pr__pfet_01v8_lvt ad=0.3045 pd=2.39 as=0.609 ps=4.78 w=2.1 l=0.35
X902 a_2901_12720# a_4119_11933# vdd vdd sky130_fd_pr__pfet_01v8 ad=0.58905 pd=3.9 as=1.1067 ps=7.76 w=3.57 l=0.15
X903 a_10891_3745# a_20664_3688# vss sky130_fd_pr__res_high_po_0p69 l=7.2
X904 a_8935_3430# a_8893_3298# a_7971_1984# vdd sky130_fd_pr__pfet_01v8_lvt ad=0.261 pd=2.38 as=0.261 ps=2.38 w=0.9 l=0.35
X905 vdd a_22959_11933# a_23221_12720# vdd sky130_fd_pr__pfet_01v8 ad=0.33495 pd=2.36 as=0.33495 ps=2.36 w=2.03 l=0.15
X906 a_3087_8796# a4 a_363_6446# vss sky130_fd_pr__nfet_01v8_lvt ad=0.132 pd=1.13 as=0.248 ps=2.22 w=0.8 l=0.15
X907 a_13911_5530# f5 a_7971_4856# vdd sky130_fd_pr__pfet_01v8_lvt ad=0.261 pd=2.38 as=0.261 ps=2.38 w=0.9 l=0.35
X908 cke1 a_23221_12720# vss vss sky130_fd_pr__nfet_01v8_lvt ad=0.198 pd=1.53 as=0.372 ps=3.02 w=1.2 l=0.15
X909 a_3421_11939# a_2909_11950# vdd vdd sky130_fd_pr__pfet_01v8 ad=0.36465 pd=2.54 as=0.36465 ps=2.54 w=2.21 l=0.15
X910 a_4588_205# a5 vdd vdd sky130_fd_pr__pfet_01v8 ad=0.261 pd=2.38 as=0.261 ps=2.38 w=0.9 l=0.18
X911 ckd0 ckd2 vdd vdd sky130_fd_pr__pfet_01v8 ad=0.5481 pd=4.36 as=0.5481 ps=4.36 w=1.89 l=0.15
X912 a_16191_7950# f6 a_4811_6504# vss sky130_fd_pr__nfet_01v8_lvt ad=0.145 pd=1.58 as=0.145 ps=1.58 w=0.5 l=0.15
X913 a_13495_6170# a_13453_1814# a_7971_6504# vdd sky130_fd_pr__pfet_01v8_lvt ad=0.261 pd=2.38 as=0.261 ps=2.38 w=0.9 l=0.35
X914 a_8267_11933# rst_n vdd vdd sky130_fd_pr__pfet_01v8 ad=0.464 pd=3.78 as=0.464 ps=3.78 w=1.6 l=0.18
X915 a_15451_3745# a_20664_3688# vss sky130_fd_pr__res_high_po_0p69 l=7.2
X916 a_23462_11162# a_22959_11933# vdd vdd sky130_fd_pr__pfet_01v8 ad=0.1218 pd=1.42 as=0.1218 ps=1.42 w=0.42 l=0.28
X917 vdd a_13911_7950# vdd vdd sky130_fd_pr__pfet_01v8 ad=0.667 pd=5.18 as=0 ps=0 w=2.3 l=0.15
X918 vss a_11631_3430# vss vss sky130_fd_pr__nfet_01v8_lvt ad=0.1595 pd=1.68 as=0 ps=0 w=0.55 l=0.15
X919 a_17731_7210# a_20664_6336# vss sky130_fd_pr__res_high_po_0p69 l=7.2
X920 cke3 a_24971_12720# vss vss sky130_fd_pr__nfet_01v8_lvt ad=0.198 pd=1.53 as=0.372 ps=3.02 w=1.2 l=0.15
X921 a_13911_6170# f5 a_7971_6504# vdd sky130_fd_pr__pfet_01v8_lvt ad=0.261 pd=2.38 as=0.261 ps=2.38 w=0.9 l=0.35
X922 a_11215_5530# f3 a_7971_4856# vss sky130_fd_pr__nfet_01v8_lvt ad=0.145 pd=1.58 as=0.145 ps=1.58 w=0.5 l=0.15
X923 a_8893_1814# f1 vss vss sky130_fd_pr__nfet_01v8 ad=0.1305 pd=1.48 as=0.1305 ps=1.48 w=0.45 l=0.18
X924 a_7971_1984# a_6247_2844# vdd vdd sky130_fd_pr__pfet_01v8 ad=0.363 pd=2.53 as=0.682 ps=5.02 w=2.2 l=0.15
X925 a_8935_5530# f1 a_4811_4856# vdd sky130_fd_pr__pfet_01v8_lvt ad=0.261 pd=2.38 as=0.261 ps=2.38 w=0.9 l=0.35
X926 a_6247_8796# b1 a_363_2814# vss sky130_fd_pr__nfet_01v8_lvt ad=0.132 pd=1.13 as=0.248 ps=2.22 w=0.8 l=0.15
X927 a_15775_7950# a_15733_3298# a_4811_6504# vss sky130_fd_pr__nfet_01v8_lvt ad=0.145 pd=1.58 as=0.145 ps=1.58 w=0.5 l=0.15
X928 a_16191_5530# f7 a_7971_4856# vdd sky130_fd_pr__pfet_01v8_lvt ad=0.261 pd=2.38 as=0.261 ps=2.38 w=0.9 l=0.35
X929 a_6247_8796# b5 a_363_6974# vss sky130_fd_pr__nfet_01v8_lvt ad=0.132 pd=1.13 as=0.248 ps=2.22 w=0.8 l=0.15
X930 a_15451_9310# a_20664_8208# vss sky130_fd_pr__res_high_po_0p69 l=7.2
X931 a_11215_10050# f3 a_7971_9376# vss sky130_fd_pr__nfet_01v8_lvt ad=0.145 pd=1.58 as=0.145 ps=1.58 w=0.5 l=0.15
X932 a_5719_11933# a_4089_11686# a_4622_11162# vdd sky130_fd_pr__pfet_01v8 ad=0.37455 pd=2.6 as=0.7037 ps=5.16 w=2.27 l=0.15
X933 a_8935_6170# f1 a_4811_6504# vdd sky130_fd_pr__pfet_01v8_lvt ad=0.261 pd=2.38 as=0.261 ps=2.38 w=0.9 l=0.35
X934 a_3461_1968# a2 vss vss sky130_fd_pr__nfet_01v8 ad=0.1305 pd=1.48 as=0.1305 ps=1.48 w=0.45 l=0.18
X935 vdd a_9351_3750# vdd vdd sky130_fd_pr__pfet_01v8 ad=0.667 pd=5.18 as=0 ps=0 w=2.3 l=0.15
X936 a_17221_12720# a_18971_12720# vss vss sky130_fd_pr__nfet_01v8_lvt ad=0.1218 pd=1.42 as=0.1218 ps=1.42 w=0.42 l=0.15
X937 a_11215_10050# a_11173_1814# a_4811_9376# vss sky130_fd_pr__nfet_01v8_lvt ad=0.145 pd=1.58 as=0.145 ps=1.58 w=0.5 l=0.15
X938 vss a_13911_3430# vss vss sky130_fd_pr__nfet_01v8_lvt ad=0.1595 pd=1.68 as=0 ps=0 w=0.55 l=0.15
X939 a_16191_6170# f7 a_7971_6504# vdd sky130_fd_pr__pfet_01v8_lvt ad=0.261 pd=2.38 as=0.261 ps=2.38 w=0.9 l=0.35
X940 a_21602_6694# a_21602_9194# vss vss sky130_fd_pr__nfet_01v8_lvt ad=0.5365 pd=4.28 as=0.5365 ps=4.28 w=1.85 l=0.15
X941 a_13171_1645# a_20664_1816# vss sky130_fd_pr__res_high_po_0p69 l=7.2
X942 a_363_6974# a_6621_1968# a_6247_4276# vdd sky130_fd_pr__pfet_01v8_lvt ad=0.609 pd=4.78 as=0.3045 ps=2.39 w=2.1 l=0.35
X943 a_8935_6170# f1 a_7971_6504# vss sky130_fd_pr__nfet_01v8_lvt ad=0.145 pd=1.58 as=0.145 ps=1.58 w=0.5 l=0.15
X944 a_4588_205# a5 vss vss sky130_fd_pr__nfet_01v8 ad=0.1305 pd=1.48 as=0.1305 ps=1.48 w=0.45 l=0.18
X945 a_10891_4790# a_8935_5530# vdd vdd sky130_fd_pr__pfet_01v8 ad=0.667 pd=5.18 as=0.667 ps=5.18 w=2.3 l=0.15
X946 a_14547_11933# a_411_11960# ep vdd sky130_fd_pr__pfet_01v8_lvt ad=0.32915 pd=2.56 as=0.6583 ps=5.12 w=2.27 l=0.35
X947 a_10902_11162# a_4089_11686# a_2901_12720# vss sky130_fd_pr__nfet_01v8_lvt ad=0.434 pd=3.42 as=0.231 ps=1.73 w=1.4 l=0.15
X948 a_11631_3750# f2 a_4811_4856# vss sky130_fd_pr__nfet_01v8_lvt ad=0.145 pd=1.58 as=0.145 ps=1.58 w=0.5 l=0.15
X949 a_5719_11933# a_4027_11933# vss vss sky130_fd_pr__nfet_01v8_lvt ad=0.1218 pd=1.42 as=0.1218 ps=1.42 w=0.42 l=0.15
X950 en rst_n a_20827_11933# vss sky130_fd_pr__nfet_01v8_lvt ad=0.403 pd=3.22 as=0.2145 ps=1.63 w=1.3 l=0.15
X951 a_17731_1645# a_20664_1816# vss sky130_fd_pr__res_high_po_0p69 l=7.2
X952 a_2909_11950# a_6055_12811# vdd vdd sky130_fd_pr__pfet_01v8 ad=0.5481 pd=4.36 as=0.5481 ps=4.36 w=1.89 l=0.15
X953 a_11215_10050# a_11173_1814# a_7971_9376# vdd sky130_fd_pr__pfet_01v8_lvt ad=0.261 pd=2.38 as=0.261 ps=2.38 w=0.9 l=0.35
X954 a_4651_12720# a_16649_11686# a_16679_11933# vdd sky130_fd_pr__pfet_01v8 ad=0.37455 pd=2.6 as=0.37455 ps=2.6 w=2.27 l=0.15
X955 a_15775_3430# a_15733_3298# a_7971_1984# vdd sky130_fd_pr__pfet_01v8_lvt ad=0.261 pd=2.38 as=0.261 ps=2.38 w=0.9 l=0.35
X956 a_11631_10050# f3 a_7971_9376# vdd sky130_fd_pr__pfet_01v8_lvt ad=0.261 pd=2.38 as=0.261 ps=2.38 w=0.9 l=0.35
X957 a_6247_7364# a_6068_205# a_363_6974# vdd sky130_fd_pr__pfet_01v8_lvt ad=0.3045 pd=2.39 as=0.609 ps=4.78 w=2.1 l=0.35
X958 a_363_4366# a_4341_1968# a_3087_7364# vdd sky130_fd_pr__pfet_01v8_lvt ad=0.609 pd=4.78 as=0.3045 ps=2.39 w=2.1 l=0.35
X959 a_4651_12720# a_4622_11162# vdd vdd sky130_fd_pr__pfet_01v8 ad=0.58905 pd=3.9 as=1.1067 ps=7.76 w=3.57 l=0.15
X960 a_17731_7210# a_15775_7950# vss vss sky130_fd_pr__nfet_01v8_lvt ad=0.1595 pd=1.68 as=0.1595 ps=1.68 w=0.55 l=0.15
X961 a_20664_8208# vss sky130_fd_pr__cap_mim_m3_1 l=3.1 w=3.1
X962 a_23462_11162# a_1058_11170# vdd vdd sky130_fd_pr__pfet_01v8 ad=0.522 pd=4.18 as=0.522 ps=4.18 w=1.8 l=0.18
X963 vdd a_23462_11162# a_24971_12720# vdd sky130_fd_pr__pfet_01v8 ad=0.33495 pd=2.36 as=0.33495 ps=2.36 w=2.03 l=0.15
X964 a_8935_8270# a_8893_3298# a_4811_9376# vss sky130_fd_pr__nfet_01v8_lvt ad=0.145 pd=1.58 as=0.145 ps=1.58 w=0.5 l=0.15
X965 a_13171_7210# a_20664_6336# vss sky130_fd_pr__res_high_po_0p69 l=7.2
X966 a_21768_9194# a_21768_6694# vdd vdd sky130_fd_pr__pfet_01v8_lvt ad=0.26825 pd=2.14 as=0.26825 ps=2.14 w=1.85 l=0.35
X967 a_2901_12720# a_4119_11933# vss vss sky130_fd_pr__nfet_01v8_lvt ad=0.2805 pd=2.03 as=0.527 ps=4.02 w=1.7 l=0.15
X968 vss a_10902_11162# a_5719_11933# vss sky130_fd_pr__nfet_01v8_lvt ad=0.527 pd=4.02 as=0.2805 ps=2.03 w=1.7 l=0.15
X969 a_13171_4790# a_11215_5530# vdd vdd sky130_fd_pr__pfet_01v8 ad=0.667 pd=5.18 as=0.667 ps=5.18 w=2.3 l=0.15
X970 a_3087_4276# a_3901_1968# a_363_8526# vdd sky130_fd_pr__pfet_01v8_lvt ad=0.3045 pd=2.39 as=0.609 ps=4.78 w=2.1 l=0.35
X971 a_363_6974# c5 vdd vdd sky130_fd_pr__pfet_01v8_lvt ad=0.2465 pd=1.99 as=0.2465 ps=1.99 w=1.7 l=0.35
X972 a_8935_5530# f1 a_7971_4856# vss sky130_fd_pr__nfet_01v8_lvt ad=0.145 pd=1.58 as=0.145 ps=1.58 w=0.5 l=0.15
X973 a_13911_3750# f4 a_4811_4856# vss sky130_fd_pr__nfet_01v8_lvt ad=0.145 pd=1.58 as=0.145 ps=1.58 w=0.5 l=0.15
X974 a_4089_11686# a_6055_12811# vdd vdd sky130_fd_pr__pfet_01v8 ad=0.36465 pd=2.54 as=0.36465 ps=2.54 w=2.21 l=0.15
X975 a_4811_6504# a_3087_7364# vss vss sky130_fd_pr__nfet_01v8_lvt ad=0.165 pd=1.33 as=0.31 ps=2.62 w=1 l=0.15
X976 a_5719_11933# a_10902_11162# vss vss sky130_fd_pr__nfet_01v8_lvt ad=0.2805 pd=2.03 as=0.527 ps=4.02 w=1.7 l=0.15
X977 a_13495_3430# f4 a_7971_1984# vss sky130_fd_pr__nfet_01v8_lvt ad=0.145 pd=1.58 as=0.145 ps=1.58 w=0.5 l=0.15
X978 a_10399_11933# a_3421_11939# a_4651_12720# vdd sky130_fd_pr__pfet_01v8 ad=0.7037 pd=5.16 as=0.37455 ps=2.6 w=2.27 l=0.15
X979 a_21768_4674# a_21768_2174# vdd vdd sky130_fd_pr__pfet_01v8_lvt ad=0.26825 pd=2.14 as=0.5365 ps=4.28 w=1.85 l=0.35
X980 a_13911_3430# a_13453_3298# a_7971_1984# vss sky130_fd_pr__nfet_01v8_lvt ad=0.145 pd=1.58 as=0.145 ps=1.58 w=0.5 l=0.15
X981 vdd a_10399_11933# a_4027_11933# vdd sky130_fd_pr__pfet_01v8 ad=1.1067 pd=7.76 as=0.58905 ps=3.9 w=3.57 l=0.15
X982 a_23462_11162# a_22959_11933# vss vss sky130_fd_pr__nfet_01v8 ad=0.1218 pd=1.42 as=0.1218 ps=1.42 w=0.42 l=0.28
X983 vdd a_11631_5530# vdd vdd sky130_fd_pr__pfet_01v8 ad=0.667 pd=5.18 as=0 ps=0 w=2.3 l=0.15
X984 a_4811_6504# a_3087_7364# vdd vdd sky130_fd_pr__pfet_01v8 ad=0.363 pd=2.53 as=0.682 ps=5.02 w=2.2 l=0.15
X985 a_21602_2174# a_21602_4674# vdd vdd sky130_fd_pr__pfet_01v8_lvt ad=0.26825 pd=2.14 as=0.26825 ps=2.14 w=1.85 l=0.35
X986 a_15469_11950# a_20335_12811# vss vss sky130_fd_pr__nfet_01v8_lvt ad=0.1305 pd=1.48 as=0.1305 ps=1.48 w=0.45 l=0.15
X987 a_18971_12720# a_17182_11162# vdd vdd sky130_fd_pr__pfet_01v8 ad=0.6293 pd=4.68 as=0.33495 ps=2.36 w=2.03 l=0.15
X988 a_11215_7950# f2 a_7971_6504# vss sky130_fd_pr__nfet_01v8_lvt ad=0.145 pd=1.58 as=0.145 ps=1.58 w=0.5 l=0.15
X989 a_13495_3750# a_13453_3298# a_4811_4856# vss sky130_fd_pr__nfet_01v8_lvt ad=0.145 pd=1.58 as=0.145 ps=1.58 w=0.5 l=0.15
X990 a_17221_12720# a_18971_12720# vdd vdd sky130_fd_pr__pfet_01v8 ad=0.5104 pd=4.1 as=0.5104 ps=4.1 w=1.76 l=0.15
X991 a_3087_7364# a0 a_363_6446# vss sky130_fd_pr__nfet_01v8_lvt ad=0.132 pd=1.13 as=0.248 ps=2.22 w=0.8 l=0.15
X992 a_20664_3688# vss sky130_fd_pr__cap_mim_m3_1 l=3.1 w=3.1
X993 vss a_9351_1650# vss vss sky130_fd_pr__nfet_01v8_lvt ad=0.1595 pd=1.68 as=0 ps=0 w=0.55 l=0.15
X994 a_6247_8796# a_6068_205# a_363_2814# vdd sky130_fd_pr__pfet_01v8_lvt ad=0.3045 pd=2.39 as=0.609 ps=4.78 w=2.1 l=0.35
X995 vdd a_3087_2844# a_4811_1984# vdd sky130_fd_pr__pfet_01v8 ad=0.363 pd=2.53 as=0.363 ps=2.53 w=2.2 l=0.15
X996 a_6247_4276# a_7061_1968# a_363_9054# vdd sky130_fd_pr__pfet_01v8_lvt ad=0.3045 pd=2.39 as=0.609 ps=4.78 w=2.1 l=0.35
X997 vdd a_20335_12811# a_16649_11686# vdd sky130_fd_pr__pfet_01v8 ad=0.6851 pd=5.04 as=0.36465 ps=2.54 w=2.21 l=0.15
X998 a_23221_12720# a_22959_11933# vdd vdd sky130_fd_pr__pfet_01v8 ad=0.6293 pd=4.68 as=0.33495 ps=2.36 w=2.03 l=0.15
X999 a_7971_1984# a_6247_2844# vss vss sky130_fd_pr__nfet_01v8_lvt ad=0.165 pd=1.33 as=0.31 ps=2.62 w=1 l=0.15
X1000 a_363_4894# b1 a_6247_4276# vss sky130_fd_pr__nfet_01v8_lvt ad=0.248 pd=2.22 as=0.132 ps=1.13 w=0.8 l=0.15
X1001 vss a_23221_12720# cke1 vss sky130_fd_pr__nfet_01v8_lvt ad=0.372 pd=3.02 as=0.198 ps=1.53 w=1.2 l=0.15
X1002 vdd c4 a_363_6446# vdd sky130_fd_pr__pfet_01v8_lvt ad=0.2465 pd=1.99 as=0.2465 ps=1.99 w=1.7 l=0.35
X1003 a_363_9054# b5 a_6247_4276# vss sky130_fd_pr__nfet_01v8_lvt ad=0.248 pd=2.22 as=0.132 ps=1.13 w=0.8 l=0.15
X1004 a_363_8526# a_4341_1968# a_3087_8796# vdd sky130_fd_pr__pfet_01v8_lvt ad=0.609 pd=4.78 as=0.3045 ps=2.39 w=2.1 l=0.35
X1005 vss a_3087_2844# a_4811_1984# vss sky130_fd_pr__nfet_01v8_lvt ad=0.31 pd=2.62 as=0.165 ps=1.33 w=1 l=0.15
X1006 a_10891_9310# a_8935_10050# vss vss sky130_fd_pr__nfet_01v8_lvt ad=0.1595 pd=1.68 as=0.1595 ps=1.68 w=0.55 l=0.15
X1007 a_9351_3750# f0 a_4811_4856# vss sky130_fd_pr__nfet_01v8_lvt ad=0.145 pd=1.58 as=0.145 ps=1.58 w=0.5 l=0.15
X1008 a_9351_3750# a_8893_3298# a_7971_4856# vss sky130_fd_pr__nfet_01v8_lvt ad=0.145 pd=1.58 as=0.145 ps=1.58 w=0.5 l=0.15
X1009 a_5719_11933# a_4027_11933# vdd vdd sky130_fd_pr__pfet_01v8 ad=0.5104 pd=4.1 as=0.5104 ps=4.1 w=1.76 l=0.15
.ends
