* NGSPICE file created from serdes_rx_cmos_pi_8ph_5g_pdk.ext - technology: sky130A

.subckt serdes_rx_cmos_pi_8ph_5g_pdk c0 c1 c2 c3 c4 c5 c6 c7 a0 a1 a2 a3 a4 a5 a6
+ a7 b0 b1 b2 b3 b4 b5 b6 b7 f0 f1 f2 f3 f4 f5 f6 f7 rst_n dp dn ep en ckd0 ckd1 ckd2
+ ckd3 cke0 cke1 cke2 cke3 vdd vss
X0 vdd a_9351_6170# vdd vdd sky130_fd_pr__pfet_01v8 ad=0.667 pd=5.18 as=186.767 ps=1.4249k w=2.3 l=0.15
X1 a_16191_3430# a_15733_3298# a_7971_1984# vss sky130_fd_pr__nfet_01v8_lvt ad=0.145 pd=1.58 as=0.145 ps=1.58 w=0.5 l=0.15
X2 a_363_6446# a4 a_3087_8796# vss sky130_fd_pr__nfet_01v8_lvt ad=0.248 pd=2.22 as=0.132 ps=1.13 w=0.8 l=0.15
X3 a_6247_7364# b7 a_363_4894# vss sky130_fd_pr__nfet_01v8_lvt ad=0.132 pd=1.13 as=0.248 ps=2.22 w=0.8 l=0.15
X4 a_11173_1814# f3 vdd vdd sky130_fd_pr__pfet_01v8 ad=0.261 pd=2.38 as=0.261 ps=2.38 w=0.9 l=0.18
X5 vdd a_13911_5530# vdd vdd sky130_fd_pr__pfet_01v8 ad=0.667 pd=5.18 as=0 ps=0 w=2.3 l=0.15
X6 vss a_24971_12720# cke3 vss sky130_fd_pr__nfet_01v8_lvt ad=0.372 pd=3.02 as=0.198 ps=1.53 w=1.2 l=0.15
X7 vdd a_4027_11933# ckd1 vdd sky130_fd_pr__pfet_01v8 ad=0.4158 pd=2.85 as=0.4158 ps=2.85 w=2.52 l=0.15
X8 a_10891_1645# a_8935_1650# vdd vdd sky130_fd_pr__pfet_01v8 ad=0.667 pd=5.18 as=0.667 ps=5.18 w=2.3 l=0.15
X9 a_13495_7950# a_13453_3298# a_7971_6504# vdd sky130_fd_pr__pfet_01v8_lvt ad=0.261 pd=2.38 as=0.261 ps=2.38 w=0.9 l=0.35
X10 a_9351_1650# a_8893_1814# a_4811_1984# vdd sky130_fd_pr__pfet_01v8_lvt ad=0.261 pd=2.38 as=0.261 ps=2.38 w=0.9 l=0.35
X11 vdd c0 a_363_2286# vdd sky130_fd_pr__pfet_01v8_lvt ad=0.493 pd=3.98 as=0.2465 ps=1.99 w=1.7 l=0.35
X12 a_8935_10050# a_8893_1814# a_4811_9376# vss sky130_fd_pr__nfet_01v8_lvt ad=0.145 pd=1.58 as=0.145 ps=1.58 w=0.5 l=0.15
X13 vss a_6247_8796# a_7971_9376# vss sky130_fd_pr__nfet_01v8_lvt ad=0.31 pd=2.62 as=0.165 ps=1.33 w=1 l=0.15
X14 vss a_21768_9194# dp vss sky130_fd_pr__nfet_01v8_lvt ad=0.434 pd=3.42 as=0.231 ps=1.73 w=1.4 l=0.15
X15 a_15981_11939# a_16649_11686# vss vss sky130_fd_pr__nfet_01v8_lvt ad=0.1305 pd=1.48 as=0.1305 ps=1.48 w=0.45 l=0.15
X16 a_363_9054# c7 vdd vdd sky130_fd_pr__pfet_01v8_lvt ad=0.2465 pd=1.99 as=0.493 ps=3.98 w=1.7 l=0.35
X17 vdd a_21602_2174# en vdd sky130_fd_pr__pfet_01v8_lvt ad=0.406 pd=3.09 as=0.406 ps=3.09 w=2.8 l=0.35
X18 a_363_8526# a0 a_3087_2844# vss sky130_fd_pr__nfet_01v8_lvt ad=0.248 pd=2.22 as=0.132 ps=1.13 w=0.8 l=0.15
X19 a_18971_12720# a_17221_12720# vss vss sky130_fd_pr__nfet_01v8_lvt ad=0.1218 pd=1.42 as=0.1218 ps=1.42 w=0.42 l=0.15
X20 a_13911_7950# f4 a_7971_6504# vdd sky130_fd_pr__pfet_01v8_lvt ad=0.261 pd=2.38 as=0.261 ps=2.38 w=0.9 l=0.35
X21 a_17731_3745# a_20664_3688# vss sky130_fd_pr__res_high_po_0p69 l=7.2
X22 vdd a_5719_11933# ckd3 vdd sky130_fd_pr__pfet_01v8 ad=0.7812 pd=5.66 as=0.4158 ps=2.85 w=2.52 l=0.15
X23 a_11631_8270# a_11173_3298# a_4811_9376# vdd sky130_fd_pr__pfet_01v8_lvt ad=0.261 pd=2.38 as=0.261 ps=2.38 w=0.9 l=0.35
X24 a_6247_2844# a_6621_1968# a_363_2814# vdd sky130_fd_pr__pfet_01v8_lvt ad=0.3045 pd=2.39 as=0.609 ps=4.78 w=2.1 l=0.35
X25 a_2901_12720# a_4651_12720# vss vss sky130_fd_pr__nfet_01v8_lvt ad=0.1218 pd=1.42 as=0.1218 ps=1.42 w=0.42 l=0.15
X26 a_4811_9376# a_3087_8796# vdd vdd sky130_fd_pr__pfet_01v8 ad=0.363 pd=2.53 as=0.682 ps=5.02 w=2.2 l=0.15
X27 ckd0 a_2901_12720# vdd vdd sky130_fd_pr__pfet_01v8 ad=0.4158 pd=2.85 as=0.7812 ps=5.66 w=2.52 l=0.15
X28 vdd a_15469_11950# a_15981_11939# vdd sky130_fd_pr__pfet_01v8 ad=0.36465 pd=2.54 as=0.36465 ps=2.54 w=2.21 l=0.15
X29 a_363_2814# c1 vdd vdd sky130_fd_pr__pfet_01v8_lvt ad=0.2465 pd=1.99 as=0.493 ps=3.98 w=1.7 l=0.35
X30 a_4622_11162# a_4089_11686# a_5719_11933# vdd sky130_fd_pr__pfet_01v8 ad=0.37455 pd=2.6 as=0.37455 ps=2.6 w=2.27 l=0.15
X31 a_15451_3745# a_13495_3750# vss vss sky130_fd_pr__nfet_01v8_lvt ad=0.1595 pd=1.68 as=0.1595 ps=1.68 w=0.55 l=0.15
X32 cke3 cke1 vdd vdd sky130_fd_pr__pfet_01v8 ad=0.5481 pd=4.36 as=0.5481 ps=4.36 w=1.89 l=0.15
X33 a_15451_2690# a_13495_3430# vdd vdd sky130_fd_pr__pfet_01v8 ad=0.667 pd=5.18 as=0.667 ps=5.18 w=2.3 l=0.15
X34 a_17731_3745# a_15775_3750# vdd vdd sky130_fd_pr__pfet_01v8 ad=0.667 pd=5.18 as=0.667 ps=5.18 w=2.3 l=0.15
X35 a_16191_1650# f7 a_4811_1984# vss sky130_fd_pr__nfet_01v8_lvt ad=0.145 pd=1.58 as=0.145 ps=1.58 w=0.5 l=0.15
X36 a_4651_12720# a_4622_11162# vss vss sky130_fd_pr__nfet_01v8_lvt ad=0.2805 pd=2.03 as=0.527 ps=4.02 w=1.7 l=0.15
X37 a_17731_4790# a_20664_3688# vss sky130_fd_pr__res_high_po_0p69 l=7.2
X38 a_13171_1645# a_11215_1650# vdd vdd sky130_fd_pr__pfet_01v8 ad=0.667 pd=5.18 as=0.667 ps=5.18 w=2.3 l=0.15
X39 a_16191_3750# a_15733_3298# a_4811_4856# vdd sky130_fd_pr__pfet_01v8_lvt ad=0.261 pd=2.38 as=0.261 ps=2.38 w=0.9 l=0.35
X40 ckd0 a_2901_12720# vdd vdd sky130_fd_pr__pfet_01v8 ad=0.4158 pd=2.85 as=0.4158 ps=2.85 w=2.52 l=0.15
X41 cke0 a_17221_12720# vdd vdd sky130_fd_pr__pfet_01v8 ad=0.4158 pd=2.85 as=0.7812 ps=5.66 w=2.52 l=0.15
X42 a_363_9054# b3 a_6247_7364# vss sky130_fd_pr__nfet_01v8_lvt ad=0.248 pd=2.22 as=0.132 ps=1.13 w=0.8 l=0.15
X43 a_363_6974# b7 a_6247_2844# vss sky130_fd_pr__nfet_01v8_lvt ad=0.248 pd=2.22 as=0.132 ps=1.13 w=0.8 l=0.15
X44 ckd2 a_4651_12720# vdd vdd sky130_fd_pr__pfet_01v8 ad=0.4158 pd=2.85 as=0.7812 ps=5.66 w=2.52 l=0.15
X45 a_1987_11933# a_411_11960# dp vdd sky130_fd_pr__pfet_01v8_lvt ad=0.32915 pd=2.56 as=0.6583 ps=5.12 w=2.27 l=0.35
X46 a_13171_9310# a_20664_8208# vss sky130_fd_pr__res_high_po_0p69 l=7.2
X47 a_8935_7950# f0 a_4811_6504# vdd sky130_fd_pr__pfet_01v8_lvt ad=0.261 pd=2.38 as=0.261 ps=2.38 w=0.9 l=0.35
X48 a_11631_3430# a_11173_3298# a_7971_1984# vss sky130_fd_pr__nfet_01v8_lvt ad=0.145 pd=1.58 as=0.145 ps=1.58 w=0.5 l=0.15
X49 vdd a_2901_12720# ckd0 vdd sky130_fd_pr__pfet_01v8 ad=0.4158 pd=2.85 as=0.4158 ps=2.85 w=2.52 l=0.15
X50 a_15451_8265# a_13495_8270# vdd vdd sky130_fd_pr__pfet_01v8 ad=0.667 pd=5.18 as=0.667 ps=5.18 w=2.3 l=0.15
X51 a_16191_7950# f6 a_7971_6504# vdd sky130_fd_pr__pfet_01v8_lvt ad=0.261 pd=2.38 as=0.261 ps=2.38 w=0.9 l=0.35
X52 a_6247_4276# b3 a_363_6974# vss sky130_fd_pr__nfet_01v8_lvt ad=0.132 pd=1.13 as=0.248 ps=2.22 w=0.8 l=0.15
X53 a_8935_7950# f0 a_7971_6504# vss sky130_fd_pr__nfet_01v8_lvt ad=0.145 pd=1.58 as=0.145 ps=1.58 w=0.5 l=0.15
X54 a_13911_8270# a_13453_3298# a_4811_9376# vdd sky130_fd_pr__pfet_01v8_lvt ad=0.261 pd=2.38 as=0.261 ps=2.38 w=0.9 l=0.35
X55 a_11215_8270# a_11173_3298# a_4811_9376# vss sky130_fd_pr__nfet_01v8_lvt ad=0.145 pd=1.58 as=0.145 ps=1.58 w=0.5 l=0.15
X56 a_11173_1814# f3 vss vss sky130_fd_pr__nfet_01v8 ad=0.1305 pd=1.48 as=0.1305 ps=1.48 w=0.45 l=0.18
X57 vdd a_11631_1650# vdd vdd sky130_fd_pr__pfet_01v8 ad=0.667 pd=5.18 as=0 ps=0 w=2.3 l=0.15
X58 a_8267_11933# rst_n dn vss sky130_fd_pr__nfet_01v8_lvt ad=0.2145 pd=1.63 as=0.403 ps=3.22 w=1.3 l=0.15
X59 a_16679_11933# a_16649_11686# a_4651_12720# vdd sky130_fd_pr__pfet_01v8 ad=0.7037 pd=5.16 as=0.37455 ps=2.6 w=2.27 l=0.15
X60 a_13171_9310# a_11215_10050# vss vss sky130_fd_pr__nfet_01v8_lvt ad=0.1595 pd=1.68 as=0.1595 ps=1.68 w=0.55 l=0.15
X61 vdd a_21602_9194# a_21602_6694# vdd sky130_fd_pr__pfet_01v8_lvt ad=0.5365 pd=4.28 as=0.26825 ps=2.14 w=1.85 l=0.35
X62 a_15775_1650# a_15733_1814# a_4811_1984# vss sky130_fd_pr__nfet_01v8_lvt ad=0.145 pd=1.58 as=0.145 ps=1.58 w=0.5 l=0.15
X63 a_15775_3750# f6 a_4811_4856# vdd sky130_fd_pr__pfet_01v8_lvt ad=0.261 pd=2.38 as=0.261 ps=2.38 w=0.9 l=0.35
X64 ep a_411_11960# a_14547_11933# vdd sky130_fd_pr__pfet_01v8_lvt ad=0.32915 pd=2.56 as=0.32915 ps=2.56 w=2.27 l=0.35
X65 a_16649_11686# a_20335_12811# vss vss sky130_fd_pr__nfet_01v8_lvt ad=0.17325 pd=1.38 as=0.3255 ps=2.72 w=1.05 l=0.15
X66 a_3087_8796# a6 a_363_8526# vss sky130_fd_pr__nfet_01v8_lvt ad=0.132 pd=1.13 as=0.248 ps=2.22 w=0.8 l=0.15
X67 a_7971_6504# a_6247_7364# vdd vdd sky130_fd_pr__pfet_01v8 ad=0.363 pd=2.53 as=0.363 ps=2.53 w=2.2 l=0.15
X68 a_11215_1650# f3 a_4811_1984# vdd sky130_fd_pr__pfet_01v8_lvt ad=0.261 pd=2.38 as=0.261 ps=2.38 w=0.9 l=0.35
X69 vss a_21602_6694# dn vss sky130_fd_pr__nfet_01v8_lvt ad=0.434 pd=3.42 as=0.231 ps=1.73 w=1.4 l=0.15
X70 a_24971_12720# a_23462_11162# vdd vdd sky130_fd_pr__pfet_01v8 ad=0.6293 pd=4.68 as=0.33495 ps=2.36 w=2.03 l=0.15
X71 a_10891_8265# a_8935_8270# vss vss sky130_fd_pr__nfet_01v8_lvt ad=0.1595 pd=1.68 as=0.1595 ps=1.68 w=0.55 l=0.15
X72 vss a_4119_11933# a_2901_12720# vss sky130_fd_pr__nfet_01v8_lvt ad=0.527 pd=4.02 as=0.2805 ps=2.03 w=1.7 l=0.15
X73 a_13495_8270# f4 a_4811_9376# vdd sky130_fd_pr__pfet_01v8_lvt ad=0.261 pd=2.38 as=0.261 ps=2.38 w=0.9 l=0.35
X74 a_3087_2844# a2 a_363_2286# vss sky130_fd_pr__nfet_01v8_lvt ad=0.132 pd=1.13 as=0.248 ps=2.22 w=0.8 l=0.15
X75 a_11631_6170# f3 a_4811_6504# vss sky130_fd_pr__nfet_01v8_lvt ad=0.145 pd=1.58 as=0.145 ps=1.58 w=0.5 l=0.15
X76 vdd a_6247_2844# a_7971_1984# vdd sky130_fd_pr__pfet_01v8 ad=0.682 pd=5.02 as=0.363 ps=2.53 w=2.2 l=0.15
X77 vdd a_16191_3430# vdd vdd sky130_fd_pr__pfet_01v8 ad=0.667 pd=5.18 as=0 ps=0 w=2.3 l=0.15
X78 vss a_16191_3750# vss vss sky130_fd_pr__nfet_01v8_lvt ad=0.1595 pd=1.68 as=55.9628 ps=516.59998 w=0.55 l=0.15
X79 a_4027_11933# a_16649_11686# a_23462_11162# vss sky130_fd_pr__nfet_01v8_lvt ad=0.231 pd=1.73 as=0.434 ps=3.42 w=1.4 l=0.15
X80 a_15451_7210# a_20664_6336# vss sky130_fd_pr__res_high_po_0p69 l=7.2
X81 vdd a_13911_1650# vdd vdd sky130_fd_pr__pfet_01v8 ad=0.667 pd=5.18 as=0 ps=0 w=2.3 l=0.15
X82 a_9351_3430# a_8893_3298# a_4811_1984# vdd sky130_fd_pr__pfet_01v8_lvt ad=0.261 pd=2.38 as=0.261 ps=2.38 w=0.9 l=0.35
X83 a_18971_12720# a_17221_12720# vdd vdd sky130_fd_pr__pfet_01v8 ad=0.5104 pd=4.1 as=0.5104 ps=4.1 w=1.76 l=0.15
X84 a_9351_8270# f0 a_7971_9376# vdd sky130_fd_pr__pfet_01v8_lvt ad=0.261 pd=2.38 as=0.261 ps=2.38 w=0.9 l=0.35
X85 a_21602_4674# a_21602_2174# vss sky130_fd_pr__res_high_po_0p35 l=10.5
X86 a_6621_1968# b3 vdd vdd sky130_fd_pr__pfet_01v8 ad=0.261 pd=2.38 as=0.261 ps=2.38 w=0.9 l=0.18
X87 a_2901_12720# a_4651_12720# vdd vdd sky130_fd_pr__pfet_01v8 ad=0.5104 pd=4.1 as=0.5104 ps=4.1 w=1.76 l=0.15
X88 a_13495_10050# f5 a_7971_9376# vss sky130_fd_pr__nfet_01v8_lvt ad=0.145 pd=1.58 as=0.145 ps=1.58 w=0.5 l=0.15
X89 a_363_4366# a2 a_3087_8796# vss sky130_fd_pr__nfet_01v8_lvt ad=0.248 pd=2.22 as=0.132 ps=1.13 w=0.8 l=0.15
X90 vdd a_16191_8270# vdd vdd sky130_fd_pr__pfet_01v8 ad=0.667 pd=5.18 as=0 ps=0 w=2.3 l=0.15
X91 a_8935_10050# f1 a_7971_9376# vss sky130_fd_pr__nfet_01v8_lvt ad=0.145 pd=1.58 as=0.145 ps=1.58 w=0.5 l=0.15
X92 a_363_2286# c0 vss vss sky130_fd_pr__nfet_01v8_lvt ad=0.493 pd=3.98 as=0.493 ps=3.98 w=1.7 l=0.15
X93 a_13495_10050# a_13453_1814# a_4811_9376# vss sky130_fd_pr__nfet_01v8_lvt ad=0.145 pd=1.58 as=0.145 ps=1.58 w=0.5 l=0.15
X94 a_13171_8265# a_11215_8270# vss vss sky130_fd_pr__nfet_01v8_lvt ad=0.1595 pd=1.68 as=0.1595 ps=1.68 w=0.55 l=0.15
X95 a_3087_7364# a_3461_1968# a_363_8526# vdd sky130_fd_pr__pfet_01v8_lvt ad=0.3045 pd=2.39 as=0.609 ps=4.78 w=2.1 l=0.35
X96 a_13911_6170# f5 a_4811_6504# vss sky130_fd_pr__nfet_01v8_lvt ad=0.145 pd=1.58 as=0.145 ps=1.58 w=0.5 l=0.15
X97 a_17731_1645# a_15775_1650# vss vss sky130_fd_pr__nfet_01v8_lvt ad=0.1595 pd=1.68 as=0.1595 ps=1.68 w=0.55 l=0.15
X98 a_7718_205# b6 vdd vdd sky130_fd_pr__pfet_01v8 ad=0.261 pd=2.38 as=0.261 ps=2.38 w=0.9 l=0.18
X99 vdd a_21768_6694# a_21768_9194# vdd sky130_fd_pr__pfet_01v8_lvt ad=0.26825 pd=2.14 as=0.26825 ps=2.14 w=1.85 l=0.35
X100 a_11631_5530# f3 a_4811_4856# vss sky130_fd_pr__nfet_01v8_lvt ad=0.145 pd=1.58 as=0.145 ps=1.58 w=0.5 l=0.15
X101 a_7971_9376# a_6247_8796# vdd vdd sky130_fd_pr__pfet_01v8 ad=0.363 pd=2.53 as=0.363 ps=2.53 w=2.2 l=0.15
X102 a_16191_5530# a_15733_1814# a_4811_4856# vdd sky130_fd_pr__pfet_01v8_lvt ad=0.261 pd=2.38 as=0.261 ps=2.38 w=0.9 l=0.35
X103 a_363_9054# a_7061_1968# a_6247_4276# vdd sky130_fd_pr__pfet_01v8_lvt ad=0.609 pd=4.78 as=0.3045 ps=2.39 w=2.1 l=0.35
X104 a_363_4894# a_6068_205# a_6247_4276# vdd sky130_fd_pr__pfet_01v8_lvt ad=0.609 pd=4.78 as=0.3045 ps=2.39 w=2.1 l=0.35
X105 vdd c3 a_363_4894# vdd sky130_fd_pr__pfet_01v8_lvt ad=0.493 pd=3.98 as=0.2465 ps=1.99 w=1.7 l=0.35
X106 a_8893_3298# f0 vdd vdd sky130_fd_pr__pfet_01v8 ad=0.261 pd=2.38 as=0.261 ps=2.38 w=0.9 l=0.18
X107 a_21602_9194# a_20664_8208# sky130_fd_pr__cap_mim_m3_1 l=4.1 w=4.1
X108 a_363_6446# c4 vdd vdd sky130_fd_pr__pfet_01v8_lvt ad=0.2465 pd=1.99 as=0.2465 ps=1.99 w=1.7 l=0.35
X109 a_363_8526# c6 vdd vdd sky130_fd_pr__pfet_01v8_lvt ad=0.2465 pd=1.99 as=0.493 ps=3.98 w=1.7 l=0.35
X110 vss a_11631_8270# vss vss sky130_fd_pr__nfet_01v8_lvt ad=0.1595 pd=1.68 as=0 ps=0 w=0.55 l=0.15
X111 a_17731_6165# a_15775_6170# vdd vdd sky130_fd_pr__pfet_01v8 ad=0.667 pd=5.18 as=0.667 ps=5.18 w=2.3 l=0.15
X112 a_15451_1645# a_20664_1816# vss sky130_fd_pr__res_high_po_0p69 l=7.2
X113 ckd1 a_4027_11933# vdd vdd sky130_fd_pr__pfet_01v8 ad=0.4158 pd=2.85 as=0.4158 ps=2.85 w=2.52 l=0.15
X114 a_16191_6170# a_15733_1814# a_4811_6504# vdd sky130_fd_pr__pfet_01v8_lvt ad=0.261 pd=2.38 as=0.261 ps=2.38 w=0.9 l=0.35
X115 a_13495_6170# a_13453_1814# a_4811_6504# vss sky130_fd_pr__nfet_01v8_lvt ad=0.145 pd=1.58 as=0.145 ps=1.58 w=0.5 l=0.15
X116 a_15775_3750# f6 a_7971_4856# vss sky130_fd_pr__nfet_01v8_lvt ad=0.145 pd=1.58 as=0.145 ps=1.58 w=0.5 l=0.15
X117 vdd a_9351_7950# vdd vdd sky130_fd_pr__pfet_01v8 ad=0.667 pd=5.18 as=0 ps=0 w=2.3 l=0.15
X118 vdd a_21602_4674# a_21602_2174# vdd sky130_fd_pr__pfet_01v8_lvt ad=0.26825 pd=2.14 as=0.26825 ps=2.14 w=1.85 l=0.35
X119 a_15775_5530# f7 a_4811_4856# vdd sky130_fd_pr__pfet_01v8_lvt ad=0.261 pd=2.38 as=0.261 ps=2.38 w=0.9 l=0.35
X120 a_363_2286# a_3901_1968# a_3087_7364# vdd sky130_fd_pr__pfet_01v8_lvt ad=0.609 pd=4.78 as=0.3045 ps=2.39 w=2.1 l=0.35
X121 a_11215_1650# f3 a_7971_1984# vss sky130_fd_pr__nfet_01v8_lvt ad=0.145 pd=1.58 as=0.145 ps=1.58 w=0.5 l=0.15
X122 a_13911_5530# f5 a_4811_4856# vss sky130_fd_pr__nfet_01v8_lvt ad=0.145 pd=1.58 as=0.145 ps=1.58 w=0.5 l=0.15
X123 a_11215_3430# f2 a_4811_1984# vdd sky130_fd_pr__pfet_01v8_lvt ad=0.261 pd=2.38 as=0.261 ps=2.38 w=0.9 l=0.35
X124 a_11215_3750# a_11173_3298# a_7971_4856# vdd sky130_fd_pr__pfet_01v8_lvt ad=0.261 pd=2.38 as=0.261 ps=2.38 w=0.9 l=0.35
X125 a_21768_4674# a_21768_2174# vss vss sky130_fd_pr__nfet_01v8_lvt ad=0.5365 pd=4.28 as=0.5365 ps=4.28 w=1.85 l=0.15
X126 a_6621_1968# b3 vss vss sky130_fd_pr__nfet_01v8 ad=0.1305 pd=1.48 as=0.1305 ps=1.48 w=0.45 l=0.18
X127 a_15981_11939# a_15469_11950# vdd vdd sky130_fd_pr__pfet_01v8 ad=0.36465 pd=2.54 as=0.36465 ps=2.54 w=2.21 l=0.15
X128 a_9351_6170# f1 a_4811_6504# vss sky130_fd_pr__nfet_01v8_lvt ad=0.145 pd=1.58 as=0.145 ps=1.58 w=0.5 l=0.15
X129 en a_21602_2174# vdd vdd sky130_fd_pr__pfet_01v8_lvt ad=0.406 pd=3.09 as=0.406 ps=3.09 w=2.8 l=0.35
X130 ckd2 ckd0 vss vss sky130_fd_pr__nfet_01v8_lvt ad=0.1305 pd=1.48 as=0.1305 ps=1.48 w=0.45 l=0.15
X131 a_5719_11933# a_4089_11686# a_4622_11162# vdd sky130_fd_pr__pfet_01v8 ad=0.7037 pd=5.16 as=0.37455 ps=2.6 w=2.27 l=0.15
X132 a_9351_6170# a_8893_1814# a_7971_6504# vss sky130_fd_pr__nfet_01v8_lvt ad=0.145 pd=1.58 as=0.145 ps=1.58 w=0.5 l=0.15
X133 a_363_2814# a_6621_1968# a_6247_2844# vdd sky130_fd_pr__pfet_01v8_lvt ad=0.609 pd=4.78 as=0.3045 ps=2.39 w=2.1 l=0.35
X134 a_11631_3750# f2 a_7971_4856# vdd sky130_fd_pr__pfet_01v8_lvt ad=0.261 pd=2.38 as=0.261 ps=2.38 w=0.9 l=0.35
X135 a_3087_8796# a_3461_1968# a_363_4366# vdd sky130_fd_pr__pfet_01v8_lvt ad=0.3045 pd=2.39 as=0.609 ps=4.78 w=2.1 l=0.35
X136 a_3087_4276# a_4341_1968# a_363_2286# vdd sky130_fd_pr__pfet_01v8_lvt ad=0.3045 pd=2.39 as=0.609 ps=4.78 w=2.1 l=0.35
X137 vss a_13911_8270# vss vss sky130_fd_pr__nfet_01v8_lvt ad=0.1595 pd=1.68 as=0 ps=0 w=0.55 l=0.15
X138 a_15775_6170# f7 a_4811_6504# vdd sky130_fd_pr__pfet_01v8_lvt ad=0.261 pd=2.38 as=0.261 ps=2.38 w=0.9 l=0.35
X139 a_363_2286# a6 a_3087_4276# vss sky130_fd_pr__nfet_01v8_lvt ad=0.248 pd=2.22 as=0.132 ps=1.13 w=0.8 l=0.15
X140 vdd c7 a_363_9054# vdd sky130_fd_pr__pfet_01v8_lvt ad=0.2465 pd=1.99 as=0.2465 ps=1.99 w=1.7 l=0.35
X141 a_11631_10050# a_11173_1814# a_4811_9376# vdd sky130_fd_pr__pfet_01v8_lvt ad=0.261 pd=2.38 as=0.261 ps=2.38 w=0.9 l=0.35
X142 a_21602_4674# a_20664_3688# sky130_fd_pr__cap_mim_m3_1 l=4.1 w=4.1
X143 vss a_4622_11162# a_4651_12720# vss sky130_fd_pr__nfet_01v8_lvt ad=0.527 pd=4.02 as=0.2805 ps=2.03 w=1.7 l=0.15
X144 a_8935_8270# a_8893_3298# a_7971_9376# vdd sky130_fd_pr__pfet_01v8_lvt ad=0.261 pd=2.38 as=0.261 ps=2.38 w=0.9 l=0.35
X145 a_16679_11933# a_17182_11162# vdd vdd sky130_fd_pr__pfet_01v8 ad=0.1218 pd=1.42 as=0.1218 ps=1.42 w=0.42 l=0.28
X146 a_7718_205# b6 vss vss sky130_fd_pr__nfet_01v8 ad=0.1305 pd=1.48 as=0.1305 ps=1.48 w=0.45 l=0.18
X147 vdd a_3087_7364# a_4811_6504# vdd sky130_fd_pr__pfet_01v8 ad=0.682 pd=5.02 as=0.363 ps=2.53 w=2.2 l=0.15
X148 vdd c1 a_363_2814# vdd sky130_fd_pr__pfet_01v8_lvt ad=0.2465 pd=1.99 as=0.2465 ps=1.99 w=1.7 l=0.35
X149 a_13495_5530# a_13453_1814# a_4811_4856# vss sky130_fd_pr__nfet_01v8_lvt ad=0.145 pd=1.58 as=0.145 ps=1.58 w=0.5 l=0.15
X150 vdd a_23221_12720# cke1 vdd sky130_fd_pr__pfet_01v8 ad=0.7812 pd=5.66 as=0.4158 ps=2.85 w=2.52 l=0.15
X151 vss a_9351_3430# vss vss sky130_fd_pr__nfet_01v8_lvt ad=0.1595 pd=1.68 as=0 ps=0 w=0.55 l=0.15
X152 a_8893_3298# f0 vss vss sky130_fd_pr__nfet_01v8 ad=0.1305 pd=1.48 as=0.1305 ps=1.48 w=0.45 l=0.18
X153 a_22959_11933# a_1418_11110# vss vss sky130_fd_pr__nfet_01v8 ad=0.29 pd=2.58 as=0.29 ps=2.58 w=1 l=0.18
X154 dn rst_n a_8267_11933# vss sky130_fd_pr__nfet_01v8_lvt ad=0.403 pd=3.22 as=0.2145 ps=1.63 w=1.3 l=0.15
X155 a_4027_11933# a_10399_11933# vdd vdd sky130_fd_pr__pfet_01v8 ad=0.58905 pd=3.9 as=1.1067 ps=7.76 w=3.57 l=0.15
X156 a_15451_6165# a_13495_6170# vss vss sky130_fd_pr__nfet_01v8_lvt ad=0.1595 pd=1.68 as=0.1595 ps=1.68 w=0.55 l=0.15
X157 a_9351_5530# f1 a_4811_4856# vss sky130_fd_pr__nfet_01v8_lvt ad=0.145 pd=1.58 as=0.145 ps=1.58 w=0.5 l=0.15
X158 cke2 a_18971_12720# vdd vdd sky130_fd_pr__pfet_01v8 ad=0.4158 pd=2.85 as=0.7812 ps=5.66 w=2.52 l=0.15
X159 vdd a_24971_12720# cke3 vdd sky130_fd_pr__pfet_01v8 ad=0.7812 pd=5.66 as=0.4158 ps=2.85 w=2.52 l=0.15
X160 a_2901_12720# a_16649_11686# a_17182_11162# vdd sky130_fd_pr__pfet_01v8 ad=0.37455 pd=2.6 as=0.7037 ps=5.16 w=2.27 l=0.15
X161 a_15451_9310# a_13495_10050# vdd vdd sky130_fd_pr__pfet_01v8 ad=0.667 pd=5.18 as=0.667 ps=5.18 w=2.3 l=0.15
X162 a_9351_5530# a_8893_1814# a_7971_4856# vss sky130_fd_pr__nfet_01v8_lvt ad=0.145 pd=1.58 as=0.145 ps=1.58 w=0.5 l=0.15
X163 a_3087_2844# a_3901_1968# a_363_4366# vdd sky130_fd_pr__pfet_01v8_lvt ad=0.3045 pd=2.39 as=0.609 ps=4.78 w=2.1 l=0.35
X164 a_20335_12811# a_20827_11933# vdd vdd sky130_fd_pr__pfet_01v8 ad=0.3465 pd=2.43 as=0.651 ps=4.82 w=2.1 l=0.15
X165 vss a_20335_12811# a_16649_11686# vss sky130_fd_pr__nfet_01v8_lvt ad=0.3255 pd=2.72 as=0.17325 ps=1.38 w=1.05 l=0.15
X166 a_363_6446# a_3901_1968# a_3087_8796# vdd sky130_fd_pr__pfet_01v8_lvt ad=0.609 pd=4.78 as=0.3045 ps=2.39 w=2.1 l=0.35
X167 a_13911_10050# a_13453_1814# a_4811_9376# vdd sky130_fd_pr__pfet_01v8_lvt ad=0.261 pd=2.38 as=0.261 ps=2.38 w=0.9 l=0.35
X168 cke1 cke3 vss vss sky130_fd_pr__nfet_01v8_lvt ad=0.1305 pd=1.48 as=0.1305 ps=1.48 w=0.45 l=0.15
X169 ckd1 ckd3 vdd vdd sky130_fd_pr__pfet_01v8 ad=0.5481 pd=4.36 as=0.5481 ps=4.36 w=1.89 l=0.15
X170 a_18971_12720# a_17182_11162# vss vss sky130_fd_pr__nfet_01v8_lvt ad=0.4205 pd=3.48 as=0.4205 ps=3.48 w=1.45 l=0.15
X171 a_16649_11686# a_20335_12811# vdd vdd sky130_fd_pr__pfet_01v8 ad=0.36465 pd=2.54 as=0.6851 ps=5.04 w=2.21 l=0.15
X172 a_23221_12720# a_22959_11933# vss vss sky130_fd_pr__nfet_01v8_lvt ad=0.4205 pd=3.48 as=0.4205 ps=3.48 w=1.45 l=0.15
X173 a_363_6974# c5 vss vss sky130_fd_pr__nfet_01v8_lvt ad=0.493 pd=3.98 as=0.493 ps=3.98 w=1.7 l=0.15
X174 vss a_9351_10050# vss vss sky130_fd_pr__nfet_01v8_lvt ad=0.1595 pd=1.68 as=0 ps=0 w=0.55 l=0.15
X175 a_11631_7950# f2 a_4811_6504# vss sky130_fd_pr__nfet_01v8_lvt ad=0.145 pd=1.58 as=0.145 ps=1.58 w=0.5 l=0.15
X176 a_13495_8270# f4 a_7971_9376# vss sky130_fd_pr__nfet_01v8_lvt ad=0.145 pd=1.58 as=0.145 ps=1.58 w=0.5 l=0.15
X177 a_4027_11933# a_5719_11933# vss vss sky130_fd_pr__nfet_01v8_lvt ad=0.1218 pd=1.42 as=0.1218 ps=1.42 w=0.42 l=0.15
X178 a_23462_11162# a_16649_11686# a_4027_11933# vss sky130_fd_pr__nfet_01v8_lvt ad=0.434 pd=3.42 as=0.231 ps=1.73 w=1.4 l=0.15
X179 vdd a_3087_8796# a_4811_9376# vdd sky130_fd_pr__pfet_01v8 ad=0.682 pd=5.02 as=0.363 ps=2.53 w=2.2 l=0.15
X180 a_13495_10050# f5 a_4811_9376# vdd sky130_fd_pr__pfet_01v8_lvt ad=0.261 pd=2.38 as=0.261 ps=2.38 w=0.9 l=0.35
X181 a_8935_1650# f1 a_7971_1984# vss sky130_fd_pr__nfet_01v8_lvt ad=0.145 pd=1.58 as=0.145 ps=1.58 w=0.5 l=0.15
X182 a_3087_4276# a4 a_363_8526# vss sky130_fd_pr__nfet_01v8_lvt ad=0.132 pd=1.13 as=0.248 ps=2.22 w=0.8 l=0.15
X183 a_10902_11162# a_3421_11939# a_2901_12720# vdd sky130_fd_pr__pfet_01v8 ad=0.37455 pd=2.6 as=0.37455 ps=2.6 w=2.27 l=0.15
X184 a_15451_4790# a_13495_5530# vss vss sky130_fd_pr__nfet_01v8_lvt ad=0.1595 pd=1.68 as=0.1595 ps=1.68 w=0.55 l=0.15
X185 a_13911_8270# a_13453_3298# a_7971_9376# vss sky130_fd_pr__nfet_01v8_lvt ad=0.145 pd=1.58 as=0.145 ps=1.58 w=0.5 l=0.15
X186 a_6247_2844# a_7061_1968# a_363_4894# vdd sky130_fd_pr__pfet_01v8_lvt ad=0.3045 pd=2.39 as=0.609 ps=4.78 w=2.1 l=0.35
X187 a_13495_1650# a_13453_1814# a_7971_1984# vdd sky130_fd_pr__pfet_01v8_lvt ad=0.261 pd=2.38 as=0.261 ps=2.38 w=0.9 l=0.35
X188 a_16191_3430# f6 a_4811_1984# vss sky130_fd_pr__nfet_01v8_lvt ad=0.145 pd=1.58 as=0.145 ps=1.58 w=0.5 l=0.15
X189 a_11215_5530# a_11173_1814# a_7971_4856# vdd sky130_fd_pr__pfet_01v8_lvt ad=0.261 pd=2.38 as=0.261 ps=2.38 w=0.9 l=0.35
X190 vdd rst_n a_411_11960# vdd sky130_fd_pr__pfet_01v8 ad=0.33 pd=2.33 as=0.33 ps=2.33 w=2 l=0.15
X191 a_2901_12720# a_3421_11939# a_10902_11162# vdd sky130_fd_pr__pfet_01v8 ad=0.37455 pd=2.6 as=0.7037 ps=5.16 w=2.27 l=0.15
X192 a_4089_11686# a_3421_11939# vss vss sky130_fd_pr__nfet_01v8_lvt ad=0.1305 pd=1.48 as=0.1305 ps=1.48 w=0.45 l=0.15
X193 a_17731_2690# a_20664_1816# vss sky130_fd_pr__res_high_po_0p69 l=7.2
X194 a_13911_1650# f5 a_7971_1984# vdd sky130_fd_pr__pfet_01v8_lvt ad=0.261 pd=2.38 as=0.261 ps=2.38 w=0.9 l=0.35
X195 a_11631_5530# f3 a_7971_4856# vdd sky130_fd_pr__pfet_01v8_lvt ad=0.261 pd=2.38 as=0.261 ps=2.38 w=0.9 l=0.35
X196 vss a_11631_10050# vss vss sky130_fd_pr__nfet_01v8_lvt ad=0.1595 pd=1.68 as=0 ps=0 w=0.55 l=0.15
X197 a_9351_10050# f1 a_7971_9376# vdd sky130_fd_pr__pfet_01v8_lvt ad=0.261 pd=2.38 as=0.261 ps=2.38 w=0.9 l=0.35
X198 a_15775_8270# a_15733_3298# a_7971_9376# vdd sky130_fd_pr__pfet_01v8_lvt ad=0.261 pd=2.38 as=0.261 ps=2.38 w=0.9 l=0.35
X199 vdd a_21602_6694# dn vdd sky130_fd_pr__pfet_01v8_lvt ad=0.812 pd=6.18 as=0.406 ps=3.09 w=2.8 l=0.35
X200 a_1987_11933# a_411_11960# vss vss sky130_fd_pr__nfet_01v8 ad=0.232 pd=2.18 as=0.232 ps=2.18 w=0.8 l=0.18
X201 a_363_8526# a_3461_1968# a_3087_7364# vdd sky130_fd_pr__pfet_01v8_lvt ad=0.609 pd=4.78 as=0.3045 ps=2.39 w=2.1 l=0.35
X202 vss a_16191_6170# vss vss sky130_fd_pr__nfet_01v8_lvt ad=0.1595 pd=1.68 as=0 ps=0 w=0.55 l=0.15
X203 vdd a_16191_10050# vdd vdd sky130_fd_pr__pfet_01v8 ad=0.667 pd=5.18 as=0 ps=0 w=2.3 l=0.15
X204 a_13911_7950# f4 a_4811_6504# vss sky130_fd_pr__nfet_01v8_lvt ad=0.145 pd=1.58 as=0.145 ps=1.58 w=0.5 l=0.15
X205 a_363_6974# b1 a_6247_7364# vss sky130_fd_pr__nfet_01v8_lvt ad=0.248 pd=2.22 as=0.132 ps=1.13 w=0.8 l=0.15
X206 a_363_2814# b5 a_6247_7364# vss sky130_fd_pr__nfet_01v8_lvt ad=0.248 pd=2.22 as=0.132 ps=1.13 w=0.8 l=0.15
X207 a_11215_6170# a_11173_1814# a_7971_6504# vdd sky130_fd_pr__pfet_01v8_lvt ad=0.261 pd=2.38 as=0.261 ps=2.38 w=0.9 l=0.35
X208 a_21768_4674# a_21768_2174# vdd vdd sky130_fd_pr__pfet_01v8_lvt ad=0.26825 pd=2.14 as=0.26825 ps=2.14 w=1.85 l=0.35
X209 ckd3 ckd1 vss vss sky130_fd_pr__nfet_01v8_lvt ad=0.1305 pd=1.48 as=0.1305 ps=1.48 w=0.45 l=0.15
X210 a_8935_3750# a_8893_3298# a_4811_4856# vss sky130_fd_pr__nfet_01v8_lvt ad=0.145 pd=1.58 as=0.145 ps=1.58 w=0.5 l=0.15
X211 ckd1 a_4027_11933# vss vss sky130_fd_pr__nfet_01v8_lvt ad=0.198 pd=1.53 as=0.372 ps=3.02 w=1.2 l=0.15
X212 a_4622_11162# a_1058_11170# vdd vdd sky130_fd_pr__pfet_01v8 ad=0.522 pd=4.18 as=0.522 ps=4.18 w=1.8 l=0.18
X213 a_15775_3430# a_15733_3298# a_4811_1984# vss sky130_fd_pr__nfet_01v8_lvt ad=0.145 pd=1.58 as=0.145 ps=1.58 w=0.5 l=0.15
X214 a_6247_4276# b1 a_363_4894# vss sky130_fd_pr__nfet_01v8_lvt ad=0.132 pd=1.13 as=0.248 ps=2.22 w=0.8 l=0.15
X215 a_11631_6170# f3 a_7971_6504# vdd sky130_fd_pr__pfet_01v8_lvt ad=0.261 pd=2.38 as=0.261 ps=2.38 w=0.9 l=0.35
X216 a_3928_205# a3 vdd vdd sky130_fd_pr__pfet_01v8 ad=0.261 pd=2.38 as=0.261 ps=2.38 w=0.9 l=0.18
X217 a_6247_4276# b5 a_363_9054# vss sky130_fd_pr__nfet_01v8_lvt ad=0.132 pd=1.13 as=0.248 ps=2.22 w=0.8 l=0.15
X218 a_16191_8270# a_15733_3298# a_7971_9376# vss sky130_fd_pr__nfet_01v8_lvt ad=0.145 pd=1.58 as=0.145 ps=1.58 w=0.5 l=0.15
X219 a_10891_9310# a_20664_8208# vss sky130_fd_pr__res_high_po_0p69 l=7.2
X220 a_4811_1984# a_3087_2844# vss vss sky130_fd_pr__nfet_01v8_lvt ad=0.165 pd=1.33 as=0.31 ps=2.62 w=1 l=0.15
X221 a_15451_9310# a_13495_10050# vss vss sky130_fd_pr__nfet_01v8_lvt ad=0.1595 pd=1.68 as=0.1595 ps=1.68 w=0.55 l=0.15
X222 a_8935_1650# f1 a_4811_1984# vdd sky130_fd_pr__pfet_01v8_lvt ad=0.261 pd=2.38 as=0.261 ps=2.38 w=0.9 l=0.35
X223 a_16679_11933# a_17182_11162# vss vss sky130_fd_pr__nfet_01v8 ad=0.1218 pd=1.42 as=0.1218 ps=1.42 w=0.42 l=0.28
X224 en a_411_11960# a_20827_11933# vdd sky130_fd_pr__pfet_01v8_lvt ad=0.32915 pd=2.56 as=0.32915 ps=2.56 w=2.27 l=0.35
X225 a_13495_7950# a_13453_3298# a_4811_6504# vss sky130_fd_pr__nfet_01v8_lvt ad=0.145 pd=1.58 as=0.145 ps=1.58 w=0.5 l=0.15
X226 a_16191_1650# f7 a_7971_1984# vdd sky130_fd_pr__pfet_01v8_lvt ad=0.261 pd=2.38 as=0.261 ps=2.38 w=0.9 l=0.35
X227 a_20827_11933# a_411_11960# en vdd sky130_fd_pr__pfet_01v8_lvt ad=0.6583 pd=5.12 as=0.32915 ps=2.56 w=2.27 l=0.35
X228 a_17731_7210# a_15775_7950# vdd vdd sky130_fd_pr__pfet_01v8 ad=0.667 pd=5.18 as=0.667 ps=5.18 w=2.3 l=0.15
X229 a_21602_2174# a_21602_4674# vss vss sky130_fd_pr__nfet_01v8_lvt ad=0.5365 pd=4.28 as=0.5365 ps=4.28 w=1.85 l=0.15
X230 a_4341_1968# a6 vdd vdd sky130_fd_pr__pfet_01v8 ad=0.261 pd=2.38 as=0.261 ps=2.38 w=0.9 l=0.18
X231 vdd c6 a_363_8526# vdd sky130_fd_pr__pfet_01v8_lvt ad=0.2465 pd=1.99 as=0.2465 ps=1.99 w=1.7 l=0.35
X232 a_5719_11933# a_10902_11162# vdd vdd sky130_fd_pr__pfet_01v8 ad=0.58905 pd=3.9 as=1.1067 ps=7.76 w=3.57 l=0.15
X233 a_16191_7950# a_15733_3298# a_4811_6504# vdd sky130_fd_pr__pfet_01v8_lvt ad=0.261 pd=2.38 as=0.261 ps=2.38 w=0.9 l=0.35
X234 vdd a_9351_5530# vdd vdd sky130_fd_pr__pfet_01v8 ad=0.667 pd=5.18 as=0 ps=0 w=2.3 l=0.15
X235 vss a_16191_5530# vss vss sky130_fd_pr__nfet_01v8_lvt ad=0.1595 pd=1.68 as=0 ps=0 w=0.55 l=0.15
X236 a_7971_9376# a_6247_8796# vss vss sky130_fd_pr__nfet_01v8_lvt ad=0.165 pd=1.33 as=0.31 ps=2.62 w=1 l=0.15
X237 a_4027_11933# a_10399_11933# vss vss sky130_fd_pr__nfet_01v8_lvt ad=0.2805 pd=2.03 as=0.527 ps=4.02 w=1.7 l=0.15
X238 dp a_21768_9194# vss vss sky130_fd_pr__nfet_01v8_lvt ad=0.231 pd=1.73 as=0.434 ps=3.42 w=1.4 l=0.15
X239 a_3087_2844# a0 a_363_8526# vss sky130_fd_pr__nfet_01v8_lvt ad=0.132 pd=1.13 as=0.248 ps=2.22 w=0.8 l=0.15
X240 a_20335_12811# a_20827_11933# vss vss sky130_fd_pr__nfet_01v8_lvt ad=0.435 pd=3.58 as=0.435 ps=3.58 w=1.5 l=0.15
X241 vss a_3087_8796# a_4811_9376# vss sky130_fd_pr__nfet_01v8_lvt ad=0.31 pd=2.62 as=0.165 ps=1.33 w=1 l=0.15
X242 vdd a_21768_9194# dp vdd sky130_fd_pr__pfet_01v8_lvt ad=0.812 pd=6.18 as=0.406 ps=3.09 w=2.8 l=0.35
X243 vss a_2901_12720# ckd0 vss sky130_fd_pr__nfet_01v8_lvt ad=0.372 pd=3.02 as=0.198 ps=1.53 w=1.2 l=0.15
X244 a_4119_11933# a_4622_11162# vdd vdd sky130_fd_pr__pfet_01v8 ad=0.1218 pd=1.42 as=0.1218 ps=1.42 w=0.42 l=0.28
X245 a_4119_11933# a_3421_11939# a_4027_11933# vss sky130_fd_pr__nfet_01v8_lvt ad=0.231 pd=1.73 as=0.434 ps=3.42 w=1.4 l=0.15
X246 vdd a_4119_11933# a_2901_12720# vdd sky130_fd_pr__pfet_01v8 ad=0.58905 pd=3.9 as=0.58905 ps=3.9 w=3.57 l=0.15
X247 a_5719_11933# a_10902_11162# vdd vdd sky130_fd_pr__pfet_01v8 ad=0.58905 pd=3.9 as=0.58905 ps=3.9 w=3.57 l=0.15
X248 a_9351_7950# f0 a_4811_6504# vss sky130_fd_pr__nfet_01v8_lvt ad=0.145 pd=1.58 as=0.145 ps=1.58 w=0.5 l=0.15
X249 a_6247_4276# a_6068_205# a_363_4894# vdd sky130_fd_pr__pfet_01v8_lvt ad=0.3045 pd=2.39 as=0.609 ps=4.78 w=2.1 l=0.35
X250 a_9351_7950# a_8893_3298# a_7971_6504# vss sky130_fd_pr__nfet_01v8_lvt ad=0.145 pd=1.58 as=0.145 ps=1.58 w=0.5 l=0.15
X251 vdd a_21768_4674# ep vdd sky130_fd_pr__pfet_01v8_lvt ad=0.406 pd=3.09 as=0.406 ps=3.09 w=2.8 l=0.35
X252 vdd a_2909_11950# a_3421_11939# vdd sky130_fd_pr__pfet_01v8 ad=0.6851 pd=5.04 as=0.36465 ps=2.54 w=2.21 l=0.15
X253 a_363_4366# a_3461_1968# a_3087_8796# vdd sky130_fd_pr__pfet_01v8_lvt ad=0.609 pd=4.78 as=0.3045 ps=2.39 w=2.1 l=0.35
X254 vdd c2 a_363_4366# vdd sky130_fd_pr__pfet_01v8_lvt ad=0.493 pd=3.98 as=0.2465 ps=1.99 w=1.7 l=0.35
X255 a_363_2286# a_4341_1968# a_3087_4276# vdd sky130_fd_pr__pfet_01v8_lvt ad=0.609 pd=4.78 as=0.3045 ps=2.39 w=2.1 l=0.35
X256 ckd0 a_2901_12720# vss vss sky130_fd_pr__nfet_01v8_lvt ad=0.198 pd=1.53 as=0.372 ps=3.02 w=1.2 l=0.15
X257 a_4027_11933# a_5719_11933# vdd vdd sky130_fd_pr__pfet_01v8 ad=0.5104 pd=4.1 as=0.5104 ps=4.1 w=1.76 l=0.15
X258 a_24971_12720# a_23462_11162# vss vss sky130_fd_pr__nfet_01v8_lvt ad=0.4205 pd=3.48 as=0.4205 ps=3.48 w=1.45 l=0.15
X259 a_9351_10050# a_8893_1814# a_7971_9376# vss sky130_fd_pr__nfet_01v8_lvt ad=0.145 pd=1.58 as=0.145 ps=1.58 w=0.5 l=0.15
X260 vdd a_10902_11162# a_5719_11933# vdd sky130_fd_pr__pfet_01v8 ad=0.58905 pd=3.9 as=0.58905 ps=3.9 w=3.57 l=0.15
X261 a_363_9054# c7 vdd vdd sky130_fd_pr__pfet_01v8_lvt ad=0.2465 pd=1.99 as=0.2465 ps=1.99 w=1.7 l=0.35
X262 a_11631_8270# a_11173_3298# a_7971_9376# vss sky130_fd_pr__nfet_01v8_lvt ad=0.145 pd=1.58 as=0.145 ps=1.58 w=0.5 l=0.15
X263 a_15775_6170# f7 a_7971_6504# vss sky130_fd_pr__nfet_01v8_lvt ad=0.145 pd=1.58 as=0.145 ps=1.58 w=0.5 l=0.15
X264 a_15775_7950# f6 a_4811_6504# vdd sky130_fd_pr__pfet_01v8_lvt ad=0.261 pd=2.38 as=0.261 ps=2.38 w=0.9 l=0.35
X265 cke2 cke0 vss vss sky130_fd_pr__nfet_01v8_lvt ad=0.1305 pd=1.48 as=0.1305 ps=1.48 w=0.45 l=0.15
X266 a_16679_11933# a_15981_11939# a_4651_12720# vss sky130_fd_pr__nfet_01v8_lvt ad=0.231 pd=1.73 as=0.434 ps=3.42 w=1.4 l=0.15
X267 a_15775_10050# f7 a_7971_9376# vss sky130_fd_pr__nfet_01v8_lvt ad=0.145 pd=1.58 as=0.145 ps=1.58 w=0.5 l=0.15
X268 a_6247_2844# b7 a_363_6974# vss sky130_fd_pr__nfet_01v8_lvt ad=0.132 pd=1.13 as=0.248 ps=2.22 w=0.8 l=0.15
X269 a_17731_2690# a_15775_3430# vss vss sky130_fd_pr__nfet_01v8_lvt ad=0.1595 pd=1.68 as=0.1595 ps=1.68 w=0.55 l=0.15
X270 vss a_13911_10050# vss vss sky130_fd_pr__nfet_01v8_lvt ad=0.1595 pd=1.68 as=0 ps=0 w=0.55 l=0.15
X271 a_8935_10050# a_8893_1814# a_7971_9376# vdd sky130_fd_pr__pfet_01v8_lvt ad=0.261 pd=2.38 as=0.261 ps=2.38 w=0.9 l=0.35
X272 a_363_2286# a0 a_3087_8796# vss sky130_fd_pr__nfet_01v8_lvt ad=0.248 pd=2.22 as=0.132 ps=1.13 w=0.8 l=0.15
X273 a_6247_7364# b3 a_363_9054# vss sky130_fd_pr__nfet_01v8_lvt ad=0.132 pd=1.13 as=0.248 ps=2.22 w=0.8 l=0.15
X274 a_363_2814# c1 vdd vdd sky130_fd_pr__pfet_01v8_lvt ad=0.2465 pd=1.99 as=0.2465 ps=1.99 w=1.7 l=0.35
X275 a_3928_205# a3 vss vss sky130_fd_pr__nfet_01v8 ad=0.1305 pd=1.48 as=0.1305 ps=1.48 w=0.45 l=0.18
X276 a_15775_10050# a_15733_1814# a_4811_9376# vss sky130_fd_pr__nfet_01v8_lvt ad=0.145 pd=1.58 as=0.145 ps=1.58 w=0.5 l=0.15
X277 a_3087_7364# a_2938_205# a_363_6446# vdd sky130_fd_pr__pfet_01v8_lvt ad=0.3045 pd=2.39 as=0.609 ps=4.78 w=2.1 l=0.35
X278 a_10891_6165# a_20664_6336# vss sky130_fd_pr__res_high_po_0p69 l=7.2
X279 a_21768_9194# a_21768_6694# vss sky130_fd_pr__res_high_po_0p35 l=10.5
X280 a_13495_3430# a_13453_3298# a_7971_1984# vdd sky130_fd_pr__pfet_01v8_lvt ad=0.261 pd=2.38 as=0.261 ps=2.38 w=0.9 l=0.35
X281 a_17182_11162# a_16649_11686# a_2901_12720# vdd sky130_fd_pr__pfet_01v8 ad=0.37455 pd=2.6 as=0.37455 ps=2.6 w=2.27 l=0.15
X282 a_13911_3430# f4 a_7971_1984# vdd sky130_fd_pr__pfet_01v8_lvt ad=0.261 pd=2.38 as=0.261 ps=2.38 w=0.9 l=0.35
X283 vdd a_20827_11933# a_20335_12811# vdd sky130_fd_pr__pfet_01v8 ad=0.3465 pd=2.43 as=0.3465 ps=2.43 w=2.1 l=0.15
X284 a_15451_7210# a_13495_7950# vss vss sky130_fd_pr__nfet_01v8_lvt ad=0.1595 pd=1.68 as=0.1595 ps=1.68 w=0.55 l=0.15
X285 a_4341_1968# a6 vss vss sky130_fd_pr__nfet_01v8 ad=0.1305 pd=1.48 as=0.1305 ps=1.48 w=0.45 l=0.18
X286 a_4811_4856# a_3087_4276# vdd vdd sky130_fd_pr__pfet_01v8 ad=0.363 pd=2.53 as=0.682 ps=5.02 w=2.2 l=0.15
X287 a_363_9054# b7 a_6247_8796# vss sky130_fd_pr__nfet_01v8_lvt ad=0.248 pd=2.22 as=0.132 ps=1.13 w=0.8 l=0.15
X288 vdd a_6247_7364# a_7971_6504# vdd sky130_fd_pr__pfet_01v8 ad=0.363 pd=2.53 as=0.363 ps=2.53 w=2.2 l=0.15
X289 a_15775_5530# f7 a_7971_4856# vss sky130_fd_pr__nfet_01v8_lvt ad=0.145 pd=1.58 as=0.145 ps=1.58 w=0.5 l=0.15
X290 a_6247_7364# a_7501_1968# a_363_4894# vdd sky130_fd_pr__pfet_01v8_lvt ad=0.3045 pd=2.39 as=0.609 ps=4.78 w=2.1 l=0.35
X291 a_4811_6504# a_3087_7364# vdd vdd sky130_fd_pr__pfet_01v8 ad=0.363 pd=2.53 as=0.363 ps=2.53 w=2.2 l=0.15
X292 dn a_21602_6694# vss vss sky130_fd_pr__nfet_01v8_lvt ad=0.231 pd=1.73 as=0.434 ps=3.42 w=1.4 l=0.15
X293 a_11215_3430# f2 a_7971_1984# vss sky130_fd_pr__nfet_01v8_lvt ad=0.145 pd=1.58 as=0.145 ps=1.58 w=0.5 l=0.15
X294 a_13171_4790# a_20664_3688# vss sky130_fd_pr__res_high_po_0p69 l=7.2
X295 a_363_2814# b3 a_6247_2844# vss sky130_fd_pr__nfet_01v8_lvt ad=0.248 pd=2.22 as=0.132 ps=1.13 w=0.8 l=0.15
X296 a_8935_3430# f0 a_4811_1984# vdd sky130_fd_pr__pfet_01v8_lvt ad=0.261 pd=2.38 as=0.261 ps=2.38 w=0.9 l=0.35
X297 a_2901_12720# a_3421_11939# a_10902_11162# vdd sky130_fd_pr__pfet_01v8 ad=0.7037 pd=5.16 as=0.37455 ps=2.6 w=2.27 l=0.15
X298 a_16191_3430# f6 a_7971_1984# vdd sky130_fd_pr__pfet_01v8_lvt ad=0.261 pd=2.38 as=0.261 ps=2.38 w=0.9 l=0.35
X299 a_11215_3750# a_11173_3298# a_4811_4856# vss sky130_fd_pr__nfet_01v8_lvt ad=0.145 pd=1.58 as=0.145 ps=1.58 w=0.5 l=0.15
X300 a_411_11960# rst_n vdd vdd sky130_fd_pr__pfet_01v8 ad=0.33 pd=2.33 as=0.33 ps=2.33 w=2 l=0.15
X301 a_363_9054# a_6068_205# a_6247_2844# vdd sky130_fd_pr__pfet_01v8_lvt ad=0.609 pd=4.78 as=0.3045 ps=2.39 w=2.1 l=0.35
X302 a_363_4894# a_7061_1968# a_6247_2844# vdd sky130_fd_pr__pfet_01v8_lvt ad=0.609 pd=4.78 as=0.3045 ps=2.39 w=2.1 l=0.35
X303 a_3087_8796# a_2938_205# a_363_2286# vdd sky130_fd_pr__pfet_01v8_lvt ad=0.3045 pd=2.39 as=0.609 ps=4.78 w=2.1 l=0.35
X304 vdd a_9351_1650# vdd vdd sky130_fd_pr__pfet_01v8 ad=0.667 pd=5.18 as=0 ps=0 w=2.3 l=0.15
X305 a_363_8526# a4 a_3087_4276# vss sky130_fd_pr__nfet_01v8_lvt ad=0.248 pd=2.22 as=0.132 ps=1.13 w=0.8 l=0.15
X306 a_6055_12811# a_2909_11950# vdd vdd sky130_fd_pr__pfet_01v8 ad=0.5481 pd=4.36 as=0.5481 ps=4.36 w=1.89 l=0.15
X307 a_3087_8796# a2 a_363_4366# vss sky130_fd_pr__nfet_01v8_lvt ad=0.132 pd=1.13 as=0.248 ps=2.22 w=0.8 l=0.15
X308 a_3421_11939# a_2909_11950# vss vss sky130_fd_pr__nfet_01v8_lvt ad=0.17325 pd=1.38 as=0.3255 ps=2.72 w=1.05 l=0.15
X309 vss a_6247_4276# a_7971_4856# vss sky130_fd_pr__nfet_01v8_lvt ad=0.31 pd=2.62 as=0.165 ps=1.33 w=1 l=0.15
X310 ckd3 a_5719_11933# vdd vdd sky130_fd_pr__pfet_01v8 ad=0.4158 pd=2.85 as=0.7812 ps=5.66 w=2.52 l=0.15
X311 vdd a_4622_11162# a_4651_12720# vdd sky130_fd_pr__pfet_01v8 ad=0.58905 pd=3.9 as=0.58905 ps=3.9 w=3.57 l=0.15
X312 vss a_16191_7950# vss vss sky130_fd_pr__nfet_01v8_lvt ad=0.1595 pd=1.68 as=0 ps=0 w=0.55 l=0.15
X313 a_3421_11939# a_4089_11686# vdd vdd sky130_fd_pr__pfet_01v8 ad=0.5481 pd=4.36 as=0.5481 ps=4.36 w=1.89 l=0.15
X314 a_1987_11933# rst_n dp vss sky130_fd_pr__nfet_01v8_lvt ad=0.2145 pd=1.63 as=0.403 ps=3.22 w=1.3 l=0.15
X315 a_10891_2690# a_8935_3430# vdd vdd sky130_fd_pr__pfet_01v8 ad=0.667 pd=5.18 as=0.667 ps=5.18 w=2.3 l=0.15
X316 a_10891_3745# a_8935_3750# vss vss sky130_fd_pr__nfet_01v8_lvt ad=0.1595 pd=1.68 as=0.1595 ps=1.68 w=0.55 l=0.15
X317 vss a_4027_11933# ckd1 vss sky130_fd_pr__nfet_01v8_lvt ad=0.372 pd=3.02 as=0.198 ps=1.53 w=1.2 l=0.15
X318 a_11631_1650# f3 a_4811_1984# vss sky130_fd_pr__nfet_01v8_lvt ad=0.145 pd=1.58 as=0.145 ps=1.58 w=0.5 l=0.15
X319 a_15775_10050# a_15733_1814# a_7971_9376# vdd sky130_fd_pr__pfet_01v8_lvt ad=0.261 pd=2.38 as=0.261 ps=2.38 w=0.9 l=0.35
X320 a_11631_3750# a_11173_3298# a_4811_4856# vdd sky130_fd_pr__pfet_01v8_lvt ad=0.261 pd=2.38 as=0.261 ps=2.38 w=0.9 l=0.35
X321 a_4119_11933# a_4622_11162# vss vss sky130_fd_pr__nfet_01v8 ad=0.1218 pd=1.42 as=0.1218 ps=1.42 w=0.42 l=0.28
X322 vdd a_6247_8796# a_7971_9376# vdd sky130_fd_pr__pfet_01v8 ad=0.363 pd=2.53 as=0.363 ps=2.53 w=2.2 l=0.15
X323 a_4811_9376# a_3087_8796# vdd vdd sky130_fd_pr__pfet_01v8 ad=0.363 pd=2.53 as=0.363 ps=2.53 w=2.2 l=0.15
X324 a_6247_8796# a_7501_1968# a_363_9054# vdd sky130_fd_pr__pfet_01v8_lvt ad=0.3045 pd=2.39 as=0.609 ps=4.78 w=2.1 l=0.35
X325 a_11215_7950# a_11173_3298# a_7971_6504# vdd sky130_fd_pr__pfet_01v8_lvt ad=0.261 pd=2.38 as=0.261 ps=2.38 w=0.9 l=0.35
X326 vdd a_6055_12811# a_4089_11686# vdd sky130_fd_pr__pfet_01v8 ad=0.6851 pd=5.04 as=0.36465 ps=2.54 w=2.21 l=0.15
X327 a_363_4366# c2 vss vss sky130_fd_pr__nfet_01v8_lvt ad=0.493 pd=3.98 as=0.493 ps=3.98 w=1.7 l=0.15
X328 cke1 a_23221_12720# vdd vdd sky130_fd_pr__pfet_01v8 ad=0.4158 pd=2.85 as=0.7812 ps=5.66 w=2.52 l=0.15
X329 a_14547_11933# rst_n ep vss sky130_fd_pr__nfet_01v8_lvt ad=0.2145 pd=1.63 as=0.403 ps=3.22 w=1.3 l=0.15
X330 a_10891_8265# a_8935_8270# vdd vdd sky130_fd_pr__pfet_01v8 ad=0.667 pd=5.18 as=0.667 ps=5.18 w=2.3 l=0.15
X331 a_5738_205# b0 vdd vdd sky130_fd_pr__pfet_01v8 ad=0.261 pd=2.38 as=0.261 ps=2.38 w=0.9 l=0.18
X332 a_11631_7950# f2 a_7971_6504# vdd sky130_fd_pr__pfet_01v8_lvt ad=0.261 pd=2.38 as=0.261 ps=2.38 w=0.9 l=0.35
X333 vdd a_21768_6694# a_21768_9194# vdd sky130_fd_pr__pfet_01v8_lvt ad=0.5365 pd=4.28 as=0.26825 ps=2.14 w=1.85 l=0.35
X334 a_9351_8270# a_8893_3298# a_4811_9376# vdd sky130_fd_pr__pfet_01v8_lvt ad=0.261 pd=2.38 as=0.261 ps=2.38 w=0.9 l=0.35
X335 a_3087_2844# a_4341_1968# a_363_6446# vdd sky130_fd_pr__pfet_01v8_lvt ad=0.3045 pd=2.39 as=0.609 ps=4.78 w=2.1 l=0.35
X336 vdd c5 a_363_6974# vdd sky130_fd_pr__pfet_01v8_lvt ad=0.493 pd=3.98 as=0.2465 ps=1.99 w=1.7 l=0.35
X337 a_17731_4790# a_15775_5530# vdd vdd sky130_fd_pr__pfet_01v8 ad=0.667 pd=5.18 as=0.667 ps=5.18 w=2.3 l=0.15
X338 a_5719_11933# a_15981_11939# a_22959_11933# vdd sky130_fd_pr__pfet_01v8 ad=0.37455 pd=2.6 as=0.37455 ps=2.6 w=2.27 l=0.15
X339 a_363_8526# c6 vdd vdd sky130_fd_pr__pfet_01v8_lvt ad=0.2465 pd=1.99 as=0.2465 ps=1.99 w=1.7 l=0.35
X340 a_8935_6170# a_8893_1814# a_4811_6504# vss sky130_fd_pr__nfet_01v8_lvt ad=0.145 pd=1.58 as=0.145 ps=1.58 w=0.5 l=0.15
X341 a_13171_3745# a_11215_3750# vss vss sky130_fd_pr__nfet_01v8_lvt ad=0.1595 pd=1.68 as=0.1595 ps=1.68 w=0.55 l=0.15
X342 vss a_10399_11933# a_4027_11933# vss sky130_fd_pr__nfet_01v8_lvt ad=0.527 pd=4.02 as=0.2805 ps=2.03 w=1.7 l=0.15
X343 a_13171_2690# a_11215_3430# vdd vdd sky130_fd_pr__pfet_01v8 ad=0.667 pd=5.18 as=0.667 ps=5.18 w=2.3 l=0.15
X344 a_15451_3745# a_13495_3750# vdd vdd sky130_fd_pr__pfet_01v8 ad=0.667 pd=5.18 as=0.667 ps=5.18 w=2.3 l=0.15
X345 a_13911_1650# f5 a_4811_1984# vss sky130_fd_pr__nfet_01v8_lvt ad=0.145 pd=1.58 as=0.145 ps=1.58 w=0.5 l=0.15
X346 a_8935_3430# f0 a_7971_1984# vss sky130_fd_pr__nfet_01v8_lvt ad=0.145 pd=1.58 as=0.145 ps=1.58 w=0.5 l=0.15
X347 a_20335_12811# a_15469_11950# vss vss sky130_fd_pr__nfet_01v8_lvt ad=0.1305 pd=1.48 as=0.1305 ps=1.48 w=0.45 l=0.15
X348 a_4027_11933# a_3421_11939# a_4119_11933# vss sky130_fd_pr__nfet_01v8_lvt ad=0.434 pd=3.42 as=0.231 ps=1.73 w=1.4 l=0.15
X349 a_10891_8265# a_20664_8208# vss sky130_fd_pr__res_high_po_0p69 l=7.2
X350 dn a_21602_6694# vdd vdd sky130_fd_pr__pfet_01v8_lvt ad=0.406 pd=3.09 as=0.812 ps=6.18 w=2.8 l=0.35
X351 a_13911_3750# a_13453_3298# a_4811_4856# vdd sky130_fd_pr__pfet_01v8_lvt ad=0.261 pd=2.38 as=0.261 ps=2.38 w=0.9 l=0.35
X352 a_2901_12720# a_4119_11933# vdd vdd sky130_fd_pr__pfet_01v8 ad=0.58905 pd=3.9 as=0.58905 ps=3.9 w=3.57 l=0.15
X353 a_22959_11933# a_15981_11939# a_5719_11933# vdd sky130_fd_pr__pfet_01v8 ad=0.37455 pd=2.6 as=0.7037 ps=5.16 w=2.27 l=0.15
X354 a_363_4366# a6 a_3087_7364# vss sky130_fd_pr__nfet_01v8_lvt ad=0.248 pd=2.22 as=0.132 ps=1.13 w=0.8 l=0.15
X355 vdd a_21768_2174# a_21768_4674# vdd sky130_fd_pr__pfet_01v8_lvt ad=0.26825 pd=2.14 as=0.26825 ps=2.14 w=1.85 l=0.35
X356 a_7971_4856# a_6247_4276# vdd vdd sky130_fd_pr__pfet_01v8 ad=0.363 pd=2.53 as=0.363 ps=2.53 w=2.2 l=0.15
X357 vdd a_21602_4674# a_21602_2174# vdd sky130_fd_pr__pfet_01v8_lvt ad=0.5365 pd=4.28 as=0.26825 ps=2.14 w=1.85 l=0.35
X358 cke0 cke2 vdd vdd sky130_fd_pr__pfet_01v8 ad=0.5481 pd=4.36 as=0.5481 ps=4.36 w=1.89 l=0.15
X359 a_13171_8265# a_11215_8270# vdd vdd sky130_fd_pr__pfet_01v8 ad=0.667 pd=5.18 as=0.667 ps=5.18 w=2.3 l=0.15
X360 ep a_21768_4674# vdd vdd sky130_fd_pr__pfet_01v8_lvt ad=0.406 pd=3.09 as=0.406 ps=3.09 w=2.8 l=0.35
X361 a_3087_4276# a6 a_363_2286# vss sky130_fd_pr__nfet_01v8_lvt ad=0.132 pd=1.13 as=0.248 ps=2.22 w=0.8 l=0.15
X362 vss a_11631_3750# vss vss sky130_fd_pr__nfet_01v8_lvt ad=0.1595 pd=1.68 as=0 ps=0 w=0.55 l=0.15
X363 a_4651_12720# a_15981_11939# a_16679_11933# vss sky130_fd_pr__nfet_01v8_lvt ad=0.434 pd=3.42 as=0.231 ps=1.73 w=1.4 l=0.15
X364 vss a_9351_8270# vss vss sky130_fd_pr__nfet_01v8_lvt ad=0.1595 pd=1.68 as=0 ps=0 w=0.55 l=0.15
X365 a_15775_7950# f6 a_7971_6504# vss sky130_fd_pr__nfet_01v8_lvt ad=0.145 pd=1.58 as=0.145 ps=1.58 w=0.5 l=0.15
X366 vdd a_11631_3430# vdd vdd sky130_fd_pr__pfet_01v8 ad=0.667 pd=5.18 as=0 ps=0 w=2.3 l=0.15
X367 vss a_21602_2174# en vss sky130_fd_pr__nfet_01v8_lvt ad=0.434 pd=3.42 as=0.231 ps=1.73 w=1.4 l=0.15
X368 a_13495_1650# a_13453_1814# a_4811_1984# vss sky130_fd_pr__nfet_01v8_lvt ad=0.145 pd=1.58 as=0.145 ps=1.58 w=0.5 l=0.15
X369 a_13495_3750# f4 a_4811_4856# vdd sky130_fd_pr__pfet_01v8_lvt ad=0.261 pd=2.38 as=0.261 ps=2.38 w=0.9 l=0.35
X370 a_8935_5530# a_8893_1814# a_4811_4856# vss sky130_fd_pr__nfet_01v8_lvt ad=0.145 pd=1.58 as=0.145 ps=1.58 w=0.5 l=0.15
X371 a_2901_12720# a_16649_11686# a_17182_11162# vdd sky130_fd_pr__pfet_01v8 ad=0.7037 pd=5.16 as=0.37455 ps=2.6 w=2.27 l=0.15
X372 a_10902_11162# a_1058_11170# vdd vdd sky130_fd_pr__pfet_01v8 ad=0.522 pd=4.18 as=0.522 ps=4.18 w=1.8 l=0.18
X373 vdd a_11631_8270# vdd vdd sky130_fd_pr__pfet_01v8 ad=0.667 pd=5.18 as=0 ps=0 w=2.3 l=0.15
X374 a_363_6446# a_2938_205# a_3087_7364# vdd sky130_fd_pr__pfet_01v8_lvt ad=0.609 pd=4.78 as=0.3045 ps=2.39 w=2.1 l=0.35
X375 a_5738_205# b0 vss vss sky130_fd_pr__nfet_01v8 ad=0.1305 pd=1.48 as=0.1305 ps=1.48 w=0.45 l=0.18
X376 a_20335_12811# a_20827_11933# vdd vdd sky130_fd_pr__pfet_01v8 ad=0.651 pd=4.82 as=0.3465 ps=2.43 w=2.1 l=0.15
X377 a_15451_2690# a_20664_1816# vss sky130_fd_pr__res_high_po_0p69 l=7.2
X378 a_11215_8270# f2 a_4811_9376# vdd sky130_fd_pr__pfet_01v8_lvt ad=0.261 pd=2.38 as=0.261 ps=2.38 w=0.9 l=0.35
X379 a_10891_7210# a_20664_6336# vss sky130_fd_pr__res_high_po_0p69 l=7.2
X380 a_9351_1650# f1 a_4811_1984# vss sky130_fd_pr__nfet_01v8_lvt ad=0.145 pd=1.58 as=0.145 ps=1.58 w=0.5 l=0.15
X381 a_16649_11686# a_15981_11939# vss vss sky130_fd_pr__nfet_01v8_lvt ad=0.1305 pd=1.48 as=0.1305 ps=1.48 w=0.45 l=0.15
X382 a_6055_12811# a_8267_11933# vdd vdd sky130_fd_pr__pfet_01v8 ad=0.3465 pd=2.43 as=0.651 ps=4.82 w=2.1 l=0.15
X383 a_9351_1650# a_8893_1814# a_7971_1984# vss sky130_fd_pr__nfet_01v8_lvt ad=0.145 pd=1.58 as=0.145 ps=1.58 w=0.5 l=0.15
X384 a_9351_3750# f0 a_7971_4856# vdd sky130_fd_pr__pfet_01v8_lvt ad=0.261 pd=2.38 as=0.261 ps=2.38 w=0.9 l=0.35
X385 dp a_21768_9194# vdd vdd sky130_fd_pr__pfet_01v8_lvt ad=0.406 pd=3.09 as=0.812 ps=6.18 w=2.8 l=0.35
X386 a_3087_4276# a_3461_1968# a_363_6446# vdd sky130_fd_pr__pfet_01v8_lvt ad=0.3045 pd=2.39 as=0.609 ps=4.78 w=2.1 l=0.35
X387 vdd a_13911_3430# vdd vdd sky130_fd_pr__pfet_01v8 ad=0.667 pd=5.18 as=0 ps=0 w=2.3 l=0.15
X388 vss a_13911_3750# vss vss sky130_fd_pr__nfet_01v8_lvt ad=0.1595 pd=1.68 as=0 ps=0 w=0.55 l=0.15
X389 vdd a_16191_3750# vdd vdd sky130_fd_pr__pfet_01v8 ad=0.667 pd=5.18 as=0 ps=0 w=2.3 l=0.15
X390 a_363_6446# a2 a_3087_4276# vss sky130_fd_pr__nfet_01v8_lvt ad=0.248 pd=2.22 as=0.132 ps=1.13 w=0.8 l=0.15
X391 a_17221_12720# a_16679_11933# vdd vdd sky130_fd_pr__pfet_01v8 ad=0.33495 pd=2.36 as=0.6293 ps=4.68 w=2.03 l=0.15
X392 a_11631_5530# a_11173_1814# a_4811_4856# vdd sky130_fd_pr__pfet_01v8_lvt ad=0.261 pd=2.38 as=0.261 ps=2.38 w=0.9 l=0.35
X393 a_4089_11686# a_6055_12811# vss vss sky130_fd_pr__nfet_01v8_lvt ad=0.17325 pd=1.38 as=0.3255 ps=2.72 w=1.05 l=0.15
X394 a_17731_9310# a_15775_10050# vss vss sky130_fd_pr__nfet_01v8_lvt ad=0.1595 pd=1.68 as=0.1595 ps=1.68 w=0.55 l=0.15
X395 vdd a_17221_12720# cke0 vdd sky130_fd_pr__pfet_01v8 ad=0.4158 pd=2.85 as=0.4158 ps=2.85 w=2.52 l=0.15
X396 a_13171_6165# a_20664_6336# vss sky130_fd_pr__res_high_po_0p69 l=7.2
X397 vdd a_2901_12720# ckd0 vdd sky130_fd_pr__pfet_01v8 ad=0.7812 pd=5.66 as=0.4158 ps=2.85 w=2.52 l=0.15
X398 a_363_4894# a_7501_1968# a_6247_7364# vdd sky130_fd_pr__pfet_01v8_lvt ad=0.609 pd=4.78 as=0.3045 ps=2.39 w=2.1 l=0.35
X399 vdd a_4651_12720# ckd2 vdd sky130_fd_pr__pfet_01v8 ad=0.4158 pd=2.85 as=0.4158 ps=2.85 w=2.52 l=0.15
X400 vdd a_13911_8270# vdd vdd sky130_fd_pr__pfet_01v8 ad=0.667 pd=5.18 as=0 ps=0 w=2.3 l=0.15
X401 a_3087_7364# a4 a_363_2286# vss sky130_fd_pr__nfet_01v8_lvt ad=0.132 pd=1.13 as=0.248 ps=2.22 w=0.8 l=0.15
X402 a_11631_6170# a_11173_1814# a_4811_6504# vdd sky130_fd_pr__pfet_01v8_lvt ad=0.261 pd=2.38 as=0.261 ps=2.38 w=0.9 l=0.35
X403 a_16191_8270# f6 a_4811_9376# vss sky130_fd_pr__nfet_01v8_lvt ad=0.145 pd=1.58 as=0.145 ps=1.58 w=0.5 l=0.15
X404 vdd a_18971_12720# cke2 vdd sky130_fd_pr__pfet_01v8 ad=0.4158 pd=2.85 as=0.4158 ps=2.85 w=2.52 l=0.15
X405 a_363_2286# c0 vdd vdd sky130_fd_pr__pfet_01v8_lvt ad=0.2465 pd=1.99 as=0.493 ps=3.98 w=1.7 l=0.35
X406 a_4119_11933# a_1418_11110# vss vss sky130_fd_pr__nfet_01v8 ad=0.29 pd=2.58 as=0.29 ps=2.58 w=1 l=0.18
X407 a_363_9054# c7 vss vss sky130_fd_pr__nfet_01v8_lvt ad=0.493 pd=3.98 as=0.493 ps=3.98 w=1.7 l=0.15
X408 a_15451_1645# a_13495_1650# vss vss sky130_fd_pr__nfet_01v8_lvt ad=0.1595 pd=1.68 as=0.1595 ps=1.68 w=0.55 l=0.15
X409 a_17731_1645# a_15775_1650# vdd vdd sky130_fd_pr__pfet_01v8 ad=0.667 pd=5.18 as=0.667 ps=5.18 w=2.3 l=0.15
X410 ckd0 ckd2 vss vss sky130_fd_pr__nfet_01v8_lvt ad=0.1305 pd=1.48 as=0.1305 ps=1.48 w=0.45 l=0.15
X411 a_24971_12720# a_23221_12720# vss vss sky130_fd_pr__nfet_01v8_lvt ad=0.1218 pd=1.42 as=0.1218 ps=1.42 w=0.42 l=0.15
X412 a_6068_205# b1 vdd vdd sky130_fd_pr__pfet_01v8 ad=0.261 pd=2.38 as=0.261 ps=2.38 w=0.9 l=0.18
X413 a_16191_1650# a_15733_1814# a_4811_1984# vdd sky130_fd_pr__pfet_01v8_lvt ad=0.261 pd=2.38 as=0.261 ps=2.38 w=0.9 l=0.35
X414 a_13911_5530# a_13453_1814# a_4811_4856# vdd sky130_fd_pr__pfet_01v8_lvt ad=0.261 pd=2.38 as=0.261 ps=2.38 w=0.9 l=0.35
X415 a_363_2286# a_2938_205# a_3087_8796# vdd sky130_fd_pr__pfet_01v8_lvt ad=0.609 pd=4.78 as=0.3045 ps=2.39 w=2.1 l=0.35
X416 a_13453_1814# f5 vdd vdd sky130_fd_pr__pfet_01v8 ad=0.261 pd=2.38 as=0.261 ps=2.38 w=0.9 l=0.18
X417 a_363_8526# a_3901_1968# a_3087_4276# vdd sky130_fd_pr__pfet_01v8_lvt ad=0.609 pd=4.78 as=0.3045 ps=2.39 w=2.1 l=0.35
X418 a_2909_11950# a_1987_11933# vdd vdd sky130_fd_pr__pfet_01v8 ad=0.3465 pd=2.43 as=0.651 ps=4.82 w=2.1 l=0.15
X419 vss a_2909_11950# a_3421_11939# vss sky130_fd_pr__nfet_01v8_lvt ad=0.3255 pd=2.72 as=0.17325 ps=1.38 w=1.05 l=0.15
X420 a_4651_12720# a_4622_11162# vdd vdd sky130_fd_pr__pfet_01v8 ad=0.58905 pd=3.9 as=0.58905 ps=3.9 w=3.57 l=0.15
X421 a_7971_6504# a_6247_7364# vdd vdd sky130_fd_pr__pfet_01v8 ad=0.363 pd=2.53 as=0.682 ps=5.02 w=2.2 l=0.15
X422 dp rst_n a_1987_11933# vss sky130_fd_pr__nfet_01v8_lvt ad=0.403 pd=3.22 as=0.2145 ps=1.63 w=1.3 l=0.15
X423 a_15451_6165# a_13495_6170# vdd vdd sky130_fd_pr__pfet_01v8 ad=0.667 pd=5.18 as=0.667 ps=5.18 w=2.3 l=0.15
X424 vss a_16191_10050# vss vss sky130_fd_pr__nfet_01v8_lvt ad=0.1595 pd=1.68 as=0 ps=0 w=0.55 l=0.15
X425 a_15775_8270# a_15733_3298# a_4811_9376# vss sky130_fd_pr__nfet_01v8_lvt ad=0.145 pd=1.58 as=0.145 ps=1.58 w=0.5 l=0.15
X426 a_6247_7364# b1 a_363_6974# vss sky130_fd_pr__nfet_01v8_lvt ad=0.132 pd=1.13 as=0.248 ps=2.22 w=0.8 l=0.15
X427 a_3421_11939# a_2909_11950# vdd vdd sky130_fd_pr__pfet_01v8 ad=0.36465 pd=2.54 as=0.6851 ps=5.04 w=2.21 l=0.15
X428 a_6247_7364# b5 a_363_2814# vss sky130_fd_pr__nfet_01v8_lvt ad=0.132 pd=1.13 as=0.248 ps=2.22 w=0.8 l=0.15
X429 a_13911_6170# a_13453_1814# a_4811_6504# vdd sky130_fd_pr__pfet_01v8_lvt ad=0.261 pd=2.38 as=0.261 ps=2.38 w=0.9 l=0.35
X430 a_7058_205# b4 vdd vdd sky130_fd_pr__pfet_01v8 ad=0.261 pd=2.38 as=0.261 ps=2.38 w=0.9 l=0.18
X431 a_11215_6170# a_11173_1814# a_4811_6504# vss sky130_fd_pr__nfet_01v8_lvt ad=0.145 pd=1.58 as=0.145 ps=1.58 w=0.5 l=0.15
X432 a_23221_12720# a_24971_12720# vss vss sky130_fd_pr__nfet_01v8_lvt ad=0.1218 pd=1.42 as=0.1218 ps=1.42 w=0.42 l=0.15
X433 a_13495_3750# f4 a_7971_4856# vss sky130_fd_pr__nfet_01v8_lvt ad=0.145 pd=1.58 as=0.145 ps=1.58 w=0.5 l=0.15
X434 vdd a_3087_4276# a_4811_4856# vdd sky130_fd_pr__pfet_01v8 ad=0.682 pd=5.02 as=0.363 ps=2.53 w=2.2 l=0.15
X435 ep rst_n a_14547_11933# vss sky130_fd_pr__nfet_01v8_lvt ad=0.403 pd=3.22 as=0.2145 ps=1.63 w=1.3 l=0.15
X436 a_363_9054# a_7501_1968# a_6247_8796# vdd sky130_fd_pr__pfet_01v8_lvt ad=0.609 pd=4.78 as=0.3045 ps=2.39 w=2.1 l=0.35
X437 a_15775_1650# f7 a_4811_1984# vdd sky130_fd_pr__pfet_01v8_lvt ad=0.261 pd=2.38 as=0.261 ps=2.38 w=0.9 l=0.35
X438 a_13495_5530# f5 a_4811_4856# vdd sky130_fd_pr__pfet_01v8_lvt ad=0.261 pd=2.38 as=0.261 ps=2.38 w=0.9 l=0.35
X439 a_7501_1968# b7 vdd vdd sky130_fd_pr__pfet_01v8 ad=0.261 pd=2.38 as=0.261 ps=2.38 w=0.9 l=0.18
X440 a_6247_2844# a_6068_205# a_363_9054# vdd sky130_fd_pr__pfet_01v8_lvt ad=0.3045 pd=2.39 as=0.609 ps=4.78 w=2.1 l=0.35
X441 a_13911_3750# a_13453_3298# a_7971_4856# vss sky130_fd_pr__nfet_01v8_lvt ad=0.145 pd=1.58 as=0.145 ps=1.58 w=0.5 l=0.15
X442 a_8935_3750# a_8893_3298# a_7971_4856# vdd sky130_fd_pr__pfet_01v8_lvt ad=0.261 pd=2.38 as=0.261 ps=2.38 w=0.9 l=0.35
X443 a_13911_10050# a_13453_1814# a_7971_9376# vss sky130_fd_pr__nfet_01v8_lvt ad=0.145 pd=1.58 as=0.145 ps=1.58 w=0.5 l=0.15
X444 a_1058_11170# a_411_11960# vdd vdd sky130_fd_pr__pfet_01v8 ad=0.435 pd=3.58 as=0.435 ps=3.58 w=1.5 l=0.18
X445 a_14547_11933# a_411_11960# vss vss sky130_fd_pr__nfet_01v8 ad=0.232 pd=2.18 as=0.232 ps=2.18 w=0.8 l=0.18
X446 a_20827_11933# a_411_11960# en vdd sky130_fd_pr__pfet_01v8_lvt ad=0.32915 pd=2.56 as=0.6583 ps=5.12 w=2.27 l=0.35
X447 a_363_6446# a_4341_1968# a_3087_2844# vdd sky130_fd_pr__pfet_01v8_lvt ad=0.609 pd=4.78 as=0.3045 ps=2.39 w=2.1 l=0.35
X448 a_10891_9310# a_8935_10050# vdd vdd sky130_fd_pr__pfet_01v8 ad=0.667 pd=5.18 as=0.667 ps=5.18 w=2.3 l=0.15
X449 a_10891_6165# a_8935_6170# vss vss sky130_fd_pr__nfet_01v8_lvt ad=0.1595 pd=1.68 as=0.1595 ps=1.68 w=0.55 l=0.15
X450 a_22959_11933# a_15981_11939# a_5719_11933# vdd sky130_fd_pr__pfet_01v8 ad=0.7037 pd=5.16 as=0.37455 ps=2.6 w=2.27 l=0.15
X451 a_13495_6170# f5 a_4811_6504# vdd sky130_fd_pr__pfet_01v8_lvt ad=0.261 pd=2.38 as=0.261 ps=2.38 w=0.9 l=0.35
X452 a_13171_2690# a_20664_1816# vss sky130_fd_pr__res_high_po_0p69 l=7.2
X453 a_9351_10050# a_8893_1814# a_4811_9376# vdd sky130_fd_pr__pfet_01v8_lvt ad=0.261 pd=2.38 as=0.261 ps=2.38 w=0.9 l=0.35
X454 a_8935_7950# a_8893_3298# a_4811_6504# vss sky130_fd_pr__nfet_01v8_lvt ad=0.145 pd=1.58 as=0.145 ps=1.58 w=0.5 l=0.15
X455 a_9351_5530# f1 a_7971_4856# vdd sky130_fd_pr__pfet_01v8_lvt ad=0.261 pd=2.38 as=0.261 ps=2.38 w=0.9 l=0.35
X456 a_17182_11162# a_1058_11170# vdd vdd sky130_fd_pr__pfet_01v8 ad=0.522 pd=4.18 as=0.522 ps=4.18 w=1.8 l=0.18
X457 a_21602_6694# a_21602_9194# vdd vdd sky130_fd_pr__pfet_01v8_lvt ad=0.26825 pd=2.14 as=0.5365 ps=4.28 w=1.85 l=0.35
X458 vss a_16191_1650# vss vss sky130_fd_pr__nfet_01v8_lvt ad=0.1595 pd=1.68 as=0 ps=0 w=0.55 l=0.15
X459 cke3 a_24971_12720# vdd vdd sky130_fd_pr__pfet_01v8 ad=0.4158 pd=2.85 as=0.7812 ps=5.66 w=2.52 l=0.15
X460 a_15451_4790# a_20664_3688# vss sky130_fd_pr__res_high_po_0p69 l=7.2
X461 a_363_9054# b1 a_6247_2844# vss sky130_fd_pr__nfet_01v8_lvt ad=0.248 pd=2.22 as=0.132 ps=1.13 w=0.8 l=0.15
X462 a_6055_12811# a_8267_11933# vss vss sky130_fd_pr__nfet_01v8_lvt ad=0.435 pd=3.58 as=0.435 ps=3.58 w=1.5 l=0.15
X463 a_4811_9376# a_3087_8796# vss vss sky130_fd_pr__nfet_01v8_lvt ad=0.165 pd=1.33 as=0.31 ps=2.62 w=1 l=0.15
X464 a_363_4894# b5 a_6247_2844# vss sky130_fd_pr__nfet_01v8_lvt ad=0.248 pd=2.22 as=0.132 ps=1.13 w=0.8 l=0.15
X465 a_11215_5530# a_11173_1814# a_4811_4856# vss sky130_fd_pr__nfet_01v8_lvt ad=0.145 pd=1.58 as=0.145 ps=1.58 w=0.5 l=0.15
X466 a_6068_205# b1 vss vss sky130_fd_pr__nfet_01v8 ad=0.1305 pd=1.48 as=0.1305 ps=1.48 w=0.45 l=0.18
X467 a_7971_9376# a_6247_8796# vdd vdd sky130_fd_pr__pfet_01v8 ad=0.363 pd=2.53 as=0.682 ps=5.02 w=2.2 l=0.15
X468 a_2938_205# a0 vdd vdd sky130_fd_pr__pfet_01v8 ad=0.261 pd=2.38 as=0.261 ps=2.38 w=0.9 l=0.18
X469 a_13453_1814# f5 vss vss sky130_fd_pr__nfet_01v8 ad=0.1305 pd=1.48 as=0.1305 ps=1.48 w=0.45 l=0.18
X470 a_2909_11950# a_6055_12811# vss vss sky130_fd_pr__nfet_01v8_lvt ad=0.1305 pd=1.48 as=0.1305 ps=1.48 w=0.45 l=0.15
X471 a_9351_6170# f1 a_7971_6504# vdd sky130_fd_pr__pfet_01v8_lvt ad=0.261 pd=2.38 as=0.261 ps=2.38 w=0.9 l=0.35
X472 a_15469_11950# a_20335_12811# vdd vdd sky130_fd_pr__pfet_01v8 ad=0.5481 pd=4.36 as=0.5481 ps=4.36 w=1.89 l=0.15
X473 a_10891_4790# a_20664_3688# vss sky130_fd_pr__res_high_po_0p69 l=7.2
X474 a_16191_3750# a_15733_3298# a_7971_4856# vss sky130_fd_pr__nfet_01v8_lvt ad=0.145 pd=1.58 as=0.145 ps=1.58 w=0.5 l=0.15
X475 a_17731_8265# a_15775_8270# vss vss sky130_fd_pr__nfet_01v8_lvt ad=0.1595 pd=1.68 as=0.1595 ps=1.68 w=0.55 l=0.15
X476 vdd a_16191_6170# vdd vdd sky130_fd_pr__pfet_01v8 ad=0.667 pd=5.18 as=0 ps=0 w=2.3 l=0.15
X477 a_13171_8265# a_20664_8208# vss sky130_fd_pr__res_high_po_0p69 l=7.2
X478 a_363_2814# c1 vss vss sky130_fd_pr__nfet_01v8_lvt ad=0.493 pd=3.98 as=0.493 ps=3.98 w=1.7 l=0.15
X479 a_4811_1984# a_3087_2844# vdd vdd sky130_fd_pr__pfet_01v8 ad=0.363 pd=2.53 as=0.682 ps=5.02 w=2.2 l=0.15
X480 vdd a_4027_11933# ckd1 vdd sky130_fd_pr__pfet_01v8 ad=0.7812 pd=5.66 as=0.4158 ps=2.85 w=2.52 l=0.15
X481 a_13171_6165# a_11215_6170# vss vss sky130_fd_pr__nfet_01v8_lvt ad=0.1595 pd=1.68 as=0.1595 ps=1.68 w=0.55 l=0.15
X482 a_7058_205# b4 vss vss sky130_fd_pr__nfet_01v8 ad=0.1305 pd=1.48 as=0.1305 ps=1.48 w=0.45 l=0.18
X483 a_13171_9310# a_11215_10050# vdd vdd sky130_fd_pr__pfet_01v8 ad=0.667 pd=5.18 as=0.667 ps=5.18 w=2.3 l=0.15
X484 a_10891_4790# a_8935_5530# vss vss sky130_fd_pr__nfet_01v8_lvt ad=0.1595 pd=1.68 as=0.1595 ps=1.68 w=0.55 l=0.15
X485 a_24971_12720# a_23221_12720# vdd vdd sky130_fd_pr__pfet_01v8 ad=0.5104 pd=4.1 as=0.5104 ps=4.1 w=1.76 l=0.15
X486 a_3087_8796# a0 a_363_2286# vss sky130_fd_pr__nfet_01v8_lvt ad=0.132 pd=1.13 as=0.248 ps=2.22 w=0.8 l=0.15
X487 a_11631_3430# f2 a_4811_1984# vss sky130_fd_pr__nfet_01v8_lvt ad=0.145 pd=1.58 as=0.145 ps=1.58 w=0.5 l=0.15
X488 vdd c4 a_363_6446# vdd sky130_fd_pr__pfet_01v8_lvt ad=0.493 pd=3.98 as=0.2465 ps=1.99 w=1.7 l=0.35
X489 a_1987_11933# a_411_11960# dp vdd sky130_fd_pr__pfet_01v8_lvt ad=0.6583 pd=5.12 as=0.32915 ps=2.56 w=2.27 l=0.35
X490 a_16191_3430# a_15733_3298# a_4811_1984# vdd sky130_fd_pr__pfet_01v8_lvt ad=0.261 pd=2.38 as=0.261 ps=2.38 w=0.9 l=0.35
X491 a_7501_1968# b7 vss vss sky130_fd_pr__nfet_01v8 ad=0.1305 pd=1.48 as=0.1305 ps=1.48 w=0.45 l=0.18
X492 vdd a_15469_11950# a_15981_11939# vdd sky130_fd_pr__pfet_01v8 ad=0.6851 pd=5.04 as=0.36465 ps=2.54 w=2.21 l=0.15
X493 a_11173_3298# f2 vdd vdd sky130_fd_pr__pfet_01v8 ad=0.261 pd=2.38 as=0.261 ps=2.38 w=0.9 l=0.18
X494 a_17221_12720# a_16679_11933# vdd vdd sky130_fd_pr__pfet_01v8 ad=0.6293 pd=4.68 as=0.33495 ps=2.36 w=2.03 l=0.15
X495 a_4119_11933# a_4089_11686# a_4027_11933# vdd sky130_fd_pr__pfet_01v8 ad=0.37455 pd=2.6 as=0.7037 ps=5.16 w=2.27 l=0.15
X496 vdd a_8267_11933# a_6055_12811# vdd sky130_fd_pr__pfet_01v8 ad=0.3465 pd=2.43 as=0.3465 ps=2.43 w=2.1 l=0.15
X497 vss a_11631_6170# vss vss sky130_fd_pr__nfet_01v8_lvt ad=0.1595 pd=1.68 as=0 ps=0 w=0.55 l=0.15
X498 a_4622_11162# a_4119_11933# vdd vdd sky130_fd_pr__pfet_01v8 ad=0.1218 pd=1.42 as=0.1218 ps=1.42 w=0.42 l=0.28
X499 a_2909_11950# a_1987_11933# vss vss sky130_fd_pr__nfet_01v8_lvt ad=0.435 pd=3.58 as=0.435 ps=3.58 w=1.5 l=0.15
X500 vdd a_11631_10050# vdd vdd sky130_fd_pr__pfet_01v8 ad=0.667 pd=5.18 as=0 ps=0 w=2.3 l=0.15
X501 vdd a_16679_11933# a_17221_12720# vdd sky130_fd_pr__pfet_01v8 ad=0.33495 pd=2.36 as=0.33495 ps=2.36 w=2.03 l=0.15
X502 a_23221_12720# a_24971_12720# vdd vdd sky130_fd_pr__pfet_01v8 ad=0.5104 pd=4.1 as=0.5104 ps=4.1 w=1.76 l=0.15
X503 vss a_6055_12811# a_4089_11686# vss sky130_fd_pr__nfet_01v8_lvt ad=0.3255 pd=2.72 as=0.17325 ps=1.38 w=1.05 l=0.15
X504 a_16191_10050# a_15733_1814# a_7971_9376# vss sky130_fd_pr__nfet_01v8_lvt ad=0.145 pd=1.58 as=0.145 ps=1.58 w=0.5 l=0.15
X505 a_6247_8796# b7 a_363_9054# vss sky130_fd_pr__nfet_01v8_lvt ad=0.132 pd=1.13 as=0.248 ps=2.22 w=0.8 l=0.15
X506 a_11215_8270# f2 a_7971_9376# vss sky130_fd_pr__nfet_01v8_lvt ad=0.145 pd=1.58 as=0.145 ps=1.58 w=0.5 l=0.15
X507 a_363_6446# a_3461_1968# a_3087_4276# vdd sky130_fd_pr__pfet_01v8_lvt ad=0.609 pd=4.78 as=0.3045 ps=2.39 w=2.1 l=0.35
X508 a_11215_10050# f3 a_4811_9376# vdd sky130_fd_pr__pfet_01v8_lvt ad=0.261 pd=2.38 as=0.261 ps=2.38 w=0.9 l=0.35
X509 cke0 a_17221_12720# vdd vdd sky130_fd_pr__pfet_01v8 ad=0.4158 pd=2.85 as=0.4158 ps=2.85 w=2.52 l=0.15
X510 a_15981_11939# a_16649_11686# vdd vdd sky130_fd_pr__pfet_01v8 ad=0.5481 pd=4.36 as=0.5481 ps=4.36 w=1.89 l=0.15
X511 a_15775_1650# f7 a_7971_1984# vss sky130_fd_pr__nfet_01v8_lvt ad=0.145 pd=1.58 as=0.145 ps=1.58 w=0.5 l=0.15
X512 a_363_4894# c3 vdd vdd sky130_fd_pr__pfet_01v8_lvt ad=0.2465 pd=1.99 as=0.493 ps=3.98 w=1.7 l=0.35
X513 ckd2 a_4651_12720# vdd vdd sky130_fd_pr__pfet_01v8 ad=0.4158 pd=2.85 as=0.4158 ps=2.85 w=2.52 l=0.15
X514 vdd a_21602_2174# en vdd sky130_fd_pr__pfet_01v8_lvt ad=0.812 pd=6.18 as=0.406 ps=3.09 w=2.8 l=0.35
X515 a_15775_3430# f6 a_4811_1984# vdd sky130_fd_pr__pfet_01v8_lvt ad=0.261 pd=2.38 as=0.261 ps=2.38 w=0.9 l=0.35
X516 a_11631_3750# a_11173_3298# a_7971_4856# vss sky130_fd_pr__nfet_01v8_lvt ad=0.145 pd=1.58 as=0.145 ps=1.58 w=0.5 l=0.15
X517 a_15775_3750# a_15733_3298# a_7971_4856# vdd sky130_fd_pr__pfet_01v8_lvt ad=0.261 pd=2.38 as=0.261 ps=2.38 w=0.9 l=0.35
X518 a_13171_4790# a_11215_5530# vss vss sky130_fd_pr__nfet_01v8_lvt ad=0.1595 pd=1.68 as=0.1595 ps=1.68 w=0.55 l=0.15
X519 vdd a_3087_7364# a_4811_6504# vdd sky130_fd_pr__pfet_01v8 ad=0.363 pd=2.53 as=0.363 ps=2.53 w=2.2 l=0.15
X520 vss a_21768_4674# ep vss sky130_fd_pr__nfet_01v8_lvt ad=0.434 pd=3.42 as=0.231 ps=1.73 w=1.4 l=0.15
X521 a_4089_11686# a_6055_12811# vdd vdd sky130_fd_pr__pfet_01v8 ad=0.36465 pd=2.54 as=0.6851 ps=5.04 w=2.21 l=0.15
X522 a_17182_11162# a_16679_11933# vdd vdd sky130_fd_pr__pfet_01v8 ad=0.1218 pd=1.42 as=0.1218 ps=1.42 w=0.42 l=0.28
X523 a_2938_205# a0 vss vss sky130_fd_pr__nfet_01v8 ad=0.1305 pd=1.48 as=0.1305 ps=1.48 w=0.45 l=0.18
X524 a_11215_1650# a_11173_1814# a_7971_1984# vdd sky130_fd_pr__pfet_01v8_lvt ad=0.261 pd=2.38 as=0.261 ps=2.38 w=0.9 l=0.35
X525 a_6247_2844# b3 a_363_2814# vss sky130_fd_pr__nfet_01v8_lvt ad=0.132 pd=1.13 as=0.248 ps=2.22 w=0.8 l=0.15
X526 a_13911_3430# f4 a_4811_1984# vss sky130_fd_pr__nfet_01v8_lvt ad=0.145 pd=1.58 as=0.145 ps=1.58 w=0.5 l=0.15
X527 a_8935_5530# a_8893_1814# a_7971_4856# vdd sky130_fd_pr__pfet_01v8_lvt ad=0.261 pd=2.38 as=0.261 ps=2.38 w=0.9 l=0.35
X528 a_21768_4674# a_21768_2174# vss sky130_fd_pr__res_high_po_0p35 l=10.5
X529 cke2 a_18971_12720# vdd vdd sky130_fd_pr__pfet_01v8 ad=0.4158 pd=2.85 as=0.4158 ps=2.85 w=2.52 l=0.15
X530 a_10891_1645# a_20664_1816# vss sky130_fd_pr__res_high_po_0p69 l=7.2
X531 a_11631_1650# f3 a_7971_1984# vdd sky130_fd_pr__pfet_01v8_lvt ad=0.261 pd=2.38 as=0.261 ps=2.38 w=0.9 l=0.35
X532 a_10399_11933# a_10902_11162# vdd vdd sky130_fd_pr__pfet_01v8 ad=0.1218 pd=1.42 as=0.1218 ps=1.42 w=0.42 l=0.28
X533 a_10399_11933# a_4089_11686# a_4651_12720# vss sky130_fd_pr__nfet_01v8_lvt ad=0.231 pd=1.73 as=0.434 ps=3.42 w=1.4 l=0.15
X534 a_11631_10050# f3 a_4811_9376# vss sky130_fd_pr__nfet_01v8_lvt ad=0.145 pd=1.58 as=0.145 ps=1.58 w=0.5 l=0.15
X535 a_13495_8270# a_13453_3298# a_7971_9376# vdd sky130_fd_pr__pfet_01v8_lvt ad=0.261 pd=2.38 as=0.261 ps=2.38 w=0.9 l=0.35
X536 a_2909_11950# a_1987_11933# vdd vdd sky130_fd_pr__pfet_01v8 ad=0.651 pd=4.82 as=0.3465 ps=2.43 w=2.1 l=0.15
X537 vdd a_10399_11933# a_4027_11933# vdd sky130_fd_pr__pfet_01v8 ad=0.58905 pd=3.9 as=0.58905 ps=3.9 w=3.57 l=0.15
X538 vss a_13911_6170# vss vss sky130_fd_pr__nfet_01v8_lvt ad=0.1595 pd=1.68 as=0 ps=0 w=0.55 l=0.15
X539 vdd a_13911_10050# vdd vdd sky130_fd_pr__pfet_01v8 ad=0.667 pd=5.18 as=0 ps=0 w=2.3 l=0.15
X540 a_363_2286# a4 a_3087_7364# vss sky130_fd_pr__nfet_01v8_lvt ad=0.248 pd=2.22 as=0.132 ps=1.13 w=0.8 l=0.15
X541 a_11631_7950# a_11173_3298# a_4811_6504# vdd sky130_fd_pr__pfet_01v8_lvt ad=0.261 pd=2.38 as=0.261 ps=2.38 w=0.9 l=0.35
X542 a_8935_6170# a_8893_1814# a_7971_6504# vdd sky130_fd_pr__pfet_01v8_lvt ad=0.261 pd=2.38 as=0.261 ps=2.38 w=0.9 l=0.35
X543 vss a_11631_5530# vss vss sky130_fd_pr__nfet_01v8_lvt ad=0.1595 pd=1.68 as=0 ps=0 w=0.55 l=0.15
X544 a_13911_8270# f4 a_7971_9376# vdd sky130_fd_pr__pfet_01v8_lvt ad=0.261 pd=2.38 as=0.261 ps=2.38 w=0.9 l=0.35
X545 vdd a_1987_11933# a_2909_11950# vdd sky130_fd_pr__pfet_01v8 ad=0.3465 pd=2.43 as=0.3465 ps=2.43 w=2.1 l=0.15
X546 a_1058_11170# a_411_11960# vss vss sky130_fd_pr__nfet_01v8 ad=0.174 pd=1.78 as=0.174 ps=1.78 w=0.6 l=0.18
X547 a_363_4894# b3 a_6247_8796# vss sky130_fd_pr__nfet_01v8_lvt ad=0.248 pd=2.22 as=0.132 ps=1.13 w=0.8 l=0.15
X548 vss a_6247_7364# a_7971_6504# vss sky130_fd_pr__nfet_01v8_lvt ad=0.31 pd=2.62 as=0.165 ps=1.33 w=1 l=0.15
X549 a_13495_3430# a_13453_3298# a_4811_1984# vss sky130_fd_pr__nfet_01v8_lvt ad=0.145 pd=1.58 as=0.145 ps=1.58 w=0.5 l=0.15
X550 a_17731_8265# a_20664_8208# vss sky130_fd_pr__res_high_po_0p69 l=7.2
X551 vdd c0 a_363_2286# vdd sky130_fd_pr__pfet_01v8_lvt ad=0.2465 pd=1.99 as=0.2465 ps=1.99 w=1.7 l=0.35
X552 vdd a_20335_12811# a_16649_11686# vdd sky130_fd_pr__pfet_01v8 ad=0.36465 pd=2.54 as=0.36465 ps=2.54 w=2.21 l=0.15
X553 a_6247_7364# a_6621_1968# a_363_9054# vdd sky130_fd_pr__pfet_01v8_lvt ad=0.3045 pd=2.39 as=0.609 ps=4.78 w=2.1 l=0.35
X554 a_11173_3298# f2 vss vss sky130_fd_pr__nfet_01v8 ad=0.1305 pd=1.48 as=0.1305 ps=1.48 w=0.45 l=0.18
X555 a_7971_4856# a_6247_4276# vss vss sky130_fd_pr__nfet_01v8_lvt ad=0.165 pd=1.33 as=0.31 ps=2.62 w=1 l=0.15
X556 vss a_3087_4276# a_4811_4856# vss sky130_fd_pr__nfet_01v8_lvt ad=0.31 pd=2.62 as=0.165 ps=1.33 w=1 l=0.15
X557 a_11215_7950# a_11173_3298# a_4811_6504# vss sky130_fd_pr__nfet_01v8_lvt ad=0.145 pd=1.58 as=0.145 ps=1.58 w=0.5 l=0.15
X558 a_15451_7210# a_13495_7950# vdd vdd sky130_fd_pr__pfet_01v8 ad=0.667 pd=5.18 as=0.667 ps=5.18 w=2.3 l=0.15
X559 a_9351_3430# f0 a_4811_1984# vss sky130_fd_pr__nfet_01v8_lvt ad=0.145 pd=1.58 as=0.145 ps=1.58 w=0.5 l=0.15
X560 a_8935_8270# f0 a_4811_9376# vdd sky130_fd_pr__pfet_01v8_lvt ad=0.261 pd=2.38 as=0.261 ps=2.38 w=0.9 l=0.35
X561 a_9351_3430# a_8893_3298# a_7971_1984# vss sky130_fd_pr__nfet_01v8_lvt ad=0.145 pd=1.58 as=0.145 ps=1.58 w=0.5 l=0.15
X562 vdd a_3087_8796# a_4811_9376# vdd sky130_fd_pr__pfet_01v8 ad=0.363 pd=2.53 as=0.363 ps=2.53 w=2.2 l=0.15
X563 a_13911_7950# a_13453_3298# a_4811_6504# vdd sky130_fd_pr__pfet_01v8_lvt ad=0.261 pd=2.38 as=0.261 ps=2.38 w=0.9 l=0.35
X564 a_3268_205# a1 vdd vdd sky130_fd_pr__pfet_01v8 ad=0.261 pd=2.38 as=0.261 ps=2.38 w=0.9 l=0.18
X565 vss a_13911_5530# vss vss sky130_fd_pr__nfet_01v8_lvt ad=0.1595 pd=1.68 as=0 ps=0 w=0.55 l=0.15
X566 cke3 cke1 vss vss sky130_fd_pr__nfet_01v8_lvt ad=0.1305 pd=1.48 as=0.1305 ps=1.48 w=0.45 l=0.15
X567 a_16191_8270# f6 a_7971_9376# vdd sky130_fd_pr__pfet_01v8_lvt ad=0.261 pd=2.38 as=0.261 ps=2.38 w=0.9 l=0.35
X568 a_7971_1984# a_6247_2844# vdd vdd sky130_fd_pr__pfet_01v8 ad=0.363 pd=2.53 as=0.363 ps=2.53 w=2.2 l=0.15
X569 a_15981_11939# a_15469_11950# vss vss sky130_fd_pr__nfet_01v8_lvt ad=0.17325 pd=1.38 as=0.3255 ps=2.72 w=1.05 l=0.15
X570 a_3087_4276# a_2938_205# a_363_4366# vdd sky130_fd_pr__pfet_01v8_lvt ad=0.3045 pd=2.39 as=0.609 ps=4.78 w=2.1 l=0.35
X571 a_10891_7210# a_8935_7950# vss vss sky130_fd_pr__nfet_01v8_lvt ad=0.1595 pd=1.68 as=0.1595 ps=1.68 w=0.55 l=0.15
X572 a_363_4366# a0 a_3087_4276# vss sky130_fd_pr__nfet_01v8_lvt ad=0.248 pd=2.22 as=0.132 ps=1.13 w=0.8 l=0.15
X573 vdd a_5719_11933# ckd3 vdd sky130_fd_pr__pfet_01v8 ad=0.4158 pd=2.85 as=0.4158 ps=2.85 w=2.52 l=0.15
X574 a_8935_8270# f0 a_7971_9376# vss sky130_fd_pr__nfet_01v8_lvt ad=0.145 pd=1.58 as=0.145 ps=1.58 w=0.5 l=0.15
X575 a_3901_1968# a4 vdd vdd sky130_fd_pr__pfet_01v8 ad=0.261 pd=2.38 as=0.261 ps=2.38 w=0.9 l=0.18
X576 a_8267_11933# a_411_11960# dn vdd sky130_fd_pr__pfet_01v8_lvt ad=0.6583 pd=5.12 as=0.32915 ps=2.56 w=2.27 l=0.35
X577 a_363_6446# c4 vss vss sky130_fd_pr__nfet_01v8_lvt ad=0.493 pd=3.98 as=0.493 ps=3.98 w=1.7 l=0.15
X578 a_20827_11933# rst_n vdd vdd sky130_fd_pr__pfet_01v8 ad=0.464 pd=3.78 as=0.464 ps=3.78 w=1.6 l=0.18
X579 a_13495_6170# f5 a_7971_6504# vss sky130_fd_pr__nfet_01v8_lvt ad=0.145 pd=1.58 as=0.145 ps=1.58 w=0.5 l=0.15
X580 a_15733_1814# f7 vdd vdd sky130_fd_pr__pfet_01v8 ad=0.261 pd=2.38 as=0.261 ps=2.38 w=0.9 l=0.18
X581 a_13495_7950# f4 a_4811_6504# vdd sky130_fd_pr__pfet_01v8_lvt ad=0.261 pd=2.38 as=0.261 ps=2.38 w=0.9 l=0.35
X582 a_15451_2690# a_13495_3430# vss vss sky130_fd_pr__nfet_01v8_lvt ad=0.1595 pd=1.68 as=0.1595 ps=1.68 w=0.55 l=0.15
X583 a_15775_5530# a_15733_1814# a_7971_4856# vdd sky130_fd_pr__pfet_01v8_lvt ad=0.261 pd=2.38 as=0.261 ps=2.38 w=0.9 l=0.35
X584 a_3087_7364# a6 a_363_4366# vss sky130_fd_pr__nfet_01v8_lvt ad=0.132 pd=1.13 as=0.248 ps=2.22 w=0.8 l=0.15
X585 a_13911_6170# a_13453_1814# a_7971_6504# vss sky130_fd_pr__nfet_01v8_lvt ad=0.145 pd=1.58 as=0.145 ps=1.58 w=0.5 l=0.15
X586 a_5248_205# a7 vdd vdd sky130_fd_pr__pfet_01v8 ad=0.261 pd=2.38 as=0.261 ps=2.38 w=0.9 l=0.18
X587 vdd a_6247_4276# a_7971_4856# vdd sky130_fd_pr__pfet_01v8 ad=0.363 pd=2.53 as=0.363 ps=2.53 w=2.2 l=0.15
X588 a_10399_11933# a_1418_11110# vss vss sky130_fd_pr__nfet_01v8 ad=0.29 pd=2.58 as=0.29 ps=2.58 w=1 l=0.18
X589 a_13911_10050# f5 a_4811_9376# vss sky130_fd_pr__nfet_01v8_lvt ad=0.145 pd=1.58 as=0.145 ps=1.58 w=0.5 l=0.15
X590 a_6247_8796# a_6621_1968# a_363_4894# vdd sky130_fd_pr__pfet_01v8_lvt ad=0.3045 pd=2.39 as=0.609 ps=4.78 w=2.1 l=0.35
X591 a_6247_4276# a_7501_1968# a_363_2814# vdd sky130_fd_pr__pfet_01v8_lvt ad=0.3045 pd=2.39 as=0.609 ps=4.78 w=2.1 l=0.35
X592 a_4622_11162# a_4119_11933# vss vss sky130_fd_pr__nfet_01v8 ad=0.1218 pd=1.42 as=0.1218 ps=1.42 w=0.42 l=0.28
X593 a_2901_12720# a_15981_11939# a_17182_11162# vss sky130_fd_pr__nfet_01v8_lvt ad=0.231 pd=1.73 as=0.434 ps=3.42 w=1.4 l=0.15
X594 a_11215_3430# a_11173_3298# a_7971_1984# vdd sky130_fd_pr__pfet_01v8_lvt ad=0.261 pd=2.38 as=0.261 ps=2.38 w=0.9 l=0.35
X595 a_4811_4856# a_3087_4276# vdd vdd sky130_fd_pr__pfet_01v8 ad=0.363 pd=2.53 as=0.363 ps=2.53 w=2.2 l=0.15
X596 a_363_2814# b7 a_6247_4276# vss sky130_fd_pr__nfet_01v8_lvt ad=0.248 pd=2.22 as=0.132 ps=1.13 w=0.8 l=0.15
X597 vdd a_21768_2174# a_21768_4674# vdd sky130_fd_pr__pfet_01v8_lvt ad=0.5365 pd=4.28 as=0.26825 ps=2.14 w=1.85 l=0.35
X598 a_11631_3430# f2 a_7971_1984# vdd sky130_fd_pr__pfet_01v8_lvt ad=0.261 pd=2.38 as=0.261 ps=2.38 w=0.9 l=0.35
X599 a_13171_7210# a_11215_7950# vss vss sky130_fd_pr__nfet_01v8_lvt ad=0.1595 pd=1.68 as=0.1595 ps=1.68 w=0.55 l=0.15
X600 a_9351_7950# f0 a_7971_6504# vdd sky130_fd_pr__pfet_01v8_lvt ad=0.261 pd=2.38 as=0.261 ps=2.38 w=0.9 l=0.35
X601 vdd a_6247_7364# a_7971_6504# vdd sky130_fd_pr__pfet_01v8 ad=0.682 pd=5.02 as=0.363 ps=2.53 w=2.2 l=0.15
X602 a_15775_6170# a_15733_1814# a_7971_6504# vdd sky130_fd_pr__pfet_01v8_lvt ad=0.261 pd=2.38 as=0.261 ps=2.38 w=0.9 l=0.35
X603 a_3087_2844# a_3461_1968# a_363_2286# vdd sky130_fd_pr__pfet_01v8_lvt ad=0.3045 pd=2.39 as=0.609 ps=4.78 w=2.1 l=0.35
X604 en a_21602_2174# vss vss sky130_fd_pr__nfet_01v8_lvt ad=0.231 pd=1.73 as=0.434 ps=3.42 w=1.4 l=0.15
X605 vdd a_16191_7950# vdd vdd sky130_fd_pr__pfet_01v8 ad=0.667 pd=5.18 as=0 ps=0 w=2.3 l=0.15
X606 a_17182_11162# a_16679_11933# vss vss sky130_fd_pr__nfet_01v8 ad=0.1218 pd=1.42 as=0.1218 ps=1.42 w=0.42 l=0.28
X607 a_3268_205# a1 vss vss sky130_fd_pr__nfet_01v8 ad=0.1305 pd=1.48 as=0.1305 ps=1.48 w=0.45 l=0.18
X608 a_8935_1650# a_8893_1814# a_4811_1984# vss sky130_fd_pr__nfet_01v8_lvt ad=0.145 pd=1.58 as=0.145 ps=1.58 w=0.5 l=0.15
X609 a_13495_5530# f5 a_7971_4856# vss sky130_fd_pr__nfet_01v8_lvt ad=0.145 pd=1.58 as=0.145 ps=1.58 w=0.5 l=0.15
X610 a_4027_11933# a_4089_11686# a_4119_11933# vdd sky130_fd_pr__pfet_01v8 ad=0.37455 pd=2.6 as=0.37455 ps=2.6 w=2.27 l=0.15
X611 a_6055_12811# a_8267_11933# vdd vdd sky130_fd_pr__pfet_01v8 ad=0.651 pd=4.82 as=0.3465 ps=2.43 w=2.1 l=0.15
X612 cke0 a_17221_12720# vss vss sky130_fd_pr__nfet_01v8_lvt ad=0.198 pd=1.53 as=0.372 ps=3.02 w=1.2 l=0.15
X613 a_10399_11933# a_10902_11162# vss vss sky130_fd_pr__nfet_01v8 ad=0.1218 pd=1.42 as=0.1218 ps=1.42 w=0.42 l=0.28
X614 a_16191_6170# a_15733_1814# a_7971_6504# vss sky130_fd_pr__nfet_01v8_lvt ad=0.145 pd=1.58 as=0.145 ps=1.58 w=0.5 l=0.15
X615 ckd2 a_4651_12720# vss vss sky130_fd_pr__nfet_01v8_lvt ad=0.198 pd=1.53 as=0.372 ps=3.02 w=1.2 l=0.15
X616 vdd a_10902_11162# a_5719_11933# vdd sky130_fd_pr__pfet_01v8 ad=1.1067 pd=7.76 as=0.58905 ps=3.9 w=3.57 l=0.15
X617 vss a_11631_7950# vss vss sky130_fd_pr__nfet_01v8_lvt ad=0.1595 pd=1.68 as=0 ps=0 w=0.55 l=0.15
X618 a_363_8526# a2 a_3087_7364# vss sky130_fd_pr__nfet_01v8_lvt ad=0.248 pd=2.22 as=0.132 ps=1.13 w=0.8 l=0.15
X619 a_363_6446# a6 a_3087_2844# vss sky130_fd_pr__nfet_01v8_lvt ad=0.248 pd=2.22 as=0.132 ps=1.13 w=0.8 l=0.15
X620 a_13911_5530# a_13453_1814# a_7971_4856# vss sky130_fd_pr__nfet_01v8_lvt ad=0.145 pd=1.58 as=0.145 ps=1.58 w=0.5 l=0.15
X621 a_3901_1968# a4 vss vss sky130_fd_pr__nfet_01v8 ad=0.1305 pd=1.48 as=0.1305 ps=1.48 w=0.45 l=0.18
X622 a_3087_4276# a2 a_363_6446# vss sky130_fd_pr__nfet_01v8_lvt ad=0.132 pd=1.13 as=0.248 ps=2.22 w=0.8 l=0.15
X623 cke2 a_18971_12720# vss vss sky130_fd_pr__nfet_01v8_lvt ad=0.198 pd=1.53 as=0.372 ps=3.02 w=1.2 l=0.15
X624 a_15733_1814# f7 vss vss sky130_fd_pr__nfet_01v8 ad=0.1305 pd=1.48 as=0.1305 ps=1.48 w=0.45 l=0.18
X625 vss a_9351_3750# vss vss sky130_fd_pr__nfet_01v8_lvt ad=0.1595 pd=1.68 as=0 ps=0 w=0.55 l=0.15
X626 a_11631_10050# a_11173_1814# a_7971_9376# vss sky130_fd_pr__nfet_01v8_lvt ad=0.145 pd=1.58 as=0.145 ps=1.58 w=0.5 l=0.15
X627 vdd a_9351_3430# vdd vdd sky130_fd_pr__pfet_01v8 ad=0.667 pd=5.18 as=0 ps=0 w=2.3 l=0.15
X628 ckd2 ckd0 vdd vdd sky130_fd_pr__pfet_01v8 ad=0.5481 pd=4.36 as=0.5481 ps=4.36 w=1.89 l=0.15
X629 a_363_4366# a_3901_1968# a_3087_2844# vdd sky130_fd_pr__pfet_01v8_lvt ad=0.609 pd=4.78 as=0.3045 ps=2.39 w=2.1 l=0.35
X630 vss a_16191_3430# vss vss sky130_fd_pr__nfet_01v8_lvt ad=0.1595 pd=1.68 as=0 ps=0 w=0.55 l=0.15
X631 a_5248_205# a7 vss vss sky130_fd_pr__nfet_01v8 ad=0.1305 pd=1.48 as=0.1305 ps=1.48 w=0.45 l=0.18
X632 a_4651_12720# a_4089_11686# a_10399_11933# vss sky130_fd_pr__nfet_01v8_lvt ad=0.434 pd=3.42 as=0.231 ps=1.73 w=1.4 l=0.15
X633 vdd c7 a_363_9054# vdd sky130_fd_pr__pfet_01v8_lvt ad=0.493 pd=3.98 as=0.2465 ps=1.99 w=1.7 l=0.35
X634 vdd c3 a_363_4894# vdd sky130_fd_pr__pfet_01v8_lvt ad=0.2465 pd=1.99 as=0.2465 ps=1.99 w=1.7 l=0.35
X635 a_4027_11933# a_10399_11933# vdd vdd sky130_fd_pr__pfet_01v8 ad=0.58905 pd=3.9 as=0.58905 ps=3.9 w=3.57 l=0.15
X636 vdd a_6247_8796# a_7971_9376# vdd sky130_fd_pr__pfet_01v8 ad=0.682 pd=5.02 as=0.363 ps=2.53 w=2.2 l=0.15
X637 vdd a_9351_8270# vdd vdd sky130_fd_pr__pfet_01v8 ad=0.667 pd=5.18 as=0 ps=0 w=2.3 l=0.15
X638 a_16191_5530# a_15733_1814# a_7971_4856# vss sky130_fd_pr__nfet_01v8_lvt ad=0.145 pd=1.58 as=0.145 ps=1.58 w=0.5 l=0.15
X639 vss a_13911_7950# vss vss sky130_fd_pr__nfet_01v8_lvt ad=0.1595 pd=1.68 as=0 ps=0 w=0.55 l=0.15
X640 a_10891_2690# a_20664_1816# vss sky130_fd_pr__res_high_po_0p69 l=7.2
X641 vdd c1 a_363_2814# vdd sky130_fd_pr__pfet_01v8_lvt ad=0.493 pd=3.98 as=0.2465 ps=1.99 w=1.7 l=0.35
X642 a_10891_3745# a_8935_3750# vdd vdd sky130_fd_pr__pfet_01v8 ad=0.667 pd=5.18 as=0.667 ps=5.18 w=2.3 l=0.15
X643 a_13495_10050# a_13453_1814# a_7971_9376# vdd sky130_fd_pr__pfet_01v8_lvt ad=0.261 pd=2.38 as=0.261 ps=2.38 w=0.9 l=0.35
X644 a_11631_6170# a_11173_1814# a_7971_6504# vss sky130_fd_pr__nfet_01v8_lvt ad=0.145 pd=1.58 as=0.145 ps=1.58 w=0.5 l=0.15
X645 vdd a_3087_2844# a_4811_1984# vdd sky130_fd_pr__pfet_01v8 ad=0.682 pd=5.02 as=0.363 ps=2.53 w=2.2 l=0.15
X646 a_9351_3750# a_8893_3298# a_4811_4856# vdd sky130_fd_pr__pfet_01v8_lvt ad=0.261 pd=2.38 as=0.261 ps=2.38 w=0.9 l=0.35
X647 a_13453_3298# f4 vdd vdd sky130_fd_pr__pfet_01v8 ad=0.261 pd=2.38 as=0.261 ps=2.38 w=0.9 l=0.18
X648 a_20664_6336# vss sky130_fd_pr__cap_mim_m3_1 l=3.1 w=3.1
X649 a_1418_11110# a_1058_11170# vss vss sky130_fd_pr__nfet_01v8 ad=0.348 pd=2.98 as=0.348 ps=2.98 w=1.2 l=0.18
X650 a_16649_11686# a_20335_12811# vdd vdd sky130_fd_pr__pfet_01v8 ad=0.36465 pd=2.54 as=0.36465 ps=2.54 w=2.21 l=0.15
X651 a_8935_7950# a_8893_3298# a_7971_6504# vdd sky130_fd_pr__pfet_01v8_lvt ad=0.261 pd=2.38 as=0.261 ps=2.38 w=0.9 l=0.35
X652 a_13911_10050# f5 a_7971_9376# vdd sky130_fd_pr__pfet_01v8_lvt ad=0.261 pd=2.38 as=0.261 ps=2.38 w=0.9 l=0.35
X653 a_363_2286# c0 vdd vdd sky130_fd_pr__pfet_01v8_lvt ad=0.2465 pd=1.99 as=0.2465 ps=1.99 w=1.7 l=0.35
X654 a_363_9054# a_6621_1968# a_6247_7364# vdd sky130_fd_pr__pfet_01v8_lvt ad=0.609 pd=4.78 as=0.3045 ps=2.39 w=2.1 l=0.35
X655 a_363_4366# c2 vdd vdd sky130_fd_pr__pfet_01v8_lvt ad=0.2465 pd=1.99 as=0.493 ps=3.98 w=1.7 l=0.35
X656 en a_21602_2174# vdd vdd sky130_fd_pr__pfet_01v8_lvt ad=0.406 pd=3.09 as=0.812 ps=6.18 w=2.8 l=0.35
X657 a_22959_11933# a_23462_11162# vdd vdd sky130_fd_pr__pfet_01v8 ad=0.1218 pd=1.42 as=0.1218 ps=1.42 w=0.42 l=0.28
X658 a_15451_8265# a_20664_8208# vss sky130_fd_pr__res_high_po_0p69 l=7.2
X659 a_3087_2844# a4 a_363_4366# vss sky130_fd_pr__nfet_01v8_lvt ad=0.132 pd=1.13 as=0.248 ps=2.22 w=0.8 l=0.15
X660 cke1 cke3 vdd vdd sky130_fd_pr__pfet_01v8 ad=0.5481 pd=4.36 as=0.5481 ps=4.36 w=1.89 l=0.15
X661 a_16679_11933# a_1418_11110# vss vss sky130_fd_pr__nfet_01v8 ad=0.29 pd=2.58 as=0.29 ps=2.58 w=1 l=0.18
X662 a_15451_4790# a_13495_5530# vdd vdd sky130_fd_pr__pfet_01v8 ad=0.667 pd=5.18 as=0.667 ps=5.18 w=2.3 l=0.15
X663 ckd1 a_4027_11933# vdd vdd sky130_fd_pr__pfet_01v8 ad=0.4158 pd=2.85 as=0.7812 ps=5.66 w=2.52 l=0.15
X664 a_16191_3750# f6 a_4811_4856# vss sky130_fd_pr__nfet_01v8_lvt ad=0.145 pd=1.58 as=0.145 ps=1.58 w=0.5 l=0.15
X665 vdd rst_n a_411_11960# vdd sky130_fd_pr__pfet_01v8 ad=0.62 pd=4.62 as=0.33 ps=2.33 w=2 l=0.15
X666 a_13171_3745# a_11215_3750# vdd vdd sky130_fd_pr__pfet_01v8 ad=0.667 pd=5.18 as=0.667 ps=5.18 w=2.3 l=0.15
X667 a_15469_11950# a_14547_11933# vdd vdd sky130_fd_pr__pfet_01v8 ad=0.3465 pd=2.43 as=0.651 ps=4.82 w=2.1 l=0.15
X668 vss a_15469_11950# a_15981_11939# vss sky130_fd_pr__nfet_01v8_lvt ad=0.3255 pd=2.72 as=0.17325 ps=1.38 w=1.05 l=0.15
X669 a_11631_5530# a_11173_1814# a_7971_4856# vss sky130_fd_pr__nfet_01v8_lvt ad=0.145 pd=1.58 as=0.145 ps=1.58 w=0.5 l=0.15
X670 a_15775_3430# f6 a_7971_1984# vss sky130_fd_pr__nfet_01v8_lvt ad=0.145 pd=1.58 as=0.145 ps=1.58 w=0.5 l=0.15
X671 a_8935_10050# f1 a_4811_9376# vdd sky130_fd_pr__pfet_01v8_lvt ad=0.261 pd=2.38 as=0.261 ps=2.38 w=0.9 l=0.35
X672 ckd3 a_5719_11933# vdd vdd sky130_fd_pr__pfet_01v8 ad=0.4158 pd=2.85 as=0.4158 ps=2.85 w=2.52 l=0.15
X673 a_8267_11933# a_411_11960# dn vdd sky130_fd_pr__pfet_01v8_lvt ad=0.32915 pd=2.56 as=0.6583 ps=5.12 w=2.27 l=0.35
X674 a_363_4366# a_2938_205# a_3087_4276# vdd sky130_fd_pr__pfet_01v8_lvt ad=0.609 pd=4.78 as=0.3045 ps=2.39 w=2.1 l=0.35
X675 a_4651_12720# a_2901_12720# vss vss sky130_fd_pr__nfet_01v8_lvt ad=0.1218 pd=1.42 as=0.1218 ps=1.42 w=0.42 l=0.15
X676 a_16191_10050# f7 a_7971_9376# vdd sky130_fd_pr__pfet_01v8_lvt ad=0.261 pd=2.38 as=0.261 ps=2.38 w=0.9 l=0.35
X677 a_20664_1816# vss sky130_fd_pr__cap_mim_m3_1 l=3.1 w=3.1
X678 a_4027_11933# a_15981_11939# a_23462_11162# vdd sky130_fd_pr__pfet_01v8 ad=0.37455 pd=2.6 as=0.7037 ps=5.16 w=2.27 l=0.15
X679 a_5719_11933# a_3421_11939# a_4622_11162# vss sky130_fd_pr__nfet_01v8_lvt ad=0.231 pd=1.73 as=0.434 ps=3.42 w=1.4 l=0.15
X680 a_13495_7950# f4 a_7971_6504# vss sky130_fd_pr__nfet_01v8_lvt ad=0.145 pd=1.58 as=0.145 ps=1.58 w=0.5 l=0.15
X681 a_3087_7364# a_3901_1968# a_363_2286# vdd sky130_fd_pr__pfet_01v8_lvt ad=0.3045 pd=2.39 as=0.609 ps=4.78 w=2.1 l=0.35
X682 a_6247_2844# b1 a_363_9054# vss sky130_fd_pr__nfet_01v8_lvt ad=0.132 pd=1.13 as=0.248 ps=2.22 w=0.8 l=0.15
X683 a_15775_3750# a_15733_3298# a_4811_4856# vss sky130_fd_pr__nfet_01v8_lvt ad=0.145 pd=1.58 as=0.145 ps=1.58 w=0.5 l=0.15
X684 vdd a_11631_3750# vdd vdd sky130_fd_pr__pfet_01v8 ad=0.667 pd=5.18 as=0 ps=0 w=2.3 l=0.15
X685 a_6247_2844# b5 a_363_4894# vss sky130_fd_pr__nfet_01v8_lvt ad=0.132 pd=1.13 as=0.248 ps=2.22 w=0.8 l=0.15
X686 a_4089_11686# a_3421_11939# vdd vdd sky130_fd_pr__pfet_01v8 ad=0.5481 pd=4.36 as=0.5481 ps=4.36 w=1.89 l=0.15
X687 a_17182_11162# a_15981_11939# a_2901_12720# vss sky130_fd_pr__nfet_01v8_lvt ad=0.434 pd=3.42 as=0.231 ps=1.73 w=1.4 l=0.15
X688 a_13911_7950# a_13453_3298# a_7971_6504# vss sky130_fd_pr__nfet_01v8_lvt ad=0.145 pd=1.58 as=0.145 ps=1.58 w=0.5 l=0.15
X689 a_13453_3298# f4 vss vss sky130_fd_pr__nfet_01v8 ad=0.1305 pd=1.48 as=0.1305 ps=1.48 w=0.45 l=0.18
X690 a_11215_1650# a_11173_1814# a_4811_1984# vss sky130_fd_pr__nfet_01v8_lvt ad=0.145 pd=1.58 as=0.145 ps=1.58 w=0.5 l=0.15
X691 a_11215_3750# f2 a_4811_4856# vdd sky130_fd_pr__pfet_01v8_lvt ad=0.261 pd=2.38 as=0.261 ps=2.38 w=0.9 l=0.35
X692 a_21602_6694# a_21602_9194# vdd vdd sky130_fd_pr__pfet_01v8_lvt ad=0.26825 pd=2.14 as=0.26825 ps=2.14 w=1.85 l=0.35
X693 a_363_2814# a_7501_1968# a_6247_4276# vdd sky130_fd_pr__pfet_01v8_lvt ad=0.609 pd=4.78 as=0.3045 ps=2.39 w=2.1 l=0.35
X694 a_363_4894# a_6621_1968# a_6247_8796# vdd sky130_fd_pr__pfet_01v8_lvt ad=0.609 pd=4.78 as=0.3045 ps=2.39 w=2.1 l=0.35
X695 ckd1 ckd3 vss vss sky130_fd_pr__nfet_01v8_lvt ad=0.1305 pd=1.48 as=0.1305 ps=1.48 w=0.45 l=0.15
X696 vdd a_23221_12720# cke1 vdd sky130_fd_pr__pfet_01v8 ad=0.4158 pd=2.85 as=0.4158 ps=2.85 w=2.52 l=0.15
X697 a_9351_10050# f1 a_4811_9376# vss sky130_fd_pr__nfet_01v8_lvt ad=0.145 pd=1.58 as=0.145 ps=1.58 w=0.5 l=0.15
X698 a_11631_8270# f2 a_4811_9376# vss sky130_fd_pr__nfet_01v8_lvt ad=0.145 pd=1.58 as=0.145 ps=1.58 w=0.5 l=0.15
X699 ckd3 ckd1 vdd vdd sky130_fd_pr__pfet_01v8 ad=0.5481 pd=4.36 as=0.5481 ps=4.36 w=1.89 l=0.15
X700 a_17731_6165# a_20664_6336# vss sky130_fd_pr__res_high_po_0p69 l=7.2
X701 a_411_11960# rst_n vss vss sky130_fd_pr__nfet_01v8_lvt ad=0.165 pd=1.33 as=0.31 ps=2.62 w=1 l=0.15
X702 a_363_2814# b1 a_6247_8796# vss sky130_fd_pr__nfet_01v8_lvt ad=0.248 pd=2.22 as=0.132 ps=1.13 w=0.8 l=0.15
X703 a_10891_1645# a_8935_1650# vss vss sky130_fd_pr__nfet_01v8_lvt ad=0.1595 pd=1.68 as=0.1595 ps=1.68 w=0.55 l=0.15
X704 a_363_2286# a_3461_1968# a_3087_2844# vdd sky130_fd_pr__pfet_01v8_lvt ad=0.609 pd=4.78 as=0.3045 ps=2.39 w=2.1 l=0.35
X705 vdd a_16191_5530# vdd vdd sky130_fd_pr__pfet_01v8 ad=0.667 pd=5.18 as=0 ps=0 w=2.3 l=0.15
X706 a_363_6974# b5 a_6247_8796# vss sky130_fd_pr__nfet_01v8_lvt ad=0.248 pd=2.22 as=0.132 ps=1.13 w=0.8 l=0.15
X707 vdd a_24971_12720# cke3 vdd sky130_fd_pr__pfet_01v8 ad=0.4158 pd=2.85 as=0.4158 ps=2.85 w=2.52 l=0.15
X708 a_15775_7950# a_15733_3298# a_7971_6504# vdd sky130_fd_pr__pfet_01v8_lvt ad=0.261 pd=2.38 as=0.261 ps=2.38 w=0.9 l=0.35
X709 a_11631_1650# a_11173_1814# a_4811_1984# vdd sky130_fd_pr__pfet_01v8_lvt ad=0.261 pd=2.38 as=0.261 ps=2.38 w=0.9 l=0.35
X710 vdd a_13911_3750# vdd vdd sky130_fd_pr__pfet_01v8 ad=0.667 pd=5.18 as=0 ps=0 w=2.3 l=0.15
X711 a_4119_11933# a_4089_11686# a_4027_11933# vdd sky130_fd_pr__pfet_01v8 ad=0.7037 pd=5.16 as=0.37455 ps=2.6 w=2.27 l=0.15
X712 a_6247_7364# a_7061_1968# a_363_2814# vdd sky130_fd_pr__pfet_01v8_lvt ad=0.3045 pd=2.39 as=0.609 ps=4.78 w=2.1 l=0.35
X713 a_9351_5530# a_8893_1814# a_4811_4856# vdd sky130_fd_pr__pfet_01v8_lvt ad=0.261 pd=2.38 as=0.261 ps=2.38 w=0.9 l=0.35
X714 vss a_17221_12720# cke0 vss sky130_fd_pr__nfet_01v8_lvt ad=0.372 pd=3.02 as=0.198 ps=1.53 w=1.2 l=0.15
X715 dp a_411_11960# a_1987_11933# vdd sky130_fd_pr__pfet_01v8_lvt ad=0.32915 pd=2.56 as=0.32915 ps=2.56 w=2.27 l=0.35
X716 a_363_4894# c3 vss vss sky130_fd_pr__nfet_01v8_lvt ad=0.493 pd=3.98 as=0.493 ps=3.98 w=1.7 l=0.15
X717 vss a_4651_12720# ckd2 vss sky130_fd_pr__nfet_01v8_lvt ad=0.372 pd=3.02 as=0.198 ps=1.53 w=1.2 l=0.15
X718 vdd a_4119_11933# a_2901_12720# vdd sky130_fd_pr__pfet_01v8 ad=1.1067 pd=7.76 as=0.58905 ps=3.9 w=3.57 l=0.15
X719 a_16191_7950# a_15733_3298# a_7971_6504# vss sky130_fd_pr__nfet_01v8_lvt ad=0.145 pd=1.58 as=0.145 ps=1.58 w=0.5 l=0.15
X720 a_10891_6165# a_8935_6170# vdd vdd sky130_fd_pr__pfet_01v8 ad=0.667 pd=5.18 as=0.667 ps=5.18 w=2.3 l=0.15
X721 a_7971_4856# a_6247_4276# vdd vdd sky130_fd_pr__pfet_01v8 ad=0.363 pd=2.53 as=0.682 ps=5.02 w=2.2 l=0.15
X722 vdd c6 a_363_8526# vdd sky130_fd_pr__pfet_01v8_lvt ad=0.493 pd=3.98 as=0.2465 ps=1.99 w=1.7 l=0.35
X723 a_9351_6170# a_8893_1814# a_4811_6504# vdd sky130_fd_pr__pfet_01v8_lvt ad=0.261 pd=2.38 as=0.261 ps=2.38 w=0.9 l=0.35
X724 a_3087_8796# a_3901_1968# a_363_6446# vdd sky130_fd_pr__pfet_01v8_lvt ad=0.3045 pd=2.39 as=0.609 ps=4.78 w=2.1 l=0.35
X725 vss a_18971_12720# cke2 vss sky130_fd_pr__nfet_01v8_lvt ad=0.372 pd=3.02 as=0.198 ps=1.53 w=1.2 l=0.15
X726 a_13911_8270# f4 a_4811_9376# vss sky130_fd_pr__nfet_01v8_lvt ad=0.145 pd=1.58 as=0.145 ps=1.58 w=0.5 l=0.15
X727 a_17731_3745# a_15775_3750# vss vss sky130_fd_pr__nfet_01v8_lvt ad=0.1595 pd=1.68 as=0.1595 ps=1.68 w=0.55 l=0.15
X728 vdd a_21602_6694# dn vdd sky130_fd_pr__pfet_01v8_lvt ad=0.406 pd=3.09 as=0.406 ps=3.09 w=2.8 l=0.35
X729 a_17731_2690# a_15775_3430# vdd vdd sky130_fd_pr__pfet_01v8 ad=0.667 pd=5.18 as=0.667 ps=5.18 w=2.3 l=0.15
X730 a_13171_1645# a_11215_1650# vss vss sky130_fd_pr__nfet_01v8_lvt ad=0.1595 pd=1.68 as=0.1595 ps=1.68 w=0.55 l=0.15
X731 a_15451_1645# a_13495_1650# vdd vdd sky130_fd_pr__pfet_01v8 ad=0.667 pd=5.18 as=0.667 ps=5.18 w=2.3 l=0.15
X732 ep a_21768_4674# vss vss sky130_fd_pr__nfet_01v8_lvt ad=0.231 pd=1.73 as=0.434 ps=3.42 w=1.4 l=0.15
X733 a_13911_1650# a_13453_1814# a_4811_1984# vdd sky130_fd_pr__pfet_01v8_lvt ad=0.261 pd=2.38 as=0.261 ps=2.38 w=0.9 l=0.35
X734 a_4651_12720# a_2901_12720# vdd vdd sky130_fd_pr__pfet_01v8 ad=0.5104 pd=4.1 as=0.5104 ps=4.1 w=1.76 l=0.15
X735 a_21768_9194# a_21768_6694# vdd vdd sky130_fd_pr__pfet_01v8_lvt ad=0.26825 pd=2.14 as=0.5365 ps=4.28 w=1.85 l=0.35
X736 vdd a_21768_4674# ep vdd sky130_fd_pr__pfet_01v8_lvt ad=0.812 pd=6.18 as=0.406 ps=3.09 w=2.8 l=0.35
X737 a_22959_11933# a_23462_11162# vss vss sky130_fd_pr__nfet_01v8 ad=0.1218 pd=1.42 as=0.1218 ps=1.42 w=0.42 l=0.28
X738 a_15469_11950# a_14547_11933# vss vss sky130_fd_pr__nfet_01v8_lvt ad=0.435 pd=3.58 as=0.435 ps=3.58 w=1.5 l=0.15
X739 a_17731_8265# a_15775_8270# vdd vdd sky130_fd_pr__pfet_01v8 ad=0.667 pd=5.18 as=0.667 ps=5.18 w=2.3 l=0.15
X740 a_363_4894# c3 vdd vdd sky130_fd_pr__pfet_01v8_lvt ad=0.2465 pd=1.99 as=0.2465 ps=1.99 w=1.7 l=0.35
X741 a_363_6974# c5 vdd vdd sky130_fd_pr__pfet_01v8_lvt ad=0.2465 pd=1.99 as=0.493 ps=3.98 w=1.7 l=0.35
X742 cke2 cke0 vdd vdd sky130_fd_pr__pfet_01v8 ad=0.5481 pd=4.36 as=0.5481 ps=4.36 w=1.89 l=0.15
X743 a_16191_8270# a_15733_3298# a_4811_9376# vdd sky130_fd_pr__pfet_01v8_lvt ad=0.261 pd=2.38 as=0.261 ps=2.38 w=0.9 l=0.35
X744 a_13171_6165# a_11215_6170# vdd vdd sky130_fd_pr__pfet_01v8 ad=0.667 pd=5.18 as=0.667 ps=5.18 w=2.3 l=0.15
X745 a_17731_9310# a_20664_8208# vss sky130_fd_pr__res_high_po_0p69 l=7.2
X746 a_13495_8270# a_13453_3298# a_4811_9376# vss sky130_fd_pr__nfet_01v8_lvt ad=0.145 pd=1.58 as=0.145 ps=1.58 w=0.5 l=0.15
X747 a_16191_10050# f7 a_4811_9376# vss sky130_fd_pr__nfet_01v8_lvt ad=0.145 pd=1.58 as=0.145 ps=1.58 w=0.5 l=0.15
X748 vss a_9351_6170# vss vss sky130_fd_pr__nfet_01v8_lvt ad=0.1595 pd=1.68 as=0 ps=0 w=0.55 l=0.15
X749 vss a_11631_1650# vss vss sky130_fd_pr__nfet_01v8_lvt ad=0.1595 pd=1.68 as=0 ps=0 w=0.55 l=0.15
X750 vdd a_9351_10050# vdd vdd sky130_fd_pr__pfet_01v8 ad=0.667 pd=5.18 as=0 ps=0 w=2.3 l=0.15
X751 a_11631_7950# a_11173_3298# a_7971_6504# vss sky130_fd_pr__nfet_01v8_lvt ad=0.145 pd=1.58 as=0.145 ps=1.58 w=0.5 l=0.15
X752 a_6247_8796# a_7061_1968# a_363_6974# vdd sky130_fd_pr__pfet_01v8_lvt ad=0.3045 pd=2.39 as=0.609 ps=4.78 w=2.1 l=0.35
X753 a_6247_8796# b3 a_363_4894# vss sky130_fd_pr__nfet_01v8_lvt ad=0.132 pd=1.13 as=0.248 ps=2.22 w=0.8 l=0.15
X754 a_7971_6504# a_6247_7364# vss vss sky130_fd_pr__nfet_01v8_lvt ad=0.165 pd=1.33 as=0.31 ps=2.62 w=1 l=0.15
X755 a_11215_3750# f2 a_7971_4856# vss sky130_fd_pr__nfet_01v8_lvt ad=0.145 pd=1.58 as=0.145 ps=1.58 w=0.5 l=0.15
X756 a_1418_11110# a_1058_11170# vdd vdd sky130_fd_pr__pfet_01v8 ad=0.87 pd=6.58 as=0.87 ps=6.58 w=3 l=0.18
X757 vss a_3087_7364# a_4811_6504# vss sky130_fd_pr__nfet_01v8_lvt ad=0.31 pd=2.62 as=0.165 ps=1.33 w=1 l=0.15
X758 a_13495_1650# f5 a_4811_1984# vdd sky130_fd_pr__pfet_01v8_lvt ad=0.261 pd=2.38 as=0.261 ps=2.38 w=0.9 l=0.35
X759 a_11215_5530# f3 a_4811_4856# vdd sky130_fd_pr__pfet_01v8_lvt ad=0.261 pd=2.38 as=0.261 ps=2.38 w=0.9 l=0.35
X760 a_6398_205# b2 vdd vdd sky130_fd_pr__pfet_01v8 ad=0.261 pd=2.38 as=0.261 ps=2.38 w=0.9 l=0.18
X761 a_8935_3430# a_8893_3298# a_4811_1984# vss sky130_fd_pr__nfet_01v8_lvt ad=0.145 pd=1.58 as=0.145 ps=1.58 w=0.5 l=0.15
X762 a_9351_8270# f0 a_4811_9376# vss sky130_fd_pr__nfet_01v8_lvt ad=0.145 pd=1.58 as=0.145 ps=1.58 w=0.5 l=0.15
X763 a_21602_2174# a_21602_4674# vdd vdd sky130_fd_pr__pfet_01v8_lvt ad=0.26825 pd=2.14 as=0.5365 ps=4.28 w=1.85 l=0.35
X764 a_3087_2844# a_2938_205# a_363_8526# vdd sky130_fd_pr__pfet_01v8_lvt ad=0.3045 pd=2.39 as=0.609 ps=4.78 w=2.1 l=0.35
X765 a_5719_11933# a_16649_11686# a_22959_11933# vss sky130_fd_pr__nfet_01v8_lvt ad=0.434 pd=3.42 as=0.231 ps=1.73 w=1.4 l=0.15
X766 a_9351_8270# a_8893_3298# a_7971_9376# vss sky130_fd_pr__nfet_01v8_lvt ad=0.145 pd=1.58 as=0.145 ps=1.58 w=0.5 l=0.15
X767 vdd a_11631_6170# vdd vdd sky130_fd_pr__pfet_01v8 ad=0.667 pd=5.18 as=0 ps=0 w=2.3 l=0.15
X768 a_15775_8270# f6 a_4811_9376# vdd sky130_fd_pr__pfet_01v8_lvt ad=0.261 pd=2.38 as=0.261 ps=2.38 w=0.9 l=0.35
X769 vdd a_21768_9194# dp vdd sky130_fd_pr__pfet_01v8_lvt ad=0.406 pd=3.09 as=0.406 ps=3.09 w=2.8 l=0.35
X770 a_4811_4856# a_3087_4276# vss vss sky130_fd_pr__nfet_01v8_lvt ad=0.165 pd=1.33 as=0.31 ps=2.62 w=1 l=0.15
X771 ckd3 a_5719_11933# vss vss sky130_fd_pr__nfet_01v8_lvt ad=0.198 pd=1.53 as=0.372 ps=3.02 w=1.2 l=0.15
X772 a_22959_11933# a_16649_11686# a_5719_11933# vss sky130_fd_pr__nfet_01v8_lvt ad=0.231 pd=1.73 as=0.434 ps=3.42 w=1.4 l=0.15
X773 a_11215_6170# f3 a_4811_6504# vdd sky130_fd_pr__pfet_01v8_lvt ad=0.261 pd=2.38 as=0.261 ps=2.38 w=0.9 l=0.35
X774 a_7061_1968# b5 vdd vdd sky130_fd_pr__pfet_01v8 ad=0.261 pd=2.38 as=0.261 ps=2.38 w=0.9 l=0.18
X775 a_10399_11933# a_3421_11939# a_4651_12720# vdd sky130_fd_pr__pfet_01v8 ad=0.37455 pd=2.6 as=0.7037 ps=5.16 w=2.27 l=0.15
X776 vdd a_14547_11933# a_15469_11950# vdd sky130_fd_pr__pfet_01v8 ad=0.3465 pd=2.43 as=0.3465 ps=2.43 w=2.1 l=0.15
X777 a_9351_1650# f1 a_7971_1984# vdd sky130_fd_pr__pfet_01v8_lvt ad=0.261 pd=2.38 as=0.261 ps=2.38 w=0.9 l=0.35
X778 vdd c2 a_363_4366# vdd sky130_fd_pr__pfet_01v8_lvt ad=0.2465 pd=1.99 as=0.2465 ps=1.99 w=1.7 l=0.35
X779 a_10902_11162# a_10399_11933# vdd vdd sky130_fd_pr__pfet_01v8 ad=0.1218 pd=1.42 as=0.1218 ps=1.42 w=0.42 l=0.28
X780 vss a_13911_1650# vss vss sky130_fd_pr__nfet_01v8_lvt ad=0.1595 pd=1.68 as=0 ps=0 w=0.55 l=0.15
X781 a_363_6446# a0 a_3087_7364# vss sky130_fd_pr__nfet_01v8_lvt ad=0.248 pd=2.22 as=0.132 ps=1.13 w=0.8 l=0.15
X782 a_13171_3745# a_20664_3688# vss sky130_fd_pr__res_high_po_0p69 l=7.2
X783 vdd a_16191_1650# vdd vdd sky130_fd_pr__pfet_01v8 ad=0.667 pd=5.18 as=0 ps=0 w=2.3 l=0.15
X784 a_11631_3430# a_11173_3298# a_4811_1984# vdd sky130_fd_pr__pfet_01v8_lvt ad=0.261 pd=2.38 as=0.261 ps=2.38 w=0.9 l=0.35
X785 a_363_4366# a4 a_3087_2844# vss sky130_fd_pr__nfet_01v8_lvt ad=0.248 pd=2.22 as=0.132 ps=1.13 w=0.8 l=0.15
X786 vss a_9351_5530# vss vss sky130_fd_pr__nfet_01v8_lvt ad=0.1595 pd=1.68 as=0 ps=0 w=0.55 l=0.15
X787 vdd a_6247_2844# a_7971_1984# vdd sky130_fd_pr__pfet_01v8 ad=0.363 pd=2.53 as=0.363 ps=2.53 w=2.2 l=0.15
X788 a_6247_2844# a_7501_1968# a_363_6974# vdd sky130_fd_pr__pfet_01v8_lvt ad=0.3045 pd=2.39 as=0.609 ps=4.78 w=2.1 l=0.35
X789 a_23462_11162# a_15981_11939# a_4027_11933# vdd sky130_fd_pr__pfet_01v8 ad=0.37455 pd=2.6 as=0.37455 ps=2.6 w=2.27 l=0.15
X790 a_4811_1984# a_3087_2844# vdd vdd sky130_fd_pr__pfet_01v8 ad=0.363 pd=2.53 as=0.363 ps=2.53 w=2.2 l=0.15
X791 a_18971_12720# a_17182_11162# vdd vdd sky130_fd_pr__pfet_01v8 ad=0.33495 pd=2.36 as=0.6293 ps=4.68 w=2.03 l=0.15
X792 vss a_6247_2844# a_7971_1984# vss sky130_fd_pr__nfet_01v8_lvt ad=0.31 pd=2.62 as=0.165 ps=1.33 w=1 l=0.15
X793 a_3087_4276# a0 a_363_4366# vss sky130_fd_pr__nfet_01v8_lvt ad=0.132 pd=1.13 as=0.248 ps=2.22 w=0.8 l=0.15
X794 vdd a_4622_11162# a_4651_12720# vdd sky130_fd_pr__pfet_01v8 ad=1.1067 pd=7.76 as=0.58905 ps=3.9 w=3.57 l=0.15
X795 a_4622_11162# a_3421_11939# a_5719_11933# vss sky130_fd_pr__nfet_01v8_lvt ad=0.434 pd=3.42 as=0.231 ps=1.73 w=1.4 l=0.15
X796 a_15981_11939# a_15469_11950# vdd vdd sky130_fd_pr__pfet_01v8 ad=0.36465 pd=2.54 as=0.6851 ps=5.04 w=2.21 l=0.15
X797 a_15451_8265# a_13495_8270# vss vss sky130_fd_pr__nfet_01v8_lvt ad=0.1595 pd=1.68 as=0.1595 ps=1.68 w=0.55 l=0.15
X798 vdd a_13911_6170# vdd vdd sky130_fd_pr__pfet_01v8 ad=0.667 pd=5.18 as=0 ps=0 w=2.3 l=0.15
X799 dn a_411_11960# a_8267_11933# vdd sky130_fd_pr__pfet_01v8_lvt ad=0.32915 pd=2.56 as=0.32915 ps=2.56 w=2.27 l=0.35
X800 a_17221_12720# a_16679_11933# vss vss sky130_fd_pr__nfet_01v8_lvt ad=0.4205 pd=3.48 as=0.4205 ps=3.48 w=1.45 l=0.15
X801 a_23221_12720# a_22959_11933# vdd vdd sky130_fd_pr__pfet_01v8 ad=0.33495 pd=2.36 as=0.6293 ps=4.68 w=2.03 l=0.15
X802 a_15733_3298# f6 vdd vdd sky130_fd_pr__pfet_01v8 ad=0.261 pd=2.38 as=0.261 ps=2.38 w=0.9 l=0.18
X803 vdd a_2909_11950# a_3421_11939# vdd sky130_fd_pr__pfet_01v8 ad=0.36465 pd=2.54 as=0.36465 ps=2.54 w=2.21 l=0.15
X804 a_16191_6170# f7 a_4811_6504# vss sky130_fd_pr__nfet_01v8_lvt ad=0.145 pd=1.58 as=0.145 ps=1.58 w=0.5 l=0.15
X805 a_21768_6694# a_20664_6336# sky130_fd_pr__cap_mim_m3_1 l=4.1 w=4.1
X806 a_363_4894# b7 a_6247_7364# vss sky130_fd_pr__nfet_01v8_lvt ad=0.248 pd=2.22 as=0.132 ps=1.13 w=0.8 l=0.15
X807 cke1 a_23221_12720# vdd vdd sky130_fd_pr__pfet_01v8 ad=0.4158 pd=2.85 as=0.4158 ps=2.85 w=2.52 l=0.15
X808 vdd a_3087_4276# a_4811_4856# vdd sky130_fd_pr__pfet_01v8 ad=0.363 pd=2.53 as=0.363 ps=2.53 w=2.2 l=0.15
X809 a_6398_205# b2 vss vss sky130_fd_pr__nfet_01v8 ad=0.1305 pd=1.48 as=0.1305 ps=1.48 w=0.45 l=0.18
X810 a_13911_3430# a_13453_3298# a_4811_1984# vdd sky130_fd_pr__pfet_01v8_lvt ad=0.261 pd=2.38 as=0.261 ps=2.38 w=0.9 l=0.35
X811 a_6247_4276# b7 a_363_2814# vss sky130_fd_pr__nfet_01v8_lvt ad=0.132 pd=1.13 as=0.248 ps=2.22 w=0.8 l=0.15
X812 vss rst_n a_411_11960# vss sky130_fd_pr__nfet_01v8_lvt ad=0.31 pd=2.62 as=0.165 ps=1.33 w=1 l=0.15
X813 cke3 a_24971_12720# vdd vdd sky130_fd_pr__pfet_01v8 ad=0.4158 pd=2.85 as=0.4158 ps=2.85 w=2.52 l=0.15
X814 a_15775_6170# a_15733_1814# a_4811_6504# vss sky130_fd_pr__nfet_01v8_lvt ad=0.145 pd=1.58 as=0.145 ps=1.58 w=0.5 l=0.15
X815 a_7061_1968# b5 vss vss sky130_fd_pr__nfet_01v8 ad=0.1305 pd=1.48 as=0.1305 ps=1.48 w=0.45 l=0.18
X816 a_8935_3750# f0 a_7971_4856# vss sky130_fd_pr__nfet_01v8_lvt ad=0.145 pd=1.58 as=0.145 ps=1.58 w=0.5 l=0.15
X817 a_363_6974# a_6068_205# a_6247_7364# vdd sky130_fd_pr__pfet_01v8_lvt ad=0.609 pd=4.78 as=0.3045 ps=2.39 w=2.1 l=0.35
X818 a_15451_6165# a_20664_6336# vss sky130_fd_pr__res_high_po_0p69 l=7.2
X819 a_13495_1650# f5 a_7971_1984# vss sky130_fd_pr__nfet_01v8_lvt ad=0.145 pd=1.58 as=0.145 ps=1.58 w=0.5 l=0.15
X820 a_16191_5530# f7 a_4811_4856# vss sky130_fd_pr__nfet_01v8_lvt ad=0.145 pd=1.58 as=0.145 ps=1.58 w=0.5 l=0.15
X821 a_363_2814# a_7061_1968# a_6247_7364# vdd sky130_fd_pr__pfet_01v8_lvt ad=0.609 pd=4.78 as=0.3045 ps=2.39 w=2.1 l=0.35
X822 a_13495_3430# f4 a_4811_1984# vdd sky130_fd_pr__pfet_01v8_lvt ad=0.261 pd=2.38 as=0.261 ps=2.38 w=0.9 l=0.35
X823 a_13495_3750# a_13453_3298# a_7971_4856# vdd sky130_fd_pr__pfet_01v8_lvt ad=0.261 pd=2.38 as=0.261 ps=2.38 w=0.9 l=0.35
X824 a_21768_2174# a_20664_1816# sky130_fd_pr__cap_mim_m3_1 l=4.1 w=4.1
X825 a_3087_7364# a2 a_363_8526# vss sky130_fd_pr__nfet_01v8_lvt ad=0.132 pd=1.13 as=0.248 ps=2.22 w=0.8 l=0.15
X826 a_8935_1650# a_8893_1814# a_7971_1984# vdd sky130_fd_pr__pfet_01v8_lvt ad=0.261 pd=2.38 as=0.261 ps=2.38 w=0.9 l=0.35
X827 a_3087_2844# a6 a_363_6446# vss sky130_fd_pr__nfet_01v8_lvt ad=0.132 pd=1.13 as=0.248 ps=2.22 w=0.8 l=0.15
X828 a_13911_1650# a_13453_1814# a_7971_1984# vss sky130_fd_pr__nfet_01v8_lvt ad=0.145 pd=1.58 as=0.145 ps=1.58 w=0.5 l=0.15
X829 a_13911_3750# f4 a_7971_4856# vdd sky130_fd_pr__pfet_01v8_lvt ad=0.261 pd=2.38 as=0.261 ps=2.38 w=0.9 l=0.35
X830 a_6247_4276# a_6621_1968# a_363_6974# vdd sky130_fd_pr__pfet_01v8_lvt ad=0.3045 pd=2.39 as=0.609 ps=4.78 w=2.1 l=0.35
X831 vss a_16191_8270# vss vss sky130_fd_pr__nfet_01v8_lvt ad=0.1595 pd=1.68 as=0 ps=0 w=0.55 l=0.15
X832 vdd a_21602_9194# a_21602_6694# vdd sky130_fd_pr__pfet_01v8_lvt ad=0.26825 pd=2.14 as=0.26825 ps=2.14 w=1.85 l=0.35
X833 a_363_6974# b3 a_6247_4276# vss sky130_fd_pr__nfet_01v8_lvt ad=0.248 pd=2.22 as=0.132 ps=1.13 w=0.8 l=0.15
X834 a_6055_12811# a_2909_11950# vss vss sky130_fd_pr__nfet_01v8_lvt ad=0.1305 pd=1.48 as=0.1305 ps=1.48 w=0.45 l=0.15
X835 a_11215_8270# a_11173_3298# a_7971_9376# vdd sky130_fd_pr__pfet_01v8_lvt ad=0.261 pd=2.38 as=0.261 ps=2.38 w=0.9 l=0.35
X836 a_10891_7210# a_8935_7950# vdd vdd sky130_fd_pr__pfet_01v8 ad=0.667 pd=5.18 as=0.667 ps=5.18 w=2.3 l=0.15
X837 a_15733_3298# f6 vss vss sky130_fd_pr__nfet_01v8 ad=0.1305 pd=1.48 as=0.1305 ps=1.48 w=0.45 l=0.18
X838 a_20335_12811# a_15469_11950# vdd vdd sky130_fd_pr__pfet_01v8 ad=0.5481 pd=4.36 as=0.5481 ps=4.36 w=1.89 l=0.15
X839 a_9351_3430# f0 a_7971_1984# vdd sky130_fd_pr__pfet_01v8_lvt ad=0.261 pd=2.38 as=0.261 ps=2.38 w=0.9 l=0.35
X840 a_9351_7950# a_8893_3298# a_4811_6504# vdd sky130_fd_pr__pfet_01v8_lvt ad=0.261 pd=2.38 as=0.261 ps=2.38 w=0.9 l=0.35
X841 dn a_21602_6694# vdd vdd sky130_fd_pr__pfet_01v8_lvt ad=0.406 pd=3.09 as=0.406 ps=3.09 w=2.8 l=0.35
X842 a_3421_11939# a_4089_11686# vss vss sky130_fd_pr__nfet_01v8_lvt ad=0.1305 pd=1.48 as=0.1305 ps=1.48 w=0.45 l=0.15
X843 a_2901_12720# a_4089_11686# a_10902_11162# vss sky130_fd_pr__nfet_01v8_lvt ad=0.231 pd=1.73 as=0.434 ps=3.42 w=1.4 l=0.15
X844 a_11631_8270# f2 a_7971_9376# vdd sky130_fd_pr__pfet_01v8_lvt ad=0.261 pd=2.38 as=0.261 ps=2.38 w=0.9 l=0.35
X845 a_21602_9194# a_21602_6694# vss sky130_fd_pr__res_high_po_0p35 l=10.5
X846 a_15775_5530# a_15733_1814# a_4811_4856# vss sky130_fd_pr__nfet_01v8_lvt ad=0.145 pd=1.58 as=0.145 ps=1.58 w=0.5 l=0.15
X847 a_14547_11933# a_411_11960# ep vdd sky130_fd_pr__pfet_01v8_lvt ad=0.6583 pd=5.12 as=0.32915 ps=2.56 w=2.27 l=0.35
X848 a_20827_11933# rst_n en vss sky130_fd_pr__nfet_01v8_lvt ad=0.2145 pd=1.63 as=0.403 ps=3.22 w=1.3 l=0.15
X849 a_411_11960# rst_n vdd vdd sky130_fd_pr__pfet_01v8 ad=0.33 pd=2.33 as=0.62 ps=4.62 w=2 l=0.15
X850 a_363_8526# a6 a_3087_8796# vss sky130_fd_pr__nfet_01v8_lvt ad=0.248 pd=2.22 as=0.132 ps=1.13 w=0.8 l=0.15
X851 a_11215_3430# a_11173_3298# a_4811_1984# vss sky130_fd_pr__nfet_01v8_lvt ad=0.145 pd=1.58 as=0.145 ps=1.58 w=0.5 l=0.15
X852 a_8935_3750# f0 a_4811_4856# vdd sky130_fd_pr__pfet_01v8_lvt ad=0.261 pd=2.38 as=0.261 ps=2.38 w=0.9 l=0.35
X853 a_16679_11933# a_16649_11686# a_4651_12720# vdd sky130_fd_pr__pfet_01v8 ad=0.37455 pd=2.6 as=0.7037 ps=5.16 w=2.27 l=0.15
X854 a_363_8526# c6 vss vss sky130_fd_pr__nfet_01v8_lvt ad=0.493 pd=3.98 as=0.493 ps=3.98 w=1.7 l=0.15
X855 a_3087_7364# a_4341_1968# a_363_4366# vdd sky130_fd_pr__pfet_01v8_lvt ad=0.3045 pd=2.39 as=0.609 ps=4.78 w=2.1 l=0.35
X856 a_16191_1650# a_15733_1814# a_7971_1984# vss sky130_fd_pr__nfet_01v8_lvt ad=0.145 pd=1.58 as=0.145 ps=1.58 w=0.5 l=0.15
X857 a_10902_11162# a_10399_11933# vss vss sky130_fd_pr__nfet_01v8 ad=0.1218 pd=1.42 as=0.1218 ps=1.42 w=0.42 l=0.28
X858 a_17731_6165# a_15775_6170# vss vss sky130_fd_pr__nfet_01v8_lvt ad=0.1595 pd=1.68 as=0.1595 ps=1.68 w=0.55 l=0.15
X859 a_363_2286# a2 a_3087_2844# vss sky130_fd_pr__nfet_01v8_lvt ad=0.248 pd=2.22 as=0.132 ps=1.13 w=0.8 l=0.15
X860 a_16191_3750# f6 a_7971_4856# vdd sky130_fd_pr__pfet_01v8_lvt ad=0.261 pd=2.38 as=0.261 ps=2.38 w=0.9 l=0.35
X861 a_17731_9310# a_15775_10050# vdd vdd sky130_fd_pr__pfet_01v8 ad=0.667 pd=5.18 as=0.667 ps=5.18 w=2.3 l=0.15
X862 vss a_9351_7950# vss vss sky130_fd_pr__nfet_01v8_lvt ad=0.1595 pd=1.68 as=0 ps=0 w=0.55 l=0.15
X863 a_24971_12720# a_23462_11162# vdd vdd sky130_fd_pr__pfet_01v8 ad=0.33495 pd=2.36 as=0.6293 ps=4.68 w=2.03 l=0.15
X864 a_363_2814# a_6068_205# a_6247_8796# vdd sky130_fd_pr__pfet_01v8_lvt ad=0.609 pd=4.78 as=0.3045 ps=2.39 w=2.1 l=0.35
X865 a_16191_10050# a_15733_1814# a_4811_9376# vdd sky130_fd_pr__pfet_01v8_lvt ad=0.261 pd=2.38 as=0.261 ps=2.38 w=0.9 l=0.35
X866 vdd c5 a_363_6974# vdd sky130_fd_pr__pfet_01v8_lvt ad=0.2465 pd=1.99 as=0.2465 ps=1.99 w=1.7 l=0.35
X867 a_13171_7210# a_11215_7950# vdd vdd sky130_fd_pr__pfet_01v8 ad=0.667 pd=5.18 as=0.667 ps=5.18 w=2.3 l=0.15
X868 vdd a_17221_12720# cke0 vdd sky130_fd_pr__pfet_01v8 ad=0.7812 pd=5.66 as=0.4158 ps=2.85 w=2.52 l=0.15
X869 a_363_6974# a_7061_1968# a_6247_8796# vdd sky130_fd_pr__pfet_01v8_lvt ad=0.609 pd=4.78 as=0.3045 ps=2.39 w=2.1 l=0.35
X870 a_10891_2690# a_8935_3430# vss vss sky130_fd_pr__nfet_01v8_lvt ad=0.1595 pd=1.68 as=0.1595 ps=1.68 w=0.55 l=0.15
X871 vdd a_4651_12720# ckd2 vdd sky130_fd_pr__pfet_01v8 ad=0.7812 pd=5.66 as=0.4158 ps=2.85 w=2.52 l=0.15
X872 a_8893_1814# f1 vdd vdd sky130_fd_pr__pfet_01v8 ad=0.261 pd=2.38 as=0.261 ps=2.38 w=0.9 l=0.18
X873 a_16649_11686# a_15981_11939# vdd vdd sky130_fd_pr__pfet_01v8 ad=0.5481 pd=4.36 as=0.5481 ps=4.36 w=1.89 l=0.15
X874 vdd a_6055_12811# a_4089_11686# vdd sky130_fd_pr__pfet_01v8 ad=0.36465 pd=2.54 as=0.36465 ps=2.54 w=2.21 l=0.15
X875 a_363_8526# a_2938_205# a_3087_2844# vdd sky130_fd_pr__pfet_01v8_lvt ad=0.609 pd=4.78 as=0.3045 ps=2.39 w=2.1 l=0.35
X876 vss a_5719_11933# ckd3 vss sky130_fd_pr__nfet_01v8_lvt ad=0.372 pd=3.02 as=0.198 ps=1.53 w=1.2 l=0.15
X877 dp a_21768_9194# vdd vdd sky130_fd_pr__pfet_01v8_lvt ad=0.406 pd=3.09 as=0.406 ps=3.09 w=2.8 l=0.35
X878 vdd a_18971_12720# cke2 vdd sky130_fd_pr__pfet_01v8 ad=0.7812 pd=5.66 as=0.4158 ps=2.85 w=2.52 l=0.15
X879 a_15469_11950# a_14547_11933# vdd vdd sky130_fd_pr__pfet_01v8 ad=0.651 pd=4.82 as=0.3465 ps=2.43 w=2.1 l=0.15
X880 a_4651_12720# a_3421_11939# a_10399_11933# vdd sky130_fd_pr__pfet_01v8 ad=0.37455 pd=2.6 as=0.37455 ps=2.6 w=2.27 l=0.15
X881 a_15775_8270# f6 a_7971_9376# vss sky130_fd_pr__nfet_01v8_lvt ad=0.145 pd=1.58 as=0.145 ps=1.58 w=0.5 l=0.15
X882 vdd a_11631_7950# vdd vdd sky130_fd_pr__pfet_01v8 ad=0.667 pd=5.18 as=0 ps=0 w=2.3 l=0.15
X883 vdd a_6247_4276# a_7971_4856# vdd sky130_fd_pr__pfet_01v8 ad=0.682 pd=5.02 as=0.363 ps=2.53 w=2.2 l=0.15
X884 a_15775_10050# f7 a_4811_9376# vdd sky130_fd_pr__pfet_01v8_lvt ad=0.261 pd=2.38 as=0.261 ps=2.38 w=0.9 l=0.35
X885 ep a_21768_4674# vdd vdd sky130_fd_pr__pfet_01v8_lvt ad=0.406 pd=3.09 as=0.812 ps=6.18 w=2.8 l=0.35
X886 cke0 cke2 vss vss sky130_fd_pr__nfet_01v8_lvt ad=0.1305 pd=1.48 as=0.1305 ps=1.48 w=0.45 l=0.15
X887 a_363_4366# c2 vdd vdd sky130_fd_pr__pfet_01v8_lvt ad=0.2465 pd=1.99 as=0.2465 ps=1.99 w=1.7 l=0.35
X888 a_363_6446# c4 vdd vdd sky130_fd_pr__pfet_01v8_lvt ad=0.2465 pd=1.99 as=0.493 ps=3.98 w=1.7 l=0.35
X889 a_11215_6170# f3 a_7971_6504# vss sky130_fd_pr__nfet_01v8_lvt ad=0.145 pd=1.58 as=0.145 ps=1.58 w=0.5 l=0.15
X890 a_17731_4790# a_15775_5530# vss vss sky130_fd_pr__nfet_01v8_lvt ad=0.1595 pd=1.68 as=0.1595 ps=1.68 w=0.55 l=0.15
X891 a_11215_7950# f2 a_4811_6504# vdd sky130_fd_pr__pfet_01v8_lvt ad=0.261 pd=2.38 as=0.261 ps=2.38 w=0.9 l=0.35
X892 vdd a_17182_11162# a_18971_12720# vdd sky130_fd_pr__pfet_01v8 ad=0.33495 pd=2.36 as=0.33495 ps=2.36 w=2.03 l=0.15
X893 a_4027_11933# a_15981_11939# a_23462_11162# vdd sky130_fd_pr__pfet_01v8 ad=0.7037 pd=5.16 as=0.37455 ps=2.6 w=2.27 l=0.15
X894 a_21768_9194# a_21768_6694# vss vss sky130_fd_pr__nfet_01v8_lvt ad=0.5365 pd=4.28 as=0.5365 ps=4.28 w=1.85 l=0.15
X895 a_3461_1968# a2 vdd vdd sky130_fd_pr__pfet_01v8 ad=0.261 pd=2.38 as=0.261 ps=2.38 w=0.9 l=0.18
X896 a_11631_1650# a_11173_1814# a_7971_1984# vss sky130_fd_pr__nfet_01v8_lvt ad=0.145 pd=1.58 as=0.145 ps=1.58 w=0.5 l=0.15
X897 a_15775_1650# a_15733_1814# a_7971_1984# vdd sky130_fd_pr__pfet_01v8_lvt ad=0.261 pd=2.38 as=0.261 ps=2.38 w=0.9 l=0.35
X898 a_13171_2690# a_11215_3430# vss vss sky130_fd_pr__nfet_01v8_lvt ad=0.1595 pd=1.68 as=0.1595 ps=1.68 w=0.55 l=0.15
X899 a_13495_5530# a_13453_1814# a_7971_4856# vdd sky130_fd_pr__pfet_01v8_lvt ad=0.261 pd=2.38 as=0.261 ps=2.38 w=0.9 l=0.35
X900 a_363_6974# a_7501_1968# a_6247_2844# vdd sky130_fd_pr__pfet_01v8_lvt ad=0.609 pd=4.78 as=0.3045 ps=2.39 w=2.1 l=0.35
X901 a_3087_8796# a_4341_1968# a_363_8526# vdd sky130_fd_pr__pfet_01v8_lvt ad=0.3045 pd=2.39 as=0.609 ps=4.78 w=2.1 l=0.35
X902 a_2901_12720# a_4119_11933# vdd vdd sky130_fd_pr__pfet_01v8 ad=0.58905 pd=3.9 as=1.1067 ps=7.76 w=3.57 l=0.15
X903 a_10891_3745# a_20664_3688# vss sky130_fd_pr__res_high_po_0p69 l=7.2
X904 a_8935_3430# a_8893_3298# a_7971_1984# vdd sky130_fd_pr__pfet_01v8_lvt ad=0.261 pd=2.38 as=0.261 ps=2.38 w=0.9 l=0.35
X905 vdd a_22959_11933# a_23221_12720# vdd sky130_fd_pr__pfet_01v8 ad=0.33495 pd=2.36 as=0.33495 ps=2.36 w=2.03 l=0.15
X906 a_3087_8796# a4 a_363_6446# vss sky130_fd_pr__nfet_01v8_lvt ad=0.132 pd=1.13 as=0.248 ps=2.22 w=0.8 l=0.15
X907 a_13911_5530# f5 a_7971_4856# vdd sky130_fd_pr__pfet_01v8_lvt ad=0.261 pd=2.38 as=0.261 ps=2.38 w=0.9 l=0.35
X908 cke1 a_23221_12720# vss vss sky130_fd_pr__nfet_01v8_lvt ad=0.198 pd=1.53 as=0.372 ps=3.02 w=1.2 l=0.15
X909 a_3421_11939# a_2909_11950# vdd vdd sky130_fd_pr__pfet_01v8 ad=0.36465 pd=2.54 as=0.36465 ps=2.54 w=2.21 l=0.15
X910 a_4588_205# a5 vdd vdd sky130_fd_pr__pfet_01v8 ad=0.261 pd=2.38 as=0.261 ps=2.38 w=0.9 l=0.18
X911 ckd0 ckd2 vdd vdd sky130_fd_pr__pfet_01v8 ad=0.5481 pd=4.36 as=0.5481 ps=4.36 w=1.89 l=0.15
X912 a_16191_7950# f6 a_4811_6504# vss sky130_fd_pr__nfet_01v8_lvt ad=0.145 pd=1.58 as=0.145 ps=1.58 w=0.5 l=0.15
X913 a_13495_6170# a_13453_1814# a_7971_6504# vdd sky130_fd_pr__pfet_01v8_lvt ad=0.261 pd=2.38 as=0.261 ps=2.38 w=0.9 l=0.35
X914 a_8267_11933# rst_n vdd vdd sky130_fd_pr__pfet_01v8 ad=0.464 pd=3.78 as=0.464 ps=3.78 w=1.6 l=0.18
X915 a_15451_3745# a_20664_3688# vss sky130_fd_pr__res_high_po_0p69 l=7.2
X916 a_23462_11162# a_22959_11933# vdd vdd sky130_fd_pr__pfet_01v8 ad=0.1218 pd=1.42 as=0.1218 ps=1.42 w=0.42 l=0.28
X917 vdd a_13911_7950# vdd vdd sky130_fd_pr__pfet_01v8 ad=0.667 pd=5.18 as=0 ps=0 w=2.3 l=0.15
X918 vss a_11631_3430# vss vss sky130_fd_pr__nfet_01v8_lvt ad=0.1595 pd=1.68 as=0 ps=0 w=0.55 l=0.15
X919 a_17731_7210# a_20664_6336# vss sky130_fd_pr__res_high_po_0p69 l=7.2
X920 cke3 a_24971_12720# vss vss sky130_fd_pr__nfet_01v8_lvt ad=0.198 pd=1.53 as=0.372 ps=3.02 w=1.2 l=0.15
X921 a_13911_6170# f5 a_7971_6504# vdd sky130_fd_pr__pfet_01v8_lvt ad=0.261 pd=2.38 as=0.261 ps=2.38 w=0.9 l=0.35
X922 a_11215_5530# f3 a_7971_4856# vss sky130_fd_pr__nfet_01v8_lvt ad=0.145 pd=1.58 as=0.145 ps=1.58 w=0.5 l=0.15
X923 a_8893_1814# f1 vss vss sky130_fd_pr__nfet_01v8 ad=0.1305 pd=1.48 as=0.1305 ps=1.48 w=0.45 l=0.18
X924 a_7971_1984# a_6247_2844# vdd vdd sky130_fd_pr__pfet_01v8 ad=0.363 pd=2.53 as=0.682 ps=5.02 w=2.2 l=0.15
X925 a_8935_5530# f1 a_4811_4856# vdd sky130_fd_pr__pfet_01v8_lvt ad=0.261 pd=2.38 as=0.261 ps=2.38 w=0.9 l=0.35
X926 a_6247_8796# b1 a_363_2814# vss sky130_fd_pr__nfet_01v8_lvt ad=0.132 pd=1.13 as=0.248 ps=2.22 w=0.8 l=0.15
X927 a_15775_7950# a_15733_3298# a_4811_6504# vss sky130_fd_pr__nfet_01v8_lvt ad=0.145 pd=1.58 as=0.145 ps=1.58 w=0.5 l=0.15
X928 a_16191_5530# f7 a_7971_4856# vdd sky130_fd_pr__pfet_01v8_lvt ad=0.261 pd=2.38 as=0.261 ps=2.38 w=0.9 l=0.35
X929 a_6247_8796# b5 a_363_6974# vss sky130_fd_pr__nfet_01v8_lvt ad=0.132 pd=1.13 as=0.248 ps=2.22 w=0.8 l=0.15
X930 a_15451_9310# a_20664_8208# vss sky130_fd_pr__res_high_po_0p69 l=7.2
X931 a_11215_10050# f3 a_7971_9376# vss sky130_fd_pr__nfet_01v8_lvt ad=0.145 pd=1.58 as=0.145 ps=1.58 w=0.5 l=0.15
X932 a_5719_11933# a_4089_11686# a_4622_11162# vdd sky130_fd_pr__pfet_01v8 ad=0.37455 pd=2.6 as=0.7037 ps=5.16 w=2.27 l=0.15
X933 a_8935_6170# f1 a_4811_6504# vdd sky130_fd_pr__pfet_01v8_lvt ad=0.261 pd=2.38 as=0.261 ps=2.38 w=0.9 l=0.35
X934 a_3461_1968# a2 vss vss sky130_fd_pr__nfet_01v8 ad=0.1305 pd=1.48 as=0.1305 ps=1.48 w=0.45 l=0.18
X935 vdd a_9351_3750# vdd vdd sky130_fd_pr__pfet_01v8 ad=0.667 pd=5.18 as=0 ps=0 w=2.3 l=0.15
X936 a_17221_12720# a_18971_12720# vss vss sky130_fd_pr__nfet_01v8_lvt ad=0.1218 pd=1.42 as=0.1218 ps=1.42 w=0.42 l=0.15
X937 a_11215_10050# a_11173_1814# a_4811_9376# vss sky130_fd_pr__nfet_01v8_lvt ad=0.145 pd=1.58 as=0.145 ps=1.58 w=0.5 l=0.15
X938 vss a_13911_3430# vss vss sky130_fd_pr__nfet_01v8_lvt ad=0.1595 pd=1.68 as=0 ps=0 w=0.55 l=0.15
X939 a_16191_6170# f7 a_7971_6504# vdd sky130_fd_pr__pfet_01v8_lvt ad=0.261 pd=2.38 as=0.261 ps=2.38 w=0.9 l=0.35
X940 a_21602_6694# a_21602_9194# vss vss sky130_fd_pr__nfet_01v8_lvt ad=0.5365 pd=4.28 as=0.5365 ps=4.28 w=1.85 l=0.15
X941 a_13171_1645# a_20664_1816# vss sky130_fd_pr__res_high_po_0p69 l=7.2
X942 a_363_6974# a_6621_1968# a_6247_4276# vdd sky130_fd_pr__pfet_01v8_lvt ad=0.609 pd=4.78 as=0.3045 ps=2.39 w=2.1 l=0.35
X943 a_8935_6170# f1 a_7971_6504# vss sky130_fd_pr__nfet_01v8_lvt ad=0.145 pd=1.58 as=0.145 ps=1.58 w=0.5 l=0.15
X944 a_4588_205# a5 vss vss sky130_fd_pr__nfet_01v8 ad=0.1305 pd=1.48 as=0.1305 ps=1.48 w=0.45 l=0.18
X945 a_10891_4790# a_8935_5530# vdd vdd sky130_fd_pr__pfet_01v8 ad=0.667 pd=5.18 as=0.667 ps=5.18 w=2.3 l=0.15
X946 a_14547_11933# a_411_11960# ep vdd sky130_fd_pr__pfet_01v8_lvt ad=0.32915 pd=2.56 as=0.6583 ps=5.12 w=2.27 l=0.35
X947 a_10902_11162# a_4089_11686# a_2901_12720# vss sky130_fd_pr__nfet_01v8_lvt ad=0.434 pd=3.42 as=0.231 ps=1.73 w=1.4 l=0.15
X948 a_11631_3750# f2 a_4811_4856# vss sky130_fd_pr__nfet_01v8_lvt ad=0.145 pd=1.58 as=0.145 ps=1.58 w=0.5 l=0.15
X949 a_5719_11933# a_4027_11933# vss vss sky130_fd_pr__nfet_01v8_lvt ad=0.1218 pd=1.42 as=0.1218 ps=1.42 w=0.42 l=0.15
X950 en rst_n a_20827_11933# vss sky130_fd_pr__nfet_01v8_lvt ad=0.403 pd=3.22 as=0.2145 ps=1.63 w=1.3 l=0.15
X951 a_17731_1645# a_20664_1816# vss sky130_fd_pr__res_high_po_0p69 l=7.2
X952 a_2909_11950# a_6055_12811# vdd vdd sky130_fd_pr__pfet_01v8 ad=0.5481 pd=4.36 as=0.5481 ps=4.36 w=1.89 l=0.15
X953 a_11215_10050# a_11173_1814# a_7971_9376# vdd sky130_fd_pr__pfet_01v8_lvt ad=0.261 pd=2.38 as=0.261 ps=2.38 w=0.9 l=0.35
X954 a_4651_12720# a_16649_11686# a_16679_11933# vdd sky130_fd_pr__pfet_01v8 ad=0.37455 pd=2.6 as=0.37455 ps=2.6 w=2.27 l=0.15
X955 a_15775_3430# a_15733_3298# a_7971_1984# vdd sky130_fd_pr__pfet_01v8_lvt ad=0.261 pd=2.38 as=0.261 ps=2.38 w=0.9 l=0.35
X956 a_11631_10050# f3 a_7971_9376# vdd sky130_fd_pr__pfet_01v8_lvt ad=0.261 pd=2.38 as=0.261 ps=2.38 w=0.9 l=0.35
X957 a_6247_7364# a_6068_205# a_363_6974# vdd sky130_fd_pr__pfet_01v8_lvt ad=0.3045 pd=2.39 as=0.609 ps=4.78 w=2.1 l=0.35
X958 a_363_4366# a_4341_1968# a_3087_7364# vdd sky130_fd_pr__pfet_01v8_lvt ad=0.609 pd=4.78 as=0.3045 ps=2.39 w=2.1 l=0.35
X959 a_4651_12720# a_4622_11162# vdd vdd sky130_fd_pr__pfet_01v8 ad=0.58905 pd=3.9 as=1.1067 ps=7.76 w=3.57 l=0.15
X960 a_17731_7210# a_15775_7950# vss vss sky130_fd_pr__nfet_01v8_lvt ad=0.1595 pd=1.68 as=0.1595 ps=1.68 w=0.55 l=0.15
X961 a_20664_8208# vss sky130_fd_pr__cap_mim_m3_1 l=3.1 w=3.1
X962 a_23462_11162# a_1058_11170# vdd vdd sky130_fd_pr__pfet_01v8 ad=0.522 pd=4.18 as=0.522 ps=4.18 w=1.8 l=0.18
X963 vdd a_23462_11162# a_24971_12720# vdd sky130_fd_pr__pfet_01v8 ad=0.33495 pd=2.36 as=0.33495 ps=2.36 w=2.03 l=0.15
X964 a_8935_8270# a_8893_3298# a_4811_9376# vss sky130_fd_pr__nfet_01v8_lvt ad=0.145 pd=1.58 as=0.145 ps=1.58 w=0.5 l=0.15
X965 a_13171_7210# a_20664_6336# vss sky130_fd_pr__res_high_po_0p69 l=7.2
X966 a_21768_9194# a_21768_6694# vdd vdd sky130_fd_pr__pfet_01v8_lvt ad=0.26825 pd=2.14 as=0.26825 ps=2.14 w=1.85 l=0.35
X967 a_2901_12720# a_4119_11933# vss vss sky130_fd_pr__nfet_01v8_lvt ad=0.2805 pd=2.03 as=0.527 ps=4.02 w=1.7 l=0.15
X968 vss a_10902_11162# a_5719_11933# vss sky130_fd_pr__nfet_01v8_lvt ad=0.527 pd=4.02 as=0.2805 ps=2.03 w=1.7 l=0.15
X969 a_13171_4790# a_11215_5530# vdd vdd sky130_fd_pr__pfet_01v8 ad=0.667 pd=5.18 as=0.667 ps=5.18 w=2.3 l=0.15
X970 a_3087_4276# a_3901_1968# a_363_8526# vdd sky130_fd_pr__pfet_01v8_lvt ad=0.3045 pd=2.39 as=0.609 ps=4.78 w=2.1 l=0.35
X971 a_363_6974# c5 vdd vdd sky130_fd_pr__pfet_01v8_lvt ad=0.2465 pd=1.99 as=0.2465 ps=1.99 w=1.7 l=0.35
X972 a_8935_5530# f1 a_7971_4856# vss sky130_fd_pr__nfet_01v8_lvt ad=0.145 pd=1.58 as=0.145 ps=1.58 w=0.5 l=0.15
X973 a_13911_3750# f4 a_4811_4856# vss sky130_fd_pr__nfet_01v8_lvt ad=0.145 pd=1.58 as=0.145 ps=1.58 w=0.5 l=0.15
X974 a_4089_11686# a_6055_12811# vdd vdd sky130_fd_pr__pfet_01v8 ad=0.36465 pd=2.54 as=0.36465 ps=2.54 w=2.21 l=0.15
X975 a_4811_6504# a_3087_7364# vss vss sky130_fd_pr__nfet_01v8_lvt ad=0.165 pd=1.33 as=0.31 ps=2.62 w=1 l=0.15
X976 a_5719_11933# a_10902_11162# vss vss sky130_fd_pr__nfet_01v8_lvt ad=0.2805 pd=2.03 as=0.527 ps=4.02 w=1.7 l=0.15
X977 a_13495_3430# f4 a_7971_1984# vss sky130_fd_pr__nfet_01v8_lvt ad=0.145 pd=1.58 as=0.145 ps=1.58 w=0.5 l=0.15
X978 a_10399_11933# a_3421_11939# a_4651_12720# vdd sky130_fd_pr__pfet_01v8 ad=0.7037 pd=5.16 as=0.37455 ps=2.6 w=2.27 l=0.15
X979 a_21768_4674# a_21768_2174# vdd vdd sky130_fd_pr__pfet_01v8_lvt ad=0.26825 pd=2.14 as=0.5365 ps=4.28 w=1.85 l=0.35
X980 a_13911_3430# a_13453_3298# a_7971_1984# vss sky130_fd_pr__nfet_01v8_lvt ad=0.145 pd=1.58 as=0.145 ps=1.58 w=0.5 l=0.15
X981 vdd a_10399_11933# a_4027_11933# vdd sky130_fd_pr__pfet_01v8 ad=1.1067 pd=7.76 as=0.58905 ps=3.9 w=3.57 l=0.15
X982 a_23462_11162# a_22959_11933# vss vss sky130_fd_pr__nfet_01v8 ad=0.1218 pd=1.42 as=0.1218 ps=1.42 w=0.42 l=0.28
X983 vdd a_11631_5530# vdd vdd sky130_fd_pr__pfet_01v8 ad=0.667 pd=5.18 as=0 ps=0 w=2.3 l=0.15
X984 a_4811_6504# a_3087_7364# vdd vdd sky130_fd_pr__pfet_01v8 ad=0.363 pd=2.53 as=0.682 ps=5.02 w=2.2 l=0.15
X985 a_21602_2174# a_21602_4674# vdd vdd sky130_fd_pr__pfet_01v8_lvt ad=0.26825 pd=2.14 as=0.26825 ps=2.14 w=1.85 l=0.35
X986 a_15469_11950# a_20335_12811# vss vss sky130_fd_pr__nfet_01v8_lvt ad=0.1305 pd=1.48 as=0.1305 ps=1.48 w=0.45 l=0.15
X987 a_18971_12720# a_17182_11162# vdd vdd sky130_fd_pr__pfet_01v8 ad=0.6293 pd=4.68 as=0.33495 ps=2.36 w=2.03 l=0.15
X988 a_11215_7950# f2 a_7971_6504# vss sky130_fd_pr__nfet_01v8_lvt ad=0.145 pd=1.58 as=0.145 ps=1.58 w=0.5 l=0.15
X989 a_13495_3750# a_13453_3298# a_4811_4856# vss sky130_fd_pr__nfet_01v8_lvt ad=0.145 pd=1.58 as=0.145 ps=1.58 w=0.5 l=0.15
X990 a_17221_12720# a_18971_12720# vdd vdd sky130_fd_pr__pfet_01v8 ad=0.5104 pd=4.1 as=0.5104 ps=4.1 w=1.76 l=0.15
X991 a_3087_7364# a0 a_363_6446# vss sky130_fd_pr__nfet_01v8_lvt ad=0.132 pd=1.13 as=0.248 ps=2.22 w=0.8 l=0.15
X992 a_20664_3688# vss sky130_fd_pr__cap_mim_m3_1 l=3.1 w=3.1
X993 vss a_9351_1650# vss vss sky130_fd_pr__nfet_01v8_lvt ad=0.1595 pd=1.68 as=0 ps=0 w=0.55 l=0.15
X994 a_6247_8796# a_6068_205# a_363_2814# vdd sky130_fd_pr__pfet_01v8_lvt ad=0.3045 pd=2.39 as=0.609 ps=4.78 w=2.1 l=0.35
X995 vdd a_3087_2844# a_4811_1984# vdd sky130_fd_pr__pfet_01v8 ad=0.363 pd=2.53 as=0.363 ps=2.53 w=2.2 l=0.15
X996 a_6247_4276# a_7061_1968# a_363_9054# vdd sky130_fd_pr__pfet_01v8_lvt ad=0.3045 pd=2.39 as=0.609 ps=4.78 w=2.1 l=0.35
X997 vdd a_20335_12811# a_16649_11686# vdd sky130_fd_pr__pfet_01v8 ad=0.6851 pd=5.04 as=0.36465 ps=2.54 w=2.21 l=0.15
X998 a_23221_12720# a_22959_11933# vdd vdd sky130_fd_pr__pfet_01v8 ad=0.6293 pd=4.68 as=0.33495 ps=2.36 w=2.03 l=0.15
X999 a_7971_1984# a_6247_2844# vss vss sky130_fd_pr__nfet_01v8_lvt ad=0.165 pd=1.33 as=0.31 ps=2.62 w=1 l=0.15
X1000 a_363_4894# b1 a_6247_4276# vss sky130_fd_pr__nfet_01v8_lvt ad=0.248 pd=2.22 as=0.132 ps=1.13 w=0.8 l=0.15
X1001 vss a_23221_12720# cke1 vss sky130_fd_pr__nfet_01v8_lvt ad=0.372 pd=3.02 as=0.198 ps=1.53 w=1.2 l=0.15
X1002 vdd c4 a_363_6446# vdd sky130_fd_pr__pfet_01v8_lvt ad=0.2465 pd=1.99 as=0.2465 ps=1.99 w=1.7 l=0.35
X1003 a_363_9054# b5 a_6247_4276# vss sky130_fd_pr__nfet_01v8_lvt ad=0.248 pd=2.22 as=0.132 ps=1.13 w=0.8 l=0.15
X1004 a_363_8526# a_4341_1968# a_3087_8796# vdd sky130_fd_pr__pfet_01v8_lvt ad=0.609 pd=4.78 as=0.3045 ps=2.39 w=2.1 l=0.35
X1005 vss a_3087_2844# a_4811_1984# vss sky130_fd_pr__nfet_01v8_lvt ad=0.31 pd=2.62 as=0.165 ps=1.33 w=1 l=0.15
X1006 a_10891_9310# a_8935_10050# vss vss sky130_fd_pr__nfet_01v8_lvt ad=0.1595 pd=1.68 as=0.1595 ps=1.68 w=0.55 l=0.15
X1007 a_9351_3750# f0 a_4811_4856# vss sky130_fd_pr__nfet_01v8_lvt ad=0.145 pd=1.58 as=0.145 ps=1.58 w=0.5 l=0.15
X1008 a_9351_3750# a_8893_3298# a_7971_4856# vss sky130_fd_pr__nfet_01v8_lvt ad=0.145 pd=1.58 as=0.145 ps=1.58 w=0.5 l=0.15
X1009 a_5719_11933# a_4027_11933# vdd vdd sky130_fd_pr__pfet_01v8 ad=0.5104 pd=4.1 as=0.5104 ps=4.1 w=1.76 l=0.15
C0 a_15981_11939# a_16649_11686# 1.16082f
C1 en cke0 0.00342f
C2 b5 a_7058_205# 0.02988f
C3 a_4811_4856# a_7971_6504# 0
C4 ep cke0 0.00141f
C5 a_15469_11950# vdd 1.89194f
C6 a_8935_5530# a_7971_6504# 0.00134f
C7 a_363_4366# a_363_2286# 1.69524f
C8 a_7971_6504# a_9351_5530# 0.00246f
C9 a_4811_6504# a_11631_5530# 0
C10 a_15733_1814# a_13911_10050# 0.00493f
C11 a_6247_8796# a_4119_11933# 0
C12 cke2 dn 0
C13 cke3 dp 0
C14 a_14547_11933# a_4651_12720# 0
C15 a_363_6974# a_8935_3750# 0
C16 f7 vdd 2.59846f
C17 cke1 dp 0
C18 a_4027_11933# a_8267_11933# 0.00133f
C19 a_6247_8796# a_8935_10050# 0.0016f
C20 a_7718_205# b3 0
C21 a_7718_205# b1 0
C22 a_13495_8270# a_15451_9310# 0
C23 a_10891_4790# a_4811_6504# 0.00132f
C24 cke0 dn 0.00213f
C25 a_10891_9310# a_7971_9376# 0.90173f
C26 a_13495_5530# a_15733_3298# 0.00739f
C27 a_7058_205# b3 0.00252f
C28 b5 a_6398_205# 0
C29 a_7058_205# b1 0
C30 a_23221_12720# a_24971_12720# 0.56261f
C31 f5 vdd 2.57958f
C32 rst_n a_11215_10050# 0
C33 a_363_4366# c6 0
C34 a_411_11960# a_1058_11170# 0.24162f
C35 a_20335_12811# a_18971_12720# 0.10032f
C36 f3 vdd 2.62062f
C37 a_363_6974# a_6247_4276# 0.53016f
C38 a_363_4366# b3 0
C39 a_3087_2844# a_3901_1968# 0.27111f
C40 a_13495_5530# a_13453_3298# 0.01768f
C41 a_363_4366# b1 0
C42 a_6247_8796# a_363_2814# 0.40474f
C43 a_2901_12720# a_10891_9310# 0
C44 vdd f1 2.6731f
C45 a_15733_1814# f6 0.83445f
C46 a_363_6974# a_9351_3750# 0
C47 c7 vdd 0.56099f
C48 a_363_4366# a6 0.33012f
C49 cke2 dp 0
C50 cke1 cke3 0.40718f
C51 a_4622_11162# a_4027_11933# 0.00425f
C52 a_4811_6504# a_7971_4856# 0
C53 a_13171_9310# a_5719_11933# 0
C54 a_15733_3298# a_13911_5530# 0.00481f
C55 a_13171_4790# a_15733_3298# 0.05997f
C56 b5 a_5738_205# 0
C57 a_4811_4856# a_4811_6504# 0
C58 a_6398_205# b3 0.02169f
C59 a_6398_205# b1 0.00248f
C60 a_13171_9310# a_13453_1814# 0.29388f
C61 a_13911_10050# a_15775_10050# 0
C62 cke0 dp 0
C63 a_23221_12720# a_4027_11933# 0.32188f
C64 a_363_2814# a_3461_1968# 0.08722f
C65 a_4811_6504# a_9351_5530# 0
C66 a_15451_6165# a_17731_6165# 0.42375f
C67 a_13171_6165# a_17731_6165# 0.0365f
C68 a_13453_3298# a_13911_5530# 0
C69 a_15775_7950# a_20664_6336# 0
C70 a_20664_6336# a_17731_7210# 0.01076f
C71 a_13171_4790# a_13453_3298# 0.069f
C72 a_20664_6336# a_16191_7950# 0
C73 a_363_4894# c0 0
C74 a_4027_11933# a_363_6446# 0
C75 a_14547_11933# a_16679_11933# 0
C76 a_2909_11950# a_3421_11939# 0.50956f
C77 a_11631_10050# vdd 0.3857f
C78 a_17731_6165# a_10891_6165# 0.04259f
C79 a_363_2286# a_2938_205# 0.40716f
C80 a_5248_205# b3 0
C81 a_4588_205# b1 0
C82 a_5248_205# b1 0.00195f
C83 a_15451_7210# a_20664_6336# 0.01304f
C84 a_363_4366# a4 0.36329f
C85 a_7501_1968# a_8935_10050# 0
C86 a_11215_5530# a_13453_3298# 0.00796f
C87 a_363_6974# a_3087_4276# 0.3624f
C88 a_15733_1814# f4 0.00114f
C89 a_4622_11162# a_4119_11933# 1.05205f
C90 b3 a_5738_205# 0
C91 b1 a_5738_205# 0.02089f
C92 a6 a_4588_205# 0.02636f
C93 cke2 cke1 0.55686f
C94 a_15733_3298# a_10891_4790# 0.06306f
C95 a_13453_3298# a_11631_5530# 0.00504f
C96 a_363_4366# a2 0.36005f
C97 a_363_4894# c1 0
C98 c2 a_363_4894# 0.00535f
C99 a_13171_6165# a_15451_6165# 0.86765f
C100 a_15775_6170# a_17731_6165# 0.09703f
C101 a_4811_9376# rst_n 0
C102 a_11215_5530# a_11173_3298# 0.01803f
C103 cke1 cke0 0
C104 a_363_4366# a0 0.37525f
C105 a_10902_11162# a_15469_11950# 0
C106 a_15775_10050# f6 0.00104f
C107 a_13453_3298# a_10891_4790# 0.06306f
C108 a_15451_6165# a_10891_6165# 0.03003f
C109 c3 a_363_4894# 0.31732f
C110 a_7501_1968# a_363_2814# 0.29881f
C111 a_13171_6165# a_10891_6165# 1.33103f
C112 a_11173_3298# a_11631_5530# 0
C113 en ckd0 0.00342f
C114 en ckd3 0.00113f
C115 a_411_11960# a_16649_11686# 0.36215f
C116 a_363_4894# c4 0
C117 a_4027_11933# a_1987_11933# 0
C118 en ckd2 0.00113f
C119 a_11173_1814# rst_n 0
C120 ep ckd0 0.00142f
C121 en ckd1 0.00322f
C122 a_15733_3298# a_7971_4856# 0.42341f
C123 ep ckd3 0
C124 a_4622_11162# a_363_2814# 0
C125 ep ckd2 0
C126 a_20664_6336# a_13171_7210# 0.02433f
C127 ep ckd1 0.00133f
C128 a6 a_2938_205# 0
C129 a_10891_4790# a_11173_3298# 0.07474f
C130 a_6055_12811# a_7971_9376# 0
C131 a4 a_3928_205# 0.03335f
C132 a_4588_205# a2 0
C133 a_15775_6170# a_15451_6165# 0.03954f
C134 a_15733_3298# a_4811_4856# 0.26049f
C135 a_363_4894# c5 0
C136 a_15775_6170# a_13171_6165# 0.04491f
C137 f5 a_10902_11162# 0
C138 a_13453_3298# a_7971_4856# 0.42424f
C139 cke2 cke0 0.40235f
C140 a_3928_205# a2 0.00243f
C141 a0 a_4588_205# 0
C142 en vdd 9.51419f
C143 ckd0 dn 0.00208f
C144 ckd3 dn 0
C145 a_15775_6170# a_10891_6165# 0.20901f
C146 a_10902_11162# f3 0
C147 a_6621_1968# rst_n 0
C148 ep vdd 2.4178f
C149 ckd2 dn 0
C150 ckd1 dn 0.00196f
C151 a_6055_12811# a_2901_12720# 0.09003f
C152 a_4811_9376# a_11215_10050# 0.31586f
C153 a_13453_3298# a_4811_4856# 0.26571f
C154 a_363_2814# a_363_6446# 0.23511f
C155 a_1058_11170# a_5719_11933# 0.42584f
C156 a_4119_11933# a_1987_11933# 0
C157 a_18971_12720# a_20664_8208# 0
C158 a0 a_3928_205# 0
C159 a_14547_11933# a_15451_9310# 0
C160 a_7971_4856# a_11173_3298# 0.42493f
C161 a4 a_2938_205# 0.00175f
C162 a_4341_1968# a_363_9054# 0.23964f
C163 a_16191_6170# a_17731_6165# 0.02054f
C164 a_11173_1814# a_11215_10050# 0.63147f
C165 a_1058_11170# a_13453_1814# 0
C166 a_3268_205# a4 0
C167 a_4811_4856# a_11173_3298# 0.26701f
C168 vdd dn 3.50099f
C169 a_2938_205# a2 1.42459f
C170 a_20664_6336# a_10891_7210# 0.02172f
C171 a_8935_5530# a_11173_3298# 0.00856f
C172 f0 a_363_4894# 0.00122f
C173 a_9351_5530# a_11173_3298# 0.00541f
C174 a_363_4366# c7 0
C175 a_3268_205# a2 0.02295f
C176 a0 a_2938_205# 2.28446f
C177 a_11631_10050# a_10902_11162# 0
C178 ckd0 dp 0.00103f
C179 ckd3 dp 0
C180 a_4027_11933# a_10891_9310# 0
C181 a_363_2814# a_7971_1984# 0.00315f
C182 a_3268_205# a0 0.00156f
C183 a_8893_3298# a_7971_4856# 0.42776f
C184 a_363_2814# a_8935_3430# 0
C185 ckd1 dp 0
C186 ckd2 dp 0
C187 a_15451_6165# a_13495_6170# 0.0933f
C188 a_16191_6170# a_15451_6165# 0.25123f
C189 a_13171_6165# a_13495_6170# 0.05293f
C190 a_13171_6165# a_16191_6170# 0.04404f
C191 ckd0 rst_n 0
C192 ckd3 rst_n 0
C193 a_16191_10050# a_10891_9310# 0.03076f
C194 rst_n ckd2 0
C195 a_8893_3298# a_4811_4856# 0.31277f
C196 a_4651_12720# a_7971_9376# 0.00124f
C197 rst_n ckd1 0
C198 b6 a_6247_2844# 0
C199 b4 a_6247_2844# 0
C200 a_1418_11110# a_9351_10050# 0
C201 a_8893_3298# a_8935_5530# 0.0191f
C202 a_13495_6170# a_10891_6165# 0.19871f
C203 a_20827_11933# a_4027_11933# 0
C204 a_16191_6170# a_10891_6165# 0.03076f
C205 a_8893_3298# a_9351_5530# 0
C206 a_6068_205# a_363_9054# 0.35749f
C207 vdd dp 2.51268f
C208 a_15451_6165# a_13911_6170# 0.01907f
C209 b7 a_363_4894# 0.28771f
C210 a_13171_6165# a_13911_6170# 0.08945f
C211 a_1418_11110# a_8893_1814# 0
C212 a_15469_11950# a_17182_11162# 0.0052f
C213 rst_n vdd 1.22911f
C214 a_2901_12720# a_4651_12720# 1.2377f
C215 a_13911_6170# a_10891_6165# 0.02908f
C216 a_15775_6170# a_13495_6170# 0.00398f
C217 a_15775_6170# a_16191_6170# 0.27357f
C218 f7 a_17182_11162# 0
C219 a_363_2814# a_4811_1984# 0.24837f
C220 a_16649_11686# a_5719_11933# 2.00503f
C221 a_363_2814# a_9351_3430# 0
C222 a_4811_9376# a_11173_1814# 0.25388f
C223 a_8935_10050# a_10891_9310# 0.0967f
C224 a_6247_2844# b2 0
C225 a_363_2286# a_363_4894# 0.33112f
C226 en a_10902_11162# 0.02123f
C227 a_15775_6170# a_13911_6170# 0
C228 vdd cke3 1.11498f
C229 b5 a_363_4894# 0.32467f
C230 a_363_9054# a_7971_9376# 0.00264f
C231 cke1 vdd 1.29431f
C232 ep a_10902_11162# 0.11885f
C233 a_6247_8796# a_1058_11170# 0
C234 a_4811_9376# a_6621_1968# 0.10535f
C235 a_20664_6336# a_4811_6504# 0.00151f
C236 a_11215_10050# vdd 0.64347f
C237 a_17731_1645# f6 0
C238 a_4341_1968# a_3087_4276# 0.31476f
C239 a_6068_205# a_6247_4276# 0.2557f
C240 a_1058_11170# a_10399_11933# 0.24052f
C241 a_10902_11162# dn 0.05769f
C242 a_3461_1968# a_1058_11170# 0
C243 c6 a_363_4894# 0
C244 a_13171_6165# a_11215_6170# 0.09999f
C245 a_363_4894# b3 0.32497f
C246 a_15451_1645# f6 0.05803f
C247 a_363_6974# a_7971_4856# 0
C248 b1 a_363_4894# 0.38904f
C249 a_16191_6170# a_13495_6170# 0.0022f
C250 a_2901_12720# a_16679_11933# 0.17699f
C251 a_6055_12811# a_4027_11933# 0.805f
C252 a6 a_363_4894# 0.06802f
C253 a_15733_1814# a_15469_11950# 0.00421f
C254 cke2 vdd 1.11004f
C255 a_11215_6170# a_10891_6165# 0.21667f
C256 a1 a_363_8526# 0
C257 a_363_6974# a_4811_4856# 0.19015f
C258 a_17731_9310# a_10891_9310# 0.04259f
C259 a_1058_11170# a_8267_11933# 0.05395f
C260 a_363_8526# c0 0
C261 a_15733_1814# f7 2.38715f
C262 cke0 vdd 1.2911f
C263 a_20664_6336# a_17731_8265# 0.00459f
C264 a5 a_3087_2844# 0
C265 a_13495_6170# a_13911_6170# 0.27357f
C266 a_11631_6170# a_13171_6165# 0.01773f
C267 a3 a_3087_2844# 0
C268 a_16191_6170# a_13911_6170# 0.00157f
C269 f6 a_13171_1645# 0.05785f
C270 a_6068_205# a_3087_4276# 0.00201f
C271 a_10902_11162# dp 0.28269f
C272 a_11631_6170# a_10891_6165# 0.05822f
C273 a_363_8526# c1 0
C274 f4 a_15451_1645# 0
C275 a_15733_1814# f5 0.09117f
C276 a_3461_1968# a_3901_1968# 0.20563f
C277 a_7501_1968# a_1058_11170# 0
C278 a4 a_363_4894# 0.06663f
C279 a_363_8526# c2 0
C280 a_17731_7210# a_20664_8208# 0.00459f
C281 rst_n a_10902_11162# 0.06003f
C282 a_6055_12811# a_4119_11933# 0.00102f
C283 a_8935_6170# a_10891_6165# 0.0967f
C284 a_10891_1645# f6 0.06119f
C285 a_9351_6170# a_10891_6165# 0.01879f
C286 a_4811_9376# vdd 6.96292f
C287 a_8935_10050# a_6055_12811# 0
C288 a_363_4894# a2 0.06661f
C289 a_21602_9194# a_10891_8265# 0.00111f
C290 a_15733_3298# a_20664_6336# 0
C291 a_4622_11162# a_1058_11170# 0.13371f
C292 c3 a_363_8526# 0
C293 a_15451_8265# a_20664_6336# 0.00329f
C294 a_15451_7210# a_20664_8208# 0.00329f
C295 a_16191_1650# f6 0.01881f
C296 f6 a_15775_1650# 0.01552f
C297 a_363_8526# c4 0
C298 a0 a_363_4894# 0.07281f
C299 a_15451_9310# a_7971_9376# 0.02923f
C300 f4 a_13171_1645# 0.06191f
C301 a_7061_1968# a_8935_6170# 0
C302 a_363_4366# rst_n 0
C303 a_23221_12720# a_1058_11170# 0
C304 a_15775_7950# a_17731_6165# 0
C305 a_17731_6165# a_17731_7210# 0
C306 a_15775_10050# a_15469_11950# 0
C307 a_11173_1814# vdd 3.20557f
C308 a_6247_7364# a_7061_1968# 0.27919f
C309 ep a_21768_2174# 0.00478f
C310 a1 a_3087_2844# 0
C311 a_363_8526# c5 0
C312 a_15775_10050# f7 0.21695f
C313 a_1418_11110# a_4089_11686# 0.78997f
C314 a_13171_1645# f2 0
C315 en a_17182_11162# 0.03969f
C316 a_1058_11170# a_363_6446# 0
C317 a_15451_7210# a_17731_6165# 0
C318 a_4027_11933# a_4651_12720# 0.08688f
C319 en a_21602_2174# 0.49196f
C320 ep a_17182_11162# 0.09191f
C321 a_15451_9310# a_2901_12720# 0
C322 f4 a_10891_1645# 0.06098f
C323 a_20664_6336# a_13171_8265# 0.00244f
C324 en a_21768_4674# 0
C325 a_13171_9310# a_10891_9310# 1.33103f
C326 a_16191_10050# a_4651_12720# 0.00431f
C327 a_13495_6170# a_11215_6170# 0.00398f
C328 a_21768_4674# ep 0.49196f
C329 a_6621_1968# vdd 1.11281f
C330 a_10891_1645# f0 0
C331 a_20664_8208# a_13171_7210# 0.00244f
C332 f4 a_13495_1650# 0.01524f
C333 a_10891_1645# f2 0.06671f
C334 a_13171_6165# a_15775_7950# 0
C335 a_15451_6165# a_17731_7210# 0
C336 a_13171_6165# a_17731_7210# 0
C337 a_15775_10050# f5 0.00247f
C338 a_13171_6165# a_16191_7950# 0
C339 en a_21602_4674# 0.00461f
C340 a_17182_11162# dn 0.05372f
C341 f4 a_13911_1650# 0.02023f
C342 a_1418_11110# a_13495_10050# 0
C343 a_15775_7950# a_10891_6165# 0
C344 a_16191_7950# a_10891_6165# 0
C345 a_17731_7210# a_10891_6165# 0
C346 a_15451_6165# a_15451_7210# 0.00582f
C347 a_13171_6165# a_15451_7210# 0
C348 a_11215_6170# a_13911_6170# 0.0022f
C349 a_4119_11933# a_4651_12720# 0.0228f
C350 a_11631_6170# a_13495_6170# 0
C351 a_1058_11170# a_1987_11933# 0.05961f
C352 ckd0 ckd2 0.40107f
C353 ckd3 ckd1 0.4076f
C354 a_15451_7210# a_10891_6165# 0
C355 a_3901_1968# a_363_6446# 0.38399f
C356 a_17731_6165# a_13171_7210# 0
C357 a_8935_10050# a_4651_12720# 0
C358 ckd1 ckd2 0.77685f
C359 a_15775_6170# a_15775_7950# 0.06789f
C360 a_15775_6170# a_17731_7210# 0
C361 a_363_4894# f1 0
C362 a_15775_6170# a_16191_7950# 0.00122f
C363 a_15451_6165# a_13495_7950# 0
C364 a_411_11960# a_13911_10050# 0.00239f
C365 c7 a_363_4894# 0.00491f
C366 a_13171_6165# a_13495_7950# 0
C367 a_11631_1650# f2 0.02074f
C368 f0 a_8935_1650# 0.01547f
C369 a_11215_1650# f2 0.01526f
C370 a_11631_6170# a_13911_6170# 0.00157f
C371 ckd0 vdd 1.31232f
C372 rst_n a_2938_205# 0
C373 ckd3 vdd 1.12679f
C374 a_23221_12720# a_16649_11686# 0.01271f
C375 a_13911_7950# a_13171_6165# 0
C376 a_13495_7950# a_10891_6165# 0
C377 a_17182_11162# dp 0.2801f
C378 a_4027_11933# a_16679_11933# 0
C379 ckd2 vdd 1.11401f
C380 ckd1 vdd 1.31838f
C381 a_21602_2174# dp 0
C382 a_15451_6165# a_13171_7210# 0
C383 a_13171_6165# a_13171_7210# 0.00793f
C384 a_13911_7950# a_10891_6165# 0
C385 rst_n a_17182_11162# 0.05722f
C386 a_16191_10050# a_16679_11933# 0
C387 a_9351_1650# f0 0.02107f
C388 a_10891_6165# a_13171_7210# 0
C389 a_17731_2690# f6 0.00786f
C390 a_17731_6165# a_10891_7210# 0
C391 a_11173_1814# a_10902_11162# 0
C392 a_6247_2844# f0 0
C393 a_8893_1814# a_10891_6165# 0.00918f
C394 a_3087_8796# a_363_2286# 0.41354f
C395 a_8935_1650# b7 0
C396 a_8935_10050# a_363_9054# 0
C397 a_4811_9376# a_363_4366# 0
C398 a_13171_6165# a_11215_7950# 0
C399 a_363_2286# a_363_8526# 1.68358f
C400 a_15775_6170# a_13171_7210# 0
C401 a_1058_11170# a_10891_9310# 0
C402 a_15775_3430# f6 0.19317f
C403 a_16191_6170# a_15775_7950# 0.00118f
C404 a_8893_1814# a_7061_1968# 0
C405 a_4341_1968# a_4811_4856# 0.01834f
C406 a_16191_6170# a_16191_7950# 0.00178f
C407 a_1418_11110# a_17221_12720# 0.20926f
C408 a_7718_205# a_6621_1968# 0.00103f
C409 a_11215_7950# a_10891_6165# 0
C410 a_10891_6165# a_11631_7950# 0
C411 a_7971_6504# a_17731_6165# 0
C412 a_15451_6165# a_10891_7210# 0
C413 a_13171_6165# a_10891_7210# 0
C414 a_4811_1984# a_3901_1968# 0
C415 a_15451_7210# a_13495_6170# 0
C416 a_11631_6170# a_11215_6170# 0.27357f
C417 a_363_9054# a_363_2814# 2.21919f
C418 a_2909_11950# a_4089_11686# 0.09863f
C419 a_20827_11933# a_1058_11170# 0.0576f
C420 a_7058_205# a_6621_1968# 0.02499f
C421 a_10891_7210# a_10891_6165# 0.27476f
C422 a_6247_2844# b7 0.16296f
C423 a_3087_8796# b1 0.00159f
C424 a_3421_11939# a_9351_10050# 0
C425 a_11215_6170# a_8935_6170# 0.00398f
C426 a_9351_6170# a_11215_6170# 0
C427 a_3087_8796# a6 0.13211f
C428 c6 a_363_8526# 0.33805f
C429 cke2 a_17182_11162# 0.00726f
C430 a_363_8526# b3 0
C431 a_15733_1814# rst_n 0
C432 b1 a_363_8526# 0
C433 a_13495_6170# a_13495_7950# 0.06789f
C434 f4 a_15775_3430# 0
C435 a_15451_6165# a_7971_6504# 0.02923f
C436 a_13171_6165# a_7971_6504# 0.05684f
C437 a6 a_363_8526# 0.33171f
C438 a_15775_6170# a_10891_7210# 0
C439 a_17731_1645# f7 0.01496f
C440 a_13911_7950# a_13495_6170# 0.00122f
C441 a_363_2814# a_8935_3750# 0
C442 a_15451_9310# a_16191_10050# 0.25123f
C443 cke0 a_17182_11162# 0.00417f
C444 a_6068_205# a_4811_4856# 0.09695f
C445 a_6398_205# a_6621_1968# 0.02241f
C446 a_7971_6504# a_10891_6165# 0.90173f
C447 a_11631_6170# a_8935_6170# 0.0022f
C448 a_11631_6170# a_9351_6170# 0.00157f
C449 a_13495_6170# a_13171_7210# 0
C450 a_16191_6170# a_13171_7210# 0
C451 a_13911_10050# a_5719_11933# 0.00422f
C452 a_20335_12811# a_17221_12720# 0
C453 ckd3 a_10902_11162# 0
C454 b5 a_6247_2844# 0.15519f
C455 a_13495_7950# a_13911_6170# 0.00118f
C456 a_15451_1645# f7 0.30394f
C457 a_3087_8796# a4 0.12515f
C458 a_363_2286# a_3087_2844# 0.54496f
C459 a_7501_1968# b6 0
C460 a_9351_6170# a_8935_6170# 0.27357f
C461 a_17731_9310# a_16679_11933# 0
C462 a_8935_7950# a_10891_6165# 0
C463 a_13911_7950# a_13911_6170# 0.00178f
C464 f6 a_16191_3430# 0.50974f
C465 a_6247_7364# a_9351_6170# 0
C466 a_7061_1968# a_7971_6504# 0.00212f
C467 a_6247_7364# a_8935_6170# 0.0016f
C468 a_6621_1968# a_5248_205# 0
C469 a_13911_10050# a_13453_1814# 0.17807f
C470 a_4811_6504# a_17731_6165# 0.00173f
C471 a_15775_6170# a_7971_6504# 0.46974f
C472 a_13171_9310# a_4651_12720# 0
C473 a_3087_8796# a2 0.12514f
C474 a_6247_4276# a_363_2814# 0.53552f
C475 a_6621_1968# a_5738_205# 0
C476 a4 a_363_8526# 0.36367f
C477 a_16649_11686# a_10891_9310# 0
C478 a_4811_9376# a_17182_11162# 0
C479 a_13911_6170# a_13171_7210# 0
C480 a_7718_205# vdd 0.12204f
C481 a_10902_11162# vdd 1.59593f
C482 a_3087_8796# a0 0.12094f
C483 a_15451_1645# f5 0.01165f
C484 a_17731_8265# a_20664_8208# 0.01076f
C485 f7 a_13171_1645# 0.29903f
C486 a_363_8526# a2 0.34973f
C487 a_6247_2844# b3 0.15305f
C488 a_6247_2844# b1 0.13645f
C489 a_20827_11933# a_16649_11686# 0
C490 a_7058_205# vdd 0.12204f
C491 a_15775_10050# rst_n 0
C492 a0 a_363_8526# 0.38353f
C493 f6 a_15451_2690# 0.25577f
C494 a_3087_2844# b3 0
C495 b1 a_3087_2844# 0.00244f
C496 a_6055_12811# a_1058_11170# 0.13634f
C497 a_15451_6165# a_4811_6504# 0.17509f
C498 a_13171_6165# a_4811_6504# 0.20137f
C499 a_13495_6170# a_10891_7210# 0
C500 a_16191_6170# a_10891_7210# 0
C501 a_363_4366# vdd 1.41791f
C502 a_10891_1645# f7 0.12876f
C503 a_15981_11939# a_15469_11950# 0.51623f
C504 a6 a_3087_2844# 0.15599f
C505 a_3461_1968# a7 0
C506 f5 a_13171_1645# 0.37442f
C507 a_6247_7364# a_3087_7364# 0
C508 f6 a_13453_1814# 0.00392f
C509 a5 a_3461_1968# 0.00104f
C510 a_4811_6504# a_10891_6165# 0.3133f
C511 a3 a_3461_1968# 0.02879f
C512 a_15981_11939# f7 0.00295f
C513 a_16191_1650# f7 0.55726f
C514 f7 a_15775_1650# 0.21134f
C515 rst_n a_363_4894# 0
C516 a_13171_1645# f3 0.00656f
C517 a_15733_3298# a_20664_8208# 0
C518 a_15451_8265# a_20664_8208# 0.01304f
C519 f7 a_13495_1650# 0.00281f
C520 a_10891_7210# a_13911_6170# 0
C521 a_6398_205# vdd 0.12204f
C522 f7 a_13911_1650# 0
C523 a_10891_1645# f5 0.12307f
C524 a_7971_6504# a_13495_6170# 0.55412f
C525 a_7061_1968# a_4811_6504# 0.09565f
C526 a_16191_6170# a_7971_6504# 0.18974f
C527 a_15775_6170# a_4811_6504# 0.29957f
C528 f4 a_15451_2690# 0.00715f
C529 a_10891_1645# f3 0.2065f
C530 f5 a_15775_1650# 0.00205f
C531 a_13171_9310# a_16679_11933# 0
C532 a4 a_3087_2844# 0.14886f
C533 a_13495_1650# f5 0.21116f
C534 a_4588_205# vdd 0.12204f
C535 a_11215_6170# a_13171_7210# 0
C536 a_10891_1645# f1 0.00668f
C537 a_5248_205# vdd 0.12632f
C538 a_15451_9310# a_17731_9310# 0.42375f
C539 a_13495_1650# f3 0.00211f
C540 a_15733_1814# a_4811_9376# 0.25142f
C541 a_13171_8265# a_20664_8208# 0.02433f
C542 f6 a_13495_3430# 0.00281f
C543 f5 a_13911_1650# 0.55798f
C544 a_8893_1814# a_11215_6170# 0
C545 a_5738_205# vdd 0.12597f
C546 f4 a_13453_1814# 0.83577f
C547 a_3087_2844# a2 0.14744f
C548 a_7971_6504# a_13911_6170# 0.19489f
C549 a_3928_205# vdd 0.12204f
C550 a1 a_3461_1968# 0.0022f
C551 a_13453_1814# f2 0.00114f
C552 a_10891_8265# a_20664_8208# 0.02172f
C553 a0 a_3087_2844# 0.13377f
C554 f5 a_11631_1650# 0
C555 c7 a_363_8526# 0.00964f
C556 a_17221_12720# a_20664_8208# 0.00525f
C557 a_15451_6165# a_15733_3298# 0.06334f
C558 f5 a_11215_1650# 0.00245f
C559 a_13171_6165# a_15733_3298# 0.05997f
C560 a_1058_11170# a_4651_12720# 0.41646f
C561 a_11215_7950# a_11215_6170# 0.06789f
C562 a_11215_6170# a_11631_7950# 0.00122f
C563 f3 a_11631_1650# 0.5584f
C564 a_8935_1650# f3 0.00281f
C565 a_11215_1650# f3 0.21218f
C566 a_3421_11939# a_4089_11686# 1.14831f
C567 a_15733_3298# a_10891_6165# 0.06306f
C568 a_2938_205# vdd 0.98358f
C569 a_11215_1650# f1 0.00218f
C570 f4 a_13495_3430# 0.19317f
C571 a_21768_2174# vdd 0.75203f
C572 a_8935_1650# f1 0.21465f
C573 a_8893_1814# a_8935_6170# 0.62444f
C574 a_15775_7950# a_17731_7210# 0.0956f
C575 a_8893_1814# a_9351_6170# 0.17831f
C576 a_3268_205# vdd 0.12204f
C577 a_15775_7950# a_16191_7950# 0.19447f
C578 a_16191_7950# a_17731_7210# 0.01721f
C579 a_13171_6165# a_13453_3298# 0.069f
C580 a_11215_6170# a_10891_7210# 0
C581 a_1418_11110# a_14547_11933# 0.05436f
C582 a_20664_8208# a_15775_8270# 0
C583 a_6247_7364# a_8893_1814# 0
C584 a_4811_6504# a_13495_6170# 0.31586f
C585 vdd a_17182_11162# 1.56551f
C586 a5 a_363_6446# 0
C587 a_16191_6170# a_4811_6504# 0.1741f
C588 a_13495_3430# f2 0
C589 a_13453_3298# a_10891_6165# 0.06306f
C590 a_21602_2174# vdd 1.65768f
C591 a_9351_1650# f3 0
C592 a_15775_7950# a_15451_7210# 0.03836f
C593 a_15451_7210# a_17731_7210# 0.37383f
C594 a_11631_6170# a_11215_7950# 0.00118f
C595 a_11631_6170# a_11631_7950# 0.00178f
C596 a_15451_7210# a_16191_7950# 0.24946f
C597 f6 a_13911_3430# 0
C598 a_21768_4674# vdd 1.63635f
C599 a_15775_6170# a_15733_3298# 0.01741f
C600 a_9351_1650# f1 0.55898f
C601 a_4811_9376# a_15775_10050# 0.29957f
C602 a_16191_8270# a_20664_8208# 0
C603 a_4811_6504# a_13911_6170# 0.17451f
C604 a_11631_6170# a_10891_7210# 0
C605 a_15451_9310# a_13171_9310# 0.86765f
C606 a_6247_2844# f1 0
C607 a_11173_3298# a_10891_6165# 0.07474f
C608 a_7971_6504# a_11215_6170# 0.55412f
C609 a_21602_4674# vdd 0.75717f
C610 en a_23462_11162# 0.01429f
C611 a_15775_7950# a_13495_7950# 0.00384f
C612 a_363_9054# a_1058_11170# 0
C613 a_16191_7950# a_13495_7950# 0.0022f
C614 a_10891_7210# a_8935_6170# 0
C615 a_4811_9376# a_363_4894# 0.19067f
C616 a_411_11960# a_15469_11950# 0.14157f
C617 a_17731_2690# f7 0.00559f
C618 ep a_23462_11162# 0.09276f
C619 a_13911_7950# a_15775_7950# 0
C620 a_13911_7950# a_16191_7950# 0.00152f
C621 a_411_11960# f7 0
C622 a_15451_7210# a_13495_7950# 0.0933f
C623 a_1058_11170# a_16679_11933# 0.23826f
C624 f4 a_13911_3430# 0.51115f
C625 a_17731_7210# a_13171_7210# 0.03661f
C626 a_15775_7950# a_13171_7210# 0.04492f
C627 a_16191_7950# a_13171_7210# 0.04458f
C628 a_13911_7950# a_15451_7210# 0.01907f
C629 a_11631_6170# a_7971_6504# 0.19489f
C630 en a_15981_11939# 0.12932f
C631 a_16649_11686# a_4651_12720# 0.33951f
C632 a_6247_8796# f0 0
C633 f7 a_15775_3430# 0.02585f
C634 ep a_15981_11939# 0.16739f
C635 a_23462_11162# dn 0.05437f
C636 c0 a_363_6446# 0
C637 a_7971_6504# a_8935_6170# 0.56846f
C638 a_15451_7210# a_13171_7210# 0.81108f
C639 a_7971_6504# a_9351_6170# 0.21125f
C640 a_411_11960# f5 0
C641 a_6247_7364# a_7971_6504# 0.29857f
C642 a_15733_3298# a_13495_6170# 0.00739f
C643 a_15733_1814# vdd 3.1588f
C644 a_16191_6170# a_15733_3298# 0
C645 a_411_11960# f3 0
C646 a_363_9054# a_3901_1968# 0.162f
C647 a_8893_3298# a_7061_1968# 0
C648 f6 a_13171_2690# 0.29442f
C649 a_13911_7950# a_13495_7950# 0.19447f
C650 a_6621_1968# a_363_4894# 0.36154f
C651 a_411_11960# f1 0
C652 a_15775_3430# f5 0.0017f
C653 a_8935_7950# a_8935_6170# 0.06789f
C654 a_15981_11939# dn 0.14744f
C655 a_8935_7950# a_9351_6170# 0.00118f
C656 a_411_11960# c7 0
C657 c1 a_363_6446# 0
C658 c2 a_363_6446# 0
C659 a_6247_7364# a_8935_7950# 0
C660 a_13495_7950# a_13171_7210# 0.05217f
C661 a_13453_3298# a_13495_6170# 0.01768f
C662 a_4811_6504# a_11215_6170# 0.31586f
C663 a_15733_3298# a_13911_6170# 0.00481f
C664 a_6247_8796# b7 0.13231f
C665 a_15775_7950# a_10891_7210# 0.20982f
C666 a_13911_7950# a_13171_7210# 0.08888f
C667 c3 a_363_6446# 0
C668 a_10891_7210# a_17731_7210# 0.04293f
C669 a_16191_7950# a_10891_7210# 0.02941f
C670 a_23462_11162# dp 0.34316f
C671 a_8893_1814# a_9351_10050# 0.17972f
C672 a_363_6446# c4 0.33977f
C673 a_15451_7210# a_10891_7210# 0.0247f
C674 a_13453_3298# a_13911_6170# 0
C675 f4 a_13171_2690# 0.35304f
C676 a_11631_6170# a_4811_6504# 0.17451f
C677 a_363_4366# a_2938_205# 0.3716f
C678 a_11215_7950# a_13495_7950# 0.00384f
C679 a_13495_7950# a_11631_7950# 0
C680 a_363_6446# c5 0.0064f
C681 a_15981_11939# dp 0.22991f
C682 a_7501_1968# f0 0.00468f
C683 a_5248_205# a_5738_205# 0.01263f
C684 a_363_2814# a_7971_4856# 0.00264f
C685 a_16649_11686# a_16679_11933# 0.5101f
C686 f7 a_16191_3430# 0.01825f
C687 a_15775_7950# a_7971_6504# 0.32994f
C688 a_13171_2690# f2 0.00174f
C689 a_15451_9310# a_1058_11170# 0
C690 a_7971_6504# a_17731_7210# 0
C691 a_4811_6504# a_9351_6170# 0.17451f
C692 a_4811_6504# a_8935_6170# 0.31586f
C693 a_13911_7950# a_11215_7950# 0.0022f
C694 a_16191_7950# a_7971_6504# 0.16534f
C695 a_13911_7950# a_11631_7950# 0.00152f
C696 b5 a_6247_8796# 0.12531f
C697 a_15981_11939# rst_n 0.46463f
C698 a_15775_10050# vdd 0.66462f
C699 a_6247_7364# a_4811_6504# 0.13378f
C700 a_3087_8796# rst_n 0
C701 a_10891_7210# a_13495_7950# 0.20051f
C702 a_4811_4856# a_363_2814# 0.03689f
C703 f4 a_11215_3430# 0.00245f
C704 a_11215_7950# a_13171_7210# 0.09999f
C705 a_23462_11162# cke3 0.00606f
C706 a_8935_5530# a_363_2814# 0
C707 a_11631_7950# a_13171_7210# 0.01773f
C708 a_15451_7210# a_7971_6504# 0.02282f
C709 cke1 a_23462_11162# 0.00339f
C710 a_9351_7950# a_8935_6170# 0.00122f
C711 a_9351_7950# a_9351_6170# 0.00178f
C712 a_13911_7950# a_10891_7210# 0.02799f
C713 a_17221_12720# a_18971_12720# 0.47549f
C714 f4 a_11631_3430# 0
C715 a_11215_3430# f0 0
C716 a_11215_3430# f2 0.19319f
C717 a_363_2286# a_3461_1968# 0.41377f
C718 rst_n a_363_8526# 0
C719 a_5719_11933# a_15469_11950# 0.24855f
C720 a_6247_7364# a_9351_7950# 0
C721 a_20664_1816# vdd 0.0297f
C722 a_363_4894# vdd 2.00146f
C723 f6 a_7971_1984# 0.31899f
C724 a_10891_7210# a_13171_7210# 1.28363f
C725 a_4588_205# a_2938_205# 0
C726 f7 a_15451_2690# 0.06713f
C727 f6 a_10891_2690# 0.12105f
C728 a_11631_3430# f2 0.51167f
C729 a_15981_11939# cke3 0.00302f
C730 a_8893_1814# a_10891_7210# 0
C731 a_7501_1968# b7 2.21023f
C732 a_15981_11939# cke1 0.04687f
C733 a_7971_6504# a_13495_7950# 0.33348f
C734 a_6247_8796# b3 0.12531f
C735 a_6247_8796# b1 0.12098f
C736 a_3928_205# a_2938_205# 0.00163f
C737 a_3087_7364# a_4811_6504# 0.28568f
C738 f7 a_13453_1814# 0.02244f
C739 a_363_6974# a_7061_1968# 0.35163f
C740 a_11215_7950# a_11631_7950# 0.19447f
C741 a_13911_7950# a_7971_6504# 0.1655f
C742 a_411_11960# en 0.37037f
C743 a_13453_3298# a_11215_6170# 0.00796f
C744 f5 a_15451_2690# 0.00457f
C745 f5 a_5719_11933# 0
C746 a_411_11960# ep 0.4123f
C747 a_13911_10050# a_10891_9310# 0.02908f
C748 a_7971_6504# a_13171_7210# 0.04726f
C749 a_3901_1968# a_3087_4276# 0.27013f
C750 a_11215_7950# a_10891_7210# 0.21782f
C751 a_10891_7210# a_11631_7950# 0.05647f
C752 a_15775_7950# a_4811_6504# 0.44721f
C753 a_4811_6504# a_17731_7210# 0.00315f
C754 a_8893_1814# a_7971_6504# 0.53084f
C755 a_16191_7950# a_4811_6504# 0.16793f
C756 f4 a_7971_1984# 0.31993f
C757 f5 a_13453_1814# 2.36774f
C758 f6 a_4811_1984# 0.1813f
C759 a6 a_3461_1968# 0.00127f
C760 f4 a_10891_2690# 0.12084f
C761 a_11215_6170# a_11173_3298# 0.01803f
C762 f3 a_13453_1814# 0.10009f
C763 cke2 a_15981_11939# 0.05251f
C764 b5 a_7501_1968# 0.00179f
C765 a_3268_205# a_2938_205# 0.05008f
C766 f0 a_7971_1984# 0.32575f
C767 f0 a_8935_3430# 0.19382f
C768 a_15451_7210# a_4811_6504# 0.18863f
C769 a_8935_3430# f2 0.00281f
C770 a_11631_6170# a_13453_3298# 0.00504f
C771 f2 a_7971_1984# 0.32103f
C772 a_15451_9310# a_16649_11686# 0
C773 a_411_11960# dn 0.41217f
C774 f0 a_10891_2690# 0.00129f
C775 a_8935_7950# a_8893_1814# 0.01545f
C776 a_10891_2690# f2 0.19338f
C777 a_1418_11110# a_2901_12720# 0.39046f
C778 a_21768_2174# a_21602_2174# 0.2098f
C779 a_7971_6504# a_11215_7950# 0.33348f
C780 a_7971_6504# a_11631_7950# 0.1655f
C781 a_15981_11939# cke0 0.13273f
C782 f6 a_17731_3745# 0.00786f
C783 a_21768_4674# a_21768_2174# 0.42075f
C784 a_11631_6170# a_11173_3298# 0
C785 f6 a_10891_9310# 0
C786 a_4811_6504# a_13495_7950# 0.49997f
C787 a4 a_3461_1968# 1.37113f
C788 a_13495_3430# f5 0.02591f
C789 a_7971_6504# a_10891_7210# 0.08347f
C790 a_15775_7950# a_17731_8265# 0
C791 a_17731_8265# a_17731_7210# 0.34565f
C792 a_8935_7950# a_11215_7950# 0.00384f
C793 a_7501_1968# b3 0
C794 a_363_2286# a_363_6446# 0.72984f
C795 a_7501_1968# b1 0
C796 a_8935_7950# a_11631_7950# 0.0022f
C797 a_11173_1814# a_13171_1645# 0.00647f
C798 f4 a_4811_1984# 0.18169f
C799 a_9351_6170# a_11173_3298# 0.00541f
C800 a_11173_3298# a_8935_6170# 0.00856f
C801 a_21768_2174# a_21602_4674# 0.02537f
C802 a_13495_3430# f3 0.00175f
C803 a_21768_4674# a_21602_2174# 0.31865f
C804 a_13911_7950# a_4811_6504# 0.17209f
C805 a_3461_1968# a2 2.0918f
C806 a_11631_10050# a_13453_1814# 0.00519f
C807 b7 a_7971_1984# 0.00437f
C808 f0 a_4811_1984# 0.21309f
C809 b7 a_8935_3430# 0.00163f
C810 f0 a_9351_3430# 0.51204f
C811 a_9351_10050# a_4089_11686# 0.01203f
C812 a_4811_1984# f2 0.18179f
C813 a_9351_3430# f2 0
C814 a_15451_7210# a_17731_8265# 0.00167f
C815 a_4811_9376# a_15981_11939# 0
C816 a_411_11960# dp 4.29575f
C817 a_4811_9376# a_3087_8796# 0.28568f
C818 a_4811_6504# a_13171_7210# 0.21318f
C819 a_8935_7950# a_10891_7210# 0.09668f
C820 a_21602_4674# a_21602_2174# 0.41038f
C821 a_20664_3688# vdd 0.0297f
C822 a0 a_3461_1968# 0.00285f
C823 a_8893_1814# a_4811_6504# 0.23202f
C824 a_10891_1645# a_11173_1814# 0.38887f
C825 a_411_11960# rst_n 0.71733f
C826 a_21768_4674# a_21602_4674# 0.23569f
C827 a_15451_3745# f6 0.25577f
C828 a_8893_1814# a_4089_11686# 0
C829 a_4811_9376# a_363_8526# 0.00212f
C830 a_15775_7950# a_15733_3298# 0.63126f
C831 a_15733_3298# a_17731_7210# 0.00209f
C832 a_15451_8265# a_15775_7950# 0.00443f
C833 a_15451_8265# a_17731_7210# 0.00167f
C834 a_15733_3298# a_16191_7950# 0.14988f
C835 a_8893_3298# a_8935_6170# 0.0191f
C836 a_15451_8265# a_16191_7950# 0.01181f
C837 f4 a_10891_9310# 0
C838 a_11173_1814# a_13495_1650# 0
C839 a_8893_3298# a_9351_6170# 0
C840 c6 a_363_6446# 0
C841 a_8893_1814# a_9351_7950# 0.02033f
C842 b3 a_363_6446# 0
C843 a_6247_7364# a_8893_3298# 0
C844 b1 a_363_6446# 0
C845 a_363_2286# a_1987_11933# 0
C846 a_15733_3298# a_15451_7210# 0.21543f
C847 a_15451_8265# a_15451_7210# 0.14709f
C848 a_8935_7950# a_7971_6504# 0.33369f
C849 a_10891_9310# f2 0
C850 b5 a_7971_1984# 0
C851 a_4811_6504# a_11215_7950# 0.49997f
C852 a6 a_363_6446# 0.31203f
C853 a_15775_7950# a_13453_3298# 0
C854 a_4811_6504# a_11631_7950# 0.17209f
C855 a_363_4366# a_363_4894# 2.05233f
C856 b7 a_4811_1984# 0.13987f
C857 f6 a_13171_3745# 0.29442f
C858 a_363_9054# b2 0
C859 a_13911_3430# f5 0.01888f
C860 a_17731_8265# a_13171_7210# 0
C861 a_10891_3745# f6 0.12105f
C862 en a_5719_11933# 0.20543f
C863 a_15733_1814# a_17182_11162# 0
C864 a_15451_7210# a_13453_3298# 0.00217f
C865 a_11173_1814# a_11631_1650# 0.1832f
C866 a_15775_7950# a_13171_8265# 0
C867 a_4811_6504# a_10891_7210# 1.14768f
C868 a_13171_8265# a_17731_7210# 0
C869 a_9351_7950# a_11215_7950# 0
C870 a_17731_1645# vdd 0.22482f
C871 f4 a_15451_3745# 0.00715f
C872 a_9351_7950# a_11631_7950# 0.00152f
C873 ep a_5719_11933# 0.61614f
C874 a_11173_1814# a_11215_1650# 0.62318f
C875 a_6247_8796# f1 0
C876 a_11173_1814# a_8935_1650# 0.00662f
C877 a_15733_3298# a_13495_7950# 0.01369f
C878 a_15451_8265# a_13495_7950# 0
C879 a_411_11960# a_11215_10050# 0
C880 a_10399_11933# f3 0
C881 a_13911_7950# a_15733_3298# 0.00548f
C882 a_15451_7210# a_13171_8265# 0
C883 a_15775_7950# a_10891_8265# 0
C884 a_10891_8265# a_17731_7210# 0
C885 ep a_13453_1814# 0
C886 a_15451_1645# vdd 0.26884f
C887 a_9351_7950# a_10891_7210# 0.01885f
C888 b3 a_7971_1984# 0
C889 a_363_2286# a_4811_1984# 0.01284f
C890 a_10399_11933# f1 0
C891 a4 a_363_6446# 0.34293f
C892 b0 a_363_9054# 0
C893 a_13453_3298# a_13495_7950# 0.63153f
C894 a_15733_3298# a_13171_7210# 0.21982f
C895 a_9351_1650# a_11173_1814# 0.00152f
C896 a_15451_8265# a_13171_7210# 0
C897 a_5719_11933# dn 0.24785f
C898 b5 a_4811_1984# 0.12887f
C899 a_15451_7210# a_10891_8265# 0
C900 f4 a_13171_3745# 0.35304f
C901 a_7971_6504# a_4811_6504# 1.33349f
C902 a_411_11960# cke2 0
C903 a_13911_7950# a_13453_3298# 0.14988f
C904 a_363_6446# a2 0.34261f
C905 f4 a_10891_3745# 0.12084f
C906 f7 a_13171_2690# 0.06169f
C907 a_21602_9194# a_17731_9310# 0
C908 a_13171_8265# a_13495_7950# 0.00452f
C909 a_13171_3745# f2 0.00174f
C910 a0 a_363_6446# 0.35267f
C911 a_11173_3298# a_13495_7950# 0
C912 a_17731_8265# a_10891_7210# 0
C913 a_13453_3298# a_13171_7210# 0.26709f
C914 a_15775_7950# a_15775_8270# 0.00363f
C915 a_13171_1645# vdd 0.38225f
C916 a_10891_3745# f0 0.00129f
C917 a_17731_7210# a_15775_8270# 0
C918 a_7971_6504# a_9351_7950# 0.1655f
C919 a_16191_7950# a_15775_8270# 0
C920 a_10891_3745# f2 0.19338f
C921 a_363_9054# a7 0
C922 a_13911_7950# a_13171_8265# 0.0091f
C923 a_8935_7950# a_4811_6504# 0.51454f
C924 a_411_11960# cke0 0
C925 a_8267_11933# f1 0
C926 a_2909_11950# a_2901_12720# 0.30086f
C927 a_23462_11162# vdd 1.58037f
C928 a5 a_363_9054# 0
C929 a3 a_363_9054# 0
C930 a_10891_8265# a_13495_7950# 0
C931 a_11631_10050# a_10399_11933# 0.00149f
C932 a_15451_7210# a_15775_8270# 0.00443f
C933 a_13171_8265# a_13171_7210# 0.09415f
C934 a_4811_1984# b3 0.12882f
C935 b1 a_4811_1984# 0.13923f
C936 a_1418_11110# a_4027_11933# 0.28898f
C937 f5 a_13171_2690# 0.06696f
C938 a_11173_3298# a_13171_7210# 0.00641f
C939 a_15775_7950# a_16191_8270# 0
C940 a_16191_8270# a_16191_7950# 0.07595f
C941 a_8935_7950# a_9351_7950# 0.19447f
C942 a_10891_1645# vdd 0.81893f
C943 a6 a_4811_1984# 0.01078f
C944 a_6247_2844# a_6621_1968# 0.28015f
C945 a_363_4894# a_2938_205# 0.12294f
C946 f3 a_13171_2690# 0.00491f
C947 f6 a_15775_3750# 0.19317f
C948 a_20664_1816# a_21768_2174# 1.99548f
C949 a_5719_11933# dp 0.31011f
C950 a_8893_1814# a_11173_3298# 0.01913f
C951 a_7501_1968# f1 0.00179f
C952 a_15981_11939# vdd 3.54561f
C953 a_1418_11110# a_16191_10050# 0
C954 a_10891_8265# a_13171_7210# 0
C955 a_363_6974# a_6247_7364# 0.40171f
C956 a_15733_3298# a_10891_7210# 0.31787f
C957 a_15775_1650# vdd 0.6643f
C958 a_16191_1650# vdd 0.40559f
C959 a_13453_3298# a_11215_7950# 0.01456f
C960 a_15451_8265# a_10891_7210# 0
C961 a_3087_8796# vdd 0.76938f
C962 a_13453_3298# a_11631_7950# 0.0058f
C963 a_16191_8270# a_15451_7210# 0.01181f
C964 a_13495_1650# vdd 0.64434f
C965 rst_n a_5719_11933# 0.23909f
C966 a_8893_1814# a_10891_8265# 0
C967 a_8893_3298# a_9351_10050# 0
C968 f6 a_16191_3750# 0.50974f
C969 a_20664_1816# a_21602_2174# 0.0659f
C970 a_13911_1650# vdd 0.40428f
C971 a_13495_3750# f6 0.00281f
C972 a_11215_3430# f3 0.0269f
C973 a_363_8526# vdd 1.4781f
C974 a_21768_4674# a_20664_1816# 0.00178f
C975 a_13495_8270# a_15451_7210# 0
C976 a_13171_8265# a_11215_7950# 0
C977 a_13453_3298# a_10891_7210# 0.31332f
C978 rst_n a_13453_1814# 0
C979 a_411_11960# a_11173_1814# 0
C980 a_11215_7950# a_11173_3298# 0.63188f
C981 a_11173_3298# a_11631_7950# 0.1499f
C982 a_11215_3430# f1 0.00183f
C983 a_1418_11110# a_4119_11933# 0.15119f
C984 f3 a_11631_3430# 0.01928f
C985 a_8893_3298# a_8893_1814# 1.92083f
C986 a4 a_4811_1984# 0
C987 a_15775_8270# a_13171_7210# 0
C988 a_363_9054# a1 0
C989 a_4811_4856# a_3901_1968# 0
C990 a_15733_3298# a_7971_6504# 0.42341f
C991 a_20664_1816# a_21602_4674# 0.00498f
C992 a_11215_7950# a_10891_8265# 0.00426f
C993 a_15451_8265# a_7971_6504# 0.00412f
C994 a_11631_1650# vdd 0.40428f
C995 a_10891_8265# a_11631_7950# 0.00676f
C996 f4 a_15775_3750# 0
C997 a_5719_11933# cke3 0.00156f
C998 a_1418_11110# a_8935_10050# 0
C999 a_13171_8265# a_10891_7210# 0
C1000 a_11215_1650# vdd 0.64434f
C1001 a_6068_205# a_7061_1968# 0.00157f
C1002 a_8935_1650# vdd 0.65181f
C1003 cke1 a_5719_11933# 0.01147f
C1004 a_11173_3298# a_10891_7210# 0.37168f
C1005 a_9351_7950# a_4811_6504# 0.18866f
C1006 a_363_6974# a_3087_7364# 0.36987f
C1007 a_13911_3750# f6 0
C1008 a_21602_9194# a_13171_9310# 0.00111f
C1009 a_4811_1984# a2 0
C1010 f7 a_7971_1984# 0.29027f
C1011 a_13911_8270# a_13495_7950# 0
C1012 a_13495_8270# a_13495_7950# 0.00363f
C1013 c7 a_363_6446# 0
C1014 a_20335_12811# a_4027_11933# 0.44587f
C1015 en a_10399_11933# 0.02244f
C1016 f7 a_10891_2690# 0.06576f
C1017 a_10891_8265# a_10891_7210# 0.06958f
C1018 a_13453_3298# a_7971_6504# 0.42424f
C1019 a_13911_7950# a_13495_8270# 0
C1020 ep a_10399_11933# 0.13993f
C1021 a_13911_7950# a_13911_8270# 0.07595f
C1022 a_8893_3298# a_11215_7950# 0
C1023 f4 a_13495_3750# 0.19317f
C1024 a_9351_1650# vdd 0.40615f
C1025 a_6247_8796# dn 0
C1026 a_15733_1814# a_15775_10050# 0.63102f
C1027 a_13495_8270# a_13171_7210# 0.00452f
C1028 a_1418_11110# a_363_2814# 0
C1029 a_13911_8270# a_13171_7210# 0.0091f
C1030 a_11215_8270# a_13171_7210# 0
C1031 a_13171_8265# a_7971_6504# 0.00315f
C1032 a_11215_10050# a_13453_1814# 0.0128f
C1033 a_13495_3750# f2 0
C1034 f5 a_7971_1984# 0.33456f
C1035 a_7971_6504# a_11173_3298# 0.42493f
C1036 a_8893_3298# a_10891_7210# 0.00913f
C1037 a_10891_2690# f5 0.0632f
C1038 a_6247_2844# vdd 0.81027f
C1039 en a_8267_11933# 0.00774f
C1040 f3 a_7971_1984# 0.33786f
C1041 a_10399_11933# dn 0.04767f
C1042 cke2 a_5719_11933# 0.13146f
C1043 a_8935_8270# a_9351_10050# 0.00118f
C1044 a_10891_2690# f3 0.07058f
C1045 a_10891_7210# a_15775_8270# 0
C1046 a_7971_6504# a_10891_8265# 0.00248f
C1047 f4 a_13911_3750# 0.51115f
C1048 a_15733_1814# a_20664_1816# 0
C1049 ep a_8267_11933# 0.05595f
C1050 f1 a_7971_1984# 0.37954f
C1051 a_8935_3430# f1 0.02818f
C1052 a_7061_1968# a_7971_9376# 0.00174f
C1053 a_3087_2844# vdd 0.77565f
C1054 a_10891_2690# f1 0.00545f
C1055 f7 a_4811_1984# 0.18908f
C1056 a_8935_7950# a_11173_3298# 0.01487f
C1057 a_9351_10050# a_9351_8270# 0.00178f
C1058 cke0 a_5719_11933# 0.15142f
C1059 a_8935_8270# a_8893_1814# 0.02447f
C1060 f4 a_11215_3750# 0.00245f
C1061 a_15733_3298# a_4811_6504# 0.26049f
C1062 a_8935_7950# a_10891_8265# 0
C1063 a_15451_8265# a_4811_6504# 0.00419f
C1064 a_11215_8270# a_11215_7950# 0.00363f
C1065 a_21768_2174# a_20664_3688# 0.00498f
C1066 a_11215_8270# a_11631_7950# 0
C1067 a_8893_3298# a_7971_6504# 0.42776f
C1068 a_411_11960# ckd0 0
C1069 a_411_11960# ckd3 0
C1070 a_1418_11110# a_17731_9310# 0
C1071 a_8267_11933# dn 0.51526f
C1072 a_8893_1814# a_9351_8270# 0.0219f
C1073 a_411_11960# ckd2 0
C1074 f0 a_11215_3750# 0
C1075 a_411_11960# ckd1 0
C1076 a_11215_3750# f2 0.19319f
C1077 a_11631_8270# a_11215_7950# 0
C1078 f7 a_17731_3745# 0.00559f
C1079 a_11631_8270# a_11631_7950# 0.07595f
C1080 a_4811_1984# f5 0.19687f
C1081 a_10891_9310# a_15469_11950# 0
C1082 a_13495_8270# a_10891_7210# 0
C1083 a_20664_3688# a_21602_2174# 0.01215f
C1084 a_6247_8796# rst_n 0
C1085 a_13453_3298# a_4811_6504# 0.26571f
C1086 en a_4622_11162# 0.02123f
C1087 a_11215_8270# a_10891_7210# 0.00426f
C1088 a_4811_1984# f3 0.19779f
C1089 a_8893_3298# a_8935_7950# 0.63354f
C1090 a_10399_11933# dp 0.33858f
C1091 f7 a_10891_9310# 0.13702f
C1092 a_21768_4674# a_20664_3688# 0.04072f
C1093 a_17731_2690# vdd 0.22482f
C1094 ep a_4622_11162# 0.09314f
C1095 a_11631_8270# a_10891_7210# 0.00676f
C1096 a_4811_1984# f1 0.20406f
C1097 a_2909_11950# a_4027_11933# 0.54062f
C1098 a_9351_3430# f1 0.01984f
C1099 a_21602_6694# a_1058_11170# 0
C1100 a_363_6974# a_8893_1814# 0
C1101 a_16191_8270# a_7971_6504# 0.00123f
C1102 en a_23221_12720# 0.06918f
C1103 a_411_11960# vdd 3.451f
C1104 a_20827_11933# a_15469_11950# 0
C1105 a_10399_11933# rst_n 0.06632f
C1106 a_13171_8265# a_4811_6504# 0.00342f
C1107 a_363_4366# a_3087_8796# 0.52788f
C1108 a_20664_3688# a_21602_4674# 2.00307f
C1109 a_4811_6504# a_11173_3298# 0.26701f
C1110 ep a_23221_12720# 0.10852f
C1111 a_8935_8270# a_10891_7210# 0
C1112 a_4811_9376# a_13453_1814# 0.25291f
C1113 a_3461_1968# rst_n 0
C1114 a_15451_8265# a_13495_10050# 0
C1115 a_15733_3298# a_17731_8265# 0.00209f
C1116 a_15451_8265# a_17731_8265# 0.37383f
C1117 a_15775_3430# vdd 0.66315f
C1118 a_13911_8270# a_7971_6504# 0.00123f
C1119 a_4622_11162# dn 0.08633f
C1120 a_17731_1645# a_21768_2174# 0
C1121 f5 a_10891_9310# 0.13154f
C1122 a_363_9054# f0 0.00132f
C1123 a_21602_9194# a_1058_11170# 0.00117f
C1124 a_4811_6504# a_10891_8265# 0.00319f
C1125 a_13911_10050# a_15451_9310# 0.01907f
C1126 a_8267_11933# dp 0.06607f
C1127 a_363_4366# a_363_8526# 0.67417f
C1128 a_3421_11939# a_2901_12720# 1.84608f
C1129 a_10891_9310# f3 0.21497f
C1130 a_15451_3745# f7 0.06713f
C1131 a_9351_7950# a_11173_3298# 0.00609f
C1132 a_11173_1814# a_13453_1814# 0.01213f
C1133 a_13453_3298# a_13495_10050# 0.00112f
C1134 a_11631_8270# a_7971_6504# 0.00123f
C1135 a_10891_9310# f1 0.00689f
C1136 a_23221_12720# dn 0.08577f
C1137 a_8267_11933# rst_n 0.25018f
C1138 a_15451_1645# a_21768_2174# 0
C1139 f4 a_11631_3750# 0
C1140 a_2909_11950# a_4119_11933# 0.01033f
C1141 a_8893_3298# a_4811_6504# 0.31277f
C1142 a_13171_8265# a_13495_10050# 0
C1143 a_11631_3750# f2 0.51167f
C1144 a_15451_8265# a_15733_3298# 0.15717f
C1145 a_17731_8265# a_13171_8265# 0.03661f
C1146 a_16191_10050# a_20664_8208# 0
C1147 a_15451_3745# f5 0.00457f
C1148 a_10399_11933# a_11215_10050# 0
C1149 a_7971_6504# a_9351_8270# 0.00123f
C1150 f0 a_8935_3750# 0.19382f
C1151 f7 a_13171_3745# 0.06169f
C1152 a_8935_3750# f2 0.00281f
C1153 a_7718_205# a_6247_2844# 0
C1154 a_1418_11110# a_13171_9310# 0
C1155 a_15733_1814# a_20664_3688# 0
C1156 a_10891_3745# f7 0.06576f
C1157 a_8893_3298# a_9351_7950# 0.1499f
C1158 a_7501_1968# rst_n 0
C1159 en a_1987_11933# 0.00867f
C1160 a_8935_8270# a_8935_7950# 0.00363f
C1161 a_10891_8265# a_13495_10050# 0
C1162 a_21768_2174# a_13171_1645# 0.00111f
C1163 a_363_9054# b7 0.29598f
C1164 a_4622_11162# dp 0.28269f
C1165 a_15733_3298# a_13453_3298# 0.01317f
C1166 a_17731_8265# a_10891_8265# 0.04293f
C1167 a_15451_8265# a_13453_3298# 0.00217f
C1168 a_2901_12720# a_18971_12720# 0.02637f
C1169 ep a_1987_11933# 0.05748f
C1170 a_11631_10050# a_10891_9310# 0.05822f
C1171 a_7058_205# a_6247_2844# 0
C1172 a_8935_7950# a_9351_8270# 0
C1173 a_16191_8270# a_4811_6504# 0.00123f
C1174 a_4622_11162# rst_n 0.06029f
C1175 a_363_6974# a_7971_6504# 0
C1176 a_2909_11950# a_363_2814# 0
C1177 a_23221_12720# dp 0.15656f
C1178 f5 a_13171_3745# 0.06696f
C1179 a_15733_3298# a_13171_8265# 0.16121f
C1180 f6 a_17731_4790# 0
C1181 a_15451_8265# a_13171_8265# 0.81108f
C1182 a_6247_4276# f0 0
C1183 a_10891_3745# f5 0.0632f
C1184 a_21602_6694# a_16649_11686# 0.00183f
C1185 a_13171_3745# f3 0.00491f
C1186 a_13911_8270# a_4811_6504# 0.00123f
C1187 a_10891_1645# a_21768_2174# 0.00111f
C1188 a_16191_3430# vdd 0.35393f
C1189 a_363_6446# dp 0
C1190 a_1987_11933# dn 0.02571f
C1191 a_10891_3745# f3 0.07058f
C1192 a_3087_8796# a_2938_205# 0.23826f
C1193 f0 a_9351_3750# 0.51204f
C1194 a_363_9054# a_363_2286# 0.26149f
C1195 a_17731_8265# a_15775_8270# 0.0956f
C1196 a_363_4366# a_3087_2844# 0.52549f
C1197 a_363_6974# a_8935_7950# 0
C1198 a_9351_3750# f2 0
C1199 a_8935_3750# b7 0.00163f
C1200 ckd3 a_5719_11933# 0.45364f
C1201 a_11631_8270# a_4811_6504# 0.00123f
C1202 a_15733_3298# a_10891_8265# 0.25542f
C1203 f6 a_15775_5530# 0.01523f
C1204 a_10891_3745# f1 0.00545f
C1205 a_15451_8265# a_10891_8265# 0.0247f
C1206 a_13453_3298# a_13171_8265# 0.19988f
C1207 b5 a_363_9054# 0.33113f
C1208 a_5719_11933# ckd2 0.00359f
C1209 rst_n a_363_6446# 0
C1210 ckd1 a_5719_11933# 0.16654f
C1211 a_13453_3298# a_11173_3298# 0.01539f
C1212 a_21602_9194# a_16649_11686# 0
C1213 a_15981_11939# a_17182_11162# 0.1827f
C1214 a_6398_205# a_6247_2844# 0
C1215 a_15733_1814# a_17731_1645# 0.00209f
C1216 a_4341_1968# a_3087_7364# 0.31476f
C1217 a_363_8526# a_2938_205# 0.39262f
C1218 a_4811_9376# a_6247_8796# 0.13378f
C1219 f6 a_16191_5530# 0.0186f
C1220 a_8935_8270# a_4811_6504# 0.0038f
C1221 a_16191_8270# a_17731_8265# 0.01721f
C1222 a_24971_12720# a_22959_11933# 0.02032f
C1223 a_411_11960# a_10902_11162# 0.58019f
C1224 a_13453_3298# a_10891_8265# 0.25086f
C1225 a_23221_12720# cke3 0.04527f
C1226 a_6068_205# a_6247_7364# 0.2557f
C1227 a_13171_8265# a_11173_3298# 0.00641f
C1228 a_4811_6504# a_9351_8270# 0.00595f
C1229 a_15733_1814# a_15451_1645# 0.26785f
C1230 a_23221_12720# cke1 0.36118f
C1231 a_15451_2690# vdd 0.23516f
C1232 a_4811_9376# a_10399_11933# 0
C1233 a_5719_11933# vdd 3.58046f
C1234 a_13495_8270# a_13495_10050# 0.06789f
C1235 a_6247_4276# b7 0.15984f
C1236 a_15733_3298# a_15775_8270# 0.61631f
C1237 a_8935_8270# a_9351_7950# 0
C1238 a_13911_8270# a_13495_10050# 0.00122f
C1239 a_15451_8265# a_15775_8270# 0.03836f
C1240 f6 a_15451_4790# 0.05696f
C1241 a_13171_8265# a_10891_8265# 1.28363f
C1242 a_4811_9376# a_3461_1968# 0
C1243 c6 a_363_9054# 0.00179f
C1244 f7 a_15775_3750# 0.02585f
C1245 a_4588_205# a_3087_2844# 0
C1246 a_1987_11933# dp 0.55774f
C1247 a_363_9054# b3 0.30861f
C1248 a_11173_3298# a_10891_8265# 0.29798f
C1249 a_363_9054# b1 0.50176f
C1250 a_9351_7950# a_9351_8270# 0.07595f
C1251 vdd a_13453_1814# 3.18046f
C1252 a_11173_1814# a_10399_11933# 0.00203f
C1253 a_20664_1816# a_20664_3688# 0.23462f
C1254 a_6055_12811# f1 0
C1255 a6 a_363_9054# 0.12363f
C1256 a_363_6974# a_4811_6504# 0.23907f
C1257 rst_n a_1987_11933# 0.14161f
C1258 a_13453_3298# a_15775_8270# 0
C1259 a_3928_205# a_3087_2844# 0
C1260 a_16191_8270# a_15733_3298# 0.14926f
C1261 a_4027_11933# a_22959_11933# 0.1847f
C1262 a_15451_8265# a_16191_8270# 0.24946f
C1263 a_15733_1814# a_13171_1645# 0.21719f
C1264 f7 a_16191_3750# 0.01825f
C1265 en a_20827_11933# 0.49647f
C1266 a_6247_8796# a_6621_1968# 0.265f
C1267 a_6068_205# a_3087_7364# 0.00201f
C1268 a_17731_9310# a_20664_8208# 0.03263f
C1269 a_8893_3298# a_11173_3298# 0.0118f
C1270 ep a_20827_11933# 0.05595f
C1271 f5 a_15775_3750# 0.0017f
C1272 a_363_6974# a_9351_7950# 0
C1273 a_13495_8270# a_15733_3298# 0.00677f
C1274 a_13171_8265# a_15775_8270# 0.04492f
C1275 a_15733_3298# a_13911_8270# 0.00146f
C1276 a_13495_8270# a_15451_8265# 0.0933f
C1277 a_15451_8265# a_13911_8270# 0.01907f
C1278 a_1418_11110# a_1058_11170# 0.7462f
C1279 b5 a_6247_4276# 0.15274f
C1280 a_8893_3298# a_10891_8265# 0.00913f
C1281 f4 a_15451_4790# 0
C1282 a_4651_12720# a_15469_11950# 0.07547f
C1283 a_15733_1814# a_10891_1645# 0.31539f
C1284 a_13495_3430# vdd 0.65214f
C1285 a_3421_11939# a_4027_11933# 0.72262f
C1286 a_10891_8265# a_15775_8270# 0.20982f
C1287 a_363_9054# a4 0.1207f
C1288 a_3087_2844# a_2938_205# 0.24666f
C1289 a_15733_1814# a_15981_11939# 0
C1290 a_13495_8270# a_13453_3298# 0.61631f
C1291 a_4811_9376# a_7501_1968# 0.10783f
C1292 a_13911_8270# a_13453_3298# 0.14926f
C1293 a_15733_1814# a_15775_1650# 0.62257f
C1294 f7 a_4651_12720# 0
C1295 a_16191_8270# a_13171_8265# 0.04458f
C1296 a_15733_1814# a_16191_1650# 0.17953f
C1297 a_13453_3298# a_11215_8270# 0.00706f
C1298 a_13495_3750# f5 0.02591f
C1299 a_20827_11933# dn 0.02691f
C1300 a_15733_1814# a_13495_1650# 0.00658f
C1301 a_3268_205# a_3087_2844# 0
C1302 a_13495_3750# f3 0.00175f
C1303 a_17731_1645# a_20664_1816# 0.03263f
C1304 a_363_9054# a2 0.12073f
C1305 a_11631_8270# a_13453_3298# 0.00155f
C1306 a_15733_1814# a_13911_1650# 0.00154f
C1307 a_13495_8270# a_13171_8265# 0.05217f
C1308 a_16191_8270# a_10891_8265# 0.02941f
C1309 a_13911_8270# a_13171_8265# 0.08888f
C1310 a_11173_1814# a_13171_2690# 0
C1311 a_13171_8265# a_11215_8270# 0.09999f
C1312 a_6247_4276# b3 0.15266f
C1313 a_13495_8270# a_11173_3298# 0
C1314 a_6247_4276# b1 0.13645f
C1315 a_11215_8270# a_11173_3298# 0.61631f
C1316 a0 a_363_9054# 0.13522f
C1317 a_13911_3750# f5 0.01888f
C1318 a_15451_1645# a_20664_1816# 0.05794f
C1319 a_11631_8270# a_13171_8265# 0.01773f
C1320 a_363_2286# a_3087_4276# 0.53572f
C1321 a_7061_1968# a_363_2814# 0.34266f
C1322 a_13495_8270# a_10891_8265# 0.20051f
C1323 a_13911_8270# a_10891_8265# 0.02799f
C1324 a_11631_8270# a_11173_3298# 0.14926f
C1325 a_11215_8270# a_10891_8265# 0.21782f
C1326 a_3421_11939# a_4119_11933# 0.23842f
C1327 a_4027_11933# a_18971_12720# 0.00611f
C1328 a_4651_12720# f1 0
C1329 a_13171_4790# f6 0.05784f
C1330 a_4811_9376# a_363_6446# 0
C1331 a_11173_1814# a_11215_3430# 0.01523f
C1332 a_20335_12811# a_1058_11170# 0.14593f
C1333 ckd3 a_10399_11933# 0.01254f
C1334 a_11631_8270# a_10891_8265# 0.05647f
C1335 a_3421_11939# a_8935_10050# 0.00149f
C1336 a_7501_1968# a_6621_1968# 0.00151f
C1337 a_8935_8270# a_11173_3298# 0.00677f
C1338 a_16191_8270# a_15775_8270# 0.19447f
C1339 a_16191_7950# a_7971_9376# 0.00123f
C1340 a_11215_3750# f3 0.0269f
C1341 a_10399_11933# ckd1 0.00131f
C1342 a_20827_11933# dp 0.07175f
C1343 f4 a_13495_5530# 0.01523f
C1344 a_11173_1814# a_11631_3430# 0.01967f
C1345 a_20664_1816# a_13171_1645# 0.02513f
C1346 a_8893_3298# a_11215_8270# 0
C1347 a_6247_8796# vdd 0.80996f
C1348 a_11173_3298# a_9351_8270# 0.00145f
C1349 a_11215_3750# f1 0.00183f
C1350 a_8935_8270# a_10891_8265# 0.09668f
C1351 a_411_11960# a_17182_11162# 0.57891f
C1352 a_5719_11933# a_10902_11162# 0.64732f
C1353 a_13171_9310# a_20664_8208# 0.02513f
C1354 a_13911_3430# vdd 0.35238f
C1355 a_20827_11933# rst_n 0.23f
C1356 a_15451_7210# a_7971_9376# 0.00412f
C1357 a_13911_8270# a_15775_8270# 0
C1358 a_13495_8270# a_15775_8270# 0.00384f
C1359 a_15981_11939# a_15775_10050# 0
C1360 a_16679_11933# a_15469_11950# 0
C1361 en a_6055_12811# 0.06978f
C1362 a_10891_8265# a_9351_8270# 0.01885f
C1363 a_1418_11110# a_16649_11686# 0.70699f
C1364 b3 a_3087_4276# 0
C1365 b1 a_3087_4276# 0.00244f
C1366 a_10902_11162# a_13453_1814# 0
C1367 ep a_6055_12811# 0.10098f
C1368 a_10399_11933# vdd 1.48271f
C1369 f7 a_16679_11933# 0
C1370 a_3421_11939# a_363_2814# 0
C1371 a_10891_1645# a_20664_1816# 0.02688f
C1372 a_8267_11933# ckd1 0.00228f
C1373 a_8935_8270# a_8893_3298# 0.61672f
C1374 a6 a_3087_4276# 0.15423f
C1375 a_3461_1968# vdd 1.07049f
C1376 a_13171_4790# f4 0.06189f
C1377 a_13495_8270# a_16191_8270# 0.0022f
C1378 f4 a_13911_5530# 0.02002f
C1379 a_16191_8270# a_13911_8270# 0.00152f
C1380 a_10891_4790# f6 0.06118f
C1381 a_20664_1816# a_15775_1650# 0.00218f
C1382 a_16191_1650# a_20664_1816# 0
C1383 a_8893_3298# a_9351_8270# 0.14926f
C1384 a_3087_8796# a_363_4894# 0.36229f
C1385 a_11215_10050# a_10891_9310# 0.21667f
C1386 a_14547_11933# a_13495_10050# 0
C1387 a_13171_4790# f2 0
C1388 a_6055_12811# dn 0.09566f
C1389 a_13495_8270# a_13911_8270# 0.19447f
C1390 a_13911_7950# a_7971_9376# 0.00123f
C1391 a_9351_10050# a_7971_9376# 0.21125f
C1392 a_363_9054# f1 0
C1393 a_13495_8270# a_11215_8270# 0.00384f
C1394 a_13911_8270# a_11215_8270# 0.0022f
C1395 a_363_9054# c7 0.31447f
C1396 a_8267_11933# vdd 0.9016f
C1397 a_11173_1814# a_8935_3430# 0
C1398 a_11173_1814# a_7971_1984# 0.46798f
C1399 a_363_8526# a_363_4894# 0.25438f
C1400 a_11173_1814# a_10891_2690# 0.06875f
C1401 a_11631_8270# a_13911_8270# 0.00152f
C1402 a_11215_5530# f2 0.01524f
C1403 a_13495_8270# a_11631_8270# 0
C1404 a_7971_9376# a_13171_7210# 0.00315f
C1405 a_11631_8270# a_11215_8270# 0.19447f
C1406 a_363_6974# a_8893_3298# 0.0074f
C1407 a4 a_3087_4276# 0.14716f
C1408 a_8893_1814# a_7971_9376# 0.54508f
C1409 f6 a_7971_4856# 0.31899f
C1410 a_11631_3750# f3 0.01928f
C1411 a_11631_5530# f2 0.02053f
C1412 a_4622_11162# ckd2 0
C1413 a_8935_8270# a_11215_8270# 0.00384f
C1414 f4 a_10891_4790# 0.06097f
C1415 a_2909_11950# a_1058_11170# 0.13661f
C1416 a_20335_12811# a_16649_11686# 0.69666f
C1417 a_3087_4276# a2 0.14709f
C1418 a_4811_4856# f6 0.1813f
C1419 a_7501_1968# vdd 1.82534f
C1420 a_13171_2690# vdd 0.3473f
C1421 a_6621_1968# a_7971_1984# 0.00113f
C1422 a_8935_3750# f1 0.02818f
C1423 a_411_11960# a_15733_1814# 0
C1424 a_8935_8270# a_11631_8270# 0.0022f
C1425 f0 a_10891_4790# 0
C1426 a_11215_8270# a_9351_8270# 0
C1427 a_10891_4790# f2 0.06671f
C1428 a0 a_3087_4276# 0.13377f
C1429 a_6055_12811# dp 0.11438f
C1430 a_4622_11162# vdd 1.58749f
C1431 a_7971_9376# a_11631_7950# 0.00123f
C1432 a_11631_8270# a_9351_8270# 0.00152f
C1433 en a_4651_12720# 0.20102f
C1434 a_11173_1814# a_9351_3430# 0
C1435 a_11173_1814# a_4811_1984# 0.2278f
C1436 a_15733_1814# a_15775_3430# 0.01523f
C1437 a_15451_9310# a_15469_11950# 0
C1438 ep a_4651_12720# 0.30947f
C1439 a_11215_3430# vdd 0.65214f
C1440 a_6055_12811# rst_n 0.1221f
C1441 f4 a_7971_4856# 0.31993f
C1442 a_8935_8270# a_9351_8270# 0.19447f
C1443 a_23221_12720# vdd 2.75638f
C1444 a_10891_7210# a_7971_9376# 0.00248f
C1445 a_4341_1968# a_4811_6504# 0.01917f
C1446 a_15451_9310# f7 0.3122f
C1447 a_4811_9376# a_10891_9310# 0.3133f
C1448 a_6247_4276# f1 0
C1449 a_6247_2844# a_363_4894# 0.52529f
C1450 a_11631_3430# vdd 0.35238f
C1451 a_1058_11170# a_20664_8208# 0
C1452 a_4341_1968# a_4089_11686# 0.00119f
C1453 f0 a_7971_4856# 0.32562f
C1454 a_7971_4856# f2 0.32103f
C1455 f4 a_4811_4856# 0.18169f
C1456 a_363_6446# vdd 1.39566f
C1457 a_9351_3750# f1 0.01984f
C1458 f7 a_17731_4790# 0.01496f
C1459 a_6621_1968# a_4811_1984# 0.09533f
C1460 a_4651_12720# dn 0.5716f
C1461 a_3087_2844# a_363_4894# 0
C1462 a_4811_4856# f0 0.21309f
C1463 a_17731_1645# a_15451_1645# 0.42375f
C1464 a_5719_11933# a_17182_11162# 0
C1465 a_11173_1814# a_10891_9310# 0.39f
C1466 a_4811_4856# f2 0.18179f
C1467 a_8935_5530# f0 0.01547f
C1468 a_10399_11933# a_10902_11162# 1.05205f
C1469 ckd0 a_1987_11933# 0.00228f
C1470 a_15451_9310# f5 0.01186f
C1471 f0 a_9351_5530# 0.02086f
C1472 f7 a_15775_5530# 0.21136f
C1473 a_411_11960# a_15775_10050# 0
C1474 f7 a_16191_5530# 0.55576f
C1475 a_20664_1816# a_17731_2690# 0.01076f
C1476 a_17731_1645# a_13171_1645# 0.0365f
C1477 a_7971_4856# b7 0.00355f
C1478 a_6068_205# a_4811_6504# 0.09686f
C1479 vdd a_8935_3430# 0.65757f
C1480 vdd a_7971_1984# 7.25862f
C1481 f5 a_15775_5530# 0.00205f
C1482 a_1987_11933# vdd 0.86332f
C1483 a_8267_11933# a_10902_11162# 0
C1484 a_10891_2690# vdd 0.67813f
C1485 en a_16679_11933# 0.01587f
C1486 a_363_4366# a_3461_1968# 0.40054f
C1487 a_4651_12720# dp 0.29992f
C1488 a_15733_1814# a_16191_3430# 0.01744f
C1489 a_4811_4856# b7 0.13529f
C1490 f7 a_15451_4790# 0.30452f
C1491 ep a_16679_11933# 0.13792f
C1492 a_15451_1645# a_13171_1645# 0.86765f
C1493 a_8935_5530# b7 0
C1494 rst_n a_4651_12720# 0.3036f
C1495 a_20664_1816# a_15775_3430# 0
C1496 a_17731_1645# a_10891_1645# 0.04259f
C1497 a_7718_205# a_7501_1968# 0.02093f
C1498 a_17731_1645# a_16191_1650# 0.02054f
C1499 a_17731_1645# a_15775_1650# 0.09703f
C1500 a_11173_1814# a_13171_3745# 0
C1501 a_6247_7364# a_363_2814# 0.52551f
C1502 a_10891_3745# a_11173_1814# 0.06875f
C1503 a_16679_11933# dn 0.04366f
C1504 a_10891_1645# a_15451_1645# 0.03003f
C1505 f5 a_15451_4790# 0.01165f
C1506 b5 a_7971_4856# 0
C1507 a_363_2286# a_4811_4856# 0.00212f
C1508 a_15733_1814# a_15451_2690# 0.06431f
C1509 a_9351_3430# vdd 0.35281f
C1510 a_16191_1650# a_15451_1645# 0.25123f
C1511 a_4811_1984# vdd 6.94675f
C1512 a_15451_1645# a_15775_1650# 0.03954f
C1513 a_4588_205# a_3461_1968# 0
C1514 a_4811_6504# a_7971_9376# 0.00197f
C1515 a_7061_1968# a_1058_11170# 0
C1516 a_15451_1645# a_13495_1650# 0.0933f
C1517 a_5248_205# a_3461_1968# 0
C1518 b5 a_4811_4856# 0.12887f
C1519 a_4089_11686# a_7971_9376# 0.00103f
C1520 a_15733_1814# a_13453_1814# 0.01145f
C1521 a_3461_1968# a_3928_205# 0.02494f
C1522 a_15451_1645# a_13911_1650# 0.01907f
C1523 a_10891_1645# a_13171_1645# 1.33103f
C1524 a_9351_7950# a_7971_9376# 0.00123f
C1525 a_1058_11170# a_22959_11933# 0.21537f
C1526 vdd a_17731_3745# 0.22482f
C1527 a_13495_5530# f7 0.00281f
C1528 a_7971_4856# b3 0
C1529 a_13171_1645# a_15775_1650# 0.04491f
C1530 a_16191_1650# a_13171_1645# 0.04404f
C1531 a_363_9054# rst_n 0
C1532 a_13495_1650# a_13171_1645# 0.05293f
C1533 a_2901_12720# a_4089_11686# 0.40248f
C1534 a_15981_11939# a_23462_11162# 0.5697f
C1535 a_10891_9310# vdd 0.79427f
C1536 a_16679_11933# dp 0.33685f
C1537 a_4811_4856# b3 0.12882f
C1538 a_4811_4856# b1 0.14164f
C1539 a_13171_1645# a_13911_1650# 0.08945f
C1540 a_13495_10050# a_7971_9376# 0.55412f
C1541 a_3461_1968# a_2938_205# 0.20824f
C1542 rst_n a_16679_11933# 0.06334f
C1543 a_17731_8265# a_7971_9376# 0
C1544 a6 a_4811_4856# 0.0104f
C1545 a_3421_11939# a_1058_11170# 0.40348f
C1546 a_20664_1816# a_16191_3430# 0
C1547 a_10891_1645# a_15775_1650# 0.20901f
C1548 a_3268_205# a_3461_1968# 0.02241f
C1549 a_16191_1650# a_10891_1645# 0.03076f
C1550 a_15733_1814# a_13495_3430# 0
C1551 a_363_4366# a_363_6446# 2.23851f
C1552 a_13495_5530# f5 0.21118f
C1553 a_20827_11933# vdd 0.90302f
C1554 a_10891_1645# a_13495_1650# 0.19871f
C1555 f7 a_13911_5530# 0
C1556 a_13171_4790# f7 0.29906f
C1557 a_13495_5530# f3 0.00211f
C1558 a_17731_2690# a_20664_3688# 0.00459f
C1559 a_16191_1650# a_15775_1650# 0.27357f
C1560 a_13171_1645# a_11631_1650# 0.01773f
C1561 a_13495_1650# a_15775_1650# 0.00398f
C1562 a_16191_1650# a_13495_1650# 0.0022f
C1563 a_13171_1645# a_11215_1650# 0.09999f
C1564 cke0 a_4651_12720# 0
C1565 a_8935_10050# a_9351_10050# 0.27357f
C1566 a_10891_1645# a_13911_1650# 0.02908f
C1567 a_15451_3745# vdd 0.23516f
C1568 a_13911_1650# a_15775_1650# 0
C1569 a_16191_1650# a_13911_1650# 0.00157f
C1570 a_13495_1650# a_13911_1650# 0.27357f
C1571 a_3087_8796# a_363_8526# 0.53555f
C1572 a_15775_10050# a_13453_1814# 0
C1573 a_15733_3298# a_7971_9376# 0.3375f
C1574 a_15451_8265# a_7971_9376# 0.02282f
C1575 a_13911_5530# f5 0.55639f
C1576 a_13171_4790# f5 0.37542f
C1577 a_20664_1816# a_15451_2690# 0.01304f
C1578 a_4811_4856# a4 0
C1579 a_8935_10050# a_8893_1814# 0.63357f
C1580 a_10891_1645# a_11631_1650# 0.05822f
C1581 a_13171_4790# f3 0.00656f
C1582 a_10891_1645# a_11215_1650# 0.21667f
C1583 a_10891_1645# a_8935_1650# 0.0967f
C1584 a_18971_12720# a_1058_11170# 0.15846f
C1585 a_13171_3745# vdd 0.3473f
C1586 a_13495_1650# a_11631_1650# 0
C1587 a_11215_5530# f5 0.00245f
C1588 a_4811_4856# a2 0
C1589 a_13453_3298# a_7971_9376# 0.33779f
C1590 f7 a_10891_4790# 0.12876f
C1591 a_13495_1650# a_11215_1650# 0.00398f
C1592 a_10891_3745# vdd 0.67813f
C1593 a_11215_5530# f3 0.21218f
C1594 a_16649_11686# a_22959_11933# 0.23663f
C1595 a_17731_1645# a_17731_2690# 0
C1596 a_13911_1650# a_11631_1650# 0.00157f
C1597 f5 a_11631_5530# 0
C1598 a_11215_1650# a_13911_1650# 0.0022f
C1599 a_11215_5530# f1 0.00218f
C1600 a_9351_1650# a_10891_1645# 0.01879f
C1601 a_15733_1814# a_13911_3430# 0
C1602 a_11631_5530# f3 0.55679f
C1603 a_13171_8265# a_7971_9376# 0.04726f
C1604 a_8893_1814# a_363_2814# 0
C1605 ckd3 a_6055_12811# 0.00504f
C1606 a_11173_3298# a_7971_9376# 0.33779f
C1607 cke2 a_16679_11933# 0.00618f
C1608 a_6055_12811# ckd2 0.00655f
C1609 a_6055_12811# ckd1 0.10895f
C1610 a_10891_4790# f5 0.12307f
C1611 a_15451_1645# a_17731_2690# 0
C1612 a_11215_1650# a_11631_1650# 0.27357f
C1613 a_11173_1814# a_11215_3750# 0.01523f
C1614 a_10891_4790# f3 0.20791f
C1615 a_17731_1645# a_15775_3430# 0
C1616 a_10891_8265# a_7971_9376# 0.08347f
C1617 a_8935_1650# a_11631_1650# 0.0022f
C1618 a_15451_9310# rst_n 0
C1619 f7 a_7971_4856# 0.29008f
C1620 a_8935_1650# a_11215_1650# 0.00398f
C1621 a_363_6446# a_2938_205# 0.3601f
C1622 a_10891_4790# f1 0.00668f
C1623 cke0 a_16679_11933# 0.03248f
C1624 a_13911_10050# a_1418_11110# 0
C1625 a_363_4366# a_4811_1984# 0
C1626 a_4811_4856# f7 0.1891f
C1627 a_6055_12811# vdd 1.7382f
C1628 a_10902_11162# a_10891_9310# 0
C1629 a_8893_3298# a_7971_9376# 0.33759f
C1630 a_17731_2690# a_13171_1645# 0
C1631 a_4811_9376# a_363_9054# 0.03689f
C1632 a_9351_1650# a_11631_1650# 0.00157f
C1633 a_363_6974# a_4341_1968# 0.26307f
C1634 a_9351_1650# a_8935_1650# 0.27357f
C1635 a_9351_1650# a_11215_1650# 0
C1636 a_7971_4856# f5 0.33441f
C1637 a_7971_9376# a_15775_8270# 0.32994f
C1638 a_17221_12720# a_2901_12720# 0.28729f
C1639 a_3087_2844# a_363_8526# 0.39811f
C1640 a_7971_4856# f3 0.33781f
C1641 a_4811_4856# f5 0.19689f
C1642 a_7971_4856# f1 0.38008f
C1643 a_6247_2844# a_8935_1650# 0.0016f
C1644 a_10891_1645# a_17731_2690# 0
C1645 a_15775_3430# a_13171_1645# 0
C1646 a_18971_12720# a_16649_11686# 0.02574f
C1647 a_4811_4856# f3 0.19781f
C1648 vdd a_15775_3750# 0.66315f
C1649 a_8935_5530# f3 0.00281f
C1650 a_16191_8270# a_7971_9376# 0.16534f
C1651 a_9351_5530# f3 0
C1652 a_4811_4856# f1 0.20408f
C1653 a_17731_2690# a_15775_1650# 0
C1654 a_15733_1814# a_13171_2690# 0.05774f
C1655 a_21768_2174# a_10891_2690# 0.00111f
C1656 a_4027_11933# a_4089_11686# 1.66089f
C1657 a_8935_5530# f1 0.21454f
C1658 a_9351_5530# f1 0.5573f
C1659 a_363_2814# a_7971_6504# 0
C1660 a_20664_3688# a_15451_2690# 0.00329f
C1661 a_411_11960# a_15981_11939# 0.09121f
C1662 ckd0 a_4651_12720# 0.02743f
C1663 a_16191_3750# vdd 0.35393f
C1664 a_9351_1650# a_6247_2844# 0
C1665 ckd3 a_4651_12720# 0.02946f
C1666 a_13911_8270# a_7971_9376# 0.1655f
C1667 a_13495_8270# a_7971_9376# 0.33348f
C1668 a_11215_8270# a_7971_9376# 0.33348f
C1669 a_10891_1645# a_15775_3430# 0
C1670 a_6247_8796# a_363_4894# 0.53572f
C1671 a_11173_1814# a_11631_3750# 0.01967f
C1672 a_363_9054# a_6621_1968# 0.33631f
C1673 a_13495_3750# vdd 0.65214f
C1674 a_4651_12720# ckd2 0.32975f
C1675 ckd1 a_4651_12720# 0.03898f
C1676 a_363_6974# a_6068_205# 0.33626f
C1677 a_11173_1814# a_8935_3750# 0
C1678 a_15775_3430# a_15775_1650# 0.06789f
C1679 a_11631_8270# a_7971_9376# 0.1655f
C1680 a_16191_1650# a_15775_3430# 0.00118f
C1681 a_4027_11933# a_13495_10050# 0
C1682 a_8935_8270# a_7971_9376# 0.33369f
C1683 a_3461_1968# a_363_4894# 0.11624f
C1684 a_6247_2844# a_3087_2844# 0
C1685 a_13911_3750# vdd 0.35238f
C1686 a_4651_12720# vdd 7.0016f
C1687 a_4119_11933# a_4089_11686# 0.50896f
C1688 a_9351_8270# a_7971_9376# 0.1655f
C1689 a_16191_10050# a_13495_10050# 0.0022f
C1690 b6 a_7061_1968# 0.02726f
C1691 a_8935_10050# a_4089_11686# 0
C1692 a_17731_1645# a_15451_2690# 0
C1693 b4 a_7061_1968# 0
C1694 a_11215_3750# vdd 0.65214f
C1695 a_11173_1814# a_9351_3750# 0
C1696 a_13171_1645# a_16191_3430# 0
C1697 a_363_6974# a_7971_9376# 0
C1698 a_4811_9376# a_15451_9310# 0.17509f
C1699 a_15451_1645# a_15451_2690# 0.00582f
C1700 a_363_2814# a_4811_6504# 0.04543f
C1701 a_6055_12811# a_10902_11162# 0.00304f
C1702 a_6621_1968# a_6247_4276# 0.27909f
C1703 a_363_2814# a_4089_11686# 0
C1704 a_15733_3298# a_16191_10050# 0
C1705 a_15733_1814# a_7971_1984# 0.45555f
C1706 a_20664_1816# a_13171_2690# 0.02433f
C1707 a_15451_1645# a_13453_1814# 0.00222f
C1708 a_7501_1968# a_363_4894# 0.28921f
C1709 a_10891_9310# a_17182_11162# 0
C1710 a_10891_1645# a_16191_3430# 0
C1711 a_15733_1814# a_10891_2690# 0.06084f
C1712 a_363_6974# a_2901_12720# 0
C1713 a_16191_3430# a_15775_1650# 0.00122f
C1714 a_16191_1650# a_16191_3430# 0.00178f
C1715 a_363_9054# vdd 2.05819f
C1716 a_13171_1645# a_15451_2690# 0
C1717 a_4622_11162# a_363_4894# 0
C1718 a_20827_11933# a_17182_11162# 0.00201f
C1719 a_23462_11162# a_5719_11933# 0.00423f
C1720 a_13171_1645# a_13453_1814# 0.29391f
C1721 a_16679_11933# vdd 1.45349f
C1722 a_13171_8265# a_16191_10050# 0
C1723 a_3087_7364# a_3901_1968# 0.27011f
C1724 a_10891_1645# a_15451_2690# 0
C1725 a_15451_1645# a_13495_3430# 0
C1726 a_11631_3750# vdd 0.35238f
C1727 a_15733_1814# a_4811_1984# 0.22724f
C1728 a_363_4894# a_363_6446# 2.01314f
C1729 a_8935_3750# vdd 0.65757f
C1730 a_15981_11939# a_5719_11933# 0.78787f
C1731 a_17221_12720# a_4027_11933# 0.00703f
C1732 a_13495_1650# a_15451_2690# 0
C1733 a_16191_10050# a_10891_8265# 0
C1734 a_10891_1645# a_13453_1814# 0.31111f
C1735 a_9351_10050# a_1058_11170# 0
C1736 a_15775_1650# a_13453_1814# 0
C1737 a_17731_2690# a_15775_3430# 0.0956f
C1738 a_13495_1650# a_13453_1814# 0.62282f
C1739 a_13495_3430# a_13171_1645# 0
C1740 a_10902_11162# a_4651_12720# 0.00606f
C1741 a_13911_1650# a_13453_1814# 0.18195f
C1742 a_17731_8265# a_17731_9310# 0
C1743 a_8893_1814# a_1058_11170# 0
C1744 a_15733_1814# a_10891_9310# 0.32609f
C1745 a_6247_4276# vdd 0.80937f
C1746 a_16191_10050# a_15775_8270# 0.00118f
C1747 a_363_4894# a_7971_1984# 0
C1748 a_8935_10050# a_10891_8265# 0
C1749 a_9351_3750# vdd 0.35281f
C1750 a_20664_1816# a_10891_2690# 0.02172f
C1751 a_10891_1645# a_13495_3430# 0
C1752 a_11631_1650# a_13453_1814# 0.00163f
C1753 a_10891_3745# a_21602_4674# 0.00111f
C1754 a_11215_1650# a_13453_1814# 0.00687f
C1755 a_14547_11933# a_2901_12720# 0
C1756 a_16191_8270# a_16191_10050# 0.00178f
C1757 a_13495_1650# a_13495_3430# 0.06789f
C1758 a_8893_3298# a_8935_10050# 0.00112f
C1759 a_20664_3688# a_13171_2690# 0.00244f
C1760 a_15451_8265# a_17731_9310# 0
C1761 a_15733_1814# a_15451_3745# 0.06431f
C1762 a_13495_3430# a_13911_1650# 0.00118f
C1763 a_15451_9310# vdd 0.23589f
C1764 a_21768_6694# dp 0.00478f
C1765 f6 a_17731_6165# 0
C1766 a_11173_1814# a_13495_5530# 0
C1767 a_13911_3430# a_13171_1645# 0
C1768 a_20664_1816# a_4811_1984# 0.00151f
C1769 vdd a_3087_4276# 0.77488f
C1770 a_17731_4790# vdd 0.22482f
C1771 a_363_4894# a_4811_1984# 0.04543f
C1772 a_6068_205# a_4341_1968# 0.00778f
C1773 a_17731_2690# a_16191_3430# 0.01721f
C1774 a_8893_3298# a_363_2814# 0.011f
C1775 a_15733_1814# a_13171_3745# 0.05774f
C1776 a_13171_8265# a_17731_9310# 0
C1777 a_15775_10050# a_10891_9310# 0.20901f
C1778 vdd a_15775_5530# 0.66447f
C1779 a_15733_1814# a_10891_3745# 0.06084f
C1780 en a_21768_9194# 0
C1781 a_363_4366# a_363_9054# 0.18238f
C1782 a_10891_1645# a_13911_3430# 0
C1783 a_20664_1816# a_17731_3745# 0.00459f
C1784 a_13171_9310# a_13495_10050# 0.05293f
C1785 a_17731_8265# a_13171_9310# 0
C1786 a_16191_5530# vdd 0.38102f
C1787 a_17731_1645# a_13171_2690# 0
C1788 a_13171_4790# a_11173_1814# 0.00647f
C1789 a_10891_8265# a_17731_9310# 0
C1790 a_15775_3430# a_16191_3430# 0.19447f
C1791 a_3087_8796# a_6247_8796# 0
C1792 a_15451_6165# f6 0.05696f
C1793 a_13171_6165# f6 0.05784f
C1794 a_13495_1650# a_13911_3430# 0.00122f
C1795 a_17221_12720# a_17731_9310# 0
C1796 a_17731_2690# a_15451_2690# 0.37383f
C1797 a_15451_1645# a_13171_2690# 0
C1798 a_11215_5530# a_11173_1814# 0.62299f
C1799 f6 a_10891_6165# 0.06118f
C1800 a_13911_3430# a_13911_1650# 0.00178f
C1801 a_21768_9194# dn 0
C1802 a_8935_8270# a_8935_10050# 0.06789f
C1803 a_15451_4790# vdd 0.23503f
C1804 a_411_11960# a_5719_11933# 0.4026f
C1805 a_1418_11110# a_15469_11950# 0.13232f
C1806 a_11173_1814# a_11631_5530# 0.17743f
C1807 a_3087_8796# a_3461_1968# 0.26114f
C1808 a_2909_11950# a_363_2286# 0
C1809 en a_21602_9194# 0.00194f
C1810 a_15733_3298# a_13171_9310# 0
C1811 a_17731_9310# a_15775_8270# 0
C1812 a_1418_11110# f7 0
C1813 a_8935_10050# a_9351_8270# 0.00122f
C1814 a_15451_8265# a_13171_9310# 0
C1815 a_4651_12720# a_17182_11162# 0.00416f
C1816 a_15775_3430# a_15451_2690# 0.03836f
C1817 a_411_11960# a_13453_1814# 0
C1818 a_15451_3745# a_20664_1816# 0.00329f
C1819 a_15775_6170# f6 0.01523f
C1820 a_21602_6694# dn 0.49196f
C1821 a_11173_1814# a_10891_4790# 0.37641f
C1822 a_3461_1968# a_363_8526# 0.3727f
C1823 a_363_9054# a_5738_205# 0
C1824 f4 a_15451_6165# 0
C1825 a_13171_1645# a_13171_2690# 0.00793f
C1826 f4 a_13171_6165# 0.06189f
C1827 a_13453_3298# a_13171_9310# 0
C1828 a_8935_8270# a_363_2814# 0
C1829 f4 a_10891_6165# 0.06097f
C1830 a_1418_11110# f5 0
C1831 a_13171_6165# f2 0
C1832 a_21602_9194# dn 0.00461f
C1833 a_363_2814# a_9351_8270# 0
C1834 a_15733_1814# a_15775_3750# 0.01523f
C1835 a_1418_11110# f3 0
C1836 a_21768_9194# dp 0.49196f
C1837 a_13171_8265# a_13171_9310# 0.00793f
C1838 a_10891_1645# a_13171_2690# 0
C1839 f0 a_10891_6165# 0
C1840 a_11215_3430# a_13171_1645# 0
C1841 a_20664_1816# a_13171_3745# 0.00244f
C1842 a_10891_6165# f2 0.06671f
C1843 a_1418_11110# f1 0
C1844 a_1058_11170# a_4089_11686# 0.40349f
C1845 a_13171_2690# a_15775_1650# 0
C1846 a_16191_1650# a_13171_2690# 0
C1847 a_11173_1814# a_7971_4856# 0.46842f
C1848 a_363_9054# a_2938_205# 0.17126f
C1849 a_23221_12720# a_23462_11162# 0.2048f
C1850 a_13495_1650# a_13171_2690# 0
C1851 a_13171_9310# a_10891_8265# 0
C1852 a_13495_5530# vdd 0.64333f
C1853 a_15733_1814# a_16191_3750# 0.01744f
C1854 a_17731_1645# a_7971_1984# 0
C1855 a_20335_12811# a_15469_11950# 0.44389f
C1856 a_363_6974# a_363_2814# 0.63107f
C1857 a_17731_1645# a_10891_2690# 0
C1858 a_15733_1814# a_13495_3750# 0
C1859 a_11173_1814# a_4811_4856# 0.22791f
C1860 a_7061_1968# f0 0
C1861 a_15775_3430# a_13495_3430# 0.00384f
C1862 a_17221_12720# a_13171_9310# 0
C1863 a_13911_1650# a_13171_2690# 0
C1864 a_10891_1645# a_11215_3430# 0
C1865 a_8935_5530# a_11173_1814# 0.00662f
C1866 a_11173_1814# a_9351_5530# 0.00152f
C1867 a_14547_11933# a_4027_11933# 0
C1868 a_15451_1645# a_7971_1984# 0.02923f
C1869 a_10891_1645# a_11631_3430# 0
C1870 a_15451_1645# a_10891_2690# 0
C1871 a_15981_11939# a_23221_12720# 0.22138f
C1872 a_20664_3688# a_17731_3745# 0.01076f
C1873 a_6621_1968# a_7971_4856# 0.00113f
C1874 a_1058_11170# a_13495_10050# 0
C1875 a_16191_6170# f6 0.0186f
C1876 a_1418_11110# a_11631_10050# 0
C1877 a_16679_11933# a_17182_11162# 1.04613f
C1878 a_363_4366# a_3087_4276# 0.41377f
C1879 a_16191_3430# a_15451_2690# 0.24946f
C1880 a_13171_4790# vdd 0.34842f
C1881 a_15733_1814# a_13911_3750# 0
C1882 a_13911_5530# vdd 0.37882f
C1883 a_4811_6504# a_3901_1968# 0
C1884 a_11215_1650# a_13171_2690# 0
C1885 a_15733_1814# a_4651_12720# 0
C1886 a_13171_9310# a_15775_8270# 0
C1887 a_7501_1968# a_8935_1650# 0
C1888 a_3461_1968# a_3087_2844# 0.27094f
C1889 a_6621_1968# a_4811_4856# 0.09524f
C1890 a_21602_9194# rst_n 0.00219f
C1891 a_3087_8796# a_363_6446# 0.52733f
C1892 a_11215_5530# vdd 0.64333f
C1893 a_17731_1645# a_4811_1984# 0.00173f
C1894 a_13171_1645# a_7971_1984# 0.05684f
C1895 a_7061_1968# b7 1.32269f
C1896 a_16191_8270# a_13171_9310# 0
C1897 a_10891_2690# a_13171_1645# 0
C1898 a_363_8526# a_363_6446# 2.08613f
C1899 a_11215_3430# a_11631_1650# 0.00118f
C1900 a_7501_1968# a_9351_1650# 0
C1901 a_11215_3430# a_11215_1650# 0.06789f
C1902 a_11631_5530# vdd 0.37882f
C1903 a_11631_3430# a_11631_1650# 0.00178f
C1904 a_15451_1645# a_4811_1984# 0.17509f
C1905 f4 a_13495_6170# 0.01523f
C1906 a_11215_1650# a_11631_3430# 0.00122f
C1907 a_13911_8270# a_13171_9310# 0
C1908 a_13495_8270# a_13171_9310# 0
C1909 a_15451_3745# a_20664_3688# 0.01304f
C1910 a_2901_12720# a_7971_9376# 0
C1911 a_15775_3430# a_13911_3430# 0
C1912 a_7501_1968# a_6247_2844# 0.33178f
C1913 a_11215_8270# a_13171_9310# 0
C1914 a_10891_1645# a_8935_3430# 0
C1915 a_411_11960# a_10399_11933# 0.08463f
C1916 a_10891_1645# a_7971_1984# 0.90173f
C1917 b6 a_8893_1814# 0
C1918 a_10891_4790# vdd 0.79888f
C1919 a_10891_1645# a_10891_2690# 0.27476f
C1920 a_15775_1650# a_7971_1984# 0.46974f
C1921 a_15451_2690# a_13453_1814# 0
C1922 a_16191_1650# a_7971_1984# 0.18974f
C1923 a_5719_11933# a_13453_1814# 0.00199f
C1924 a_13495_1650# a_7971_1984# 0.55412f
C1925 a_10891_2690# a_15775_1650# 0
C1926 a_16191_1650# a_10891_2690# 0
C1927 a_13495_3430# a_16191_3430# 0.0022f
C1928 a_13495_1650# a_10891_2690# 0
C1929 b5 a_7061_1968# 2.15055f
C1930 f4 a_13911_6170# 0.02002f
C1931 a_4811_1984# a_13171_1645# 0.20137f
C1932 a_13911_1650# a_7971_1984# 0.19489f
C1933 a_20664_3688# a_13171_3745# 0.02433f
C1934 en a_1418_11110# 0.05233f
C1935 a_10891_2690# a_13911_1650# 0
C1936 a_15775_10050# a_4651_12720# 0
C1937 a_363_8526# a_1987_11933# 0
C1938 a_10891_3745# a_20664_3688# 0.02172f
C1939 a_411_11960# a_8267_11933# 0.27198f
C1940 ep a_1418_11110# 0.05272f
C1941 a_15733_1814# a_16679_11933# 0
C1942 a_7971_4856# vdd 7.25037f
C1943 a_11631_1650# a_7971_1984# 0.19489f
C1944 a_15451_9310# a_17182_11162# 0
C1945 a_2938_205# a_3087_4276# 0.24675f
C1946 a_10891_1645# a_4811_1984# 0.3133f
C1947 a_8935_1650# a_7971_1984# 0.56846f
C1948 a_11215_1650# a_7971_1984# 0.55412f
C1949 a_8935_1650# a_8935_3430# 0.06789f
C1950 a_13495_3430# a_15451_2690# 0.0933f
C1951 a_10891_2690# a_11631_1650# 0
C1952 a_17221_12720# a_1058_11170# 0.16953f
C1953 a_4811_4856# vdd 6.9616f
C1954 a_17731_2690# a_13171_2690# 0.03661f
C1955 a_10891_2690# a_11215_1650# 0
C1956 a_8935_1650# a_10891_2690# 0
C1957 a_8935_5530# vdd 0.6508f
C1958 a_9351_5530# vdd 0.38069f
C1959 a_4811_1984# a_15775_1650# 0.29957f
C1960 a_16191_1650# a_4811_1984# 0.1741f
C1961 a_7061_1968# b3 0.00265f
C1962 a_3087_2844# a_363_6446# 0.53547f
C1963 a_7061_1968# b1 0
C1964 a_1418_11110# dn 0.05269f
C1965 a_13495_1650# a_4811_1984# 0.31586f
C1966 a_13495_3430# a_13453_1814# 0.01523f
C1967 a_4811_1984# a_13911_1650# 0.17451f
C1968 a_9351_1650# a_8935_3430# 0.00118f
C1969 a_21768_6694# vdd 0.76305f
C1970 a_9351_1650# a_7971_1984# 0.21125f
C1971 a_363_8526# a_4811_1984# 0
C1972 a_411_11960# a_4622_11162# 0.58006f
C1973 a_15775_3430# a_13171_2690# 0.04492f
C1974 a_13911_3430# a_16191_3430# 0.00152f
C1975 a_20827_11933# a_23462_11162# 0
C1976 a_6247_2844# a_7971_1984# 0.29857f
C1977 en a_20335_12811# 0.08144f
C1978 a_6247_2844# a_8935_3430# 0
C1979 a_21602_4674# a_17731_4790# 0
C1980 a_15981_11939# a_10891_9310# 0
C1981 a_4811_1984# a_11631_1650# 0.17451f
C1982 a_4811_1984# a_11215_1650# 0.31586f
C1983 a_8935_1650# a_4811_1984# 0.31586f
C1984 a_4341_1968# a_4119_11933# 0
C1985 a_8935_1650# a_9351_3430# 0.00122f
C1986 ep a_20335_12811# 0.10098f
C1987 f7 a_17731_6165# 0.01496f
C1988 a_15775_10050# a_16679_11933# 0
C1989 a_1418_11110# dp 0.45536f
C1990 a_11215_6170# f2 0.01524f
C1991 a_15981_11939# a_20827_11933# 0.00373f
C1992 a_363_9054# a_363_4894# 0.66432f
C1993 a_20664_3688# a_15775_3750# 0
C1994 a_13911_3430# a_15451_2690# 0.01907f
C1995 a_1418_11110# rst_n 4.33066f
C1996 a_9351_1650# a_4811_1984# 0.17451f
C1997 a_9351_1650# a_9351_3430# 0.00178f
C1998 a_20335_12811# dn 0.08474f
C1999 a_15733_1814# a_15451_9310# 0.26686f
C2000 a_13911_3430# a_13453_1814# 0.0189f
C2001 a_20664_3688# a_16191_3750# 0
C2002 a_10399_11933# a_5719_11933# 0.02018f
C2003 a_15451_6165# f7 0.30452f
C2004 a_13171_6165# f7 0.29906f
C2005 a_6247_2844# a_4811_1984# 0.13378f
C2006 a_6247_2844# a_9351_3430# 0
C2007 a_17731_2690# a_7971_1984# 0
C2008 a_17221_12720# a_16649_11686# 0.07668f
C2009 a_11631_6170# f2 0.02053f
C2010 a_4341_1968# a_363_2814# 0.18092f
C2011 a_21602_4674# a_15451_4790# 0
C2012 a_15733_1814# a_17731_4790# 0.00209f
C2013 a_17731_2690# a_10891_2690# 0.04293f
C2014 f7 a_10891_6165# 0.12876f
C2015 a_3087_2844# a_4811_1984# 0.28568f
C2016 a_8935_3750# a_363_4894# 0
C2017 a_6068_205# a_4119_11933# 0
C2018 f0 a_9351_6170# 0.02086f
C2019 f0 a_8935_6170# 0.01547f
C2020 a_411_11960# a_1987_11933# 0.37023f
C2021 a_13171_2690# a_16191_3430# 0.04458f
C2022 a_6247_7364# f0 0
C2023 a_15733_1814# a_15775_5530# 0.62299f
C2024 a_13171_6165# f5 0.37542f
C2025 a_15451_6165# f5 0.01165f
C2026 a_8267_11933# a_5719_11933# 0
C2027 a_15775_3430# a_7971_1984# 0.32994f
C2028 a_15775_7950# f6 0.19317f
C2029 f6 a_17731_7210# 0.00786f
C2030 a_13171_6165# f3 0.00656f
C2031 a_15775_3430# a_10891_2690# 0.20982f
C2032 a_1418_11110# a_11215_10050# 0
C2033 a_20335_12811# dp 0.13111f
C2034 a_16191_7950# f6 0.50974f
C2035 a_13495_3430# a_13911_3430# 0.19447f
C2036 a_15733_1814# a_16191_5530# 0.1752f
C2037 f5 a_10891_6165# 0.12307f
C2038 a_15775_6170# f7 0.21136f
C2039 a_16191_10050# a_7971_9376# 0.18974f
C2040 a_363_6974# a_1058_11170# 0
C2041 en a_2909_11950# 0.07137f
C2042 a_20335_12811# rst_n 0.01909f
C2043 f3 a_10891_6165# 0.20791f
C2044 a_6247_4276# a_363_4894# 0.40388f
C2045 a_15451_7210# f6 0.25577f
C2046 ep a_2909_11950# 0.10169f
C2047 a_4027_11933# a_2901_12720# 0.38045f
C2048 vdd a_21768_9194# 1.67303f
C2049 f1 a_10891_6165# 0.00668f
C2050 a_17731_2690# a_4811_1984# 0.00315f
C2051 a_363_4894# a_9351_3750# 0
C2052 a_13171_2690# a_15451_2690# 0.81108f
C2053 a_15733_1814# a_15451_4790# 0.25423f
C2054 a_6068_205# a_363_2814# 0.36429f
C2055 b7 a_8935_6170# 0
C2056 a_363_4366# a_4811_4856# 0.01274f
C2057 a_15451_9310# a_15775_10050# 0.03954f
C2058 a_15775_6170# f5 0.00205f
C2059 a_6247_7364# b7 0.15984f
C2060 a_4622_11162# a_5719_11933# 0.68948f
C2061 a_13171_2690# a_13453_1814# 0.06526f
C2062 a_21602_6694# vdd 1.65927f
C2063 a_7061_1968# f1 0
C2064 a_2909_11950# dn 0.08575f
C2065 f6 a_13495_7950# 0.00281f
C2066 f4 a_15775_7950# 0
C2067 a_17731_2690# a_17731_3745# 0.34565f
C2068 a_15775_3430# a_4811_1984# 0.44721f
C2069 a_8935_10050# a_7971_9376# 0.56846f
C2070 a_20335_12811# cke1 0.00371f
C2071 en a_20664_8208# 0
C2072 a_13911_7950# f6 0
C2073 a_23221_12720# a_5719_11933# 0.03743f
C2074 a_363_6974# a_3901_1968# 0.18373f
C2075 a_2901_12720# a_4119_11933# 0.30888f
C2076 f4 a_15451_7210# 0.00715f
C2077 a_21602_9194# vdd 0.76711f
C2078 a_11215_3430# a_13453_1814# 0
C2079 a_411_11960# a_10891_9310# 0
C2080 f6 a_13171_7210# 0.29442f
C2081 a_363_4894# a_3087_4276# 0.14217f
C2082 a_15775_3430# a_17731_3745# 0
C2083 a_13171_4790# a_21602_4674# 0.00111f
C2084 f7 a_13495_6170# 0.00281f
C2085 a_16191_6170# f7 0.55576f
C2086 a_11631_3430# a_13453_1814# 0
C2087 a_16191_3430# a_7971_1984# 0.16534f
C2088 a_6247_7364# b5 0.15274f
C2089 a_363_2814# a_7971_9376# 0.00292f
C2090 a_4811_9376# a_1418_11110# 0
C2091 a_13495_3430# a_13171_2690# 0.05217f
C2092 a_10891_2690# a_16191_3430# 0.02941f
C2093 a_3421_11939# f3 0
C2094 a_18971_12720# a_15469_11950# 0.13423f
C2095 a_411_11960# a_20827_11933# 0.23711f
C2096 f4 a_13495_7950# 0.19317f
C2097 a_3421_11939# f1 0
C2098 a_2909_11950# dp 0.12124f
C2099 cke2 a_20335_12811# 0.00667f
C2100 a_15451_3745# a_17731_2690# 0.00167f
C2101 a_15733_1814# a_13495_5530# 0.00658f
C2102 a_13911_7950# f4 0.51115f
C2103 f7 a_13911_6170# 0
C2104 a_1418_11110# a_11173_1814# 0
C2105 a_13495_6170# f5 0.21118f
C2106 a_2909_11950# rst_n 0.11289f
C2107 a_13495_7950# f2 0
C2108 a_14547_11933# a_1058_11170# 0.05707f
C2109 a_11215_3430# a_13495_3430# 0.00384f
C2110 a_13495_6170# f3 0.00211f
C2111 f4 a_13171_7210# 0.35304f
C2112 a_9351_10050# f0 0
C2113 a_15451_2690# a_7971_1984# 0.02282f
C2114 a_3087_7364# a_363_2286# 0.52571f
C2115 a_6247_7364# b3 0.15266f
C2116 a_10891_4790# a_21602_4674# 0.00111f
C2117 a_15451_3745# a_15775_3430# 0.00443f
C2118 a_6247_7364# b1 0.13645f
C2119 a_10891_2690# a_15451_2690# 0.0247f
C2120 a_13495_3430# a_11631_3430# 0
C2121 a_20664_6336# vdd 0.0297f
C2122 f6 a_10891_7210# 0.12105f
C2123 a_17731_9310# a_7971_9376# 0
C2124 a_17731_2690# a_13171_3745# 0
C2125 a_15733_1814# a_13171_4790# 0.21721f
C2126 a_13171_7210# f2 0.00174f
C2127 a_4811_1984# a_16191_3430# 0.16793f
C2128 a_15733_1814# a_13911_5530# 0.00154f
C2129 f5 a_13911_6170# 0.55639f
C2130 a_15981_11939# a_4651_12720# 0.73425f
C2131 a_13453_1814# a_7971_1984# 0.46601f
C2132 a_3421_11939# a_11631_10050# 0
C2133 a_10891_3745# a_17731_2690# 0
C2134 a_8893_1814# f0 0.88771f
C2135 a_8893_1814# f2 0.00392f
C2136 a_8267_11933# a_10399_11933# 0
C2137 a_10891_2690# a_13453_1814# 0.06084f
C2138 a_7501_1968# a_6247_8796# 0.30051f
C2139 rst_n a_20664_8208# 0.00211f
C2140 a_8893_3298# b6 0
C2141 a_24971_12720# a_4027_11933# 0.09275f
C2142 f4 a_11215_7950# 0.00245f
C2143 a_13911_3430# a_13171_2690# 0.08888f
C2144 a_2901_12720# a_17731_9310# 0.00255f
C2145 a_15775_3430# a_13171_3745# 0
C2146 f4 a_11631_7950# 0
C2147 a_10891_3745# a_15775_3430# 0
C2148 a_7971_6504# f6 0.31899f
C2149 a_3087_7364# b3 0
C2150 a_3087_7364# b1 0.00244f
C2151 f0 a_11215_7950# 0
C2152 a_4622_11162# a_6247_8796# 0
C2153 a_11215_7950# f2 0.19319f
C2154 a_4811_1984# a_15451_2690# 0.18863f
C2155 a_11631_7950# f2 0.51167f
C2156 a_21602_2174# a_21768_6694# 0
C2157 f4 a_10891_7210# 0.12084f
C2158 a_3087_7364# a6 0.15423f
C2159 a_15733_1814# a_10891_4790# 0.31539f
C2160 a_13495_3430# a_7971_1984# 0.33348f
C2161 a_11215_3430# a_13911_3430# 0.0022f
C2162 en a_22959_11933# 0.01536f
C2163 a_10891_2690# a_13495_3430# 0.20051f
C2164 f0 a_10891_7210# 0.00129f
C2165 a_8893_1814# b7 0.00119f
C2166 a_4811_1984# a_13453_1814# 0.22795f
C2167 a_10891_7210# f2 0.19338f
C2168 ep a_22959_11933# 0.13792f
C2169 a_20664_3688# a_17731_4790# 0.03263f
C2170 a_13911_3430# a_11631_3430# 0.00152f
C2171 a_15451_2690# a_17731_3745# 0.00167f
C2172 a_411_11960# a_6055_12811# 0.12844f
C2173 a_1418_11110# ckd0 0
C2174 a_1418_11110# ckd3 0
C2175 a_21602_4674# a_21768_6694# 0.05839f
C2176 a_3087_8796# a_363_9054# 0
C2177 a_1418_11110# ckd1 0
C2178 a_14547_11933# a_16649_11686# 0
C2179 a_1418_11110# ckd2 0
C2180 a_15451_3745# a_16191_3430# 0.01181f
C2181 a_20664_3688# a_15775_5530# 0.00218f
C2182 a_5719_11933# a_10891_9310# 0
C2183 f4 a_7971_6504# 0.31993f
C2184 a_11215_6170# f5 0.00245f
C2185 en a_3421_11939# 0.12904f
C2186 a_15733_1814# a_7971_4856# 0.45592f
C2187 a_22959_11933# dn 0.04367f
C2188 a_3087_7364# a4 0.14716f
C2189 a_15981_11939# a_16679_11933# 0.23856f
C2190 a_363_9054# a_363_8526# 1.95464f
C2191 a_13171_9310# a_7971_9376# 0.05684f
C2192 a_4622_11162# a_8267_11933# 0.00181f
C2193 a_11215_6170# f3 0.21218f
C2194 ep a_3421_11939# 0.16722f
C2195 a_20664_3688# a_16191_5530# 0
C2196 f0 a_7971_6504# 0.32562f
C2197 a_17731_2690# a_15775_3750# 0
C2198 a_7971_6504# f2 0.32103f
C2199 a_10891_9310# a_13453_1814# 0.32181f
C2200 a_3461_1968# a_363_6446# 0.35535f
C2201 a_11215_6170# f1 0.00218f
C2202 a_15733_1814# a_4811_4856# 0.22734f
C2203 a_13495_3430# a_4811_1984# 0.49997f
C2204 a_4341_1968# a_1058_11170# 0
C2205 a_1418_11110# vdd 0.43561f
C2206 a_3087_7364# a2 0.14709f
C2207 a_20827_11933# a_5719_11933# 0
C2208 a_13911_10050# a_13495_10050# 0.27357f
C2209 a_4027_11933# a_4119_11933# 0.57305f
C2210 a_4811_6504# f6 0.1813f
C2211 a_8935_7950# f0 0.19382f
C2212 a_3087_7364# a0 0.13377f
C2213 a_8935_7950# f2 0.00281f
C2214 a_15451_3745# a_15451_2690# 0.14709f
C2215 a_20664_3688# a_15451_4790# 0.05794f
C2216 a_11631_6170# f5 0
C2217 a_2901_12720# a_13171_9310# 0
C2218 a_3421_11939# dn 0.1465f
C2219 a_15775_3430# a_15775_3750# 0.00363f
C2220 a_13911_3430# a_7971_1984# 0.1655f
C2221 a_10891_2690# a_13911_3430# 0.02799f
C2222 a_11631_6170# f3 0.55679f
C2223 a_7061_1968# rst_n 0
C2224 a_11215_3430# a_13171_2690# 0.09999f
C2225 en a_18971_12720# 0.43628f
C2226 a_15451_3745# a_13453_1814# 0
C2227 a_22959_11933# dp 0.36195f
C2228 a_15775_3430# a_16191_3750# 0
C2229 a_8935_6170# f3 0.00281f
C2230 ep a_18971_12720# 0.11299f
C2231 a_363_6974# b6 0
C2232 a_9351_6170# f3 0
C2233 a_7971_6504# b7 0.00355f
C2234 a_13171_2690# a_11631_3430# 0.01773f
C2235 a_13171_3745# a_15451_2690# 0
C2236 a_9351_6170# f1 0.5573f
C2237 a_8935_6170# f1 0.21454f
C2238 rst_n a_22959_11933# 0
C2239 a_4027_11933# a_363_2814# 0
C2240 a_10891_3745# a_15451_2690# 0
C2241 a_6247_7364# f1 0
C2242 a_4341_1968# a_3901_1968# 0.20487f
C2243 a_411_11960# a_4651_12720# 0.47125f
C2244 a_6247_2844# a_363_9054# 0.40148f
C2245 f4 a_4811_6504# 0.18169f
C2246 a_6068_205# a_1058_11170# 0
C2247 a_4811_9376# a_20664_8208# 0.00151f
C2248 a_8935_7950# b7 0.00163f
C2249 a_17731_8265# f6 0.00786f
C2250 a_21602_2174# a_21768_9194# 0
C2251 a_13171_3745# a_13453_1814# 0.06526f
C2252 a_13911_10050# a_13453_3298# 0
C2253 a_18971_12720# dn 0.08839f
C2254 a_20335_12811# vdd 1.76537f
C2255 a_13911_3430# a_4811_1984# 0.17209f
C2256 a_3421_11939# dp 0.17696f
C2257 a_363_9054# a_3087_2844# 0.3697f
C2258 f0 a_4811_6504# 0.21309f
C2259 a_11215_3430# a_11631_3430# 0.19447f
C2260 a_10891_3745# a_13453_1814# 0.06084f
C2261 a_4811_6504# f2 0.18179f
C2262 a_15451_3745# a_13495_3430# 0
C2263 a_15775_7950# f7 0.02585f
C2264 f7 a_17731_7210# 0.00559f
C2265 a_3421_11939# rst_n 0.54343f
C2266 a_16191_7950# f7 0.01825f
C2267 a_15981_11939# a_15451_9310# 0.00204f
C2268 a_22959_11933# cke3 0.01044f
C2269 a_7971_4856# a_363_4894# 0.00292f
C2270 b5 a_7971_6504# 0
C2271 a_13911_10050# a_13171_8265# 0
C2272 a_21602_4674# a_21768_9194# 0
C2273 cke1 a_22959_11933# 0.03084f
C2274 f0 a_9351_7950# 0.51204f
C2275 a_9351_7950# f2 0
C2276 a_15451_7210# f7 0.06713f
C2277 a_3461_1968# a_4811_1984# 0
C2278 a_363_2814# a_4119_11933# 0
C2279 a_4811_4856# a_363_4894# 0.29269f
C2280 a_15733_3298# f6 2.08418f
C2281 a_15451_8265# f6 0.20347f
C2282 a_16191_3430# a_15775_3750# 0
C2283 a_13171_2690# a_7971_1984# 0.04726f
C2284 a_7501_1968# a_8935_3430# 0
C2285 a_7501_1968# a_7971_1984# 0.03475f
C2286 a_13911_10050# a_10891_8265# 0
C2287 f4 a_13495_10050# 0.00104f
C2288 a_10891_2690# a_13171_2690# 1.28363f
C2289 a_21602_9194# a_17182_11162# 0
C2290 a_6055_12811# a_5719_11933# 0.12838f
C2291 a_13495_3430# a_13171_3745# 0.00452f
C2292 a_15775_7950# f5 0.0017f
C2293 a_16191_10050# a_17731_9310# 0.02054f
C2294 a_10891_3745# a_13495_3430# 0
C2295 a_18971_12720# dp 0.13215f
C2296 a_4811_6504# b7 0.13529f
C2297 a_13171_4790# a_20664_3688# 0.02513f
C2298 a_363_8526# a_3087_4276# 0.52758f
C2299 a_4622_11162# a_1987_11933# 0
C2300 a_13453_3298# f6 0.02244f
C2301 a_411_11960# a_363_9054# 0
C2302 a_16191_3750# a_16191_3430# 0.07595f
C2303 a_7971_6504# b3 0
C2304 a_10399_11933# a_10891_9310# 0
C2305 a_15451_7210# f5 0.00457f
C2306 a_11215_3430# a_7971_1984# 0.33348f
C2307 a_11215_3430# a_8935_3430# 0.00384f
C2308 a_2909_11950# ckd0 0.13552f
C2309 a_6247_2844# a_6247_4276# 0
C2310 a_1418_11110# a_10902_11162# 0.10998f
C2311 a_18971_12720# rst_n 0.14082f
C2312 a_11215_3430# a_10891_2690# 0.21782f
C2313 a_2909_11950# ckd2 0.11215f
C2314 a_2909_11950# ckd1 0.00131f
C2315 a_13171_8265# f6 0.23793f
C2316 a_11631_3430# a_8935_3430# 0.0022f
C2317 a_11631_3430# a_7971_1984# 0.1655f
C2318 a_411_11960# a_16679_11933# 0.08194f
C2319 a_15451_2690# a_15775_3750# 0.00443f
C2320 a_2901_12720# a_1058_11170# 0.43225f
C2321 a_10891_2690# a_11631_3430# 0.05647f
C2322 f4 a_15733_3298# 0.03923f
C2323 f4 a_15451_8265# 0.00698f
C2324 f7 a_13171_7210# 0.06169f
C2325 a_4811_1984# a_13171_2690# 0.21318f
C2326 a_7501_1968# a_9351_3430# 0
C2327 a_7501_1968# a_4811_1984# 0.11014f
C2328 a_11173_1814# a_13171_6165# 0.00647f
C2329 a_363_2286# a_4811_6504# 0
C2330 f5 a_13495_7950# 0.02591f
C2331 f6 a_10891_8265# 0.06061f
C2332 a_363_4366# a_1418_11110# 0
C2333 a_16191_3750# a_15451_2690# 0.01181f
C2334 b5 a_4811_6504# 0.12887f
C2335 a_2909_11950# vdd 1.91518f
C2336 a_13495_7950# f3 0.00175f
C2337 a_13495_3750# a_15451_2690# 0
C2338 a_11173_1814# a_10891_6165# 0.37641f
C2339 a_13911_7950# f5 0.01888f
C2340 f4 a_13453_3298# 2.12695f
C2341 a_10891_4790# a_20664_3688# 0.02688f
C2342 a_18971_12720# cke1 0
C2343 a_4811_9376# a_7061_1968# 0.10555f
C2344 a_9351_10050# f3 0
C2345 a_13911_10050# a_13495_8270# 0.00118f
C2346 a_11215_3430# a_9351_3430# 0
C2347 a_13911_10050# a_13911_8270# 0.00178f
C2348 f5 a_13171_7210# 0.06696f
C2349 a_13171_2690# a_17731_3745# 0
C2350 a_13911_3430# a_13171_3745# 0.0091f
C2351 a_11215_3430# a_4811_1984# 0.49997f
C2352 a_13453_3298# f2 0.04615f
C2353 a_9351_10050# f1 0.5648f
C2354 a_13495_3750# a_13453_1814# 0.01523f
C2355 f3 a_13171_7210# 0.00491f
C2356 f4 a_13171_8265# 0.2925f
C2357 a_4811_1984# a_11631_3430# 0.17209f
C2358 a_9351_3430# a_11631_3430# 0.00152f
C2359 f6 a_15775_8270# 0.17929f
C2360 a_4027_11933# a_13171_9310# 0
C2361 f4 a_11173_3298# 0.01665f
C2362 a_20664_6336# a_21602_4674# 0.00258f
C2363 a_8893_1814# f3 0.02148f
C2364 a_5719_11933# a_4651_12720# 0.15729f
C2365 a_8935_3430# a_7971_1984# 0.33369f
C2366 a_4811_1984# a_363_6446# 0.00216f
C2367 a_13171_8265# f2 0.00155f
C2368 a_3087_2844# a_3087_4276# 0
C2369 a_10891_2690# a_8935_3430# 0.09668f
C2370 a_10891_2690# a_7971_1984# 0.08347f
C2371 a_4811_6504# b3 0.12882f
C2372 a_8893_1814# f1 2.50261f
C2373 f4 a_10891_8265# 0.06061f
C2374 f0 a_11173_3298# 0.04614f
C2375 a_16191_10050# a_13171_9310# 0.04404f
C2376 a_4811_6504# b1 0.13923f
C2377 a_11173_3298# f2 2.16213f
C2378 f7 a_10891_7210# 0.06576f
C2379 a_20664_8208# vdd 0.03566f
C2380 a_16649_11686# a_7971_9376# 0
C2381 a_13911_3750# a_13453_1814# 0.0189f
C2382 a6 a_4811_6504# 0.0104f
C2383 cke2 a_18971_12720# 0.39965f
C2384 a_16191_8270# f6 0.49363f
C2385 f0 a_10891_8265# 0.00114f
C2386 a_10891_8265# f2 0.12742f
C2387 a_4811_4856# a_20664_3688# 0.00151f
C2388 a_4811_9376# a_3421_11939# 0
C2389 a_9351_10050# a_11631_10050# 0.00157f
C2390 a_6621_1968# a_7061_1968# 0.20692f
C2391 a_11215_7950# f3 0.0269f
C2392 f3 a_11631_7950# 0.01928f
C2393 a_13495_3750# a_13495_3430# 0.00363f
C2394 a_363_6974# c0 0
C2395 a_15451_3745# a_13171_2690# 0
C2396 a_13495_8270# f6 0.00281f
C2397 a_11215_3750# a_13453_1814# 0
C2398 a_13911_8270# f6 0
C2399 a_18971_12720# cke0 0.02162f
C2400 a_11215_7950# f1 0.00183f
C2401 a_2901_12720# a_16649_11686# 0.26693f
C2402 f5 a_10891_7210# 0.0632f
C2403 f4 a_15775_8270# 0
C2404 a_8893_3298# f0 2.18555f
C2405 a_3421_11939# a_11173_1814# 0
C2406 a_8893_3298# f2 0.02148f
C2407 a_17731_6165# vdd 0.22482f
C2408 f7 a_7971_6504# 0.29008f
C2409 a_20664_3688# a_21768_6694# 0.00258f
C2410 a_10891_7210# f3 0.07058f
C2411 a_4811_1984# a_7971_1984# 1.33349f
C2412 a_4811_1984# a_8935_3430# 0.51454f
C2413 a_9351_3430# a_8935_3430# 0.19447f
C2414 a_9351_3430# a_7971_1984# 0.1655f
C2415 a_15733_1814# a_20664_6336# 0
C2416 a_10891_2690# a_4811_1984# 1.14768f
C2417 a_10891_7210# f1 0.00545f
C2418 a_10891_2690# a_9351_3430# 0.01885f
C2419 a_4811_6504# a4 0
C2420 a_6055_12811# a_10399_11933# 0
C2421 a_13911_3750# a_13495_3430# 0
C2422 a_363_6974# c1 0
C2423 a_13171_3745# a_13171_2690# 0.09415f
C2424 a_363_6974# c2 0
C2425 a_10891_3745# a_13171_2690# 0
C2426 a_11173_1814# a_13495_6170# 0
C2427 a_4811_6504# a2 0
C2428 a_1418_11110# a_17182_11162# 0.1072f
C2429 a_7971_6504# f5 0.33441f
C2430 a_363_6974# c3 0.00101f
C2431 f4 a_13495_8270# 0.17929f
C2432 a_15451_6165# vdd 0.23503f
C2433 f4 a_13911_8270# 0.49363f
C2434 a_10891_2690# a_17731_3745# 0
C2435 a_5719_11933# a_16679_11933# 0
C2436 f4 a_11215_8270# 0.00245f
C2437 a_7971_6504# f3 0.33781f
C2438 a_13171_6165# vdd 0.34842f
C2439 a_363_6974# c4 0.00666f
C2440 a_11215_3430# a_13171_3745# 0
C2441 a_6055_12811# a_8267_11933# 0.20824f
C2442 a_7971_6504# f1 0.38008f
C2443 a_8893_3298# b7 0.0058f
C2444 f4 a_11631_8270# 0
C2445 f0 a_11215_8270# 0
C2446 a_13495_8270# f2 0
C2447 vdd a_10891_6165# 0.79888f
C2448 a_10891_3745# a_11215_3430# 0.00426f
C2449 a_11215_8270# f2 0.17929f
C2450 a_13495_3750# a_13911_3430# 0
C2451 a_4811_1984# a_9351_3430# 0.18866f
C2452 a_363_6974# c5 0.33996f
C2453 a_10891_3745# a_11631_3430# 0.00676f
C2454 a_11631_8270# f2 0.49363f
C2455 a_11631_3750# a_13453_1814# 0
C2456 a_8935_7950# f1 0.02818f
C2457 a_4341_1968# b2 0
C2458 a_7061_1968# vdd 1.1485f
C2459 a_4027_11933# a_1058_11170# 0.30183f
C2460 a_8935_8270# f0 0.1797f
C2461 a_2909_11950# a_363_4366# 0
C2462 a_8935_8270# f2 0.00281f
C2463 f7 a_4811_6504# 0.1891f
C2464 a_6068_205# b6 0
C2465 a_15775_6170# vdd 0.66447f
C2466 a_6247_8796# a_4651_12720# 0
C2467 a_15451_3745# a_7971_1984# 0.00412f
C2468 b4 a_6068_205# 0.00212f
C2469 a_13911_3750# a_13911_3430# 0.07595f
C2470 a_13171_9310# a_17731_9310# 0.0365f
C2471 a_16191_10050# a_1058_11170# 0.00238f
C2472 a_15451_3745# a_10891_2690# 0
C2473 f0 a_9351_8270# 0.49363f
C2474 a_4622_11162# a_6055_12811# 0
C2475 a_9351_8270# f2 0
C2476 a_3421_11939# ckd0 0.07653f
C2477 a_22959_11933# vdd 1.45115f
C2478 a_3421_11939# ckd3 0.02282f
C2479 a_20335_12811# a_17182_11162# 0
C2480 a_3421_11939# ckd1 0.14138f
C2481 a_3421_11939# ckd2 0.06223f
C2482 a_10399_11933# a_4651_12720# 0.57608f
C2483 a_13911_10050# a_14547_11933# 0
C2484 a_4341_1968# b0 0
C2485 a_4811_6504# f5 0.19689f
C2486 a_13171_2690# a_15775_3750# 0
C2487 a_363_6974# f0 0.00121f
C2488 a_13171_3745# a_7971_1984# 0.00315f
C2489 a_4811_6504# f3 0.19781f
C2490 a_15733_1814# a_1418_11110# 0
C2491 a_1058_11170# a_4119_11933# 0.24052f
C2492 a_10891_2690# a_13171_3745# 0
C2493 a_10891_3745# a_7971_1984# 0.00248f
C2494 a_10891_3745# a_8935_3430# 0
C2495 a_8935_8270# b7 0.00162f
C2496 a_4811_6504# f1 0.20408f
C2497 a_3421_11939# vdd 3.01256f
C2498 a_4089_11686# f3 0
C2499 a_10891_3745# a_10891_2690# 0.06958f
C2500 f7 a_13495_10050# 0.00281f
C2501 a_4027_11933# a_3901_1968# 0
C2502 a_8935_10050# a_1058_11170# 0
C2503 a_6068_205# b2 0.11295f
C2504 a_24971_12720# a_16649_11686# 0
C2505 a_17731_8265# f7 0.00559f
C2506 a_15451_3745# a_4811_1984# 0.00419f
C2507 a_4089_11686# f1 0.00335f
C2508 a_8267_11933# a_4651_12720# 0.01621f
C2509 a_11173_1814# a_11215_6170# 0.62299f
C2510 a_4811_4856# a_363_8526# 0
C2511 a_13495_3750# a_13171_2690# 0.00452f
C2512 a_4341_1968# a7 0.02726f
C2513 a_4341_1968# a5 0
C2514 a_9351_7950# f1 0.01984f
C2515 a_6247_8796# a_363_9054# 0.5353f
C2516 a_15451_9310# a_13453_1814# 0.00222f
C2517 a_13495_6170# vdd 0.64333f
C2518 a_16191_6170# vdd 0.38102f
C2519 a_9351_10050# rst_n 0
C2520 f5 a_13495_10050# 0.21677f
C2521 a_15451_3745# a_17731_3745# 0.37383f
C2522 a_6068_205# b0 0.00103f
C2523 a_13495_10050# f3 0.00253f
C2524 a_363_6974# b7 0.27405f
C2525 a_363_2814# a_1058_11170# 0
C2526 a_4811_1984# a_13171_3745# 0.00342f
C2527 a_13911_3750# a_13171_2690# 0.0091f
C2528 a_11631_6170# a_11173_1814# 0.17743f
C2529 a_15733_3298# f7 0.09649f
C2530 a_4027_11933# a_16649_11686# 1.27309f
C2531 a_15451_8265# f7 0.07539f
C2532 a_10891_3745# a_4811_1984# 0.00319f
C2533 a_11631_10050# a_4089_11686# 0.00804f
C2534 a_18971_12720# vdd 1.84018f
C2535 a_363_9054# a_3461_1968# 0.16241f
C2536 a_2909_11950# a_2938_205# 0.00132f
C2537 a_8893_1814# rst_n 0.00108f
C2538 a_13911_6170# vdd 0.37882f
C2539 a_11173_1814# a_8935_6170# 0.00662f
C2540 a_4622_11162# a_4651_12720# 0.64835f
C2541 a_16191_10050# a_16649_11686# 0.00158f
C2542 a_11173_1814# a_9351_6170# 0.00152f
C2543 a_11215_3750# a_13171_2690# 0
C2544 a_13453_1814# a_15775_5530# 0
C2545 a_1418_11110# a_15775_10050# 0
C2546 a_13171_3745# a_17731_3745# 0.03661f
C2547 a_6068_205# a7 0
C2548 a_15733_3298# f5 0.28498f
C2549 a_10891_3745# a_17731_3745# 0.04293f
C2550 a_6068_205# a5 0
C2551 a_15451_8265# f5 0.00478f
C2552 a_363_6974# a_363_2286# 0.24994f
C2553 a_7718_205# a_7061_1968# 0.02294f
C2554 a_13171_8265# f7 0.06995f
C2555 a_363_6974# b5 0.31203f
C2556 a_1058_11170# a_17731_9310# 0
C2557 a_10891_2690# a_15775_3750# 0
C2558 a_11631_10050# a_13495_10050# 0
C2559 a_11215_3430# a_11215_3750# 0.00363f
C2560 a_9351_10050# a_11215_10050# 0
C2561 a_4811_9376# a_3087_7364# 0
C2562 a_4811_4856# a_3087_2844# 0
C2563 a_7058_205# a_7061_1968# 0.0192f
C2564 a_13453_3298# f5 0.0963f
C2565 a_363_2814# a_3901_1968# 0.09231f
C2566 a_6247_7364# a_6621_1968# 0.27908f
C2567 a_15451_4790# a_13453_1814# 0.00222f
C2568 a_11215_3750# a_11631_3430# 0
C2569 f7 a_10891_8265# 0.07402f
C2570 a_17221_12720# a_15469_11950# 0.00411f
C2571 a_13453_3298# f3 0.2868f
C2572 a_16191_3750# a_7971_1984# 0.00123f
C2573 a_20664_6336# a_20664_3688# 0.07079f
C2574 a_7501_1968# a_363_9054# 0.29109f
C2575 a_8893_1814# a_11215_10050# 0
C2576 a_20664_8208# a_17182_11162# 0
C2577 a_13495_3750# a_10891_2690# 0
C2578 a_13171_8265# f5 0.07543f
C2579 a_4811_9376# a_16191_7950# 0.00123f
C2580 a_15451_3745# a_13171_3745# 0.81108f
C2581 a_363_6974# c6 0.00214f
C2582 a_13171_8265# f3 0.00512f
C2583 a_4622_11162# a_363_9054# 0
C2584 a_363_6974# b3 0.31218f
C2585 a_15451_3745# a_10891_3745# 0.0247f
C2586 a_363_6974# b1 0.41087f
C2587 a_11173_3298# f3 0.1291f
C2588 en a_4089_11686# 0.12738f
C2589 a_3421_11939# a_10902_11162# 0.56482f
C2590 a_4811_9376# a_15451_7210# 0.00419f
C2591 a_10891_8265# f5 0.07167f
C2592 a_11173_3298# f1 0.28738f
C2593 a_363_6974# a6 0.13321f
C2594 f7 a_15775_8270# 0.03147f
C2595 ep a_4089_11686# 0.16659f
C2596 a_13911_3750# a_7971_1984# 0.00123f
C2597 a_11215_6170# vdd 0.64333f
C2598 a_10891_8265# f3 0.07906f
C2599 a_7501_1968# a_8935_3750# 0
C2600 a_10891_8265# f1 0.00566f
C2601 a_4811_1984# a_16191_3750# 0.00123f
C2602 a_363_9054# a_363_6446# 0.18457f
C2603 a_10891_3745# a_13171_3745# 1.28363f
C2604 a_16191_8270# f7 0.0283f
C2605 a_363_4366# a_3421_11939# 0
C2606 a_15775_3750# a_17731_3745# 0.0956f
C2607 a_11215_3750# a_10891_2690# 0.00426f
C2608 a_21602_6694# a_15981_11939# 0
C2609 a_4089_11686# dn 0.14564f
C2610 a_11215_3430# a_11631_3750# 0
C2611 f5 a_15775_8270# 0.00212f
C2612 a_13495_5530# a_13453_1814# 0.62299f
C2613 a_11631_6170# vdd 0.37882f
C2614 a_4811_9376# a_9351_10050# 0.17451f
C2615 a_8893_3298# f1 0.16694f
C2616 a_4811_9376# a_13911_7950# 0.00123f
C2617 a_363_6974# a4 0.13011f
C2618 a_11631_10050# a_11173_3298# 0
C2619 a_11631_3750# a_11631_3430# 0.07595f
C2620 a_1058_11170# a_13171_9310# 0
C2621 a_16191_3750# a_17731_3745# 0.01721f
C2622 a_16649_11686# a_17731_9310# 0
C2623 a_7501_1968# a_6247_4276# 0.32265f
C2624 a_3461_1968# a_3087_4276# 0.27002f
C2625 a_8935_6170# vdd 0.6508f
C2626 a_4811_9376# a_13171_7210# 0.00342f
C2627 a_9351_6170# vdd 0.38069f
C2628 a_13911_3750# a_4811_1984# 0.00123f
C2629 a_11631_10050# a_10891_8265# 0
C2630 a_363_6974# a2 0.13057f
C2631 a_11173_1814# a_9351_10050# 0.00536f
C2632 a_6247_7364# vdd 0.80937f
C2633 a_7501_1968# a_9351_3750# 0
C2634 a_4811_9376# a_8893_1814# 0.25422f
C2635 a_15733_1814# a_20664_8208# 0
C2636 a_13911_5530# a_13453_1814# 0.17666f
C2637 a_363_9054# a_8935_3430# 0
C2638 a_363_9054# a_7971_1984# 0
C2639 a_13171_4790# a_13453_1814# 0.28066f
C2640 a_363_6974# a0 0.14299f
C2641 a_11173_1814# a_13171_7210# 0
C2642 a_13495_8270# f5 0.03153f
C2643 a_13911_8270# f5 0.02976f
C2644 a_15451_3745# a_15775_3750# 0.03836f
C2645 a_13495_8270# f3 0.00218f
C2646 a_8893_1814# a_11173_1814# 0.00679f
C2647 a_11215_8270# f3 0.03252f
C2648 a_4089_11686# dp 0.1764f
C2649 a_13911_10050# a_7971_9376# 0.19489f
C2650 a_11215_5530# a_13453_1814# 0.00687f
C2651 a_11215_8270# f1 0.00225f
C2652 a_4811_9376# a_11631_7950# 0.00123f
C2653 a_11631_8270# f3 0.03048f
C2654 a_10891_9310# a_4651_12720# 0
C2655 rst_n a_4089_11686# 0.54261f
C2656 a_11631_5530# a_13453_1814# 0.00163f
C2657 a_15451_3745# a_16191_3750# 0.24946f
C2658 a_15733_1814# a_17731_6165# 0.00209f
C2659 a_7971_4856# a_16191_3430# 0.00123f
C2660 a_11631_3750# a_7971_1984# 0.00123f
C2661 a_15451_3745# a_13495_3750# 0.0933f
C2662 a_3087_7364# vdd 0.77488f
C2663 a_10891_2690# a_11631_3750# 0.00676f
C2664 a_8935_3750# a_8935_3430# 0.00363f
C2665 a_13171_3745# a_15775_3750# 0.04492f
C2666 a_4811_9376# a_10891_7210# 0.00319f
C2667 a_11173_1814# a_11215_7950# 0.01523f
C2668 a_11173_1814# a_11631_7950# 0.01967f
C2669 a_4811_4856# a_16191_3430# 0.00123f
C2670 a_8935_3750# a_10891_2690# 0
C2671 a_8935_8270# f1 0.0338f
C2672 a_10891_3745# a_15775_3750# 0.20982f
C2673 a_10891_4790# a_13453_1814# 0.31111f
C2674 a_363_9054# a_4811_1984# 0.23907f
C2675 a_363_9054# a_9351_3430# 0
C2676 a_2909_11950# a_363_4894# 0
C2677 a_9351_8270# f1 0.03133f
C2678 a_13171_3745# a_16191_3750# 0.04458f
C2679 a_15775_7950# vdd 0.66315f
C2680 a_17731_7210# vdd 0.22482f
C2681 a_11215_8270# a_11631_10050# 0.00118f
C2682 rst_n a_13495_10050# 0
C2683 a_11173_1814# a_10891_7210# 0.06875f
C2684 a_16191_7950# vdd 0.35393f
C2685 a_15451_3745# a_13911_3750# 0.01907f
C2686 a_13495_3750# a_13171_3745# 0.05217f
C2687 a_10891_3745# a_16191_3750# 0.02941f
C2688 a_15733_1814# a_15451_6165# 0.25423f
C2689 f6 a_7971_9376# 0.23711f
C2690 a_15733_1814# a_13171_6165# 0.21721f
C2691 a_7971_4856# a_15451_2690# 0.00412f
C2692 a_15775_10050# a_20664_8208# 0.00218f
C2693 a_13171_9310# a_16649_11686# 0
C2694 a_10891_3745# a_13495_3750# 0.20051f
C2695 en a_17221_12720# 0.07296f
C2696 a_11631_8270# a_11631_10050# 0.00178f
C2697 a_4811_9376# a_7971_6504# 0.00197f
C2698 a_15451_7210# vdd 0.23516f
C2699 ep a_17221_12720# 0.10832f
C2700 a_11215_10050# a_4089_11686# 0
C2701 a_15733_1814# a_10891_6165# 0.31539f
C2702 a_4811_1984# a_11631_3750# 0.00123f
C2703 a_4811_4856# a_15451_2690# 0.00419f
C2704 a_363_6446# a_3087_4276# 0.52808f
C2705 a_363_6974# f1 0
C2706 a_7971_4856# a_13453_1814# 0.46645f
C2707 a_9351_3750# a_8935_3430# 0
C2708 a_9351_3750# a_7971_1984# 0.00123f
C2709 a_8935_3750# a_9351_3430# 0
C2710 a_363_6974# c7 0
C2711 a_8935_3750# a_4811_1984# 0.0038f
C2712 a_13911_3750# a_13171_3745# 0.08888f
C2713 a_4811_9376# a_8935_7950# 0.0038f
C2714 a_11173_1814# a_7971_6504# 0.46842f
C2715 a_4341_1968# a_363_2286# 0.36451f
C2716 a_4811_4856# a_13453_1814# 0.22805f
C2717 a_10891_3745# a_13911_3750# 0.02799f
C2718 a_13495_7950# vdd 0.65214f
C2719 a_17221_12720# dn 0.08548f
C2720 a_16679_11933# a_10891_9310# 0
C2721 a_15733_1814# a_15775_6170# 0.62299f
C2722 a_11215_3750# a_13171_3745# 0.09999f
C2723 f4 a_7971_9376# 0.23711f
C2724 a_9351_10050# vdd 0.38757f
C2725 a_13911_7950# vdd 0.35238f
C2726 a_11215_10050# a_13495_10050# 0.00398f
C2727 a_18971_12720# a_17182_11162# 0.49645f
C2728 a_8935_7950# a_11173_1814# 0
C2729 a_10891_3745# a_11215_3750# 0.21782f
C2730 a_6068_205# b7 0
C2731 a_1418_11110# a_23462_11162# 0.04904f
C2732 f0 a_7971_9376# 0.23714f
C2733 a_7971_9376# f2 0.23711f
C2734 vdd a_13171_7210# 0.3473f
C2735 a_6621_1968# a_7971_6504# 0.00113f
C2736 a_14547_11933# a_15469_11950# 0.21693f
C2737 a_9351_3430# a_9351_3750# 0.07595f
C2738 a_4811_1984# a_9351_3750# 0.00595f
C2739 a_8893_1814# vdd 3.40589f
C2740 a_1418_11110# a_15981_11939# 0.70167f
C2741 a_4341_1968# b1 0.07025f
C2742 a_3087_8796# a_1418_11110# 0
C2743 a_6055_12811# a_4651_12720# 0.14253f
C2744 a_16191_3750# a_15775_3750# 0.19447f
C2745 a_4811_9376# a_4811_6504# 0.00705f
C2746 a_4341_1968# a6 2.22398f
C2747 a_1058_11170# a_3901_1968# 0
C2748 a_6068_205# a_363_2286# 0
C2749 a_13495_3750# a_15775_3750# 0.00384f
C2750 a_17221_12720# dp 0.12361f
C2751 a_4811_9376# a_4089_11686# 0
C2752 a_6068_205# b5 0.00182f
C2753 a_11215_7950# vdd 0.65214f
C2754 vdd a_11631_7950# 0.35238f
C2755 a_17221_12720# rst_n 0.23861f
C2756 a_14547_11933# f5 0
C2757 a_11173_1814# a_4811_6504# 0.22791f
C2758 a_4811_9376# a_9351_7950# 0.00595f
C2759 b7 a_7971_9376# 0.00245f
C2760 a_13495_3750# a_16191_3750# 0.0022f
C2761 a_15733_1814# a_13495_6170# 0.00658f
C2762 a_4811_1984# a_3087_4276# 0
C2763 a_15733_1814# a_16191_6170# 0.1752f
C2764 b0 a_363_2814# 0
C2765 a_11173_1814# a_4089_11686# 0.00848f
C2766 a_13911_3750# a_15775_3750# 0
C2767 a_10891_7210# vdd 0.67813f
C2768 a_20335_12811# a_23462_11162# 0.00306f
C2769 a_363_4366# a_3087_7364# 0.5355f
C2770 a_13171_3745# a_11631_3750# 0.01773f
C2771 a_11173_1814# a_9351_7950# 0
C2772 a_1058_11170# a_16649_11686# 0.42385f
C2773 a_10891_3745# a_11631_3750# 0.05647f
C2774 a_4341_1968# a4 0.00174f
C2775 a_13171_8265# a_11215_10050# 0
C2776 a_7971_4856# a_13911_3430# 0.00123f
C2777 a_4811_9376# a_13495_10050# 0.31586f
C2778 a_7061_1968# a_363_4894# 0.35473f
C2779 a_6068_205# b3 1.42319f
C2780 a_11215_10050# a_11173_3298# 0.00112f
C2781 a_4811_9376# a_17731_8265# 0.00315f
C2782 a_6068_205# b1 2.28785f
C2783 a_10891_3745# a_8935_3750# 0.09668f
C2784 a_15451_9310# a_10891_9310# 0.03003f
C2785 a_6621_1968# a_4811_6504# 0.09533f
C2786 a_13911_3750# a_16191_3750# 0.00152f
C2787 a_17221_12720# cke1 0
C2788 a_17731_4790# a_17731_3745# 0
C2789 a_15733_1814# a_13911_6170# 0.00154f
C2790 a_4811_4856# a_13911_3430# 0.00123f
C2791 a_13495_3750# a_13911_3750# 0.19447f
C2792 a_4341_1968# a2 0
C2793 a_6068_205# a6 0
C2794 a_20335_12811# a_15981_11939# 0.13199f
C2795 a_11215_10050# a_10891_8265# 0
C2796 a_363_2814# a7 0
C2797 a5 a_363_2814# 0
C2798 a_11173_1814# a_13495_10050# 0
C2799 a3 a_363_2814# 0
C2800 a_7971_6504# vdd 7.25037f
C2801 a_4341_1968# a0 0
C2802 a_17731_3745# a_15775_5530# 0
C2803 a_13911_10050# a_16191_10050# 0.00157f
C2804 a_13495_3750# a_11215_3750# 0.00384f
C2805 a_4811_4856# a_3461_1968# 0
C2806 a_4811_9376# a_15733_3298# 0.18022f
C2807 a_4811_9376# a_15451_8265# 0.18863f
C2808 a_8935_7950# vdd 0.65757f
C2809 a_17731_6165# a_20664_3688# 0.0026f
C2810 a_10891_3745# a_9351_3750# 0.01885f
C2811 a_21602_6694# a_5719_11933# 0.00125f
C2812 cke2 a_17221_12720# 0.03677f
C2813 a_3421_11939# a_363_4894# 0
C2814 a_13911_3750# a_11215_3750# 0.0022f
C2815 a_15451_3745# a_17731_4790# 0
C2816 a_15451_4790# a_17731_3745# 0
C2817 a_4811_9376# a_13453_3298# 0.1844f
C2818 a_7718_205# a_8893_1814# 0
C2819 a_17221_12720# cke0 0.32453f
C2820 ckd0 a_4089_11686# 0.0182f
C2821 ckd3 a_4089_11686# 0.06299f
C2822 a_7501_1968# a_7971_4856# 0.0296f
C2823 a_4811_9376# a_13171_8265# 0.21318f
C2824 a_7971_4856# a_13171_2690# 0.00315f
C2825 a_16191_10050# f6 0
C2826 a_4089_11686# ckd2 0.18563f
C2827 ckd1 a_4089_11686# 0.12895f
C2828 a_11173_1814# a_13453_3298# 0.01606f
C2829 a_363_2814# a1 0
C2830 a_3087_7364# a_2938_205# 0.24674f
C2831 a_4811_9376# a_11173_3298# 0.18425f
C2832 a_363_6974# dp 0
C2833 a_13171_3745# a_17731_4790# 0
C2834 a_363_2814# c0 0.01294f
C2835 a_11215_8270# a_11215_10050# 0.06789f
C2836 a_7501_1968# a_4811_4856# 0.10188f
C2837 a_4811_4856# a_13171_2690# 0.00342f
C2838 a_10891_3745# a_17731_4790# 0
C2839 a_4811_9376# a_10891_8265# 1.14768f
C2840 a_7501_1968# a_8935_5530# 0
C2841 a_7501_1968# a_9351_5530# 0
C2842 a_411_11960# a_1418_11110# 4.35869f
C2843 a_363_6974# rst_n 0
C2844 a_11173_1814# a_13171_8265# 0
C2845 a_4811_6504# vdd 6.94603f
C2846 a_11631_8270# a_11215_10050# 0.00122f
C2847 en a_14547_11933# 0.00867f
C2848 a_11173_1814# a_11173_3298# 1.84786f
C2849 a_13171_3745# a_15775_5530# 0
C2850 a_13495_3750# a_11631_3750# 0
C2851 a_4089_11686# vdd 2.22017f
C2852 ep a_14547_11933# 0.5438f
C2853 a_2909_11950# a_3087_8796# 0
C2854 a_15451_3745# a_15451_4790# 0.00582f
C2855 a_10891_3745# a_15775_5530# 0
C2856 a_11173_1814# a_10891_8265# 0.0833f
C2857 a_7971_4856# a_11631_3430# 0.00123f
C2858 a_363_2814# c1 0.34107f
C2859 a_16191_5530# a_13171_3745# 0
C2860 a_9351_7950# vdd 0.35281f
C2861 a_363_2814# c2 0
C2862 a_4811_9376# a_8893_3298# 0.23183f
C2863 a_16679_11933# a_4651_12720# 0.57298f
C2864 a_10891_3745# a_16191_5530# 0
C2865 a_4811_4856# a_11631_3430# 0.00123f
C2866 a_4811_9376# a_15775_8270# 0.44721f
C2867 a_13911_3750# a_11631_3750# 0.00152f
C2868 c3 a_363_2814# 0
C2869 a_14547_11933# dn 0.02571f
C2870 a_4811_4856# a_363_6446# 0
C2871 a_8893_3298# a_11173_1814# 0.00278f
C2872 a_15451_4790# a_13171_3745# 0
C2873 a_363_2814# c4 0
C2874 a_13495_10050# vdd 0.64347f
C2875 a_17731_8265# vdd 0.22482f
C2876 a_10891_3745# a_15451_4790# 0
C2877 a_11215_3750# a_11631_3750# 0.19447f
C2878 a_4811_9376# a_16191_8270# 0.16793f
C2879 a_11215_3750# a_8935_3750# 0.00384f
C2880 a_13171_4790# a_17731_3745# 0
C2881 a_363_2814# c5 0
C2882 a_15469_11950# a_7971_9376# 0
C2883 a_411_11960# a_20335_12811# 0.00765f
C2884 a_4811_9376# a_13495_8270# 0.49997f
C2885 a_4811_9376# a_13911_8270# 0.17209f
C2886 a_4811_9376# a_11215_8270# 0.49997f
C2887 f7 a_7971_9376# 0.29727f
C2888 a_7971_4856# a_10891_2690# 0.00248f
C2889 a_15451_3745# a_13495_5530# 0
C2890 a_8935_10050# f0 0.00104f
C2891 a_17731_4790# a_15775_3750# 0
C2892 a_4811_9376# a_11631_8270# 0.17209f
C2893 a_15733_3298# vdd 2.87794f
C2894 a_4811_4856# a_7971_1984# 0.00197f
C2895 a_15451_8265# vdd 0.23516f
C2896 a_4811_4856# a_8935_3430# 0.0038f
C2897 a_14547_11933# dp 0.08218f
C2898 a_4811_4856# a_10891_2690# 0.00319f
C2899 a_2901_12720# a_15469_11950# 0.07131f
C2900 a_11173_1814# a_11215_8270# 0.02345f
C2901 a_15775_3750# a_15775_5530# 0.06789f
C2902 a_8935_8270# a_4811_9376# 0.51454f
C2903 a_14547_11933# rst_n 0.1416f
C2904 a_11631_8270# a_11173_1814# 0.02125f
C2905 f5 a_7971_9376# 0.34417f
C2906 a_11215_3750# a_9351_3750# 0
C2907 a_13453_3298# vdd 2.87401f
C2908 a_10891_4790# a_17731_3745# 0
C2909 a_4811_9376# a_9351_8270# 0.18866f
C2910 a_15733_1814# a_15775_7950# 0.01523f
C2911 a_16191_5530# a_15775_3750# 0.00118f
C2912 f3 a_7971_9376# 0.34766f
C2913 a_13495_5530# a_13171_3745# 0
C2914 a_15733_1814# a_16191_7950# 0.01744f
C2915 a_13171_4790# a_15451_3745# 0
C2916 a_363_2814# f0 0.00132f
C2917 a_16191_3750# a_15775_5530# 0.00122f
C2918 a_15451_9310# a_4651_12720# 0
C2919 a_10891_3745# a_13495_5530# 0
C2920 a_8935_8270# a_11173_1814# 0.00624f
C2921 a_7971_9376# f1 0.38952f
C2922 a_7971_4856# a_4811_1984# 0.00197f
C2923 a_7971_4856# a_9351_3430# 0.00123f
C2924 a_13171_8265# vdd 0.3473f
C2925 a_15733_1814# a_15451_7210# 0.06431f
C2926 a_16191_5530# a_16191_3750# 0.00178f
C2927 a_11173_1814# a_9351_8270# 0.00338f
C2928 a_11173_3298# vdd 2.89093f
C2929 a_363_4894# a_8935_6170# 0
C2930 a_10902_11162# a_4089_11686# 0.18154f
C2931 a_4811_4856# a_9351_3430# 0.00595f
C2932 a_8935_3750# a_11631_3750# 0.0022f
C2933 a_363_6974# a_4811_9376# 0.03538f
C2934 a_4811_4856# a_4811_1984# 0.00705f
C2935 a_2901_12720# f3 0.00122f
C2936 a_1418_11110# a_5719_11933# 0.45641f
C2937 a_13911_10050# a_13171_9310# 0.08945f
C2938 a_6247_7364# a_363_4894# 0.53519f
C2939 a_363_9054# a_6247_4276# 0.5272f
C2940 a_10891_8265# vdd 0.67813f
C2941 a_13171_4790# a_13171_3745# 0.00793f
C2942 a_13911_5530# a_13171_3745# 0
C2943 a_7971_4856# a_17731_3745# 0
C2944 a_13171_4790# a_10891_3745# 0
C2945 a_17221_12720# vdd 2.58711f
C2946 a_10891_3745# a_13911_5530# 0
C2947 a_23462_11162# a_22959_11933# 1.04613f
C2948 a_1418_11110# a_13453_1814# 0
C2949 a_363_4366# a_4811_6504# 0.00216f
C2950 a_15733_1814# a_13495_7950# 0
C2951 a_411_11960# a_2909_11950# 0.13863f
C2952 a_15451_3745# a_10891_4790# 0
C2953 a_11631_10050# a_7971_9376# 0.19489f
C2954 a_13495_3750# a_15451_4790# 0
C2955 a_11215_5530# a_13171_3745# 0
C2956 a_4811_4856# a_17731_3745# 0.00315f
C2957 a_363_2814# b7 0.32877f
C2958 a_8893_3298# vdd 3.41588f
C2959 a_15733_1814# a_13911_7950# 0
C2960 a_11215_5530# a_10891_3745# 0
C2961 a_13495_10050# a_10902_11162# 0
C2962 a_15775_8270# vdd 0.66315f
C2963 a_15981_11939# a_22959_11933# 0.51567f
C2964 a_10891_3745# a_11631_5530# 0
C2965 a_6247_4276# a_8935_3750# 0
C2966 a_15733_1814# a_13171_7210# 0.05774f
C2967 a_9351_3750# a_11631_3750# 0.00152f
C2968 a_3087_7364# a_363_4894# 0.00204f
C2969 a_2901_12720# a_11631_10050# 0.00106f
C2970 a_363_6974# a_6621_1968# 0.32511f
C2971 a_8935_3750# a_9351_3750# 0.19447f
C2972 f6 a_13171_9310# 0
C2973 a_10891_4790# a_13171_3745# 0
C2974 a_16191_8270# vdd 0.35393f
C2975 a_15451_3745# a_7971_4856# 0.02282f
C2976 a_363_2286# a_363_2814# 2.10952f
C2977 a_10891_3745# a_10891_4790# 0.27476f
C2978 a_363_9054# a_3087_4276# 0.00205f
C2979 a_15451_9310# a_16679_11933# 0
C2980 a_7061_1968# a_8935_1650# 0
C2981 a_20335_12811# a_5719_11933# 0.13681f
C2982 b5 a_363_2814# 0.32591f
C2983 a_15451_3745# a_4811_4856# 0.18863f
C2984 a_3087_8796# a_3421_11939# 0.00148f
C2985 a_13495_8270# vdd 0.65214f
C2986 a_13911_8270# vdd 0.35238f
C2987 a_11215_8270# vdd 0.65214f
C2988 a_4341_1968# rst_n 0
C2989 a_6247_4276# a_9351_3750# 0
C2990 a_11631_8270# vdd 0.35238f
C2991 a_7971_4856# a_13171_3745# 0.04726f
C2992 a_13495_5530# a_13495_3750# 0.06789f
C2993 a5 a_3901_1968# 0.02726f
C2994 a3 a_3901_1968# 0
C2995 a_10891_3745# a_7971_4856# 0.08347f
C2996 a_13171_4790# a_15775_3750# 0
C2997 a_15733_1814# a_10891_7210# 0.06084f
C2998 a_4811_9376# a_14547_11933# 0
C2999 f4 a_13171_9310# 0
C3000 c6 a_363_2814# 0
C3001 a_8935_8270# vdd 0.65897f
C3002 a_4811_4856# a_13171_3745# 0.21318f
C3003 a_6247_2844# a_7061_1968# 0.28045f
C3004 a_363_2814# b3 0.33864f
C3005 a_363_2814# b1 0.49081f
C3006 a_10891_3745# a_4811_4856# 1.14768f
C3007 a_8935_5530# a_10891_3745# 0
C3008 a6 a_363_2814# 0.06427f
C3009 a_13495_5530# a_13911_3750# 0.00122f
C3010 a_13171_4790# a_16191_3750# 0
C3011 a_9351_8270# vdd 0.35281f
C3012 a_15981_11939# a_18971_12720# 0.44658f
C3013 a_13171_4790# a_13495_3750# 0
C3014 a_13495_3750# a_13911_5530# 0.00118f
C3015 a_4027_11933# a_15469_11950# 1.05635f
C3016 a_13911_10050# a_1058_11170# 0
C3017 en a_2901_12720# 0.20907f
C3018 ep a_2901_12720# 0.29124f
C3019 a_6247_4276# a_3087_4276# 0
C3020 a_15733_1814# a_7971_6504# 0.45592f
C3021 a_6068_205# rst_n 0
C3022 a_16191_10050# a_15469_11950# 0
C3023 a_363_6974# vdd 1.80712f
C3024 a_1418_11110# a_10399_11933# 0.15119f
C3025 a_10891_4790# a_15775_3750# 0
C3026 a_16191_10050# f7 0.56184f
C3027 a_8893_1814# a_363_4894# 0
C3028 a_13911_3750# a_13911_5530# 0.00178f
C3029 a_13171_4790# a_13911_3750# 0
C3030 a_7718_205# a_8893_3298# 0.0013f
C3031 a_363_2814# a4 0.06131f
C3032 a_2909_11950# a_5719_11933# 0.09836f
C3033 a_2901_12720# dn 0.24344f
C3034 a_4027_11933# f5 0
C3035 a_10891_4790# a_16191_3750# 0
C3036 a_13171_4790# a_11215_3750# 0
C3037 a_13495_3750# a_10891_4790# 0
C3038 a_4027_11933# f3 0
C3039 a_363_2814# a2 0.05916f
C3040 a_1418_11110# a_8267_11933# 0.0582f
C3041 a_7971_4856# a_15775_3750# 0.32994f
C3042 a0 a_363_2814# 0.06059f
C3043 a_11215_5530# a_11215_3750# 0.06789f
C3044 rst_n a_7971_9376# 0
C3045 a_11215_3750# a_11631_5530# 0.00118f
C3046 a_4811_4856# a_15775_3750# 0.44721f
C3047 a_10891_4790# a_13911_3750# 0
C3048 a_20827_11933# a_21768_9194# 0
C3049 a_7971_4856# a_16191_3750# 0.16534f
C3050 a_17731_4790# a_15775_5530# 0.09703f
C3051 a_13495_3750# a_7971_4856# 0.33348f
C3052 a_2901_12720# dp 0.29616f
C3053 a_15733_1814# a_4811_6504# 0.22734f
C3054 a_4811_4856# a_16191_3750# 0.16793f
C3055 a_10891_4790# a_11215_3750# 0
C3056 a_4027_11933# a_11631_10050# 0.00345f
C3057 a_411_11960# a_3421_11939# 0.45194f
C3058 a_4811_9376# a_4341_1968# 0.01234f
C3059 a_16191_5530# a_17731_4790# 0.02054f
C3060 a_2901_12720# rst_n 0.43574f
C3061 a_13495_3750# a_4811_4856# 0.49997f
C3062 a_1418_11110# a_4622_11162# 0.11f
C3063 a_8935_10050# f3 0.00281f
C3064 a_21602_9194# a_10891_9310# 0.00111f
C3065 a_7971_6504# a_363_4894# 0.00265f
C3066 a_8935_10050# f1 0.22012f
C3067 a_13911_3750# a_7971_4856# 0.1655f
C3068 a_16191_5530# a_15775_5530# 0.27357f
C3069 a_1418_11110# a_23221_12720# 0
C3070 a_14547_11933# vdd 0.86507f
C3071 a_15451_4790# a_17731_4790# 0.42375f
C3072 a_20827_11933# a_21602_9194# 0.00121f
C3073 a_4811_4856# a_13911_3750# 0.17209f
C3074 a_11215_10050# a_7971_9376# 0.55412f
C3075 a_8935_7950# a_363_4894# 0
C3076 a_11215_3750# a_7971_4856# 0.33348f
C3077 a_15733_1814# a_13495_10050# 0.01207f
C3078 a_2901_12720# cke1 0
C3079 en a_24971_12720# 0.0673f
C3080 a_15451_4790# a_15775_5530# 0.03954f
C3081 a_11215_5530# a_11631_3750# 0.00122f
C3082 ep a_24971_12720# 0.1147f
C3083 a_4811_4856# a_11215_3750# 0.49997f
C3084 a_363_2814# f1 0
C3085 f7 a_17731_9310# 0.01496f
C3086 a_411_11960# a_18971_12720# 0.30498f
C3087 a_363_2814# c7 0
C3088 a_16191_5530# a_15451_4790# 0.25123f
C3089 a_8935_10050# a_11631_10050# 0.0022f
C3090 a_11631_5530# a_11631_3750# 0.00178f
C3091 a_2901_12720# a_11215_10050# 0
C3092 a_6068_205# a_4811_9376# 0.10942f
C3093 a_17221_12720# a_17182_11162# 0.19697f
C3094 a_15451_6165# a_13453_1814# 0.00222f
C3095 a_13171_6165# a_13453_1814# 0.28066f
C3096 a_10891_4790# a_11631_3750# 0
C3097 a_24971_12720# dn 0.08868f
C3098 en a_4027_11933# 0.2028f
C3099 a_363_6974# a_363_4366# 0.3187f
C3100 a_15733_1814# a_15733_3298# 1.7786f
C3101 a_15733_1814# a_15451_8265# 0.07762f
C3102 a_10891_4790# a_8935_3750# 0
C3103 a_13453_1814# a_10891_6165# 0.31111f
C3104 a_363_9054# a_7971_4856# 0
C3105 cke2 a_2901_12720# 0.03045f
C3106 a_3087_8796# a_3087_7364# 0
C3107 a_1418_11110# a_1987_11933# 0.05488f
C3108 ep a_4027_11933# 0.30153f
C3109 a_20335_12811# a_23221_12720# 0.00162f
C3110 a_4811_6504# a_363_4894# 0.04849f
C3111 a_2909_11950# a_3461_1968# 0
C3112 a_363_9054# a_4811_4856# 0.0359f
C3113 a_363_4894# a_4089_11686# 0
C3114 a_15733_1814# a_13453_3298# 0.00159f
C3115 a_363_2286# a_1058_11170# 0
C3116 a_3087_7364# a_363_8526# 0.54524f
C3117 a_2901_12720# cke0 0.31819f
C3118 a_5719_11933# a_22959_11933# 0.57391f
C3119 a_6068_205# a_6621_1968# 0.21033f
C3120 a_15775_6170# a_13453_1814# 0
C3121 a_13495_5530# a_15775_5530# 0.00398f
C3122 a_4027_11933# dn 0.24462f
C3123 a_15775_10050# a_13495_10050# 0.00398f
C3124 a_7971_4856# a_11631_3750# 0.1655f
C3125 a_4811_9376# a_7971_9376# 1.33349f
C3126 a_17731_8265# a_15775_10050# 0
C3127 a_15733_1814# a_13171_8265# 0.06845f
C3128 a_7971_4856# a_8935_3750# 0.33369f
C3129 en a_4119_11933# 0.02244f
C3130 a_13495_5530# a_16191_5530# 0.0022f
C3131 a_24971_12720# dp 0.19643f
C3132 a_4811_4856# a_11631_3750# 0.17209f
C3133 a_13171_4790# a_17731_4790# 0.0365f
C3134 ep a_4119_11933# 0.13915f
C3135 a_13171_9310# a_15469_11950# 0
C3136 a_4811_4856# a_8935_3750# 0.51454f
C3137 a_11173_1814# a_7971_9376# 0.48387f
C3138 a_15733_1814# a_10891_8265# 0.07154f
C3139 a_8935_5530# a_8935_3750# 0.06789f
C3140 a_9351_5530# a_8935_3750# 0.00118f
C3141 a_3421_11939# a_5719_11933# 0.24485f
C3142 f7 a_13171_9310# 0.30729f
C3143 a_13171_4790# a_15775_5530# 0.04491f
C3144 a_13911_5530# a_15775_5530# 0
C3145 a_4341_1968# vdd 1.28875f
C3146 a_13495_5530# a_15451_4790# 0.0933f
C3147 a_15733_3298# a_15775_10050# 0.00112f
C3148 a_14547_11933# a_10902_11162# 0.00181f
C3149 a_363_2286# a_3901_1968# 0.3896f
C3150 a_6247_4276# a_7971_4856# 0.29857f
C3151 a_4119_11933# dn 0.04861f
C3152 b0 a7 0.03612f
C3153 a_13171_4790# a_16191_5530# 0.04404f
C3154 a_13911_5530# a_16191_5530# 0.00157f
C3155 a_11173_1814# a_2901_12720# 0
C3156 a_2909_11950# a_4622_11162# 0.01052f
C3157 a_4027_11933# dp 0.31279f
C3158 a_7971_4856# a_9351_3750# 0.1655f
C3159 a_6621_1968# a_7971_9376# 0
C3160 a_6247_4276# a_4811_4856# 0.13378f
C3161 a_24971_12720# cke3 0.41939f
C3162 a_15733_1814# a_15775_8270# 0.02299f
C3163 a_1418_11110# a_10891_9310# 0
C3164 a_13171_9310# f5 0.38286f
C3165 a_20664_1816# a_15733_3298# 0
C3166 a_4027_11933# rst_n 0.32024f
C3167 a_24971_12720# cke1 0.02652f
C3168 a_8935_5530# a_6247_4276# 0.0016f
C3169 a_10891_4790# a_17731_4790# 0.04259f
C3170 a_363_6974# a_2938_205# 0.19298f
C3171 a_6247_4276# a_9351_5530# 0
C3172 a_8893_1814# a_10891_1645# 0.00918f
C3173 a_13171_9310# f3 0.00677f
C3174 a_4811_4856# a_9351_3750# 0.18866f
C3175 a_13911_5530# a_15451_4790# 0.01907f
C3176 a_13171_4790# a_15451_4790# 0.86765f
C3177 a_13495_6170# a_13453_1814# 0.62299f
C3178 a_8935_5530# a_9351_3750# 0.00122f
C3179 a_9351_5530# a_9351_3750# 0.00178f
C3180 a_16191_10050# rst_n 0
C3181 a_18971_12720# a_5719_11933# 0.43642f
C3182 a_2901_12720# a_6621_1968# 0.00137f
C3183 a_1418_11110# a_20827_11933# 0.06809f
C3184 a_13171_8265# a_15775_10050# 0
C3185 a_10891_4790# a_15775_5530# 0.20901f
C3186 a_15733_1814# a_16191_8270# 0.01901f
C3187 a_6068_205# vdd 1.05452f
C3188 a_10891_4790# a_16191_5530# 0.03076f
C3189 a_4119_11933# dp 0.33858f
C3190 a_4027_11933# cke3 0.20264f
C3191 a_13911_6170# a_13453_1814# 0.17666f
C3192 a_15733_1814# a_13495_8270# 0.0053f
C3193 a_15775_10050# a_10891_8265# 0
C3194 a6 a_3901_1968# 1.32835f
C3195 a_15733_1814# a_13911_8270# 0.00293f
C3196 a_4027_11933# cke1 0.1536f
C3197 a_7971_4856# a_17731_4790# 0
C3198 a_6247_8796# a_7061_1968# 0.26511f
C3199 rst_n a_4119_11933# 0.06631f
C3200 a_4811_4856# a_3087_4276# 0.28568f
C3201 a_4811_4856# a_17731_4790# 0.00173f
C3202 a_11631_10050# a_13171_9310# 0.01773f
C3203 a_8893_1814# a_11215_1650# 0
C3204 a_4027_11933# a_11215_10050# 0
C3205 a_7971_4856# a_15775_5530# 0.46974f
C3206 a_10891_4790# a_15451_4790# 0.03003f
C3207 a_8935_10050# rst_n 0
C3208 a_8893_1814# a_8935_1650# 0.62504f
C3209 a_7971_4856# a_16191_5530# 0.18974f
C3210 a_4811_4856# a_15775_5530# 0.29957f
C3211 a_2909_11950# a_1987_11933# 0.21693f
C3212 a_15775_10050# a_15775_8270# 0.06789f
C3213 a_13171_4790# a_13495_5530# 0.05293f
C3214 a_2901_12720# ckd0 0.60925f
C3215 a_13495_5530# a_13911_5530# 0.27357f
C3216 a4 a_3901_1968# 2.16021f
C3217 ckd3 a_2901_12720# 0.1266f
C3218 a_8893_1814# a_9351_1650# 0.1846f
C3219 a_4811_4856# a_16191_5530# 0.1741f
C3220 a_1058_11170# a_15469_11950# 0.13643f
C3221 cke2 a_4027_11933# 0.23657f
C3222 a_20335_12811# a_20827_11933# 0.21007f
C3223 a_2901_12720# ckd2 0.14224f
C3224 a_2901_12720# ckd1 0.30386f
C3225 a_8893_3298# a_363_4894# 0.00663f
C3226 a_7971_9376# vdd 7.25729f
C3227 a_363_2814# rst_n 0
C3228 f7 a_1058_11170# 0
C3229 a_16191_8270# a_15775_10050# 0.00122f
C3230 a_7971_4856# a_15451_4790# 0.02923f
C3231 a_3901_1968# a2 0.00253f
C3232 a_11215_5530# a_13495_5530# 0.00398f
C3233 a_8893_1814# a_6247_2844# 0
C3234 a_4027_11933# cke0 0.09593f
C3235 b6 f0 0
C3236 a0 a_3901_1968# 0
C3237 a_13495_5530# a_11631_5530# 0
C3238 a_4811_4856# a_15451_4790# 0.17509f
C3239 a_13171_4790# a_13911_5530# 0.08945f
C3240 a_8935_10050# a_11215_10050# 0.00398f
C3241 a_3421_11939# a_10399_11933# 0.50791f
C3242 a_2901_12720# vdd 4.16479f
C3243 a_14547_11933# a_17182_11162# 0
C3244 a_11215_6170# a_13453_1814# 0.00687f
C3245 a_1058_11170# f5 0
C3246 a_3421_11939# a_3461_1968# 0
C3247 a_15733_3298# a_20664_3688# 0
C3248 a_13495_5530# a_10891_4790# 0.19871f
C3249 a_1418_11110# a_6055_12811# 0.13227f
C3250 a_7501_1968# a_7061_1968# 0.2057f
C3251 a_13171_4790# a_11215_5530# 0.09999f
C3252 a_11215_5530# a_13911_5530# 0.0022f
C3253 a_1058_11170# f3 0
C3254 a_4341_1968# a_363_4366# 0.34741f
C3255 a_1058_11170# f1 0
C3256 rst_n a_17731_9310# 0
C3257 a_13171_4790# a_11631_5530# 0.01773f
C3258 a_13911_5530# a_11631_5530# 0.00157f
C3259 a_4811_9376# a_4027_11933# 0
C3260 a_3421_11939# a_8267_11933# 0
C3261 a_11631_6170# a_13453_1814# 0.00163f
C3262 a_4811_9376# a_16191_10050# 0.1741f
C3263 b6 b7 0.05984f
C3264 a_6398_205# a_4341_1968# 0
C3265 a_6068_205# a_7718_205# 0
C3266 a_11215_5530# a_11631_5530# 0.27357f
C3267 a_13171_4790# a_10891_4790# 1.33103f
C3268 a_10891_4790# a_13911_5530# 0.02908f
C3269 a_11173_1814# a_4027_11933# 0
C3270 a_13495_5530# a_7971_4856# 0.55412f
C3271 a_8935_8270# a_363_4894# 0
C3272 a_411_11960# a_8893_1814# 0
C3273 a_6068_205# a_7058_205# 0.00173f
C3274 a_11215_5530# a_10891_4790# 0.21667f
C3275 a_13495_5530# a_4811_4856# 0.31586f
C3276 a_363_4894# a_9351_8270# 0
C3277 a_4341_1968# a_4588_205# 0.02123f
C3278 a_4341_1968# a_5248_205# 0.02294f
C3279 a_3087_8796# a_4811_6504# 0
C3280 a_1058_11170# a_11631_10050# 0
C3281 a_16649_11686# a_15469_11950# 0.11745f
C3282 a_23221_12720# a_22959_11933# 0.17636f
C3283 a_4341_1968# a_5738_205# 0
C3284 a_3087_8796# a_4089_11686# 0.00172f
C3285 a_10891_4790# a_11631_5530# 0.05822f
C3286 a_6068_205# a_363_4366# 0
C3287 f7 a_16649_11686# 0
C3288 a_4622_11162# a_3421_11939# 0.19293f
C3289 a_4811_6504# a_363_8526# 0.01284f
C3290 a_4811_9376# a_8935_10050# 0.31586f
C3291 c1 c0 0.05689f
C3292 a_7971_4856# a_13911_5530# 0.19489f
C3293 a_13171_4790# a_7971_4856# 0.05684f
C3294 a_15451_1645# a_15733_3298# 0.06344f
C3295 b5 b6 0.04935f
C3296 b4 b5 0.0564f
C3297 a_363_6974# a_363_4894# 2.70636f
C3298 a_10891_9310# a_20664_8208# 0.02688f
C3299 a_363_8526# a_4089_11686# 0
C3300 a_4811_4856# a_13911_5530# 0.17451f
C3301 a_13171_4790# a_4811_4856# 0.20137f
C3302 a_6068_205# a_6398_205# 0.04965f
C3303 a_11215_5530# a_7971_4856# 0.55412f
C3304 a_1418_11110# a_4651_12720# 0.42645f
C3305 a_8935_10050# a_11173_1814# 0.013f
C3306 a_7061_1968# a_7971_1984# 0.00212f
C3307 a_3421_11939# a_363_6446# 0
C3308 a_20827_11933# a_20664_8208# 0
C3309 a_4341_1968# a_2938_205# 0
C3310 a_7971_4856# a_11631_5530# 0.19489f
C3311 c2 c1 0.033f
C3312 a_11215_5530# a_4811_4856# 0.31586f
C3313 a_15733_3298# a_13171_1645# 0.05997f
C3314 a_21602_9194# a_15451_9310# 0
C3315 a_13171_9310# rst_n 0
C3316 a_4811_9376# a_363_2814# 0.29269f
C3317 a_11215_5530# a_8935_5530# 0.00398f
C3318 a_11215_5530# a_9351_5530# 0
C3319 a_6068_205# a_4588_205# 0
C3320 a_6068_205# a_5248_205# 0
C3321 b6 b3 0
C3322 a_4811_4856# a_11631_5530# 0.17451f
C3323 b6 b1 0
C3324 a_2901_12720# a_10902_11162# 0.69021f
C3325 b4 b3 0.05183f
C3326 b4 b1 0.00136f
C3327 a_6068_205# a_5738_205# 0.02124f
C3328 a_8935_5530# a_11631_5530# 0.0022f
C3329 b5 b2 0
C3330 a_10891_4790# a_7971_4856# 0.90173f
C3331 a_9351_5530# a_11631_5530# 0.00157f
C3332 c3 c2 0.05689f
C3333 a_24971_12720# vdd 2.09138f
C3334 a_13453_3298# a_13171_1645# 0.069f
C3335 a_4027_11933# ckd0 0.0512f
C3336 ckd3 a_4027_11933# 0.25607f
C3337 en a_1058_11170# 0.04759f
C3338 a_10891_1645# a_15733_3298# 0.06306f
C3339 a_4811_4856# a_10891_4790# 0.3133f
C3340 a_4027_11933# ckd1 0.37673f
C3341 a_15451_7210# a_13453_1814# 0
C3342 a_4027_11933# ckd2 0.25194f
C3343 ep a_1058_11170# 0.06255f
C3344 a_8935_5530# a_10891_4790# 0.0967f
C3345 a_15733_3298# a_15775_1650# 0.01741f
C3346 a_16191_1650# a_15733_3298# 0
C3347 a_10891_4790# a_9351_5530# 0.01879f
C3348 c3 c4 0.033f
C3349 a_15733_3298# a_13495_1650# 0.00739f
C3350 a_7061_1968# a_4811_1984# 0.09565f
C3351 a_4811_9376# a_17731_9310# 0.00173f
C3352 a_3421_11939# a_1987_11933# 0
C3353 a_10891_1645# a_13453_3298# 0.06306f
C3354 a_15733_3298# a_13911_1650# 0.00481f
C3355 a_6247_7364# a_6247_8796# 0
C3356 a_6621_1968# a_363_2814# 0.36898f
C3357 b2 b3 0.05611f
C3358 a_13171_9310# a_11215_10050# 0.09999f
C3359 a_4027_11933# vdd 3.11238f
C3360 a_2909_11950# a_6055_12811# 0.44177f
C3361 b2 b1 0.07309f
C3362 a_13495_7950# a_13453_1814# 0.01523f
C3363 a_13453_3298# a_13495_1650# 0.01768f
C3364 a_1058_11170# dn 0.05691f
C3365 c4 c5 0.05689f
C3366 a_13911_10050# f4 0
C3367 a_4811_4856# a_7971_4856# 1.33349f
C3368 a_1418_11110# a_16679_11933# 0.14787f
C3369 ckd0 a_4119_11933# 0.00131f
C3370 a_13911_7950# a_13453_1814# 0.0189f
C3371 a_13453_3298# a_13911_1650# 0
C3372 a_10891_1645# a_11173_3298# 0.07474f
C3373 a_8935_5530# a_7971_4856# 0.56846f
C3374 a_16191_10050# vdd 0.3879f
C3375 a_4119_11933# ckd2 0.01256f
C3376 a_9351_5530# a_7971_4856# 0.21125f
C3377 a_20664_6336# a_17731_4790# 0.0026f
C3378 a_13453_1814# a_13171_7210# 0.06526f
C3379 a_8935_5530# a_4811_4856# 0.31586f
C3380 a_4811_4856# a_9351_5530# 0.17451f
C3381 b0 b1 0.06084f
C3382 b0 b3 0
C3383 a_8935_5530# a_9351_5530# 0.27357f
C3384 a_13453_3298# a_11631_1650# 0.00504f
C3385 a_13453_3298# a_11215_1650# 0.00796f
C3386 a_15981_11939# a_17221_12720# 0.50749f
C3387 a_4119_11933# vdd 1.47803f
C3388 a_411_11960# a_4089_11686# 0.4515f
C3389 a_8935_10050# vdd 0.65235f
C3390 a_1058_11170# dp 0.06925f
C3391 a_11173_3298# a_11631_1650# 0
C3392 f4 f6 0.00356f
C3393 a7 b3 0
C3394 en a_16649_11686# 0.12754f
C3395 a_11173_3298# a_11215_1650# 0.01803f
C3396 a_11215_7950# a_13453_1814# 0
C3397 a_20827_11933# a_22959_11933# 0
C3398 a_13453_1814# a_11631_7950# 0
C3399 a_8935_1650# a_11173_3298# 0.00856f
C3400 b1 a7 0.00226f
C3401 a_1058_11170# rst_n 4.37505f
C3402 a_3087_7364# a_3461_1968# 0.27001f
C3403 a5 b1 0
C3404 ep a_16649_11686# 0.16655f
C3405 a_7501_1968# a_8935_6170# 0
C3406 a6 a7 0.04935f
C3407 a_7501_1968# a_9351_6170# 0
C3408 a6 a5 0.05984f
C3409 a_6247_7364# a_7501_1968# 0.32265f
C3410 a_4811_9376# a_13171_9310# 0.20137f
C3411 a_10891_7210# a_13453_1814# 0.06084f
C3412 a_411_11960# a_13495_10050# 0
C3413 a_2909_11950# a_4651_12720# 0.02198f
C3414 a_363_2814# vdd 2.35799f
C3415 a_9351_1650# a_11173_3298# 0.00541f
C3416 a_363_2286# c0 0.32678f
C3417 a_2901_12720# a_17182_11162# 0.68915f
C3418 a_16649_11686# dn 0.14533f
C3419 a_11173_1814# a_13171_9310# 0.00647f
C3420 a_8893_3298# a_8935_1650# 0.0191f
C3421 a_1058_11170# cke1 0
C3422 a_1418_11110# a_15451_9310# 0
C3423 a_15733_3298# a_17731_2690# 0.00209f
C3424 a_7971_6504# a_13453_1814# 0.46645f
C3425 a5 a4 0.04935f
C3426 a_363_2286# c1 0.01374f
C3427 rst_n a_3901_1968# 0
C3428 a3 a4 0.0564f
C3429 a_6247_8796# a_9351_10050# 0
C3430 a_1058_11170# a_11215_10050# 0
C3431 a_363_2286# c2 0.01132f
C3432 f4 f2 0.00311f
C3433 a_8893_3298# a_9351_1650# 0
C3434 a_4027_11933# a_10902_11162# 0.21397f
C3435 a7 a2 0
C3436 a5 a2 0
C3437 a3 a2 0.05166f
C3438 a_17731_9310# vdd 0.22804f
C3439 f0 f2 0.00287f
C3440 c3 a_363_2286# 0.01236f
C3441 a_4341_1968# a_363_4894# 0.21559f
C3442 a_9351_10050# a_10399_11933# 0
C3443 a_15733_3298# a_15775_3430# 0.63126f
C3444 a_20827_11933# a_18971_12720# 0.01642f
C3445 a_6247_8796# a_8893_1814# 0
C3446 a_8893_3298# a_6247_2844# 0
C3447 a0 a5 0
C3448 a_363_2286# c4 0.01132f
C3449 a0 a3 0.00127f
C3450 a_16649_11686# dp 0.19323f
C3451 a_15733_1814# a_7971_9376# 0.47062f
C3452 rst_n a_16649_11686# 0.08495f
C3453 a_8893_1814# a_10399_11933# 0
C3454 a_13453_3298# a_15775_3430# 0
C3455 a_363_2286# c5 0.01132f
C3456 a_1058_11170# cke0 0
C3457 a_3087_7364# a_363_6446# 0.39827f
C3458 a_9351_10050# a_8267_11933# 0
C3459 a_363_6974# a_3087_8796# 0
C3460 a1 a4 0
C3461 f0 b7 0.01887f
C3462 a_8935_10050# a_10902_11162# 0
C3463 a_5719_11933# a_4089_11686# 1.15896f
C3464 a_21768_6694# a_21768_9194# 0.42075f
C3465 a_363_6974# a_363_8526# 2.03393f
C3466 a_411_11960# a_17221_12720# 0.10967f
C3467 a_4811_6504# a_13453_1814# 0.22805f
C3468 a1 a2 0.05651f
C3469 a_16649_11686# cke3 0
C3470 a_8893_1814# a_8267_11933# 0.00114f
C3471 a_6068_205# a_363_4894# 0.36172f
C3472 cke1 a_16649_11686# 0.00524f
C3473 a_3421_11939# a_6055_12811# 0.09908f
C3474 a_4811_9376# a_1058_11170# 0
C3475 a0 a1 0.06742f
C3476 c6 c5 0.033f
C3477 a_21602_6694# a_21768_6694# 0.2098f
C3478 a_16679_11933# a_20664_8208# 0
C3479 a_363_6974# a_8935_1650# 0
C3480 a_11173_1814# a_1058_11170# 0
C3481 a_5719_11933# a_13495_10050# 0
C3482 a_15775_10050# a_7971_9376# 0.46974f
C3483 a_15733_3298# a_16191_3430# 0.14988f
C3484 a_7501_1968# a_8893_1814# 0.00378f
C3485 a_13171_9310# vdd 0.34896f
C3486 a_21602_9194# a_21768_6694# 0.02537f
C3487 a_13495_10050# a_13453_1814# 0.63122f
C3488 cke2 a_16649_11686# 0.31706f
C3489 a_363_4366# a_363_2814# 1.97727f
C3490 a_363_4894# a_7971_9376# 0
C3491 a_6621_1968# a_1058_11170# 0
C3492 a_4811_9376# a_3901_1968# 0
C3493 a_363_6974# a_6247_2844# 0.53508f
C3494 a_16649_11686# cke0 0.13346f
C3495 a_15733_3298# a_15451_2690# 0.21543f
C3496 a_4027_11933# a_17182_11162# 0
C3497 a_13911_10050# f7 0
C3498 a_363_6974# a_3087_2844# 0
C3499 b5 b7 0.13982f
C3500 a_14547_11933# a_15981_11939# 0
C3501 a_2901_12720# a_363_4894# 0
C3502 a_16191_10050# a_17182_11162# 0
C3503 a_15733_3298# a_13453_1814# 0.01323f
C3504 a_15451_8265# a_13453_1814# 0
C3505 a_13453_3298# a_15451_2690# 0.00217f
C3506 a_3421_11939# a_4651_12720# 1.75409f
C3507 a_363_2814# a_5248_205# 0
C3508 a_20664_6336# a_21768_6694# 1.99548f
C3509 a_13911_10050# f5 0.56329f
C3510 a_363_2814# a_5738_205# 0
C3511 a_13453_3298# a_13453_1814# 1.83241f
C3512 a_363_2814# a_3928_205# 0
C3513 a_363_9054# a_7061_1968# 0.33427f
C3514 a_15451_9310# a_20664_8208# 0.05794f
C3515 a_7501_1968# a_7971_6504# 0.0296f
C3516 b7 b3 0
C3517 b1 b7 0
C3518 ckd3 a_1058_11170# 0
C3519 a_8893_1814# a_7971_1984# 0.52991f
C3520 a_1058_11170# ckd2 0
C3521 a_13171_8265# a_13453_1814# 0.07903f
C3522 a_8893_1814# a_8935_3430# 0.01545f
C3523 f7 f6 1.85317f
C3524 a_8893_1814# a_10891_2690# 0
C3525 a_15733_3298# a_13495_3430# 0.01369f
C3526 a_11173_3298# a_13453_1814# 0.00213f
C3527 a_7501_1968# a_8935_7950# 0
C3528 a_17221_12720# a_5719_11933# 0.07799f
C3529 a_10399_11933# a_4089_11686# 0.23644f
C3530 a_4811_6504# a_3461_1968# 0
C3531 a_21602_6694# a_21768_9194# 0.31865f
C3532 a_10891_8265# a_13453_1814# 0.07154f
C3533 a_363_2814# a_2938_205# 0.08623f
C3534 c6 a_363_2286# 0.02112f
C3535 a_13453_3298# a_13495_3430# 0.63153f
C3536 a_3268_205# a_363_2814# 0
C3537 a_363_2286# b3 0
C3538 a_1058_11170# vdd 1.27611f
C3539 a_363_2286# b1 0
C3540 f6 f5 0.01882f
C3541 a_13171_9310# a_10902_11162# 0
C3542 a_13911_10050# a_11631_10050# 0.00157f
C3543 b5 b3 0.14071f
C3544 a_21602_9194# a_21768_9194# 0.23569f
C3545 b5 b1 0.00129f
C3546 a6 a_363_2286# 0.36467f
C3547 a_17731_6165# a_17731_4790# 0.06644f
C3548 a_15733_1814# a_16191_10050# 0.17662f
C3549 a_8267_11933# a_4089_11686# 0
C3550 a_8893_1814# a_9351_3430# 0.02033f
C3551 a_13495_3430# a_11173_3298# 0
C3552 a_8893_1814# a_4811_1984# 0.23192f
C3553 a_6247_4276# a_7061_1968# 0.2792f
C3554 a_17731_6165# a_15775_5530# 0
C3555 a_21602_6694# a_21602_9194# 0.41038f
C3556 a_7501_1968# a_4811_6504# 0.10188f
C3557 a_9351_10050# a_10891_9310# 0.01879f
C3558 a_15733_3298# a_13911_3430# 0.00548f
C3559 b1 b3 0.14216f
C3560 a_15451_6165# a_17731_4790# 0
C3561 a_13171_6165# a_17731_4790# 0
C3562 a_4341_1968# a_3087_8796# 0.29722f
C3563 f4 f5 1.89219f
C3564 a_363_2286# a4 0.3699f
C3565 a_17731_9310# a_17182_11162# 0
C3566 a_3901_1968# vdd 1.10573f
C3567 f4 f3 0.01834f
C3568 a6 b1 0.00292f
C3569 a_7501_1968# a_9351_7950# 0
C3570 a_8893_1814# a_10891_9310# 0.00918f
C3571 a_17731_4790# a_10891_6165# 0
C3572 a_13495_8270# a_13453_1814# 0.02319f
C3573 a_363_2286# a2 0.38103f
C3574 a_13911_8270# a_13453_1814# 0.02047f
C3575 a_4622_11162# a_4089_11686# 0.56553f
C3576 a_17731_6165# a_15451_4790# 0
C3577 a_15451_6165# a_15775_5530# 0.00247f
C3578 a_13453_3298# a_13911_3430# 0.14988f
C3579 a_20664_6336# a_21768_9194# 0.00178f
C3580 a_11215_8270# a_13453_1814# 0.00575f
C3581 a_4341_1968# a_363_8526# 0.34949f
C3582 a_13171_6165# a_15775_5530# 0
C3583 a_18971_12720# a_16679_11933# 0.01834f
C3584 f3 f2 1.90826f
C3585 a_15451_6165# a_16191_5530# 0.00441f
C3586 f0 f1 1.90761f
C3587 a_411_11960# a_14547_11933# 0.37003f
C3588 a0 a_363_2286# 0.3862f
C3589 a_11631_8270# a_13453_1814# 0.00309f
C3590 f1 f2 0.01956f
C3591 a_4811_6504# a_363_6446# 0
C3592 a_15775_6170# a_17731_4790# 0
C3593 a_15775_10050# a_16191_10050# 0.27357f
C3594 a_21602_6694# a_20664_6336# 0.0659f
C3595 ep a_13911_10050# 0.00188f
C3596 a_16649_11686# vdd 2.20746f
C3597 a_4027_11933# a_363_4894# 0
C3598 a_15451_6165# a_15451_4790# 0.07569f
C3599 a_13171_6165# a_15451_4790# 0
C3600 a6 a4 0.14f
C3601 a_6068_205# a_3087_8796# 0.00201f
C3602 a_15775_6170# a_15775_5530# 0
C3603 a_21602_9194# a_20664_6336# 0.00498f
C3604 a_15451_4790# a_10891_6165# 0
C3605 a_15775_6170# a_16191_5530# 0
C3606 a_11631_10050# f2 0
C3607 a6 a2 0
C3608 a_6068_205# a_363_8526# 0
C3609 a_8893_3298# a_6247_8796# 0
C3610 b7 f1 0
C3611 a_15733_3298# a_13171_2690# 0.21982f
C3612 a_1058_11170# a_10902_11162# 0.13371f
C3613 a6 a0 0
C3614 a_8893_1814# a_10891_3745# 0
C3615 a_15733_1814# a_17731_9310# 0.00209f
C3616 a_13171_9310# a_17182_11162# 0
C3617 a_15775_6170# a_15451_4790# 0.00247f
C3618 a_4089_11686# a_1987_11933# 0
C3619 a_13453_3298# a_13171_2690# 0.26709f
C3620 a_4341_1968# a_3087_2844# 0.31814f
C3621 a_363_4366# a_1058_11170# 0
C3622 a_15981_11939# a_7971_9376# 0
C3623 a4 a2 0.14082f
C3624 a_363_2286# c7 0
C3625 a_6055_12811# a_9351_10050# 0.00437f
C3626 a_13171_4790# a_17731_6165# 0
C3627 b6 a_6621_1968# 0.00108f
C3628 a_13495_5530# a_15451_6165# 0
C3629 a_11173_3298# a_13171_2690# 0.00641f
C3630 a_13495_5530# a_13171_6165# 0.00262f
C3631 b4 a_6621_1968# 0.02881f
C3632 a0 a4 0.00124f
C3633 a_11215_3430# a_13453_3298# 0.01456f
C3634 a_13911_10050# rst_n 0.00249f
C3635 a_16191_6170# a_15775_5530# 0
C3636 a_15981_11939# a_2901_12720# 0.62549f
C3637 a_13453_3298# a_11631_3430# 0.0058f
C3638 a_8893_1814# a_6055_12811# 0.00158f
C3639 a0 a2 0.14212f
C3640 a_6068_205# a_6247_2844# 0.25562f
C3641 a_363_2814# a_363_4894# 2.32497f
C3642 a_6247_7364# a_363_9054# 0.53617f
C3643 a_16191_6170# a_16191_5530# 0.04234f
C3644 a_11215_3430# a_11173_3298# 0.63188f
C3645 a_8935_8270# a_6247_8796# 0
C3646 a_13171_4790# a_15451_6165# 0
C3647 a_6068_205# a_3087_2844# 0.00201f
C3648 a_13171_4790# a_13171_6165# 0.05521f
C3649 a_13171_6165# a_13911_5530# 0.00424f
C3650 a_8893_3298# a_7501_1968# 0.01284f
C3651 c6 c7 0.05689f
C3652 a_11173_3298# a_11631_3430# 0.1499f
C3653 a_363_4366# a_3901_1968# 0.39585f
C3654 a_15775_10050# a_17731_9310# 0.09703f
C3655 a_6247_8796# a_9351_8270# 0
C3656 a_10891_4790# a_17731_6165# 0
C3657 a_6621_1968# b2 0.0022f
C3658 a_14547_11933# a_5719_11933# 0.01576f
C3659 a_13495_6170# a_15451_4790# 0
C3660 a_16191_6170# a_15451_4790# 0.00441f
C3661 a_13171_4790# a_10891_6165# 0
C3662 a_15733_3298# a_7971_1984# 0.42341f
C3663 a_11215_5530# a_13171_6165# 0
C3664 a_15733_3298# a_10891_2690# 0.31787f
C3665 a_15733_1814# a_13171_9310# 0.2279f
C3666 a_10891_9310# a_4089_11686# 0
C3667 a_14547_11933# a_13453_1814# 0
C3668 a_8893_3298# a_11215_3430# 0
C3669 a_13911_10050# a_11215_10050# 0.0022f
C3670 a_11215_5530# a_10891_6165# 0.0026f
C3671 a_3087_7364# a_363_9054# 0.13085f
C3672 a_363_6974# a_6247_8796# 0.52698f
C3673 a_13453_3298# a_7971_1984# 0.42428f
C3674 a_11631_5530# a_10891_6165# 0.00358f
C3675 a_13171_4790# a_15775_6170# 0
C3676 a_13453_3298# a_10891_2690# 0.31332f
C3677 b0 a_6621_1968# 0
C3678 a_1058_11170# a_2938_205# 0
C3679 a_15451_6165# a_10891_4790# 0
C3680 a_13171_6165# a_10891_4790# 0
C3681 a_9351_10050# a_4651_12720# 0.00334f
C3682 a_4588_205# a_3901_1968# 0.02294f
C3683 a_20664_8208# a_21768_6694# 0.00498f
C3684 b6 vdd 0.09627f
C3685 b4 vdd 0.09634f
C3686 a_10891_4790# a_10891_6165# 0.04396f
C3687 a_11173_3298# a_7971_1984# 0.42503f
C3688 a_11173_3298# a_8935_3430# 0.01487f
C3689 a_1058_11170# a_17182_11162# 0.13167f
C3690 a_6247_7364# a_6247_4276# 0.00148f
C3691 a_363_6974# a_3461_1968# 0.18391f
C3692 a_13495_10050# a_10891_9310# 0.19871f
C3693 a_3928_205# a_3901_1968# 0.01918f
C3694 a_10891_2690# a_11173_3298# 0.37168f
C3695 a_15733_3298# a_4811_1984# 0.26049f
C3696 f7 a_15469_11950# 0
C3697 a_17731_8265# a_10891_9310# 0
C3698 a_8893_1814# a_4651_12720# 0
C3699 a_6621_1968# a7 0
C3700 a_8935_8270# a_7501_1968# 0
C3701 a_13495_5530# a_13495_6170# 0
C3702 a_20335_12811# a_21602_9194# 0.0026f
C3703 a_17731_6165# a_21768_6694# 0
C3704 a_13453_3298# a_4811_1984# 0.26571f
C3705 a_24971_12720# a_23462_11162# 0.50067f
C3706 a_15733_3298# a_17731_3745# 0.00209f
C3707 a_7501_1968# a_9351_8270# 0
C3708 a_8893_3298# a_8935_3430# 0.63354f
C3709 a_8893_3298# a_7971_1984# 0.42788f
C3710 a_15451_6165# a_4811_4856# 0.00145f
C3711 a_7971_4856# a_10891_6165# 0
C3712 a_13171_6165# a_4811_4856# 0.00143f
C3713 a_15775_10050# a_13171_9310# 0.04491f
C3714 a_3901_1968# a_2938_205# 0.0015f
C3715 a_8893_3298# a_10891_2690# 0.00913f
C3716 b2 vdd 0.09627f
C3717 a_15733_3298# a_10891_9310# 0
C3718 a_15451_8265# a_10891_9310# 0
C3719 f7 f5 0.00535f
C3720 a_411_11960# a_7971_9376# 0
C3721 a_13495_5530# a_13911_6170# 0
C3722 a_11173_3298# a_4811_1984# 0.26701f
C3723 a_4811_4856# a_10891_6165# 0.00132f
C3724 a_11173_3298# a_9351_3430# 0.00609f
C3725 a_13911_5530# a_13495_6170# 0
C3726 a_4811_9376# a_13911_10050# 0.17451f
C3727 a_13171_4790# a_13495_6170# 0.00262f
C3728 a_15981_11939# a_24971_12720# 0.00197f
C3729 a_8935_5530# a_10891_6165# 0
C3730 a_363_6974# a_7501_1968# 0.28492f
C3731 a_15451_6165# a_21768_6694# 0
C3732 a_7061_1968# a_7971_4856# 0.00212f
C3733 a_13171_6165# a_21768_6694# 0.00111f
C3734 a_13453_3298# a_10891_9310# 0
C3735 a_4027_11933# a_23462_11162# 0.70001f
C3736 a_411_11960# a_2901_12720# 0.28757f
C3737 a_8893_1814# a_363_9054# 0
C3738 a_4811_4856# a_7061_1968# 0.09566f
C3739 a_21768_6694# a_10891_6165# 0.00111f
C3740 b0 vdd 0.09825f
C3741 a_8935_5530# a_7061_1968# 0
C3742 a_13911_5530# a_13911_6170# 0.04234f
C3743 a_15451_3745# a_15733_3298# 0.21543f
C3744 a_13171_4790# a_13911_6170# 0.00424f
C3745 f5 f3 0.00535f
C3746 a_13171_8265# a_10891_9310# 0
C3747 a_11215_10050# f2 0.00104f
C3748 a_8893_3298# a_4811_1984# 0.31277f
C3749 a_8893_3298# a_9351_3430# 0.1499f
C3750 a_15733_1814# a_1058_11170# 0
C3751 a_11173_3298# a_10891_9310# 0
C3752 a_6055_12811# a_4089_11686# 0.67871f
C3753 a_15981_11939# a_4027_11933# 0.23885f
C3754 a_3087_8796# a_4027_11933# 0.00224f
C3755 f3 f1 0.00675f
C3756 a_16649_11686# a_17182_11162# 0.56456f
C3757 a_10891_8265# a_10891_9310# 0.27476f
C3758 a_15451_3745# a_13453_3298# 0.00217f
C3759 a_3087_7364# a_3087_4276# 0.00148f
C3760 a_363_6974# a_363_6446# 2.049f
C3761 a_4811_9376# f6 0.12571f
C3762 a_15981_11939# a_16191_10050# 0.01682f
C3763 a7 vdd 0.09775f
C3764 a_363_2286# rst_n 0
C3765 a_20664_8208# a_21768_9194# 0.04072f
C3766 a_8893_1814# a_8935_3750# 0.01545f
C3767 a5 vdd 0.09636f
C3768 a_15733_3298# a_13171_3745# 0.21982f
C3769 a3 vdd 0.09623f
C3770 a_10891_3745# a_15733_3298# 0.31787f
C3771 a_7718_205# b6 0.08433f
C3772 a_11631_10050# f5 0
C3773 a_17221_12720# a_20827_11933# 0
C3774 a_13453_3298# a_13171_3745# 0.26709f
C3775 a_10891_9310# a_15775_8270# 0
C3776 a_21602_6694# a_20664_8208# 0.01215f
C3777 a_11631_10050# f3 0.56402f
C3778 b4 a_7058_205# 0.08433f
C3779 a_3087_8796# a_4119_11933# 0
C3780 a_16191_6170# a_7971_4856# 0
C3781 a_10891_3745# a_13453_3298# 0.31332f
C3782 a_8893_1814# a_6247_4276# 0
C3783 a_4811_9376# f4 0.12611f
C3784 a_16191_6170# a_4811_4856# 0
C3785 a_363_6974# a_8935_3430# 0
C3786 a_363_6974# a_7971_1984# 0.00265f
C3787 a_363_6974# a_1987_11933# 0
C3788 a_363_9054# a_7971_6504# 0.00315f
C3789 a_16191_8270# a_10891_9310# 0
C3790 a_8893_1814# a_9351_3750# 0.02033f
C3791 a_11173_3298# a_13171_3745# 0.00641f
C3792 a_21602_9194# a_20664_8208# 2.00307f
C3793 a_15775_10050# a_1058_11170# 0
C3794 a_13171_4790# a_11215_6170# 0
C3795 a_10891_3745# a_11173_3298# 0.37168f
C3796 a_4811_9376# f0 0.15392f
C3797 a_4811_9376# f2 0.12621f
C3798 a_7971_4856# a_13911_6170# 0
C3799 en a_15469_11950# 0.07565f
C3800 f4 a_11173_1814# 0.00392f
C3801 a_13911_8270# a_10891_9310# 0
C3802 a1 vdd 0.09636f
C3803 ep a_15469_11950# 0.11094f
C3804 a_13495_8270# a_10891_9310# 0
C3805 a_11215_8270# a_10891_9310# 0
C3806 a_11215_5530# a_11215_6170# 0
C3807 a_4811_4856# a_13911_6170# 0
C3808 a_8935_7950# a_363_9054# 0
C3809 a_4651_12720# a_4089_11686# 0.76601f
C3810 a_15733_1814# a_16649_11686# 0
C3811 c0 vdd 0.54286f
C3812 a_5719_11933# a_7971_9376# 0
C3813 a_11173_1814# f0 0.00114f
C3814 a_20335_12811# a_1418_11110# 0.15524f
C3815 a_1058_11170# a_363_4894# 0
C3816 a_3087_8796# a_363_2814# 0.1452f
C3817 a_11173_1814# f2 0.86116f
C3818 a_11631_8270# a_10891_9310# 0
C3819 a_11215_6170# a_11631_5530# 0
C3820 a_13911_10050# vdd 0.3857f
C3821 a_7971_9376# a_13453_1814# 0.48137f
C3822 a_8893_3298# a_10891_3745# 0.00913f
C3823 a_363_2814# a_363_8526# 0.25352f
C3824 a_8935_8270# a_10891_9310# 0
C3825 a_363_6974# a_4811_1984# 0.04797f
C3826 a_15469_11950# dn 0.08551f
C3827 a_15733_3298# a_15775_3750# 0.63126f
C3828 a_10891_4790# a_11215_6170# 0.0026f
C3829 a_11631_6170# a_11215_5530# 0
C3830 a_2901_12720# a_5719_11933# 2.87586f
C3831 c1 vdd 0.55988f
C3832 a_4811_9376# b7 0.08125f
C3833 ep f5 0
C3834 c2 vdd 0.56709f
C3835 a_20664_6336# a_20664_8208# 0.23462f
C3836 a_11631_6170# a_11631_5530# 0.04234f
C3837 a_6398_205# b2 0.08433f
C3838 a_4341_1968# a_3461_1968# 0.00145f
C3839 a_15733_3298# a_16191_3750# 0.14988f
C3840 a_13453_3298# a_15775_3750# 0
C3841 a_15981_11939# a_17731_9310# 0.00336f
C3842 c3 vdd 0.56791f
C3843 a_15733_3298# a_13495_3750# 0.01369f
C3844 a_6247_4276# a_7971_6504# 0
C3845 a_363_9054# a_4811_6504# 0.24837f
C3846 vdd c4 0.56709f
C3847 a_11631_6170# a_10891_4790# 0.00358f
C3848 a_363_4894# a_3901_1968# 0.11678f
C3849 a_411_11960# a_4027_11933# 0.19318f
C3850 a_4811_9376# a_363_2286# 0.01274f
C3851 a_20664_6336# a_17731_6165# 0.03263f
C3852 f6 vdd 2.38491f
C3853 a_13453_3298# a_13495_3750# 0.63153f
C3854 a_6068_205# a_6247_8796# 0.24212f
C3855 a_15469_11950# dp 0.11303f
C3856 a_15775_10050# a_16649_11686# 0.00117f
C3857 a_10891_4790# a_8935_6170# 0
C3858 a_4811_9376# b5 0.07517f
C3859 a_363_9054# a_9351_7950# 0
C3860 vdd c5 0.56709f
C3861 a_15733_3298# a_13911_3750# 0.00548f
C3862 a_411_11960# a_16191_10050# 0
C3863 a_21602_6694# a_22959_11933# 0
C3864 a_6621_1968# b7 0.00131f
C3865 rst_n a_15469_11950# 0.11271f
C3866 a_6247_2844# a_363_2814# 0.53595f
C3867 a_363_4366# a3 0
C3868 a_13495_3750# a_11173_3298# 0
C3869 f7 rst_n 0
C3870 a_2909_11950# a_1418_11110# 0.13242f
C3871 a_13453_3298# a_13911_3750# 0.14988f
C3872 a_11631_6170# a_7971_4856# 0
C3873 b0 a_5248_205# 0.00826f
C3874 a_363_2814# a_3087_2844# 0.13044f
C3875 a_15451_6165# a_20664_6336# 0.05794f
C3876 a_411_11960# a_4119_11933# 0.08464f
C3877 a_13171_6165# a_20664_6336# 0.02513f
C3878 b0 a_5738_205# 0.08433f
C3879 a_7971_4856# a_8935_6170# 0.00134f
C3880 a_11631_6170# a_4811_4856# 0
C3881 a_7971_4856# a_9351_6170# 0.00246f
C3882 a_4811_9376# b3 0.07515f
C3883 f4 vdd 2.375f
C3884 a_4811_9376# b1 0.08158f
C3885 a_13453_3298# a_11215_3750# 0.01456f
C3886 a_411_11960# a_8935_10050# 0
C3887 a_6247_7364# a_7971_4856# 0
C3888 a_20664_6336# a_10891_6165# 0.02688f
C3889 a_4811_9376# a6 0.00956f
C3890 cke1 a_15469_11950# 0.00131f
C3891 rst_n f5 0.0014f
C3892 a_4811_4856# a_9351_6170# 0
C3893 b5 a_6621_1968# 1.36728f
C3894 a_8935_5530# a_8935_6170# 0
C3895 a_6247_8796# a_7971_9376# 0.29857f
C3896 f0 vdd 2.37939f
C3897 rst_n f3 0
C3898 a_9351_5530# a_8935_6170# 0
C3899 vdd f2 2.39076f
C3900 a_8935_5530# a_9351_6170# 0
C3901 a_5248_205# a7 0.08433f
C3902 a_9351_5530# a_9351_6170# 0.04234f
C3903 a_4588_205# a5 0.08433f
C3904 rst_n f1 0
C3905 a_7971_6504# a_16191_5530# 0
C3906 a_15981_11939# a_13171_9310# 0
C3907 a_11215_3750# a_11173_3298# 0.63188f
C3908 rst_n c7 0
C3909 a_17221_12720# a_4651_12720# 0.0085f
C3910 a_13911_10050# a_10902_11162# 0.00155f
C3911 a_15775_6170# a_20664_6336# 0.00218f
C3912 a_4341_1968# a_363_6446# 0.33341f
C3913 a3 a_3928_205# 0.08433f
C3914 a_411_11960# a_363_2814# 0
C3915 a_6247_8796# a_2901_12720# 0.00182f
C3916 a_6068_205# a_7501_1968# 0
C3917 a_363_4366# c0 0
C3918 a_4811_9376# a4 0
C3919 en ep 0.26952f
C3920 a_6621_1968# b3 2.09738f
C3921 cke2 a_15469_11950# 0.0965f
C3922 a_6621_1968# b1 0.00297f
C3923 a_2901_12720# a_10399_11933# 0.18263f
C3924 a_8893_3298# a_11215_3750# 0
C3925 b7 vdd 0.43376f
C3926 a_11215_10050# f5 0.00245f
C3927 a_11631_10050# rst_n 0
C3928 a_4811_9376# a2 0
C3929 a_8267_11933# a_7971_9376# 0
C3930 a5 a_2938_205# 0
C3931 a3 a_2938_205# 0.00197f
C3932 a_21602_9194# a_18971_12720# 0.00365f
C3933 a_11215_10050# f3 0.21776f
C3934 a_363_4366# c1 0.00276f
C3935 cke0 a_15469_11950# 0.06581f
C3936 a_363_4366# c2 0.33965f
C3937 a_11215_10050# f1 0.0026f
C3938 en dn 7.18877f
C3939 a_13453_3298# a_11631_3750# 0.0058f
C3940 a_11215_5530# a_8893_1814# 0
C3941 a_411_11960# a_17731_9310# 0
C3942 a_4027_11933# a_5719_11933# 1.37375f
C3943 ep dn 7.23f
C3944 c3 a_363_4366# 0.00716f
C3945 a_6068_205# a_363_6446# 0
C3946 a_2901_12720# a_8267_11933# 0
C3947 a_7501_1968# a_7971_9376# 0.01782f
C3948 a_363_2286# vdd 1.71919f
C3949 a_363_4366# c4 0
C3950 a_15451_9310# a_13495_10050# 0.0933f
C3951 a_4811_6504# a_16191_5530# 0
C3952 a_4027_11933# a_13453_1814# 0.00274f
C3953 a_11173_3298# a_11631_3750# 0.1499f
C3954 a_15451_9310# a_17731_8265# 0
C3955 a_16191_6170# a_20664_6336# 0
C3956 b5 vdd 0.43863f
C3957 a_8893_3298# a_363_9054# 0.01182f
C3958 a_4811_9376# a_15469_11950# 0
C3959 a_8935_3750# a_11173_3298# 0.01487f
C3960 a_17221_12720# a_16679_11933# 0.17112f
C3961 a_8893_1814# a_10891_4790# 0.00918f
C3962 a_363_4366# c5 0
C3963 a_4811_9376# f7 0.19637f
C3964 a_11631_10050# a_11215_10050# 0.27357f
C3965 a_1058_11170# a_23462_11162# 0.06937f
C3966 a_4811_6504# a_15451_4790# 0.00145f
C3967 a_4341_1968# a_4811_1984# 0.02243f
C3968 en dp 0.25916f
C3969 a1 a_2938_205# 0.11396f
C3970 a_4119_11933# a_5719_11933# 0.18215f
C3971 a_3268_205# a1 0.08433f
C3972 ep dp 7.21627f
C3973 a_4622_11162# a_2901_12720# 0.21408f
C3974 c6 vdd 0.56134f
C3975 en rst_n 0.07814f
C3976 a_15451_8265# a_15451_9310# 0.00582f
C3977 b3 vdd 0.23917f
C3978 b1 vdd 0.36624f
C3979 a_4811_9376# f5 0.20435f
C3980 a_8893_3298# a_8935_3750# 0.63354f
C3981 a_15981_11939# a_1058_11170# 0.40817f
C3982 a_3087_8796# a_1058_11170# 0
C3983 ep rst_n 0.0845f
C3984 a_7971_6504# a_13911_5530# 0
C3985 a_1418_11110# a_22959_11933# 0.11089f
C3986 a_8893_1814# a_7971_4856# 0.53084f
C3987 a_4811_9376# f3 0.20527f
C3988 a6 vdd 0.39136f
C3989 b4 a_363_4894# 0
C3990 a_11173_3298# a_9351_3750# 0.00609f
C3991 a_4811_9376# f1 0.21154f
C3992 dn dp 0.2911f
C3993 a_8893_1814# a_4811_4856# 0.23202f
C3994 a_1058_11170# a_363_8526# 0
C3995 a_11173_1814# f5 0.01665f
C3996 a_8893_1814# a_8935_5530# 0.62444f
C3997 a_8893_1814# a_9351_5530# 0.17831f
C3998 a_11173_1814# f3 2.42388f
C3999 a_411_11960# a_13171_9310# 0
C4000 en cke3 0.00113f
C4001 a_15733_3298# a_15775_5530# 0.01741f
C4002 rst_n dn 0.08496f
C4003 a_7971_6504# a_11631_5530# 0
C4004 en cke1 0.00322f
C4005 a_11173_1814# f1 0.10015f
C4006 a_15451_9310# a_13171_8265# 0
C4007 ep cke3 0
C4008 a_8893_3298# a_6247_4276# 0
C4009 a_1418_11110# a_3421_11939# 0.79004f
C4010 a_6068_205# a_4811_1984# 0.09686f
C4011 a_8935_8270# a_363_9054# 0
C4012 ep cke1 0.00137f
C4013 a_15733_3298# a_16191_5530# 0
C4014 a_7718_205# b7 0.02636f
C4015 a_8893_3298# a_9351_3750# 0.1499f
C4016 a4 vdd 0.43538f
C4017 a_10891_4790# a_7971_6504# 0
C4018 a_15451_9310# a_10891_8265# 0
C4019 a_4811_9376# a_11631_10050# 0.17451f
C4020 a_3087_8796# a_3901_1968# 0.26125f
C4021 a_17221_12720# a_15451_9310# 0
C4022 cke3 dn 0
C4023 vdd a2 0.24079f
C4024 a_15733_3298# a_15451_4790# 0.06334f
C4025 cke1 dn 0.00201f
C4026 a_16649_11686# a_23462_11162# 0.18159f
C4027 a_20335_12811# a_22959_11933# 0
C4028 a_2901_12720# a_1987_11933# 0.00156f
C4029 a_363_8526# a_3901_1968# 0.37263f
C4030 a_11173_1814# a_11631_10050# 0.17884f
C4031 a0 vdd 0.22183f
C4032 en cke2 0.00113f
C4033 a_363_6974# a_363_9054# 2.50456f
C4034 rst_n dp 0.10335f
C4035 a_4811_6504# a_13911_5530# 0
C4036 a_13171_4790# a_4811_6504# 0.00143f
C4037 a_4027_11933# a_10399_11933# 0.30795f
C4038 cke2 ep 0
C4039 a_1418_11110# a_18971_12720# 0.27249f
C4040 a_7971_6504# a_7971_4856# 0
C4041 a_10891_7210# a_21768_6694# 0.00111f
C4042 b6 vss 0.37031f
C4043 b4 vss 0.37051f
C4044 b2 vss 0.36872f
C4045 b0 vss 0.39341f
C4046 a7 vss 0.38807f
C4047 a5 vss 0.37058f
C4048 a3 vss 0.37037f
C4049 a1 vss 0.3696f
C4050 c0 vss 0.94288f
C4051 c1 vss 0.86701f
C4052 c2 vss 0.85587f
C4053 c3 vss 0.87035f
C4054 c4 vss 0.85587f
C4055 c5 vss 0.85587f
C4056 f6 vss 3.41603f
C4057 f4 vss 3.38345f
C4058 f2 vss 3.37422f
C4059 f0 vss 3.47873f
C4060 b7 vss 2.35275f
C4061 b5 vss 1.97782f
C4062 b3 vss 1.96546f
C4063 c6 vss 0.85725f
C4064 b1 vss 2.70662f
C4065 a6 vss 2.33328f
C4066 a4 vss 1.97245f
C4067 a2 vss 1.95267f
C4068 a0 vss 3.47106f
C4069 f7 vss 4.31368f
C4070 f5 vss 3.42963f
C4071 f3 vss 3.45204f
C4072 c7 vss 0.90774f
C4073 f1 vss 3.54657f
C4074 en vss 5.60656f
C4075 ep vss 3.55142f
C4076 dn vss 3.39362f
C4077 dp vss 5.31937f
C4078 rst_n vss 4.00097f
C4079 cke3 vss 2.01713f
C4080 cke1 vss 3.30945f
C4081 cke2 vss 2.34899f
C4082 cke0 vss 2.77696f
C4083 ckd3 vss 2.00951f
C4084 ckd1 vss 2.67647f
C4085 ckd2 vss 2.91027f
C4086 ckd0 vss 2.06372f
C4087 vdd vss 0.39871p
C4088 a_7718_205# vss 0.10985f
C4089 a_7058_205# vss 0.10985f
C4090 a_6398_205# vss 0.10985f
C4091 a_5738_205# vss 0.11402f
C4092 a_5248_205# vss 0.1161f
C4093 a_4588_205# vss 0.10985f
C4094 a_3928_205# vss 0.10985f
C4095 a_3268_205# vss 0.10985f
C4096 a_21768_2174# vss 2.02651f
C4097 a_21768_4674# vss 2.08646f
C4098 a_21602_2174# vss 2.09751f
C4099 a_21602_4674# vss 1.89887f
C4100 a_20664_1816# vss 5.25758f
C4101 a_20664_3688# vss 5.09219f
C4102 a_17731_1645# vss 1.25523f
C4103 a_15451_1645# vss 1.09987f
C4104 a_13171_1645# vss 1.19873f
C4105 a_10891_1645# vss 1.09133f
C4106 a_15775_1650# vss 0.44393f
C4107 a_16191_1650# vss 0.80653f
C4108 a_13495_1650# vss 0.41695f
C4109 a_13911_1650# vss 0.80334f
C4110 a_11215_1650# vss 0.41695f
C4111 a_11631_1650# vss 0.80334f
C4112 a_8935_1650# vss 0.42215f
C4113 a_9351_1650# vss 0.81112f
C4114 a_6247_2844# vss 1.08556f
C4115 a_3087_2844# vss 1.09478f
C4116 a_17731_2690# vss 0.75529f
C4117 a_15775_3430# vss 0.41986f
C4118 a_16191_3430# vss 0.67249f
C4119 a_15451_2690# vss 0.83362f
C4120 a_13495_3430# vss 0.39415f
C4121 a_13911_3430# vss 0.66652f
C4122 a_13171_2690# vss 0.90065f
C4123 a_11215_3430# vss 0.39415f
C4124 a_11631_3430# vss 0.66652f
C4125 a_10891_2690# vss 0.97018f
C4126 a_7971_1984# vss 1.87491f
C4127 a_8935_3430# vss 0.3984f
C4128 a_4811_1984# vss 2.84988f
C4129 a_9351_3430# vss 0.67516f
C4130 a_17731_3745# vss 0.75529f
C4131 a_15451_3745# vss 0.83362f
C4132 a_13171_3745# vss 0.90065f
C4133 a_10891_3745# vss 0.97018f
C4134 a_15775_3750# vss 0.41986f
C4135 a_16191_3750# vss 0.67249f
C4136 a_13495_3750# vss 0.39415f
C4137 a_13911_3750# vss 0.66652f
C4138 a_11215_3750# vss 0.39415f
C4139 a_11631_3750# vss 0.66652f
C4140 a_8935_3750# vss 0.3984f
C4141 a_9351_3750# vss 0.67516f
C4142 a_6247_4276# vss 1.08767f
C4143 a_3087_4276# vss 1.097f
C4144 a_17731_4790# vss 1.11676f
C4145 a_15775_5530# vss 0.44212f
C4146 a_16191_5530# vss 0.73566f
C4147 a_15451_4790# vss 0.98226f
C4148 a_13495_5530# vss 0.41642f
C4149 a_13911_5530# vss 0.73399f
C4150 a_13171_4790# vss 1.11475f
C4151 a_11215_5530# vss 0.41642f
C4152 a_11631_5530# vss 0.73399f
C4153 a_10891_4790# vss 1.01594f
C4154 a_7971_4856# vss 1.87718f
C4155 a_8935_5530# vss 0.42162f
C4156 a_4811_4856# vss 2.90685f
C4157 a_9351_5530# vss 0.74177f
C4158 a_21768_6694# vss 1.86944f
C4159 a_21768_9194# vss 2.0574f
C4160 a_21602_6694# vss 2.11478f
C4161 a_21602_9194# vss 2.02389f
C4162 a_20664_6336# vss 5.07846f
C4163 a_20664_8208# vss 5.17264f
C4164 a_17731_6165# vss 1.11676f
C4165 a_15451_6165# vss 0.98226f
C4166 a_13171_6165# vss 1.11475f
C4167 a_10891_6165# vss 1.01594f
C4168 a_15775_6170# vss 0.44212f
C4169 a_16191_6170# vss 0.73566f
C4170 a_13495_6170# vss 0.41642f
C4171 a_13911_6170# vss 0.73399f
C4172 a_11215_6170# vss 0.41642f
C4173 a_11631_6170# vss 0.73399f
C4174 a_8935_6170# vss 0.42162f
C4175 a_9351_6170# vss 0.74177f
C4176 a_6247_7364# vss 1.09047f
C4177 a_3087_7364# vss 1.0998f
C4178 a_17731_7210# vss 0.75529f
C4179 a_15775_7950# vss 0.41986f
C4180 a_16191_7950# vss 0.67249f
C4181 a_15451_7210# vss 0.83362f
C4182 a_13495_7950# vss 0.39415f
C4183 a_13911_7950# vss 0.66652f
C4184 a_13171_7210# vss 0.90065f
C4185 a_11215_7950# vss 0.39415f
C4186 a_11631_7950# vss 0.66652f
C4187 a_10891_7210# vss 0.97018f
C4188 a_7971_6504# vss 1.87718f
C4189 a_8935_7950# vss 0.3984f
C4190 a_4811_6504# vss 2.88421f
C4191 a_9351_7950# vss 0.67516f
C4192 a_17731_8265# vss 0.75529f
C4193 a_15733_3298# vss 2.6979f
C4194 a_15451_8265# vss 0.83362f
C4195 a_13453_3298# vss 2.70582f
C4196 a_13171_8265# vss 0.90065f
C4197 a_11173_3298# vss 2.72382f
C4198 a_10891_8265# vss 0.97031f
C4199 a_8893_3298# vss 2.81764f
C4200 a_15775_8270# vss 0.41986f
C4201 a_16191_8270# vss 0.67249f
C4202 a_13495_8270# vss 0.39415f
C4203 a_13911_8270# vss 0.66652f
C4204 a_11215_8270# vss 0.39415f
C4205 a_11631_8270# vss 0.66652f
C4206 a_8935_8270# vss 0.3984f
C4207 a_9351_8270# vss 0.67516f
C4208 a_363_6974# vss 4.30819f
C4209 a_363_4894# vss 4.68573f
C4210 a_363_2814# vss 5.21528f
C4211 a_6247_8796# vss 1.12283f
C4212 a_7501_1968# vss 1.83702f
C4213 a_7061_1968# vss 1.30767f
C4214 a_6621_1968# vss 1.28682f
C4215 a_6068_205# vss 1.58009f
C4216 a_363_8526# vss 3.87412f
C4217 a_363_6446# vss 3.60464f
C4218 a_363_4366# vss 3.93914f
C4219 a_363_2286# vss 5.1106f
C4220 a_3087_8796# vss 1.1206f
C4221 a_4341_1968# vss 1.95648f
C4222 a_3901_1968# vss 1.30689f
C4223 a_3461_1968# vss 1.25403f
C4224 a_2938_205# vss 1.69998f
C4225 a_17731_9310# vss 1.23175f
C4226 a_15775_10050# vss 0.45089f
C4227 a_16191_10050# vss 0.81169f
C4228 a_15733_1814# vss 3.05216f
C4229 a_15451_9310# vss 1.06973f
C4230 a_13495_10050# vss 0.42813f
C4231 a_13911_10050# vss 0.84739f
C4232 a_13453_1814# vss 3.02979f
C4233 a_13171_9310# vss 1.16731f
C4234 a_11215_10050# vss 0.42953f
C4235 a_11631_10050# vss 0.84306f
C4236 a_11173_1814# vss 3.04935f
C4237 a_10891_9310# vss 1.0596f
C4238 a_363_9054# vss 6.35433f
C4239 a_7971_9376# vss 1.78478f
C4240 a_8935_10050# vss 0.43943f
C4241 a_4811_9376# vss 2.8425f
C4242 a_9351_10050# vss 0.84292f
C4243 a_8893_1814# vss 3.24183f
C4244 a_23462_11162# vss 1.52029f
C4245 a_22959_11933# vss 1.33782f
C4246 a_20827_11933# vss 0.83585f
C4247 a_17182_11162# vss 1.46375f
C4248 a_16679_11933# vss 1.32957f
C4249 a_14547_11933# vss 0.8527f
C4250 a_8267_11933# vss 0.83291f
C4251 a_1987_11933# vss 0.85208f
C4252 a_1418_11110# vss 2.15049f
C4253 a_411_11960# vss 2.63272f
C4254 a_1058_11170# vss 5.4222f
C4255 a_10902_11162# vss 1.64468f
C4256 a_10399_11933# vss 1.54452f
C4257 a_4622_11162# vss 1.6072f
C4258 a_4119_11933# vss 1.53573f
C4259 a_16649_11686# vss 3.12567f
C4260 a_15981_11939# vss 2.60909f
C4261 a_20335_12811# vss 2.57994f
C4262 a_15469_11950# vss 3.51166f
C4263 a_4089_11686# vss 3.03399f
C4264 a_3421_11939# vss 2.59036f
C4265 a_6055_12811# vss 3.10472f
C4266 a_2909_11950# vss 3.18657f
C4267 a_24971_12720# vss 2.44957f
C4268 a_23221_12720# vss 1.80526f
C4269 a_18971_12720# vss 1.63324f
C4270 a_17221_12720# vss 1.70801f
C4271 a_5719_11933# vss 3.2327f
C4272 a_4027_11933# vss 6.20485f
C4273 a_4651_12720# vss 2.54181f
C4274 a_2901_12720# vss 2.75459f
.ends
