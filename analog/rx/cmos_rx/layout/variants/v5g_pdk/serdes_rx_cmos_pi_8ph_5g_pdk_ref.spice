* Exact flattened LVS reference netlist for serdes_rx_cmos_pi_8ph_5g_pdk
* Source subckt: serdes_rx_cmos_pi_8ph (analog/rx/cmos_rx/spice/rx_cmos_pi_5g_cand.spice)
.subckt serdes_rx_cmos_pi_8ph_5g_pdk c0 c1 c2 c3 c4 c5 c6 c7 a0 a1 a2 a3 a4 a5 a6 a7 b0 b1 b2 b3 b4 b5 b6 b7 f0 f1 f2 f3 f4 f5 f6 f7 rst_n dp dn ep en ckd0 ckd1 ckd2 ckd3 cke0 cke1 cke2 cke3 vdd vss
X1 t_Xpi_ab0 a0 vss vss sky130_fd_pr__nfet_01v8 w=0.45 l=0.18
X2 t_Xpi_ab0 a0 vdd vdd sky130_fd_pr__pfet_01v8 w=0.9 l=0.18
X3 t_Xpi_ab1 a1 vss vss sky130_fd_pr__nfet_01v8 w=0.45 l=0.18
X4 t_Xpi_ab1 a1 vdd vdd sky130_fd_pr__pfet_01v8 w=0.9 l=0.18
X5 t_Xpi_ab2 a2 vss vss sky130_fd_pr__nfet_01v8 w=0.45 l=0.18
X6 t_Xpi_ab2 a2 vdd vdd sky130_fd_pr__pfet_01v8 w=0.9 l=0.18
X7 t_Xpi_ab3 a3 vss vss sky130_fd_pr__nfet_01v8 w=0.45 l=0.18
X8 t_Xpi_ab3 a3 vdd vdd sky130_fd_pr__pfet_01v8 w=0.9 l=0.18
X9 t_Xpi_ab4 a4 vss vss sky130_fd_pr__nfet_01v8 w=0.45 l=0.18
X10 t_Xpi_ab4 a4 vdd vdd sky130_fd_pr__pfet_01v8 w=0.9 l=0.18
X11 t_Xpi_ab5 a5 vss vss sky130_fd_pr__nfet_01v8 w=0.45 l=0.18
X12 t_Xpi_ab5 a5 vdd vdd sky130_fd_pr__pfet_01v8 w=0.9 l=0.18
X13 t_Xpi_ab6 a6 vss vss sky130_fd_pr__nfet_01v8 w=0.45 l=0.18
X14 t_Xpi_ab6 a6 vdd vdd sky130_fd_pr__pfet_01v8 w=0.9 l=0.18
X15 t_Xpi_ab7 a7 vss vss sky130_fd_pr__nfet_01v8 w=0.45 l=0.18
X16 t_Xpi_ab7 a7 vdd vdd sky130_fd_pr__pfet_01v8 w=0.9 l=0.18
X17 t_Xpi_bb0 b0 vss vss sky130_fd_pr__nfet_01v8 w=0.45 l=0.18
X18 t_Xpi_bb0 b0 vdd vdd sky130_fd_pr__pfet_01v8 w=0.9 l=0.18
X19 t_Xpi_bb1 b1 vss vss sky130_fd_pr__nfet_01v8 w=0.45 l=0.18
X20 t_Xpi_bb1 b1 vdd vdd sky130_fd_pr__pfet_01v8 w=0.9 l=0.18
X21 t_Xpi_bb2 b2 vss vss sky130_fd_pr__nfet_01v8 w=0.45 l=0.18
X22 t_Xpi_bb2 b2 vdd vdd sky130_fd_pr__pfet_01v8 w=0.9 l=0.18
X23 t_Xpi_bb3 b3 vss vss sky130_fd_pr__nfet_01v8 w=0.45 l=0.18
X24 t_Xpi_bb3 b3 vdd vdd sky130_fd_pr__pfet_01v8 w=0.9 l=0.18
X25 t_Xpi_bb4 b4 vss vss sky130_fd_pr__nfet_01v8 w=0.45 l=0.18
X26 t_Xpi_bb4 b4 vdd vdd sky130_fd_pr__pfet_01v8 w=0.9 l=0.18
X27 t_Xpi_bb5 b5 vss vss sky130_fd_pr__nfet_01v8 w=0.45 l=0.18
X28 t_Xpi_bb5 b5 vdd vdd sky130_fd_pr__pfet_01v8 w=0.9 l=0.18
X29 t_Xpi_bb6 b6 vss vss sky130_fd_pr__nfet_01v8 w=0.45 l=0.18
X30 t_Xpi_bb6 b6 vdd vdd sky130_fd_pr__pfet_01v8 w=0.9 l=0.18
X31 t_Xpi_bb7 b7 vss vss sky130_fd_pr__nfet_01v8 w=0.45 l=0.18
X32 t_Xpi_bb7 b7 vdd vdd sky130_fd_pr__pfet_01v8 w=0.9 l=0.18
X33 t_Xpi_fb0 f0 vss vss sky130_fd_pr__nfet_01v8 w=0.45 l=0.18
X34 t_Xpi_fb0 f0 vdd vdd sky130_fd_pr__pfet_01v8 w=0.9 l=0.18
X35 t_Xpi_fb1 f1 vss vss sky130_fd_pr__nfet_01v8 w=0.45 l=0.18
X36 t_Xpi_fb1 f1 vdd vdd sky130_fd_pr__pfet_01v8 w=0.9 l=0.18
X37 t_Xpi_fb2 f2 vss vss sky130_fd_pr__nfet_01v8 w=0.45 l=0.18
X38 t_Xpi_fb2 f2 vdd vdd sky130_fd_pr__pfet_01v8 w=0.9 l=0.18
X39 t_Xpi_fb3 f3 vss vss sky130_fd_pr__nfet_01v8 w=0.45 l=0.18
X40 t_Xpi_fb3 f3 vdd vdd sky130_fd_pr__pfet_01v8 w=0.9 l=0.18
X41 t_Xpi_fb4 f4 vss vss sky130_fd_pr__nfet_01v8 w=0.45 l=0.18
X42 t_Xpi_fb4 f4 vdd vdd sky130_fd_pr__pfet_01v8 w=0.9 l=0.18
X43 t_Xpi_fb5 f5 vss vss sky130_fd_pr__nfet_01v8 w=0.45 l=0.18
X44 t_Xpi_fb5 f5 vdd vdd sky130_fd_pr__pfet_01v8 w=0.9 l=0.18
X45 t_Xpi_fb6 f6 vss vss sky130_fd_pr__nfet_01v8 w=0.45 l=0.18
X46 t_Xpi_fb6 f6 vdd vdd sky130_fd_pr__pfet_01v8 w=0.9 l=0.18
X47 t_Xpi_fb7 f7 vss vss sky130_fd_pr__nfet_01v8 w=0.45 l=0.18
X48 t_Xpi_fb7 f7 vdd vdd sky130_fd_pr__pfet_01v8 w=0.9 l=0.18
X49 t_Xpi_cb0 c0 vss vss sky130_fd_pr__nfet_01v8_lvt w=1.7 l=0.15
X50 t_Xpi_cb0 c0 vdd vdd sky130_fd_pr__pfet_01v8_lvt w=6.8 l=0.35
X51 t_Xpi_cb1 c1 vss vss sky130_fd_pr__nfet_01v8_lvt w=1.7 l=0.15
X52 t_Xpi_cb1 c1 vdd vdd sky130_fd_pr__pfet_01v8_lvt w=6.8 l=0.35
X53 t_Xpi_cb2 c2 vss vss sky130_fd_pr__nfet_01v8_lvt w=1.7 l=0.15
X54 t_Xpi_cb2 c2 vdd vdd sky130_fd_pr__pfet_01v8_lvt w=6.8 l=0.35
X55 t_Xpi_cb3 c3 vss vss sky130_fd_pr__nfet_01v8_lvt w=1.7 l=0.15
X56 t_Xpi_cb3 c3 vdd vdd sky130_fd_pr__pfet_01v8_lvt w=6.8 l=0.35
X57 t_Xpi_cb4 c4 vss vss sky130_fd_pr__nfet_01v8_lvt w=1.7 l=0.15
X58 t_Xpi_cb4 c4 vdd vdd sky130_fd_pr__pfet_01v8_lvt w=6.8 l=0.35
X59 t_Xpi_cb5 c5 vss vss sky130_fd_pr__nfet_01v8_lvt w=1.7 l=0.15
X60 t_Xpi_cb5 c5 vdd vdd sky130_fd_pr__pfet_01v8_lvt w=6.8 l=0.35
X61 t_Xpi_cb6 c6 vss vss sky130_fd_pr__nfet_01v8_lvt w=1.7 l=0.15
X62 t_Xpi_cb6 c6 vdd vdd sky130_fd_pr__pfet_01v8_lvt w=6.8 l=0.35
X63 t_Xpi_cb7 c7 vss vss sky130_fd_pr__nfet_01v8_lvt w=1.7 l=0.15
X64 t_Xpi_cb7 c7 vdd vdd sky130_fd_pr__pfet_01v8_lvt w=6.8 l=0.35
X65 t_Xpi_cb0 a0 t_Xpi_Xch_d_Xmap_m vss sky130_fd_pr__nfet_01v8_lvt w=1.6 l=0.15
X66 t_Xpi_cb0 t_Xpi_ab0 t_Xpi_Xch_d_Xmap_m vdd sky130_fd_pr__pfet_01v8_lvt w=4.2 l=0.35
X67 t_Xpi_cb2 a2 t_Xpi_Xch_d_Xmap_m vss sky130_fd_pr__nfet_01v8_lvt w=1.6 l=0.15
X68 t_Xpi_cb2 t_Xpi_ab2 t_Xpi_Xch_d_Xmap_m vdd sky130_fd_pr__pfet_01v8_lvt w=4.2 l=0.35
X69 t_Xpi_cb4 a4 t_Xpi_Xch_d_Xmap_m vss sky130_fd_pr__nfet_01v8_lvt w=1.6 l=0.15
X70 t_Xpi_cb4 t_Xpi_ab4 t_Xpi_Xch_d_Xmap_m vdd sky130_fd_pr__pfet_01v8_lvt w=4.2 l=0.35
X71 t_Xpi_cb6 a6 t_Xpi_Xch_d_Xmap_m vss sky130_fd_pr__nfet_01v8_lvt w=1.6 l=0.15
X72 t_Xpi_cb6 t_Xpi_ab6 t_Xpi_Xch_d_Xmap_m vdd sky130_fd_pr__pfet_01v8_lvt w=4.2 l=0.35
X73 t_Xpi_Xch_d_cap t_Xpi_Xch_d_Xmap_m vss vss sky130_fd_pr__nfet_01v8_lvt w=2 l=0.15
X74 t_Xpi_Xch_d_cap t_Xpi_Xch_d_Xmap_m vdd vdd sky130_fd_pr__pfet_01v8 w=8.8 l=0.15
X75 t_Xpi_cb4 a0 t_Xpi_Xch_d_Xman_m vss sky130_fd_pr__nfet_01v8_lvt w=1.6 l=0.15
X76 t_Xpi_cb4 t_Xpi_ab0 t_Xpi_Xch_d_Xman_m vdd sky130_fd_pr__pfet_01v8_lvt w=4.2 l=0.35
X77 t_Xpi_cb6 a2 t_Xpi_Xch_d_Xman_m vss sky130_fd_pr__nfet_01v8_lvt w=1.6 l=0.15
X78 t_Xpi_cb6 t_Xpi_ab2 t_Xpi_Xch_d_Xman_m vdd sky130_fd_pr__pfet_01v8_lvt w=4.2 l=0.35
X79 t_Xpi_cb0 a4 t_Xpi_Xch_d_Xman_m vss sky130_fd_pr__nfet_01v8_lvt w=1.6 l=0.15
X80 t_Xpi_cb0 t_Xpi_ab4 t_Xpi_Xch_d_Xman_m vdd sky130_fd_pr__pfet_01v8_lvt w=4.2 l=0.35
X81 t_Xpi_cb2 a6 t_Xpi_Xch_d_Xman_m vss sky130_fd_pr__nfet_01v8_lvt w=1.6 l=0.15
X82 t_Xpi_cb2 t_Xpi_ab6 t_Xpi_Xch_d_Xman_m vdd sky130_fd_pr__pfet_01v8_lvt w=4.2 l=0.35
X83 t_Xpi_Xch_d_can t_Xpi_Xch_d_Xman_m vss vss sky130_fd_pr__nfet_01v8_lvt w=2 l=0.15
X84 t_Xpi_Xch_d_can t_Xpi_Xch_d_Xman_m vdd vdd sky130_fd_pr__pfet_01v8 w=8.8 l=0.15
X85 t_Xpi_cb1 b1 t_Xpi_Xch_d_Xmbp_m vss sky130_fd_pr__nfet_01v8_lvt w=1.6 l=0.15
X86 t_Xpi_cb1 t_Xpi_bb1 t_Xpi_Xch_d_Xmbp_m vdd sky130_fd_pr__pfet_01v8_lvt w=4.2 l=0.35
X87 t_Xpi_cb3 b3 t_Xpi_Xch_d_Xmbp_m vss sky130_fd_pr__nfet_01v8_lvt w=1.6 l=0.15
X88 t_Xpi_cb3 t_Xpi_bb3 t_Xpi_Xch_d_Xmbp_m vdd sky130_fd_pr__pfet_01v8_lvt w=4.2 l=0.35
X89 t_Xpi_cb5 b5 t_Xpi_Xch_d_Xmbp_m vss sky130_fd_pr__nfet_01v8_lvt w=1.6 l=0.15
X90 t_Xpi_cb5 t_Xpi_bb5 t_Xpi_Xch_d_Xmbp_m vdd sky130_fd_pr__pfet_01v8_lvt w=4.2 l=0.35
X91 t_Xpi_cb7 b7 t_Xpi_Xch_d_Xmbp_m vss sky130_fd_pr__nfet_01v8_lvt w=1.6 l=0.15
X92 t_Xpi_cb7 t_Xpi_bb7 t_Xpi_Xch_d_Xmbp_m vdd sky130_fd_pr__pfet_01v8_lvt w=4.2 l=0.35
X93 t_Xpi_Xch_d_cbp t_Xpi_Xch_d_Xmbp_m vss vss sky130_fd_pr__nfet_01v8_lvt w=2 l=0.15
X94 t_Xpi_Xch_d_cbp t_Xpi_Xch_d_Xmbp_m vdd vdd sky130_fd_pr__pfet_01v8 w=8.8 l=0.15
X95 t_Xpi_cb5 b1 t_Xpi_Xch_d_Xmbn_m vss sky130_fd_pr__nfet_01v8_lvt w=1.6 l=0.15
X96 t_Xpi_cb5 t_Xpi_bb1 t_Xpi_Xch_d_Xmbn_m vdd sky130_fd_pr__pfet_01v8_lvt w=4.2 l=0.35
X97 t_Xpi_cb7 b3 t_Xpi_Xch_d_Xmbn_m vss sky130_fd_pr__nfet_01v8_lvt w=1.6 l=0.15
X98 t_Xpi_cb7 t_Xpi_bb3 t_Xpi_Xch_d_Xmbn_m vdd sky130_fd_pr__pfet_01v8_lvt w=4.2 l=0.35
X99 t_Xpi_cb1 b5 t_Xpi_Xch_d_Xmbn_m vss sky130_fd_pr__nfet_01v8_lvt w=1.6 l=0.15
X100 t_Xpi_cb1 t_Xpi_bb5 t_Xpi_Xch_d_Xmbn_m vdd sky130_fd_pr__pfet_01v8_lvt w=4.2 l=0.35
X101 t_Xpi_cb3 b7 t_Xpi_Xch_d_Xmbn_m vss sky130_fd_pr__nfet_01v8_lvt w=1.6 l=0.15
X102 t_Xpi_cb3 t_Xpi_bb7 t_Xpi_Xch_d_Xmbn_m vdd sky130_fd_pr__pfet_01v8_lvt w=4.2 l=0.35
X103 t_Xpi_Xch_d_cbn t_Xpi_Xch_d_Xmbn_m vss vss sky130_fd_pr__nfet_01v8_lvt w=2 l=0.15
X104 t_Xpi_Xch_d_cbn t_Xpi_Xch_d_Xmbn_m vdd vdd sky130_fd_pr__pfet_01v8 w=8.8 l=0.15
X105 t_Xpi_Xch_d_cap t_Xpi_fb0 t_Xpi_Xch_d_Xmixp_Xs0_sel vss sky130_fd_pr__nfet_01v8_lvt w=0.5 l=0.15
X106 t_Xpi_Xch_d_cap f0 t_Xpi_Xch_d_Xmixp_Xs0_sel vdd sky130_fd_pr__pfet_01v8_lvt w=0.9 l=0.35
X107 t_Xpi_Xch_d_cbp f0 t_Xpi_Xch_d_Xmixp_Xs0_sel vss sky130_fd_pr__nfet_01v8_lvt w=0.5 l=0.15
X108 t_Xpi_Xch_d_cbp t_Xpi_fb0 t_Xpi_Xch_d_Xmixp_Xs0_sel vdd sky130_fd_pr__pfet_01v8_lvt w=0.9 l=0.35
X109 t_Xpi_Xch_d_Xmixp_Xs0_drv t_Xpi_Xch_d_Xmixp_Xs0_sel vss vss sky130_fd_pr__nfet_01v8_lvt w=0.55 l=0.15
X110 t_Xpi_Xch_d_Xmixp_Xs0_drv t_Xpi_Xch_d_Xmixp_Xs0_sel vdd vdd sky130_fd_pr__pfet_01v8 w=2.3 l=0.15
X111 t_Xpi_Xch_d_Xmixp_Xs0_drv t_Xpi_Xch_d_mixp vss sky130_fd_pr__res_high_po_0p69 l=7.2
X112 t_Xpi_Xch_d_cap f0 t_Xpi_Xch_d_Xmixp_Xs0_dum vss sky130_fd_pr__nfet_01v8_lvt w=0.5 l=0.15
X113 t_Xpi_Xch_d_cap t_Xpi_fb0 t_Xpi_Xch_d_Xmixp_Xs0_dum vdd sky130_fd_pr__pfet_01v8_lvt w=0.9 l=0.35
X114 t_Xpi_Xch_d_cbp t_Xpi_fb0 t_Xpi_Xch_d_Xmixp_Xs0_dum vss sky130_fd_pr__nfet_01v8_lvt w=0.5 l=0.15
X115 t_Xpi_Xch_d_cbp f0 t_Xpi_Xch_d_Xmixp_Xs0_dum vdd sky130_fd_pr__pfet_01v8_lvt w=0.9 l=0.35
X116 vss t_Xpi_Xch_d_Xmixp_Xs0_dum vss vss sky130_fd_pr__nfet_01v8_lvt w=0.55 l=0.15
X117 vdd t_Xpi_Xch_d_Xmixp_Xs0_dum vdd vdd sky130_fd_pr__pfet_01v8 w=2.3 l=0.15
X118 t_Xpi_Xch_d_cap t_Xpi_fb1 t_Xpi_Xch_d_Xmixp_Xs1_sel vss sky130_fd_pr__nfet_01v8_lvt w=0.5 l=0.15
X119 t_Xpi_Xch_d_cap f1 t_Xpi_Xch_d_Xmixp_Xs1_sel vdd sky130_fd_pr__pfet_01v8_lvt w=0.9 l=0.35
X120 t_Xpi_Xch_d_cbp f1 t_Xpi_Xch_d_Xmixp_Xs1_sel vss sky130_fd_pr__nfet_01v8_lvt w=0.5 l=0.15
X121 t_Xpi_Xch_d_cbp t_Xpi_fb1 t_Xpi_Xch_d_Xmixp_Xs1_sel vdd sky130_fd_pr__pfet_01v8_lvt w=0.9 l=0.35
X122 t_Xpi_Xch_d_Xmixp_Xs1_drv t_Xpi_Xch_d_Xmixp_Xs1_sel vss vss sky130_fd_pr__nfet_01v8_lvt w=0.55 l=0.15
X123 t_Xpi_Xch_d_Xmixp_Xs1_drv t_Xpi_Xch_d_Xmixp_Xs1_sel vdd vdd sky130_fd_pr__pfet_01v8 w=2.3 l=0.15
X124 t_Xpi_Xch_d_Xmixp_Xs1_drv t_Xpi_Xch_d_mixp vss sky130_fd_pr__res_high_po_0p69 l=7.2
X125 t_Xpi_Xch_d_cap f1 t_Xpi_Xch_d_Xmixp_Xs1_dum vss sky130_fd_pr__nfet_01v8_lvt w=0.5 l=0.15
X126 t_Xpi_Xch_d_cap t_Xpi_fb1 t_Xpi_Xch_d_Xmixp_Xs1_dum vdd sky130_fd_pr__pfet_01v8_lvt w=0.9 l=0.35
X127 t_Xpi_Xch_d_cbp t_Xpi_fb1 t_Xpi_Xch_d_Xmixp_Xs1_dum vss sky130_fd_pr__nfet_01v8_lvt w=0.5 l=0.15
X128 t_Xpi_Xch_d_cbp f1 t_Xpi_Xch_d_Xmixp_Xs1_dum vdd sky130_fd_pr__pfet_01v8_lvt w=0.9 l=0.35
X129 vss t_Xpi_Xch_d_Xmixp_Xs1_dum vss vss sky130_fd_pr__nfet_01v8_lvt w=0.55 l=0.15
X130 vdd t_Xpi_Xch_d_Xmixp_Xs1_dum vdd vdd sky130_fd_pr__pfet_01v8 w=2.3 l=0.15
X131 t_Xpi_Xch_d_cap t_Xpi_fb2 t_Xpi_Xch_d_Xmixp_Xs2_sel vss sky130_fd_pr__nfet_01v8_lvt w=0.5 l=0.15
X132 t_Xpi_Xch_d_cap f2 t_Xpi_Xch_d_Xmixp_Xs2_sel vdd sky130_fd_pr__pfet_01v8_lvt w=0.9 l=0.35
X133 t_Xpi_Xch_d_cbp f2 t_Xpi_Xch_d_Xmixp_Xs2_sel vss sky130_fd_pr__nfet_01v8_lvt w=0.5 l=0.15
X134 t_Xpi_Xch_d_cbp t_Xpi_fb2 t_Xpi_Xch_d_Xmixp_Xs2_sel vdd sky130_fd_pr__pfet_01v8_lvt w=0.9 l=0.35
X135 t_Xpi_Xch_d_Xmixp_Xs2_drv t_Xpi_Xch_d_Xmixp_Xs2_sel vss vss sky130_fd_pr__nfet_01v8_lvt w=0.55 l=0.15
X136 t_Xpi_Xch_d_Xmixp_Xs2_drv t_Xpi_Xch_d_Xmixp_Xs2_sel vdd vdd sky130_fd_pr__pfet_01v8 w=2.3 l=0.15
X137 t_Xpi_Xch_d_Xmixp_Xs2_drv t_Xpi_Xch_d_mixp vss sky130_fd_pr__res_high_po_0p69 l=7.2
X138 t_Xpi_Xch_d_cap f2 t_Xpi_Xch_d_Xmixp_Xs2_dum vss sky130_fd_pr__nfet_01v8_lvt w=0.5 l=0.15
X139 t_Xpi_Xch_d_cap t_Xpi_fb2 t_Xpi_Xch_d_Xmixp_Xs2_dum vdd sky130_fd_pr__pfet_01v8_lvt w=0.9 l=0.35
X140 t_Xpi_Xch_d_cbp t_Xpi_fb2 t_Xpi_Xch_d_Xmixp_Xs2_dum vss sky130_fd_pr__nfet_01v8_lvt w=0.5 l=0.15
X141 t_Xpi_Xch_d_cbp f2 t_Xpi_Xch_d_Xmixp_Xs2_dum vdd sky130_fd_pr__pfet_01v8_lvt w=0.9 l=0.35
X142 vss t_Xpi_Xch_d_Xmixp_Xs2_dum vss vss sky130_fd_pr__nfet_01v8_lvt w=0.55 l=0.15
X143 vdd t_Xpi_Xch_d_Xmixp_Xs2_dum vdd vdd sky130_fd_pr__pfet_01v8 w=2.3 l=0.15
X144 t_Xpi_Xch_d_cap t_Xpi_fb3 t_Xpi_Xch_d_Xmixp_Xs3_sel vss sky130_fd_pr__nfet_01v8_lvt w=0.5 l=0.15
X145 t_Xpi_Xch_d_cap f3 t_Xpi_Xch_d_Xmixp_Xs3_sel vdd sky130_fd_pr__pfet_01v8_lvt w=0.9 l=0.35
X146 t_Xpi_Xch_d_cbp f3 t_Xpi_Xch_d_Xmixp_Xs3_sel vss sky130_fd_pr__nfet_01v8_lvt w=0.5 l=0.15
X147 t_Xpi_Xch_d_cbp t_Xpi_fb3 t_Xpi_Xch_d_Xmixp_Xs3_sel vdd sky130_fd_pr__pfet_01v8_lvt w=0.9 l=0.35
X148 t_Xpi_Xch_d_Xmixp_Xs3_drv t_Xpi_Xch_d_Xmixp_Xs3_sel vss vss sky130_fd_pr__nfet_01v8_lvt w=0.55 l=0.15
X149 t_Xpi_Xch_d_Xmixp_Xs3_drv t_Xpi_Xch_d_Xmixp_Xs3_sel vdd vdd sky130_fd_pr__pfet_01v8 w=2.3 l=0.15
X150 t_Xpi_Xch_d_Xmixp_Xs3_drv t_Xpi_Xch_d_mixp vss sky130_fd_pr__res_high_po_0p69 l=7.2
X151 t_Xpi_Xch_d_cap f3 t_Xpi_Xch_d_Xmixp_Xs3_dum vss sky130_fd_pr__nfet_01v8_lvt w=0.5 l=0.15
X152 t_Xpi_Xch_d_cap t_Xpi_fb3 t_Xpi_Xch_d_Xmixp_Xs3_dum vdd sky130_fd_pr__pfet_01v8_lvt w=0.9 l=0.35
X153 t_Xpi_Xch_d_cbp t_Xpi_fb3 t_Xpi_Xch_d_Xmixp_Xs3_dum vss sky130_fd_pr__nfet_01v8_lvt w=0.5 l=0.15
X154 t_Xpi_Xch_d_cbp f3 t_Xpi_Xch_d_Xmixp_Xs3_dum vdd sky130_fd_pr__pfet_01v8_lvt w=0.9 l=0.35
X155 vss t_Xpi_Xch_d_Xmixp_Xs3_dum vss vss sky130_fd_pr__nfet_01v8_lvt w=0.55 l=0.15
X156 vdd t_Xpi_Xch_d_Xmixp_Xs3_dum vdd vdd sky130_fd_pr__pfet_01v8 w=2.3 l=0.15
X157 t_Xpi_Xch_d_cap t_Xpi_fb4 t_Xpi_Xch_d_Xmixp_Xs4_sel vss sky130_fd_pr__nfet_01v8_lvt w=0.5 l=0.15
X158 t_Xpi_Xch_d_cap f4 t_Xpi_Xch_d_Xmixp_Xs4_sel vdd sky130_fd_pr__pfet_01v8_lvt w=0.9 l=0.35
X159 t_Xpi_Xch_d_cbp f4 t_Xpi_Xch_d_Xmixp_Xs4_sel vss sky130_fd_pr__nfet_01v8_lvt w=0.5 l=0.15
X160 t_Xpi_Xch_d_cbp t_Xpi_fb4 t_Xpi_Xch_d_Xmixp_Xs4_sel vdd sky130_fd_pr__pfet_01v8_lvt w=0.9 l=0.35
X161 t_Xpi_Xch_d_Xmixp_Xs4_drv t_Xpi_Xch_d_Xmixp_Xs4_sel vss vss sky130_fd_pr__nfet_01v8_lvt w=0.55 l=0.15
X162 t_Xpi_Xch_d_Xmixp_Xs4_drv t_Xpi_Xch_d_Xmixp_Xs4_sel vdd vdd sky130_fd_pr__pfet_01v8 w=2.3 l=0.15
X163 t_Xpi_Xch_d_Xmixp_Xs4_drv t_Xpi_Xch_d_mixp vss sky130_fd_pr__res_high_po_0p69 l=7.2
X164 t_Xpi_Xch_d_cap f4 t_Xpi_Xch_d_Xmixp_Xs4_dum vss sky130_fd_pr__nfet_01v8_lvt w=0.5 l=0.15
X165 t_Xpi_Xch_d_cap t_Xpi_fb4 t_Xpi_Xch_d_Xmixp_Xs4_dum vdd sky130_fd_pr__pfet_01v8_lvt w=0.9 l=0.35
X166 t_Xpi_Xch_d_cbp t_Xpi_fb4 t_Xpi_Xch_d_Xmixp_Xs4_dum vss sky130_fd_pr__nfet_01v8_lvt w=0.5 l=0.15
X167 t_Xpi_Xch_d_cbp f4 t_Xpi_Xch_d_Xmixp_Xs4_dum vdd sky130_fd_pr__pfet_01v8_lvt w=0.9 l=0.35
X168 vss t_Xpi_Xch_d_Xmixp_Xs4_dum vss vss sky130_fd_pr__nfet_01v8_lvt w=0.55 l=0.15
X169 vdd t_Xpi_Xch_d_Xmixp_Xs4_dum vdd vdd sky130_fd_pr__pfet_01v8 w=2.3 l=0.15
X170 t_Xpi_Xch_d_cap t_Xpi_fb5 t_Xpi_Xch_d_Xmixp_Xs5_sel vss sky130_fd_pr__nfet_01v8_lvt w=0.5 l=0.15
X171 t_Xpi_Xch_d_cap f5 t_Xpi_Xch_d_Xmixp_Xs5_sel vdd sky130_fd_pr__pfet_01v8_lvt w=0.9 l=0.35
X172 t_Xpi_Xch_d_cbp f5 t_Xpi_Xch_d_Xmixp_Xs5_sel vss sky130_fd_pr__nfet_01v8_lvt w=0.5 l=0.15
X173 t_Xpi_Xch_d_cbp t_Xpi_fb5 t_Xpi_Xch_d_Xmixp_Xs5_sel vdd sky130_fd_pr__pfet_01v8_lvt w=0.9 l=0.35
X174 t_Xpi_Xch_d_Xmixp_Xs5_drv t_Xpi_Xch_d_Xmixp_Xs5_sel vss vss sky130_fd_pr__nfet_01v8_lvt w=0.55 l=0.15
X175 t_Xpi_Xch_d_Xmixp_Xs5_drv t_Xpi_Xch_d_Xmixp_Xs5_sel vdd vdd sky130_fd_pr__pfet_01v8 w=2.3 l=0.15
X176 t_Xpi_Xch_d_Xmixp_Xs5_drv t_Xpi_Xch_d_mixp vss sky130_fd_pr__res_high_po_0p69 l=7.2
X177 t_Xpi_Xch_d_cap f5 t_Xpi_Xch_d_Xmixp_Xs5_dum vss sky130_fd_pr__nfet_01v8_lvt w=0.5 l=0.15
X178 t_Xpi_Xch_d_cap t_Xpi_fb5 t_Xpi_Xch_d_Xmixp_Xs5_dum vdd sky130_fd_pr__pfet_01v8_lvt w=0.9 l=0.35
X179 t_Xpi_Xch_d_cbp t_Xpi_fb5 t_Xpi_Xch_d_Xmixp_Xs5_dum vss sky130_fd_pr__nfet_01v8_lvt w=0.5 l=0.15
X180 t_Xpi_Xch_d_cbp f5 t_Xpi_Xch_d_Xmixp_Xs5_dum vdd sky130_fd_pr__pfet_01v8_lvt w=0.9 l=0.35
X181 vss t_Xpi_Xch_d_Xmixp_Xs5_dum vss vss sky130_fd_pr__nfet_01v8_lvt w=0.55 l=0.15
X182 vdd t_Xpi_Xch_d_Xmixp_Xs5_dum vdd vdd sky130_fd_pr__pfet_01v8 w=2.3 l=0.15
X183 t_Xpi_Xch_d_cap t_Xpi_fb6 t_Xpi_Xch_d_Xmixp_Xs6_sel vss sky130_fd_pr__nfet_01v8_lvt w=0.5 l=0.15
X184 t_Xpi_Xch_d_cap f6 t_Xpi_Xch_d_Xmixp_Xs6_sel vdd sky130_fd_pr__pfet_01v8_lvt w=0.9 l=0.35
X185 t_Xpi_Xch_d_cbp f6 t_Xpi_Xch_d_Xmixp_Xs6_sel vss sky130_fd_pr__nfet_01v8_lvt w=0.5 l=0.15
X186 t_Xpi_Xch_d_cbp t_Xpi_fb6 t_Xpi_Xch_d_Xmixp_Xs6_sel vdd sky130_fd_pr__pfet_01v8_lvt w=0.9 l=0.35
X187 t_Xpi_Xch_d_Xmixp_Xs6_drv t_Xpi_Xch_d_Xmixp_Xs6_sel vss vss sky130_fd_pr__nfet_01v8_lvt w=0.55 l=0.15
X188 t_Xpi_Xch_d_Xmixp_Xs6_drv t_Xpi_Xch_d_Xmixp_Xs6_sel vdd vdd sky130_fd_pr__pfet_01v8 w=2.3 l=0.15
X189 t_Xpi_Xch_d_Xmixp_Xs6_drv t_Xpi_Xch_d_mixp vss sky130_fd_pr__res_high_po_0p69 l=7.2
X190 t_Xpi_Xch_d_cap f6 t_Xpi_Xch_d_Xmixp_Xs6_dum vss sky130_fd_pr__nfet_01v8_lvt w=0.5 l=0.15
X191 t_Xpi_Xch_d_cap t_Xpi_fb6 t_Xpi_Xch_d_Xmixp_Xs6_dum vdd sky130_fd_pr__pfet_01v8_lvt w=0.9 l=0.35
X192 t_Xpi_Xch_d_cbp t_Xpi_fb6 t_Xpi_Xch_d_Xmixp_Xs6_dum vss sky130_fd_pr__nfet_01v8_lvt w=0.5 l=0.15
X193 t_Xpi_Xch_d_cbp f6 t_Xpi_Xch_d_Xmixp_Xs6_dum vdd sky130_fd_pr__pfet_01v8_lvt w=0.9 l=0.35
X194 vss t_Xpi_Xch_d_Xmixp_Xs6_dum vss vss sky130_fd_pr__nfet_01v8_lvt w=0.55 l=0.15
X195 vdd t_Xpi_Xch_d_Xmixp_Xs6_dum vdd vdd sky130_fd_pr__pfet_01v8 w=2.3 l=0.15
X196 t_Xpi_Xch_d_cap t_Xpi_fb7 t_Xpi_Xch_d_Xmixp_Xs7_sel vss sky130_fd_pr__nfet_01v8_lvt w=0.5 l=0.15
X197 t_Xpi_Xch_d_cap f7 t_Xpi_Xch_d_Xmixp_Xs7_sel vdd sky130_fd_pr__pfet_01v8_lvt w=0.9 l=0.35
X198 t_Xpi_Xch_d_cbp f7 t_Xpi_Xch_d_Xmixp_Xs7_sel vss sky130_fd_pr__nfet_01v8_lvt w=0.5 l=0.15
X199 t_Xpi_Xch_d_cbp t_Xpi_fb7 t_Xpi_Xch_d_Xmixp_Xs7_sel vdd sky130_fd_pr__pfet_01v8_lvt w=0.9 l=0.35
X200 t_Xpi_Xch_d_Xmixp_Xs7_drv t_Xpi_Xch_d_Xmixp_Xs7_sel vss vss sky130_fd_pr__nfet_01v8_lvt w=0.55 l=0.15
X201 t_Xpi_Xch_d_Xmixp_Xs7_drv t_Xpi_Xch_d_Xmixp_Xs7_sel vdd vdd sky130_fd_pr__pfet_01v8 w=2.3 l=0.15
X202 t_Xpi_Xch_d_Xmixp_Xs7_drv t_Xpi_Xch_d_mixp vss sky130_fd_pr__res_high_po_0p69 l=7.2
X203 t_Xpi_Xch_d_cap f7 t_Xpi_Xch_d_Xmixp_Xs7_dum vss sky130_fd_pr__nfet_01v8_lvt w=0.5 l=0.15
X204 t_Xpi_Xch_d_cap t_Xpi_fb7 t_Xpi_Xch_d_Xmixp_Xs7_dum vdd sky130_fd_pr__pfet_01v8_lvt w=0.9 l=0.35
X205 t_Xpi_Xch_d_cbp t_Xpi_fb7 t_Xpi_Xch_d_Xmixp_Xs7_dum vss sky130_fd_pr__nfet_01v8_lvt w=0.5 l=0.15
X206 t_Xpi_Xch_d_cbp f7 t_Xpi_Xch_d_Xmixp_Xs7_dum vdd sky130_fd_pr__pfet_01v8_lvt w=0.9 l=0.35
X207 vss t_Xpi_Xch_d_Xmixp_Xs7_dum vss vss sky130_fd_pr__nfet_01v8_lvt w=0.55 l=0.15
X208 vdd t_Xpi_Xch_d_Xmixp_Xs7_dum vdd vdd sky130_fd_pr__pfet_01v8 w=2.3 l=0.15
X209 t_Xpi_Xch_d_mixp vss sky130_fd_pr__cap_mim_m3_1 w=3.1 l=3.1
X210 t_Xpi_Xch_d_can t_Xpi_fb0 t_Xpi_Xch_d_Xmixn_Xs0_sel vss sky130_fd_pr__nfet_01v8_lvt w=0.5 l=0.15
X211 t_Xpi_Xch_d_can f0 t_Xpi_Xch_d_Xmixn_Xs0_sel vdd sky130_fd_pr__pfet_01v8_lvt w=0.9 l=0.35
X212 t_Xpi_Xch_d_cbn f0 t_Xpi_Xch_d_Xmixn_Xs0_sel vss sky130_fd_pr__nfet_01v8_lvt w=0.5 l=0.15
X213 t_Xpi_Xch_d_cbn t_Xpi_fb0 t_Xpi_Xch_d_Xmixn_Xs0_sel vdd sky130_fd_pr__pfet_01v8_lvt w=0.9 l=0.35
X214 t_Xpi_Xch_d_Xmixn_Xs0_drv t_Xpi_Xch_d_Xmixn_Xs0_sel vss vss sky130_fd_pr__nfet_01v8_lvt w=0.55 l=0.15
X215 t_Xpi_Xch_d_Xmixn_Xs0_drv t_Xpi_Xch_d_Xmixn_Xs0_sel vdd vdd sky130_fd_pr__pfet_01v8 w=2.3 l=0.15
X216 t_Xpi_Xch_d_Xmixn_Xs0_drv t_Xpi_Xch_d_mixn vss sky130_fd_pr__res_high_po_0p69 l=7.2
X217 t_Xpi_Xch_d_can f0 t_Xpi_Xch_d_Xmixn_Xs0_dum vss sky130_fd_pr__nfet_01v8_lvt w=0.5 l=0.15
X218 t_Xpi_Xch_d_can t_Xpi_fb0 t_Xpi_Xch_d_Xmixn_Xs0_dum vdd sky130_fd_pr__pfet_01v8_lvt w=0.9 l=0.35
X219 t_Xpi_Xch_d_cbn t_Xpi_fb0 t_Xpi_Xch_d_Xmixn_Xs0_dum vss sky130_fd_pr__nfet_01v8_lvt w=0.5 l=0.15
X220 t_Xpi_Xch_d_cbn f0 t_Xpi_Xch_d_Xmixn_Xs0_dum vdd sky130_fd_pr__pfet_01v8_lvt w=0.9 l=0.35
X221 vss t_Xpi_Xch_d_Xmixn_Xs0_dum vss vss sky130_fd_pr__nfet_01v8_lvt w=0.55 l=0.15
X222 vdd t_Xpi_Xch_d_Xmixn_Xs0_dum vdd vdd sky130_fd_pr__pfet_01v8 w=2.3 l=0.15
X223 t_Xpi_Xch_d_can t_Xpi_fb1 t_Xpi_Xch_d_Xmixn_Xs1_sel vss sky130_fd_pr__nfet_01v8_lvt w=0.5 l=0.15
X224 t_Xpi_Xch_d_can f1 t_Xpi_Xch_d_Xmixn_Xs1_sel vdd sky130_fd_pr__pfet_01v8_lvt w=0.9 l=0.35
X225 t_Xpi_Xch_d_cbn f1 t_Xpi_Xch_d_Xmixn_Xs1_sel vss sky130_fd_pr__nfet_01v8_lvt w=0.5 l=0.15
X226 t_Xpi_Xch_d_cbn t_Xpi_fb1 t_Xpi_Xch_d_Xmixn_Xs1_sel vdd sky130_fd_pr__pfet_01v8_lvt w=0.9 l=0.35
X227 t_Xpi_Xch_d_Xmixn_Xs1_drv t_Xpi_Xch_d_Xmixn_Xs1_sel vss vss sky130_fd_pr__nfet_01v8_lvt w=0.55 l=0.15
X228 t_Xpi_Xch_d_Xmixn_Xs1_drv t_Xpi_Xch_d_Xmixn_Xs1_sel vdd vdd sky130_fd_pr__pfet_01v8 w=2.3 l=0.15
X229 t_Xpi_Xch_d_Xmixn_Xs1_drv t_Xpi_Xch_d_mixn vss sky130_fd_pr__res_high_po_0p69 l=7.2
X230 t_Xpi_Xch_d_can f1 t_Xpi_Xch_d_Xmixn_Xs1_dum vss sky130_fd_pr__nfet_01v8_lvt w=0.5 l=0.15
X231 t_Xpi_Xch_d_can t_Xpi_fb1 t_Xpi_Xch_d_Xmixn_Xs1_dum vdd sky130_fd_pr__pfet_01v8_lvt w=0.9 l=0.35
X232 t_Xpi_Xch_d_cbn t_Xpi_fb1 t_Xpi_Xch_d_Xmixn_Xs1_dum vss sky130_fd_pr__nfet_01v8_lvt w=0.5 l=0.15
X233 t_Xpi_Xch_d_cbn f1 t_Xpi_Xch_d_Xmixn_Xs1_dum vdd sky130_fd_pr__pfet_01v8_lvt w=0.9 l=0.35
X234 vss t_Xpi_Xch_d_Xmixn_Xs1_dum vss vss sky130_fd_pr__nfet_01v8_lvt w=0.55 l=0.15
X235 vdd t_Xpi_Xch_d_Xmixn_Xs1_dum vdd vdd sky130_fd_pr__pfet_01v8 w=2.3 l=0.15
X236 t_Xpi_Xch_d_can t_Xpi_fb2 t_Xpi_Xch_d_Xmixn_Xs2_sel vss sky130_fd_pr__nfet_01v8_lvt w=0.5 l=0.15
X237 t_Xpi_Xch_d_can f2 t_Xpi_Xch_d_Xmixn_Xs2_sel vdd sky130_fd_pr__pfet_01v8_lvt w=0.9 l=0.35
X238 t_Xpi_Xch_d_cbn f2 t_Xpi_Xch_d_Xmixn_Xs2_sel vss sky130_fd_pr__nfet_01v8_lvt w=0.5 l=0.15
X239 t_Xpi_Xch_d_cbn t_Xpi_fb2 t_Xpi_Xch_d_Xmixn_Xs2_sel vdd sky130_fd_pr__pfet_01v8_lvt w=0.9 l=0.35
X240 t_Xpi_Xch_d_Xmixn_Xs2_drv t_Xpi_Xch_d_Xmixn_Xs2_sel vss vss sky130_fd_pr__nfet_01v8_lvt w=0.55 l=0.15
X241 t_Xpi_Xch_d_Xmixn_Xs2_drv t_Xpi_Xch_d_Xmixn_Xs2_sel vdd vdd sky130_fd_pr__pfet_01v8 w=2.3 l=0.15
X242 t_Xpi_Xch_d_Xmixn_Xs2_drv t_Xpi_Xch_d_mixn vss sky130_fd_pr__res_high_po_0p69 l=7.2
X243 t_Xpi_Xch_d_can f2 t_Xpi_Xch_d_Xmixn_Xs2_dum vss sky130_fd_pr__nfet_01v8_lvt w=0.5 l=0.15
X244 t_Xpi_Xch_d_can t_Xpi_fb2 t_Xpi_Xch_d_Xmixn_Xs2_dum vdd sky130_fd_pr__pfet_01v8_lvt w=0.9 l=0.35
X245 t_Xpi_Xch_d_cbn t_Xpi_fb2 t_Xpi_Xch_d_Xmixn_Xs2_dum vss sky130_fd_pr__nfet_01v8_lvt w=0.5 l=0.15
X246 t_Xpi_Xch_d_cbn f2 t_Xpi_Xch_d_Xmixn_Xs2_dum vdd sky130_fd_pr__pfet_01v8_lvt w=0.9 l=0.35
X247 vss t_Xpi_Xch_d_Xmixn_Xs2_dum vss vss sky130_fd_pr__nfet_01v8_lvt w=0.55 l=0.15
X248 vdd t_Xpi_Xch_d_Xmixn_Xs2_dum vdd vdd sky130_fd_pr__pfet_01v8 w=2.3 l=0.15
X249 t_Xpi_Xch_d_can t_Xpi_fb3 t_Xpi_Xch_d_Xmixn_Xs3_sel vss sky130_fd_pr__nfet_01v8_lvt w=0.5 l=0.15
X250 t_Xpi_Xch_d_can f3 t_Xpi_Xch_d_Xmixn_Xs3_sel vdd sky130_fd_pr__pfet_01v8_lvt w=0.9 l=0.35
X251 t_Xpi_Xch_d_cbn f3 t_Xpi_Xch_d_Xmixn_Xs3_sel vss sky130_fd_pr__nfet_01v8_lvt w=0.5 l=0.15
X252 t_Xpi_Xch_d_cbn t_Xpi_fb3 t_Xpi_Xch_d_Xmixn_Xs3_sel vdd sky130_fd_pr__pfet_01v8_lvt w=0.9 l=0.35
X253 t_Xpi_Xch_d_Xmixn_Xs3_drv t_Xpi_Xch_d_Xmixn_Xs3_sel vss vss sky130_fd_pr__nfet_01v8_lvt w=0.55 l=0.15
X254 t_Xpi_Xch_d_Xmixn_Xs3_drv t_Xpi_Xch_d_Xmixn_Xs3_sel vdd vdd sky130_fd_pr__pfet_01v8 w=2.3 l=0.15
X255 t_Xpi_Xch_d_Xmixn_Xs3_drv t_Xpi_Xch_d_mixn vss sky130_fd_pr__res_high_po_0p69 l=7.2
X256 t_Xpi_Xch_d_can f3 t_Xpi_Xch_d_Xmixn_Xs3_dum vss sky130_fd_pr__nfet_01v8_lvt w=0.5 l=0.15
X257 t_Xpi_Xch_d_can t_Xpi_fb3 t_Xpi_Xch_d_Xmixn_Xs3_dum vdd sky130_fd_pr__pfet_01v8_lvt w=0.9 l=0.35
X258 t_Xpi_Xch_d_cbn t_Xpi_fb3 t_Xpi_Xch_d_Xmixn_Xs3_dum vss sky130_fd_pr__nfet_01v8_lvt w=0.5 l=0.15
X259 t_Xpi_Xch_d_cbn f3 t_Xpi_Xch_d_Xmixn_Xs3_dum vdd sky130_fd_pr__pfet_01v8_lvt w=0.9 l=0.35
X260 vss t_Xpi_Xch_d_Xmixn_Xs3_dum vss vss sky130_fd_pr__nfet_01v8_lvt w=0.55 l=0.15
X261 vdd t_Xpi_Xch_d_Xmixn_Xs3_dum vdd vdd sky130_fd_pr__pfet_01v8 w=2.3 l=0.15
X262 t_Xpi_Xch_d_can t_Xpi_fb4 t_Xpi_Xch_d_Xmixn_Xs4_sel vss sky130_fd_pr__nfet_01v8_lvt w=0.5 l=0.15
X263 t_Xpi_Xch_d_can f4 t_Xpi_Xch_d_Xmixn_Xs4_sel vdd sky130_fd_pr__pfet_01v8_lvt w=0.9 l=0.35
X264 t_Xpi_Xch_d_cbn f4 t_Xpi_Xch_d_Xmixn_Xs4_sel vss sky130_fd_pr__nfet_01v8_lvt w=0.5 l=0.15
X265 t_Xpi_Xch_d_cbn t_Xpi_fb4 t_Xpi_Xch_d_Xmixn_Xs4_sel vdd sky130_fd_pr__pfet_01v8_lvt w=0.9 l=0.35
X266 t_Xpi_Xch_d_Xmixn_Xs4_drv t_Xpi_Xch_d_Xmixn_Xs4_sel vss vss sky130_fd_pr__nfet_01v8_lvt w=0.55 l=0.15
X267 t_Xpi_Xch_d_Xmixn_Xs4_drv t_Xpi_Xch_d_Xmixn_Xs4_sel vdd vdd sky130_fd_pr__pfet_01v8 w=2.3 l=0.15
X268 t_Xpi_Xch_d_Xmixn_Xs4_drv t_Xpi_Xch_d_mixn vss sky130_fd_pr__res_high_po_0p69 l=7.2
X269 t_Xpi_Xch_d_can f4 t_Xpi_Xch_d_Xmixn_Xs4_dum vss sky130_fd_pr__nfet_01v8_lvt w=0.5 l=0.15
X270 t_Xpi_Xch_d_can t_Xpi_fb4 t_Xpi_Xch_d_Xmixn_Xs4_dum vdd sky130_fd_pr__pfet_01v8_lvt w=0.9 l=0.35
X271 t_Xpi_Xch_d_cbn t_Xpi_fb4 t_Xpi_Xch_d_Xmixn_Xs4_dum vss sky130_fd_pr__nfet_01v8_lvt w=0.5 l=0.15
X272 t_Xpi_Xch_d_cbn f4 t_Xpi_Xch_d_Xmixn_Xs4_dum vdd sky130_fd_pr__pfet_01v8_lvt w=0.9 l=0.35
X273 vss t_Xpi_Xch_d_Xmixn_Xs4_dum vss vss sky130_fd_pr__nfet_01v8_lvt w=0.55 l=0.15
X274 vdd t_Xpi_Xch_d_Xmixn_Xs4_dum vdd vdd sky130_fd_pr__pfet_01v8 w=2.3 l=0.15
X275 t_Xpi_Xch_d_can t_Xpi_fb5 t_Xpi_Xch_d_Xmixn_Xs5_sel vss sky130_fd_pr__nfet_01v8_lvt w=0.5 l=0.15
X276 t_Xpi_Xch_d_can f5 t_Xpi_Xch_d_Xmixn_Xs5_sel vdd sky130_fd_pr__pfet_01v8_lvt w=0.9 l=0.35
X277 t_Xpi_Xch_d_cbn f5 t_Xpi_Xch_d_Xmixn_Xs5_sel vss sky130_fd_pr__nfet_01v8_lvt w=0.5 l=0.15
X278 t_Xpi_Xch_d_cbn t_Xpi_fb5 t_Xpi_Xch_d_Xmixn_Xs5_sel vdd sky130_fd_pr__pfet_01v8_lvt w=0.9 l=0.35
X279 t_Xpi_Xch_d_Xmixn_Xs5_drv t_Xpi_Xch_d_Xmixn_Xs5_sel vss vss sky130_fd_pr__nfet_01v8_lvt w=0.55 l=0.15
X280 t_Xpi_Xch_d_Xmixn_Xs5_drv t_Xpi_Xch_d_Xmixn_Xs5_sel vdd vdd sky130_fd_pr__pfet_01v8 w=2.3 l=0.15
X281 t_Xpi_Xch_d_Xmixn_Xs5_drv t_Xpi_Xch_d_mixn vss sky130_fd_pr__res_high_po_0p69 l=7.2
X282 t_Xpi_Xch_d_can f5 t_Xpi_Xch_d_Xmixn_Xs5_dum vss sky130_fd_pr__nfet_01v8_lvt w=0.5 l=0.15
X283 t_Xpi_Xch_d_can t_Xpi_fb5 t_Xpi_Xch_d_Xmixn_Xs5_dum vdd sky130_fd_pr__pfet_01v8_lvt w=0.9 l=0.35
X284 t_Xpi_Xch_d_cbn t_Xpi_fb5 t_Xpi_Xch_d_Xmixn_Xs5_dum vss sky130_fd_pr__nfet_01v8_lvt w=0.5 l=0.15
X285 t_Xpi_Xch_d_cbn f5 t_Xpi_Xch_d_Xmixn_Xs5_dum vdd sky130_fd_pr__pfet_01v8_lvt w=0.9 l=0.35
X286 vss t_Xpi_Xch_d_Xmixn_Xs5_dum vss vss sky130_fd_pr__nfet_01v8_lvt w=0.55 l=0.15
X287 vdd t_Xpi_Xch_d_Xmixn_Xs5_dum vdd vdd sky130_fd_pr__pfet_01v8 w=2.3 l=0.15
X288 t_Xpi_Xch_d_can t_Xpi_fb6 t_Xpi_Xch_d_Xmixn_Xs6_sel vss sky130_fd_pr__nfet_01v8_lvt w=0.5 l=0.15
X289 t_Xpi_Xch_d_can f6 t_Xpi_Xch_d_Xmixn_Xs6_sel vdd sky130_fd_pr__pfet_01v8_lvt w=0.9 l=0.35
X290 t_Xpi_Xch_d_cbn f6 t_Xpi_Xch_d_Xmixn_Xs6_sel vss sky130_fd_pr__nfet_01v8_lvt w=0.5 l=0.15
X291 t_Xpi_Xch_d_cbn t_Xpi_fb6 t_Xpi_Xch_d_Xmixn_Xs6_sel vdd sky130_fd_pr__pfet_01v8_lvt w=0.9 l=0.35
X292 t_Xpi_Xch_d_Xmixn_Xs6_drv t_Xpi_Xch_d_Xmixn_Xs6_sel vss vss sky130_fd_pr__nfet_01v8_lvt w=0.55 l=0.15
X293 t_Xpi_Xch_d_Xmixn_Xs6_drv t_Xpi_Xch_d_Xmixn_Xs6_sel vdd vdd sky130_fd_pr__pfet_01v8 w=2.3 l=0.15
X294 t_Xpi_Xch_d_Xmixn_Xs6_drv t_Xpi_Xch_d_mixn vss sky130_fd_pr__res_high_po_0p69 l=7.2
X295 t_Xpi_Xch_d_can f6 t_Xpi_Xch_d_Xmixn_Xs6_dum vss sky130_fd_pr__nfet_01v8_lvt w=0.5 l=0.15
X296 t_Xpi_Xch_d_can t_Xpi_fb6 t_Xpi_Xch_d_Xmixn_Xs6_dum vdd sky130_fd_pr__pfet_01v8_lvt w=0.9 l=0.35
X297 t_Xpi_Xch_d_cbn t_Xpi_fb6 t_Xpi_Xch_d_Xmixn_Xs6_dum vss sky130_fd_pr__nfet_01v8_lvt w=0.5 l=0.15
X298 t_Xpi_Xch_d_cbn f6 t_Xpi_Xch_d_Xmixn_Xs6_dum vdd sky130_fd_pr__pfet_01v8_lvt w=0.9 l=0.35
X299 vss t_Xpi_Xch_d_Xmixn_Xs6_dum vss vss sky130_fd_pr__nfet_01v8_lvt w=0.55 l=0.15
X300 vdd t_Xpi_Xch_d_Xmixn_Xs6_dum vdd vdd sky130_fd_pr__pfet_01v8 w=2.3 l=0.15
X301 t_Xpi_Xch_d_can t_Xpi_fb7 t_Xpi_Xch_d_Xmixn_Xs7_sel vss sky130_fd_pr__nfet_01v8_lvt w=0.5 l=0.15
X302 t_Xpi_Xch_d_can f7 t_Xpi_Xch_d_Xmixn_Xs7_sel vdd sky130_fd_pr__pfet_01v8_lvt w=0.9 l=0.35
X303 t_Xpi_Xch_d_cbn f7 t_Xpi_Xch_d_Xmixn_Xs7_sel vss sky130_fd_pr__nfet_01v8_lvt w=0.5 l=0.15
X304 t_Xpi_Xch_d_cbn t_Xpi_fb7 t_Xpi_Xch_d_Xmixn_Xs7_sel vdd sky130_fd_pr__pfet_01v8_lvt w=0.9 l=0.35
X305 t_Xpi_Xch_d_Xmixn_Xs7_drv t_Xpi_Xch_d_Xmixn_Xs7_sel vss vss sky130_fd_pr__nfet_01v8_lvt w=0.55 l=0.15
X306 t_Xpi_Xch_d_Xmixn_Xs7_drv t_Xpi_Xch_d_Xmixn_Xs7_sel vdd vdd sky130_fd_pr__pfet_01v8 w=2.3 l=0.15
X307 t_Xpi_Xch_d_Xmixn_Xs7_drv t_Xpi_Xch_d_mixn vss sky130_fd_pr__res_high_po_0p69 l=7.2
X308 t_Xpi_Xch_d_can f7 t_Xpi_Xch_d_Xmixn_Xs7_dum vss sky130_fd_pr__nfet_01v8_lvt w=0.5 l=0.15
X309 t_Xpi_Xch_d_can t_Xpi_fb7 t_Xpi_Xch_d_Xmixn_Xs7_dum vdd sky130_fd_pr__pfet_01v8_lvt w=0.9 l=0.35
X310 t_Xpi_Xch_d_cbn t_Xpi_fb7 t_Xpi_Xch_d_Xmixn_Xs7_dum vss sky130_fd_pr__nfet_01v8_lvt w=0.5 l=0.15
X311 t_Xpi_Xch_d_cbn f7 t_Xpi_Xch_d_Xmixn_Xs7_dum vdd sky130_fd_pr__pfet_01v8_lvt w=0.9 l=0.35
X312 vss t_Xpi_Xch_d_Xmixn_Xs7_dum vss vss sky130_fd_pr__nfet_01v8_lvt w=0.55 l=0.15
X313 vdd t_Xpi_Xch_d_Xmixn_Xs7_dum vdd vdd sky130_fd_pr__pfet_01v8 w=2.3 l=0.15
X314 t_Xpi_Xch_d_mixn vss sky130_fd_pr__cap_mim_m3_1 w=3.1 l=3.1
X315 t_Xpi_Xch_d_Xrec_acp t_Xpi_Xch_d_mixp sky130_fd_pr__cap_mim_m3_1 w=4.1 l=4.1
X316 t_Xpi_Xch_d_Xrec_acn t_Xpi_Xch_d_mixn sky130_fd_pr__cap_mim_m3_1 w=4.1 l=4.1
X317 t_Xpi_Xch_d_Xrec_acp t_Xpi_Xch_d_r1p vss sky130_fd_pr__res_high_po_0p35 l=10.5
X318 t_Xpi_Xch_d_Xrec_acn t_Xpi_Xch_d_r1n vss sky130_fd_pr__res_high_po_0p35 l=10.5
X319 t_Xpi_Xch_d_r1p t_Xpi_Xch_d_Xrec_acp vss vss sky130_fd_pr__nfet_01v8_lvt w=1.85 l=0.15
X320 t_Xpi_Xch_d_r1p t_Xpi_Xch_d_Xrec_acp vdd vdd sky130_fd_pr__pfet_01v8_lvt w=7.4 l=0.35
X321 t_Xpi_Xch_d_r1n t_Xpi_Xch_d_Xrec_acn vss vss sky130_fd_pr__nfet_01v8_lvt w=1.85 l=0.15
X322 t_Xpi_Xch_d_r1n t_Xpi_Xch_d_Xrec_acn vdd vdd sky130_fd_pr__pfet_01v8_lvt w=7.4 l=0.35
X323 dp t_Xpi_Xch_d_r1n vss vss sky130_fd_pr__nfet_01v8_lvt w=2.8 l=0.15
X324 dp t_Xpi_Xch_d_r1n vdd vdd sky130_fd_pr__pfet_01v8_lvt w=11.2 l=0.35
X325 dn t_Xpi_Xch_d_r1p vss vss sky130_fd_pr__nfet_01v8_lvt w=2.8 l=0.15
X326 dn t_Xpi_Xch_d_r1p vdd vdd sky130_fd_pr__pfet_01v8_lvt w=11.2 l=0.35
X327 t_Xpi_cb2 a0 t_Xpi_Xch_e_Xmap_m vss sky130_fd_pr__nfet_01v8_lvt w=1.6 l=0.15
X328 t_Xpi_cb2 t_Xpi_ab0 t_Xpi_Xch_e_Xmap_m vdd sky130_fd_pr__pfet_01v8_lvt w=4.2 l=0.35
X329 t_Xpi_cb4 a2 t_Xpi_Xch_e_Xmap_m vss sky130_fd_pr__nfet_01v8_lvt w=1.6 l=0.15
X330 t_Xpi_cb4 t_Xpi_ab2 t_Xpi_Xch_e_Xmap_m vdd sky130_fd_pr__pfet_01v8_lvt w=4.2 l=0.35
X331 t_Xpi_cb6 a4 t_Xpi_Xch_e_Xmap_m vss sky130_fd_pr__nfet_01v8_lvt w=1.6 l=0.15
X332 t_Xpi_cb6 t_Xpi_ab4 t_Xpi_Xch_e_Xmap_m vdd sky130_fd_pr__pfet_01v8_lvt w=4.2 l=0.35
X333 t_Xpi_cb0 a6 t_Xpi_Xch_e_Xmap_m vss sky130_fd_pr__nfet_01v8_lvt w=1.6 l=0.15
X334 t_Xpi_cb0 t_Xpi_ab6 t_Xpi_Xch_e_Xmap_m vdd sky130_fd_pr__pfet_01v8_lvt w=4.2 l=0.35
X335 t_Xpi_Xch_e_cap t_Xpi_Xch_e_Xmap_m vss vss sky130_fd_pr__nfet_01v8_lvt w=2 l=0.15
X336 t_Xpi_Xch_e_cap t_Xpi_Xch_e_Xmap_m vdd vdd sky130_fd_pr__pfet_01v8 w=8.8 l=0.15
X337 t_Xpi_cb6 a0 t_Xpi_Xch_e_Xman_m vss sky130_fd_pr__nfet_01v8_lvt w=1.6 l=0.15
X338 t_Xpi_cb6 t_Xpi_ab0 t_Xpi_Xch_e_Xman_m vdd sky130_fd_pr__pfet_01v8_lvt w=4.2 l=0.35
X339 t_Xpi_cb0 a2 t_Xpi_Xch_e_Xman_m vss sky130_fd_pr__nfet_01v8_lvt w=1.6 l=0.15
X340 t_Xpi_cb0 t_Xpi_ab2 t_Xpi_Xch_e_Xman_m vdd sky130_fd_pr__pfet_01v8_lvt w=4.2 l=0.35
X341 t_Xpi_cb2 a4 t_Xpi_Xch_e_Xman_m vss sky130_fd_pr__nfet_01v8_lvt w=1.6 l=0.15
X342 t_Xpi_cb2 t_Xpi_ab4 t_Xpi_Xch_e_Xman_m vdd sky130_fd_pr__pfet_01v8_lvt w=4.2 l=0.35
X343 t_Xpi_cb4 a6 t_Xpi_Xch_e_Xman_m vss sky130_fd_pr__nfet_01v8_lvt w=1.6 l=0.15
X344 t_Xpi_cb4 t_Xpi_ab6 t_Xpi_Xch_e_Xman_m vdd sky130_fd_pr__pfet_01v8_lvt w=4.2 l=0.35
X345 t_Xpi_Xch_e_can t_Xpi_Xch_e_Xman_m vss vss sky130_fd_pr__nfet_01v8_lvt w=2 l=0.15
X346 t_Xpi_Xch_e_can t_Xpi_Xch_e_Xman_m vdd vdd sky130_fd_pr__pfet_01v8 w=8.8 l=0.15
X347 t_Xpi_cb3 b1 t_Xpi_Xch_e_Xmbp_m vss sky130_fd_pr__nfet_01v8_lvt w=1.6 l=0.15
X348 t_Xpi_cb3 t_Xpi_bb1 t_Xpi_Xch_e_Xmbp_m vdd sky130_fd_pr__pfet_01v8_lvt w=4.2 l=0.35
X349 t_Xpi_cb5 b3 t_Xpi_Xch_e_Xmbp_m vss sky130_fd_pr__nfet_01v8_lvt w=1.6 l=0.15
X350 t_Xpi_cb5 t_Xpi_bb3 t_Xpi_Xch_e_Xmbp_m vdd sky130_fd_pr__pfet_01v8_lvt w=4.2 l=0.35
X351 t_Xpi_cb7 b5 t_Xpi_Xch_e_Xmbp_m vss sky130_fd_pr__nfet_01v8_lvt w=1.6 l=0.15
X352 t_Xpi_cb7 t_Xpi_bb5 t_Xpi_Xch_e_Xmbp_m vdd sky130_fd_pr__pfet_01v8_lvt w=4.2 l=0.35
X353 t_Xpi_cb1 b7 t_Xpi_Xch_e_Xmbp_m vss sky130_fd_pr__nfet_01v8_lvt w=1.6 l=0.15
X354 t_Xpi_cb1 t_Xpi_bb7 t_Xpi_Xch_e_Xmbp_m vdd sky130_fd_pr__pfet_01v8_lvt w=4.2 l=0.35
X355 t_Xpi_Xch_e_cbp t_Xpi_Xch_e_Xmbp_m vss vss sky130_fd_pr__nfet_01v8_lvt w=2 l=0.15
X356 t_Xpi_Xch_e_cbp t_Xpi_Xch_e_Xmbp_m vdd vdd sky130_fd_pr__pfet_01v8 w=8.8 l=0.15
X357 t_Xpi_cb7 b1 t_Xpi_Xch_e_Xmbn_m vss sky130_fd_pr__nfet_01v8_lvt w=1.6 l=0.15
X358 t_Xpi_cb7 t_Xpi_bb1 t_Xpi_Xch_e_Xmbn_m vdd sky130_fd_pr__pfet_01v8_lvt w=4.2 l=0.35
X359 t_Xpi_cb1 b3 t_Xpi_Xch_e_Xmbn_m vss sky130_fd_pr__nfet_01v8_lvt w=1.6 l=0.15
X360 t_Xpi_cb1 t_Xpi_bb3 t_Xpi_Xch_e_Xmbn_m vdd sky130_fd_pr__pfet_01v8_lvt w=4.2 l=0.35
X361 t_Xpi_cb3 b5 t_Xpi_Xch_e_Xmbn_m vss sky130_fd_pr__nfet_01v8_lvt w=1.6 l=0.15
X362 t_Xpi_cb3 t_Xpi_bb5 t_Xpi_Xch_e_Xmbn_m vdd sky130_fd_pr__pfet_01v8_lvt w=4.2 l=0.35
X363 t_Xpi_cb5 b7 t_Xpi_Xch_e_Xmbn_m vss sky130_fd_pr__nfet_01v8_lvt w=1.6 l=0.15
X364 t_Xpi_cb5 t_Xpi_bb7 t_Xpi_Xch_e_Xmbn_m vdd sky130_fd_pr__pfet_01v8_lvt w=4.2 l=0.35
X365 t_Xpi_Xch_e_cbn t_Xpi_Xch_e_Xmbn_m vss vss sky130_fd_pr__nfet_01v8_lvt w=2 l=0.15
X366 t_Xpi_Xch_e_cbn t_Xpi_Xch_e_Xmbn_m vdd vdd sky130_fd_pr__pfet_01v8 w=8.8 l=0.15
X367 t_Xpi_Xch_e_cap t_Xpi_fb0 t_Xpi_Xch_e_Xmixp_Xs0_sel vss sky130_fd_pr__nfet_01v8_lvt w=0.5 l=0.15
X368 t_Xpi_Xch_e_cap f0 t_Xpi_Xch_e_Xmixp_Xs0_sel vdd sky130_fd_pr__pfet_01v8_lvt w=0.9 l=0.35
X369 t_Xpi_Xch_e_cbp f0 t_Xpi_Xch_e_Xmixp_Xs0_sel vss sky130_fd_pr__nfet_01v8_lvt w=0.5 l=0.15
X370 t_Xpi_Xch_e_cbp t_Xpi_fb0 t_Xpi_Xch_e_Xmixp_Xs0_sel vdd sky130_fd_pr__pfet_01v8_lvt w=0.9 l=0.35
X371 t_Xpi_Xch_e_Xmixp_Xs0_drv t_Xpi_Xch_e_Xmixp_Xs0_sel vss vss sky130_fd_pr__nfet_01v8_lvt w=0.55 l=0.15
X372 t_Xpi_Xch_e_Xmixp_Xs0_drv t_Xpi_Xch_e_Xmixp_Xs0_sel vdd vdd sky130_fd_pr__pfet_01v8 w=2.3 l=0.15
X373 t_Xpi_Xch_e_Xmixp_Xs0_drv t_Xpi_Xch_e_mixp vss sky130_fd_pr__res_high_po_0p69 l=7.2
X374 t_Xpi_Xch_e_cap f0 t_Xpi_Xch_e_Xmixp_Xs0_dum vss sky130_fd_pr__nfet_01v8_lvt w=0.5 l=0.15
X375 t_Xpi_Xch_e_cap t_Xpi_fb0 t_Xpi_Xch_e_Xmixp_Xs0_dum vdd sky130_fd_pr__pfet_01v8_lvt w=0.9 l=0.35
X376 t_Xpi_Xch_e_cbp t_Xpi_fb0 t_Xpi_Xch_e_Xmixp_Xs0_dum vss sky130_fd_pr__nfet_01v8_lvt w=0.5 l=0.15
X377 t_Xpi_Xch_e_cbp f0 t_Xpi_Xch_e_Xmixp_Xs0_dum vdd sky130_fd_pr__pfet_01v8_lvt w=0.9 l=0.35
X378 vss t_Xpi_Xch_e_Xmixp_Xs0_dum vss vss sky130_fd_pr__nfet_01v8_lvt w=0.55 l=0.15
X379 vdd t_Xpi_Xch_e_Xmixp_Xs0_dum vdd vdd sky130_fd_pr__pfet_01v8 w=2.3 l=0.15
X380 t_Xpi_Xch_e_cap t_Xpi_fb1 t_Xpi_Xch_e_Xmixp_Xs1_sel vss sky130_fd_pr__nfet_01v8_lvt w=0.5 l=0.15
X381 t_Xpi_Xch_e_cap f1 t_Xpi_Xch_e_Xmixp_Xs1_sel vdd sky130_fd_pr__pfet_01v8_lvt w=0.9 l=0.35
X382 t_Xpi_Xch_e_cbp f1 t_Xpi_Xch_e_Xmixp_Xs1_sel vss sky130_fd_pr__nfet_01v8_lvt w=0.5 l=0.15
X383 t_Xpi_Xch_e_cbp t_Xpi_fb1 t_Xpi_Xch_e_Xmixp_Xs1_sel vdd sky130_fd_pr__pfet_01v8_lvt w=0.9 l=0.35
X384 t_Xpi_Xch_e_Xmixp_Xs1_drv t_Xpi_Xch_e_Xmixp_Xs1_sel vss vss sky130_fd_pr__nfet_01v8_lvt w=0.55 l=0.15
X385 t_Xpi_Xch_e_Xmixp_Xs1_drv t_Xpi_Xch_e_Xmixp_Xs1_sel vdd vdd sky130_fd_pr__pfet_01v8 w=2.3 l=0.15
X386 t_Xpi_Xch_e_Xmixp_Xs1_drv t_Xpi_Xch_e_mixp vss sky130_fd_pr__res_high_po_0p69 l=7.2
X387 t_Xpi_Xch_e_cap f1 t_Xpi_Xch_e_Xmixp_Xs1_dum vss sky130_fd_pr__nfet_01v8_lvt w=0.5 l=0.15
X388 t_Xpi_Xch_e_cap t_Xpi_fb1 t_Xpi_Xch_e_Xmixp_Xs1_dum vdd sky130_fd_pr__pfet_01v8_lvt w=0.9 l=0.35
X389 t_Xpi_Xch_e_cbp t_Xpi_fb1 t_Xpi_Xch_e_Xmixp_Xs1_dum vss sky130_fd_pr__nfet_01v8_lvt w=0.5 l=0.15
X390 t_Xpi_Xch_e_cbp f1 t_Xpi_Xch_e_Xmixp_Xs1_dum vdd sky130_fd_pr__pfet_01v8_lvt w=0.9 l=0.35
X391 vss t_Xpi_Xch_e_Xmixp_Xs1_dum vss vss sky130_fd_pr__nfet_01v8_lvt w=0.55 l=0.15
X392 vdd t_Xpi_Xch_e_Xmixp_Xs1_dum vdd vdd sky130_fd_pr__pfet_01v8 w=2.3 l=0.15
X393 t_Xpi_Xch_e_cap t_Xpi_fb2 t_Xpi_Xch_e_Xmixp_Xs2_sel vss sky130_fd_pr__nfet_01v8_lvt w=0.5 l=0.15
X394 t_Xpi_Xch_e_cap f2 t_Xpi_Xch_e_Xmixp_Xs2_sel vdd sky130_fd_pr__pfet_01v8_lvt w=0.9 l=0.35
X395 t_Xpi_Xch_e_cbp f2 t_Xpi_Xch_e_Xmixp_Xs2_sel vss sky130_fd_pr__nfet_01v8_lvt w=0.5 l=0.15
X396 t_Xpi_Xch_e_cbp t_Xpi_fb2 t_Xpi_Xch_e_Xmixp_Xs2_sel vdd sky130_fd_pr__pfet_01v8_lvt w=0.9 l=0.35
X397 t_Xpi_Xch_e_Xmixp_Xs2_drv t_Xpi_Xch_e_Xmixp_Xs2_sel vss vss sky130_fd_pr__nfet_01v8_lvt w=0.55 l=0.15
X398 t_Xpi_Xch_e_Xmixp_Xs2_drv t_Xpi_Xch_e_Xmixp_Xs2_sel vdd vdd sky130_fd_pr__pfet_01v8 w=2.3 l=0.15
X399 t_Xpi_Xch_e_Xmixp_Xs2_drv t_Xpi_Xch_e_mixp vss sky130_fd_pr__res_high_po_0p69 l=7.2
X400 t_Xpi_Xch_e_cap f2 t_Xpi_Xch_e_Xmixp_Xs2_dum vss sky130_fd_pr__nfet_01v8_lvt w=0.5 l=0.15
X401 t_Xpi_Xch_e_cap t_Xpi_fb2 t_Xpi_Xch_e_Xmixp_Xs2_dum vdd sky130_fd_pr__pfet_01v8_lvt w=0.9 l=0.35
X402 t_Xpi_Xch_e_cbp t_Xpi_fb2 t_Xpi_Xch_e_Xmixp_Xs2_dum vss sky130_fd_pr__nfet_01v8_lvt w=0.5 l=0.15
X403 t_Xpi_Xch_e_cbp f2 t_Xpi_Xch_e_Xmixp_Xs2_dum vdd sky130_fd_pr__pfet_01v8_lvt w=0.9 l=0.35
X404 vss t_Xpi_Xch_e_Xmixp_Xs2_dum vss vss sky130_fd_pr__nfet_01v8_lvt w=0.55 l=0.15
X405 vdd t_Xpi_Xch_e_Xmixp_Xs2_dum vdd vdd sky130_fd_pr__pfet_01v8 w=2.3 l=0.15
X406 t_Xpi_Xch_e_cap t_Xpi_fb3 t_Xpi_Xch_e_Xmixp_Xs3_sel vss sky130_fd_pr__nfet_01v8_lvt w=0.5 l=0.15
X407 t_Xpi_Xch_e_cap f3 t_Xpi_Xch_e_Xmixp_Xs3_sel vdd sky130_fd_pr__pfet_01v8_lvt w=0.9 l=0.35
X408 t_Xpi_Xch_e_cbp f3 t_Xpi_Xch_e_Xmixp_Xs3_sel vss sky130_fd_pr__nfet_01v8_lvt w=0.5 l=0.15
X409 t_Xpi_Xch_e_cbp t_Xpi_fb3 t_Xpi_Xch_e_Xmixp_Xs3_sel vdd sky130_fd_pr__pfet_01v8_lvt w=0.9 l=0.35
X410 t_Xpi_Xch_e_Xmixp_Xs3_drv t_Xpi_Xch_e_Xmixp_Xs3_sel vss vss sky130_fd_pr__nfet_01v8_lvt w=0.55 l=0.15
X411 t_Xpi_Xch_e_Xmixp_Xs3_drv t_Xpi_Xch_e_Xmixp_Xs3_sel vdd vdd sky130_fd_pr__pfet_01v8 w=2.3 l=0.15
X412 t_Xpi_Xch_e_Xmixp_Xs3_drv t_Xpi_Xch_e_mixp vss sky130_fd_pr__res_high_po_0p69 l=7.2
X413 t_Xpi_Xch_e_cap f3 t_Xpi_Xch_e_Xmixp_Xs3_dum vss sky130_fd_pr__nfet_01v8_lvt w=0.5 l=0.15
X414 t_Xpi_Xch_e_cap t_Xpi_fb3 t_Xpi_Xch_e_Xmixp_Xs3_dum vdd sky130_fd_pr__pfet_01v8_lvt w=0.9 l=0.35
X415 t_Xpi_Xch_e_cbp t_Xpi_fb3 t_Xpi_Xch_e_Xmixp_Xs3_dum vss sky130_fd_pr__nfet_01v8_lvt w=0.5 l=0.15
X416 t_Xpi_Xch_e_cbp f3 t_Xpi_Xch_e_Xmixp_Xs3_dum vdd sky130_fd_pr__pfet_01v8_lvt w=0.9 l=0.35
X417 vss t_Xpi_Xch_e_Xmixp_Xs3_dum vss vss sky130_fd_pr__nfet_01v8_lvt w=0.55 l=0.15
X418 vdd t_Xpi_Xch_e_Xmixp_Xs3_dum vdd vdd sky130_fd_pr__pfet_01v8 w=2.3 l=0.15
X419 t_Xpi_Xch_e_cap t_Xpi_fb4 t_Xpi_Xch_e_Xmixp_Xs4_sel vss sky130_fd_pr__nfet_01v8_lvt w=0.5 l=0.15
X420 t_Xpi_Xch_e_cap f4 t_Xpi_Xch_e_Xmixp_Xs4_sel vdd sky130_fd_pr__pfet_01v8_lvt w=0.9 l=0.35
X421 t_Xpi_Xch_e_cbp f4 t_Xpi_Xch_e_Xmixp_Xs4_sel vss sky130_fd_pr__nfet_01v8_lvt w=0.5 l=0.15
X422 t_Xpi_Xch_e_cbp t_Xpi_fb4 t_Xpi_Xch_e_Xmixp_Xs4_sel vdd sky130_fd_pr__pfet_01v8_lvt w=0.9 l=0.35
X423 t_Xpi_Xch_e_Xmixp_Xs4_drv t_Xpi_Xch_e_Xmixp_Xs4_sel vss vss sky130_fd_pr__nfet_01v8_lvt w=0.55 l=0.15
X424 t_Xpi_Xch_e_Xmixp_Xs4_drv t_Xpi_Xch_e_Xmixp_Xs4_sel vdd vdd sky130_fd_pr__pfet_01v8 w=2.3 l=0.15
X425 t_Xpi_Xch_e_Xmixp_Xs4_drv t_Xpi_Xch_e_mixp vss sky130_fd_pr__res_high_po_0p69 l=7.2
X426 t_Xpi_Xch_e_cap f4 t_Xpi_Xch_e_Xmixp_Xs4_dum vss sky130_fd_pr__nfet_01v8_lvt w=0.5 l=0.15
X427 t_Xpi_Xch_e_cap t_Xpi_fb4 t_Xpi_Xch_e_Xmixp_Xs4_dum vdd sky130_fd_pr__pfet_01v8_lvt w=0.9 l=0.35
X428 t_Xpi_Xch_e_cbp t_Xpi_fb4 t_Xpi_Xch_e_Xmixp_Xs4_dum vss sky130_fd_pr__nfet_01v8_lvt w=0.5 l=0.15
X429 t_Xpi_Xch_e_cbp f4 t_Xpi_Xch_e_Xmixp_Xs4_dum vdd sky130_fd_pr__pfet_01v8_lvt w=0.9 l=0.35
X430 vss t_Xpi_Xch_e_Xmixp_Xs4_dum vss vss sky130_fd_pr__nfet_01v8_lvt w=0.55 l=0.15
X431 vdd t_Xpi_Xch_e_Xmixp_Xs4_dum vdd vdd sky130_fd_pr__pfet_01v8 w=2.3 l=0.15
X432 t_Xpi_Xch_e_cap t_Xpi_fb5 t_Xpi_Xch_e_Xmixp_Xs5_sel vss sky130_fd_pr__nfet_01v8_lvt w=0.5 l=0.15
X433 t_Xpi_Xch_e_cap f5 t_Xpi_Xch_e_Xmixp_Xs5_sel vdd sky130_fd_pr__pfet_01v8_lvt w=0.9 l=0.35
X434 t_Xpi_Xch_e_cbp f5 t_Xpi_Xch_e_Xmixp_Xs5_sel vss sky130_fd_pr__nfet_01v8_lvt w=0.5 l=0.15
X435 t_Xpi_Xch_e_cbp t_Xpi_fb5 t_Xpi_Xch_e_Xmixp_Xs5_sel vdd sky130_fd_pr__pfet_01v8_lvt w=0.9 l=0.35
X436 t_Xpi_Xch_e_Xmixp_Xs5_drv t_Xpi_Xch_e_Xmixp_Xs5_sel vss vss sky130_fd_pr__nfet_01v8_lvt w=0.55 l=0.15
X437 t_Xpi_Xch_e_Xmixp_Xs5_drv t_Xpi_Xch_e_Xmixp_Xs5_sel vdd vdd sky130_fd_pr__pfet_01v8 w=2.3 l=0.15
X438 t_Xpi_Xch_e_Xmixp_Xs5_drv t_Xpi_Xch_e_mixp vss sky130_fd_pr__res_high_po_0p69 l=7.2
X439 t_Xpi_Xch_e_cap f5 t_Xpi_Xch_e_Xmixp_Xs5_dum vss sky130_fd_pr__nfet_01v8_lvt w=0.5 l=0.15
X440 t_Xpi_Xch_e_cap t_Xpi_fb5 t_Xpi_Xch_e_Xmixp_Xs5_dum vdd sky130_fd_pr__pfet_01v8_lvt w=0.9 l=0.35
X441 t_Xpi_Xch_e_cbp t_Xpi_fb5 t_Xpi_Xch_e_Xmixp_Xs5_dum vss sky130_fd_pr__nfet_01v8_lvt w=0.5 l=0.15
X442 t_Xpi_Xch_e_cbp f5 t_Xpi_Xch_e_Xmixp_Xs5_dum vdd sky130_fd_pr__pfet_01v8_lvt w=0.9 l=0.35
X443 vss t_Xpi_Xch_e_Xmixp_Xs5_dum vss vss sky130_fd_pr__nfet_01v8_lvt w=0.55 l=0.15
X444 vdd t_Xpi_Xch_e_Xmixp_Xs5_dum vdd vdd sky130_fd_pr__pfet_01v8 w=2.3 l=0.15
X445 t_Xpi_Xch_e_cap t_Xpi_fb6 t_Xpi_Xch_e_Xmixp_Xs6_sel vss sky130_fd_pr__nfet_01v8_lvt w=0.5 l=0.15
X446 t_Xpi_Xch_e_cap f6 t_Xpi_Xch_e_Xmixp_Xs6_sel vdd sky130_fd_pr__pfet_01v8_lvt w=0.9 l=0.35
X447 t_Xpi_Xch_e_cbp f6 t_Xpi_Xch_e_Xmixp_Xs6_sel vss sky130_fd_pr__nfet_01v8_lvt w=0.5 l=0.15
X448 t_Xpi_Xch_e_cbp t_Xpi_fb6 t_Xpi_Xch_e_Xmixp_Xs6_sel vdd sky130_fd_pr__pfet_01v8_lvt w=0.9 l=0.35
X449 t_Xpi_Xch_e_Xmixp_Xs6_drv t_Xpi_Xch_e_Xmixp_Xs6_sel vss vss sky130_fd_pr__nfet_01v8_lvt w=0.55 l=0.15
X450 t_Xpi_Xch_e_Xmixp_Xs6_drv t_Xpi_Xch_e_Xmixp_Xs6_sel vdd vdd sky130_fd_pr__pfet_01v8 w=2.3 l=0.15
X451 t_Xpi_Xch_e_Xmixp_Xs6_drv t_Xpi_Xch_e_mixp vss sky130_fd_pr__res_high_po_0p69 l=7.2
X452 t_Xpi_Xch_e_cap f6 t_Xpi_Xch_e_Xmixp_Xs6_dum vss sky130_fd_pr__nfet_01v8_lvt w=0.5 l=0.15
X453 t_Xpi_Xch_e_cap t_Xpi_fb6 t_Xpi_Xch_e_Xmixp_Xs6_dum vdd sky130_fd_pr__pfet_01v8_lvt w=0.9 l=0.35
X454 t_Xpi_Xch_e_cbp t_Xpi_fb6 t_Xpi_Xch_e_Xmixp_Xs6_dum vss sky130_fd_pr__nfet_01v8_lvt w=0.5 l=0.15
X455 t_Xpi_Xch_e_cbp f6 t_Xpi_Xch_e_Xmixp_Xs6_dum vdd sky130_fd_pr__pfet_01v8_lvt w=0.9 l=0.35
X456 vss t_Xpi_Xch_e_Xmixp_Xs6_dum vss vss sky130_fd_pr__nfet_01v8_lvt w=0.55 l=0.15
X457 vdd t_Xpi_Xch_e_Xmixp_Xs6_dum vdd vdd sky130_fd_pr__pfet_01v8 w=2.3 l=0.15
X458 t_Xpi_Xch_e_cap t_Xpi_fb7 t_Xpi_Xch_e_Xmixp_Xs7_sel vss sky130_fd_pr__nfet_01v8_lvt w=0.5 l=0.15
X459 t_Xpi_Xch_e_cap f7 t_Xpi_Xch_e_Xmixp_Xs7_sel vdd sky130_fd_pr__pfet_01v8_lvt w=0.9 l=0.35
X460 t_Xpi_Xch_e_cbp f7 t_Xpi_Xch_e_Xmixp_Xs7_sel vss sky130_fd_pr__nfet_01v8_lvt w=0.5 l=0.15
X461 t_Xpi_Xch_e_cbp t_Xpi_fb7 t_Xpi_Xch_e_Xmixp_Xs7_sel vdd sky130_fd_pr__pfet_01v8_lvt w=0.9 l=0.35
X462 t_Xpi_Xch_e_Xmixp_Xs7_drv t_Xpi_Xch_e_Xmixp_Xs7_sel vss vss sky130_fd_pr__nfet_01v8_lvt w=0.55 l=0.15
X463 t_Xpi_Xch_e_Xmixp_Xs7_drv t_Xpi_Xch_e_Xmixp_Xs7_sel vdd vdd sky130_fd_pr__pfet_01v8 w=2.3 l=0.15
X464 t_Xpi_Xch_e_Xmixp_Xs7_drv t_Xpi_Xch_e_mixp vss sky130_fd_pr__res_high_po_0p69 l=7.2
X465 t_Xpi_Xch_e_cap f7 t_Xpi_Xch_e_Xmixp_Xs7_dum vss sky130_fd_pr__nfet_01v8_lvt w=0.5 l=0.15
X466 t_Xpi_Xch_e_cap t_Xpi_fb7 t_Xpi_Xch_e_Xmixp_Xs7_dum vdd sky130_fd_pr__pfet_01v8_lvt w=0.9 l=0.35
X467 t_Xpi_Xch_e_cbp t_Xpi_fb7 t_Xpi_Xch_e_Xmixp_Xs7_dum vss sky130_fd_pr__nfet_01v8_lvt w=0.5 l=0.15
X468 t_Xpi_Xch_e_cbp f7 t_Xpi_Xch_e_Xmixp_Xs7_dum vdd sky130_fd_pr__pfet_01v8_lvt w=0.9 l=0.35
X469 vss t_Xpi_Xch_e_Xmixp_Xs7_dum vss vss sky130_fd_pr__nfet_01v8_lvt w=0.55 l=0.15
X470 vdd t_Xpi_Xch_e_Xmixp_Xs7_dum vdd vdd sky130_fd_pr__pfet_01v8 w=2.3 l=0.15
X471 t_Xpi_Xch_e_mixp vss sky130_fd_pr__cap_mim_m3_1 w=3.1 l=3.1
X472 t_Xpi_Xch_e_can t_Xpi_fb0 t_Xpi_Xch_e_Xmixn_Xs0_sel vss sky130_fd_pr__nfet_01v8_lvt w=0.5 l=0.15
X473 t_Xpi_Xch_e_can f0 t_Xpi_Xch_e_Xmixn_Xs0_sel vdd sky130_fd_pr__pfet_01v8_lvt w=0.9 l=0.35
X474 t_Xpi_Xch_e_cbn f0 t_Xpi_Xch_e_Xmixn_Xs0_sel vss sky130_fd_pr__nfet_01v8_lvt w=0.5 l=0.15
X475 t_Xpi_Xch_e_cbn t_Xpi_fb0 t_Xpi_Xch_e_Xmixn_Xs0_sel vdd sky130_fd_pr__pfet_01v8_lvt w=0.9 l=0.35
X476 t_Xpi_Xch_e_Xmixn_Xs0_drv t_Xpi_Xch_e_Xmixn_Xs0_sel vss vss sky130_fd_pr__nfet_01v8_lvt w=0.55 l=0.15
X477 t_Xpi_Xch_e_Xmixn_Xs0_drv t_Xpi_Xch_e_Xmixn_Xs0_sel vdd vdd sky130_fd_pr__pfet_01v8 w=2.3 l=0.15
X478 t_Xpi_Xch_e_Xmixn_Xs0_drv t_Xpi_Xch_e_mixn vss sky130_fd_pr__res_high_po_0p69 l=7.2
X479 t_Xpi_Xch_e_can f0 t_Xpi_Xch_e_Xmixn_Xs0_dum vss sky130_fd_pr__nfet_01v8_lvt w=0.5 l=0.15
X480 t_Xpi_Xch_e_can t_Xpi_fb0 t_Xpi_Xch_e_Xmixn_Xs0_dum vdd sky130_fd_pr__pfet_01v8_lvt w=0.9 l=0.35
X481 t_Xpi_Xch_e_cbn t_Xpi_fb0 t_Xpi_Xch_e_Xmixn_Xs0_dum vss sky130_fd_pr__nfet_01v8_lvt w=0.5 l=0.15
X482 t_Xpi_Xch_e_cbn f0 t_Xpi_Xch_e_Xmixn_Xs0_dum vdd sky130_fd_pr__pfet_01v8_lvt w=0.9 l=0.35
X483 vss t_Xpi_Xch_e_Xmixn_Xs0_dum vss vss sky130_fd_pr__nfet_01v8_lvt w=0.55 l=0.15
X484 vdd t_Xpi_Xch_e_Xmixn_Xs0_dum vdd vdd sky130_fd_pr__pfet_01v8 w=2.3 l=0.15
X485 t_Xpi_Xch_e_can t_Xpi_fb1 t_Xpi_Xch_e_Xmixn_Xs1_sel vss sky130_fd_pr__nfet_01v8_lvt w=0.5 l=0.15
X486 t_Xpi_Xch_e_can f1 t_Xpi_Xch_e_Xmixn_Xs1_sel vdd sky130_fd_pr__pfet_01v8_lvt w=0.9 l=0.35
X487 t_Xpi_Xch_e_cbn f1 t_Xpi_Xch_e_Xmixn_Xs1_sel vss sky130_fd_pr__nfet_01v8_lvt w=0.5 l=0.15
X488 t_Xpi_Xch_e_cbn t_Xpi_fb1 t_Xpi_Xch_e_Xmixn_Xs1_sel vdd sky130_fd_pr__pfet_01v8_lvt w=0.9 l=0.35
X489 t_Xpi_Xch_e_Xmixn_Xs1_drv t_Xpi_Xch_e_Xmixn_Xs1_sel vss vss sky130_fd_pr__nfet_01v8_lvt w=0.55 l=0.15
X490 t_Xpi_Xch_e_Xmixn_Xs1_drv t_Xpi_Xch_e_Xmixn_Xs1_sel vdd vdd sky130_fd_pr__pfet_01v8 w=2.3 l=0.15
X491 t_Xpi_Xch_e_Xmixn_Xs1_drv t_Xpi_Xch_e_mixn vss sky130_fd_pr__res_high_po_0p69 l=7.2
X492 t_Xpi_Xch_e_can f1 t_Xpi_Xch_e_Xmixn_Xs1_dum vss sky130_fd_pr__nfet_01v8_lvt w=0.5 l=0.15
X493 t_Xpi_Xch_e_can t_Xpi_fb1 t_Xpi_Xch_e_Xmixn_Xs1_dum vdd sky130_fd_pr__pfet_01v8_lvt w=0.9 l=0.35
X494 t_Xpi_Xch_e_cbn t_Xpi_fb1 t_Xpi_Xch_e_Xmixn_Xs1_dum vss sky130_fd_pr__nfet_01v8_lvt w=0.5 l=0.15
X495 t_Xpi_Xch_e_cbn f1 t_Xpi_Xch_e_Xmixn_Xs1_dum vdd sky130_fd_pr__pfet_01v8_lvt w=0.9 l=0.35
X496 vss t_Xpi_Xch_e_Xmixn_Xs1_dum vss vss sky130_fd_pr__nfet_01v8_lvt w=0.55 l=0.15
X497 vdd t_Xpi_Xch_e_Xmixn_Xs1_dum vdd vdd sky130_fd_pr__pfet_01v8 w=2.3 l=0.15
X498 t_Xpi_Xch_e_can t_Xpi_fb2 t_Xpi_Xch_e_Xmixn_Xs2_sel vss sky130_fd_pr__nfet_01v8_lvt w=0.5 l=0.15
X499 t_Xpi_Xch_e_can f2 t_Xpi_Xch_e_Xmixn_Xs2_sel vdd sky130_fd_pr__pfet_01v8_lvt w=0.9 l=0.35
X500 t_Xpi_Xch_e_cbn f2 t_Xpi_Xch_e_Xmixn_Xs2_sel vss sky130_fd_pr__nfet_01v8_lvt w=0.5 l=0.15
X501 t_Xpi_Xch_e_cbn t_Xpi_fb2 t_Xpi_Xch_e_Xmixn_Xs2_sel vdd sky130_fd_pr__pfet_01v8_lvt w=0.9 l=0.35
X502 t_Xpi_Xch_e_Xmixn_Xs2_drv t_Xpi_Xch_e_Xmixn_Xs2_sel vss vss sky130_fd_pr__nfet_01v8_lvt w=0.55 l=0.15
X503 t_Xpi_Xch_e_Xmixn_Xs2_drv t_Xpi_Xch_e_Xmixn_Xs2_sel vdd vdd sky130_fd_pr__pfet_01v8 w=2.3 l=0.15
X504 t_Xpi_Xch_e_Xmixn_Xs2_drv t_Xpi_Xch_e_mixn vss sky130_fd_pr__res_high_po_0p69 l=7.2
X505 t_Xpi_Xch_e_can f2 t_Xpi_Xch_e_Xmixn_Xs2_dum vss sky130_fd_pr__nfet_01v8_lvt w=0.5 l=0.15
X506 t_Xpi_Xch_e_can t_Xpi_fb2 t_Xpi_Xch_e_Xmixn_Xs2_dum vdd sky130_fd_pr__pfet_01v8_lvt w=0.9 l=0.35
X507 t_Xpi_Xch_e_cbn t_Xpi_fb2 t_Xpi_Xch_e_Xmixn_Xs2_dum vss sky130_fd_pr__nfet_01v8_lvt w=0.5 l=0.15
X508 t_Xpi_Xch_e_cbn f2 t_Xpi_Xch_e_Xmixn_Xs2_dum vdd sky130_fd_pr__pfet_01v8_lvt w=0.9 l=0.35
X509 vss t_Xpi_Xch_e_Xmixn_Xs2_dum vss vss sky130_fd_pr__nfet_01v8_lvt w=0.55 l=0.15
X510 vdd t_Xpi_Xch_e_Xmixn_Xs2_dum vdd vdd sky130_fd_pr__pfet_01v8 w=2.3 l=0.15
X511 t_Xpi_Xch_e_can t_Xpi_fb3 t_Xpi_Xch_e_Xmixn_Xs3_sel vss sky130_fd_pr__nfet_01v8_lvt w=0.5 l=0.15
X512 t_Xpi_Xch_e_can f3 t_Xpi_Xch_e_Xmixn_Xs3_sel vdd sky130_fd_pr__pfet_01v8_lvt w=0.9 l=0.35
X513 t_Xpi_Xch_e_cbn f3 t_Xpi_Xch_e_Xmixn_Xs3_sel vss sky130_fd_pr__nfet_01v8_lvt w=0.5 l=0.15
X514 t_Xpi_Xch_e_cbn t_Xpi_fb3 t_Xpi_Xch_e_Xmixn_Xs3_sel vdd sky130_fd_pr__pfet_01v8_lvt w=0.9 l=0.35
X515 t_Xpi_Xch_e_Xmixn_Xs3_drv t_Xpi_Xch_e_Xmixn_Xs3_sel vss vss sky130_fd_pr__nfet_01v8_lvt w=0.55 l=0.15
X516 t_Xpi_Xch_e_Xmixn_Xs3_drv t_Xpi_Xch_e_Xmixn_Xs3_sel vdd vdd sky130_fd_pr__pfet_01v8 w=2.3 l=0.15
X517 t_Xpi_Xch_e_Xmixn_Xs3_drv t_Xpi_Xch_e_mixn vss sky130_fd_pr__res_high_po_0p69 l=7.2
X518 t_Xpi_Xch_e_can f3 t_Xpi_Xch_e_Xmixn_Xs3_dum vss sky130_fd_pr__nfet_01v8_lvt w=0.5 l=0.15
X519 t_Xpi_Xch_e_can t_Xpi_fb3 t_Xpi_Xch_e_Xmixn_Xs3_dum vdd sky130_fd_pr__pfet_01v8_lvt w=0.9 l=0.35
X520 t_Xpi_Xch_e_cbn t_Xpi_fb3 t_Xpi_Xch_e_Xmixn_Xs3_dum vss sky130_fd_pr__nfet_01v8_lvt w=0.5 l=0.15
X521 t_Xpi_Xch_e_cbn f3 t_Xpi_Xch_e_Xmixn_Xs3_dum vdd sky130_fd_pr__pfet_01v8_lvt w=0.9 l=0.35
X522 vss t_Xpi_Xch_e_Xmixn_Xs3_dum vss vss sky130_fd_pr__nfet_01v8_lvt w=0.55 l=0.15
X523 vdd t_Xpi_Xch_e_Xmixn_Xs3_dum vdd vdd sky130_fd_pr__pfet_01v8 w=2.3 l=0.15
X524 t_Xpi_Xch_e_can t_Xpi_fb4 t_Xpi_Xch_e_Xmixn_Xs4_sel vss sky130_fd_pr__nfet_01v8_lvt w=0.5 l=0.15
X525 t_Xpi_Xch_e_can f4 t_Xpi_Xch_e_Xmixn_Xs4_sel vdd sky130_fd_pr__pfet_01v8_lvt w=0.9 l=0.35
X526 t_Xpi_Xch_e_cbn f4 t_Xpi_Xch_e_Xmixn_Xs4_sel vss sky130_fd_pr__nfet_01v8_lvt w=0.5 l=0.15
X527 t_Xpi_Xch_e_cbn t_Xpi_fb4 t_Xpi_Xch_e_Xmixn_Xs4_sel vdd sky130_fd_pr__pfet_01v8_lvt w=0.9 l=0.35
X528 t_Xpi_Xch_e_Xmixn_Xs4_drv t_Xpi_Xch_e_Xmixn_Xs4_sel vss vss sky130_fd_pr__nfet_01v8_lvt w=0.55 l=0.15
X529 t_Xpi_Xch_e_Xmixn_Xs4_drv t_Xpi_Xch_e_Xmixn_Xs4_sel vdd vdd sky130_fd_pr__pfet_01v8 w=2.3 l=0.15
X530 t_Xpi_Xch_e_Xmixn_Xs4_drv t_Xpi_Xch_e_mixn vss sky130_fd_pr__res_high_po_0p69 l=7.2
X531 t_Xpi_Xch_e_can f4 t_Xpi_Xch_e_Xmixn_Xs4_dum vss sky130_fd_pr__nfet_01v8_lvt w=0.5 l=0.15
X532 t_Xpi_Xch_e_can t_Xpi_fb4 t_Xpi_Xch_e_Xmixn_Xs4_dum vdd sky130_fd_pr__pfet_01v8_lvt w=0.9 l=0.35
X533 t_Xpi_Xch_e_cbn t_Xpi_fb4 t_Xpi_Xch_e_Xmixn_Xs4_dum vss sky130_fd_pr__nfet_01v8_lvt w=0.5 l=0.15
X534 t_Xpi_Xch_e_cbn f4 t_Xpi_Xch_e_Xmixn_Xs4_dum vdd sky130_fd_pr__pfet_01v8_lvt w=0.9 l=0.35
X535 vss t_Xpi_Xch_e_Xmixn_Xs4_dum vss vss sky130_fd_pr__nfet_01v8_lvt w=0.55 l=0.15
X536 vdd t_Xpi_Xch_e_Xmixn_Xs4_dum vdd vdd sky130_fd_pr__pfet_01v8 w=2.3 l=0.15
X537 t_Xpi_Xch_e_can t_Xpi_fb5 t_Xpi_Xch_e_Xmixn_Xs5_sel vss sky130_fd_pr__nfet_01v8_lvt w=0.5 l=0.15
X538 t_Xpi_Xch_e_can f5 t_Xpi_Xch_e_Xmixn_Xs5_sel vdd sky130_fd_pr__pfet_01v8_lvt w=0.9 l=0.35
X539 t_Xpi_Xch_e_cbn f5 t_Xpi_Xch_e_Xmixn_Xs5_sel vss sky130_fd_pr__nfet_01v8_lvt w=0.5 l=0.15
X540 t_Xpi_Xch_e_cbn t_Xpi_fb5 t_Xpi_Xch_e_Xmixn_Xs5_sel vdd sky130_fd_pr__pfet_01v8_lvt w=0.9 l=0.35
X541 t_Xpi_Xch_e_Xmixn_Xs5_drv t_Xpi_Xch_e_Xmixn_Xs5_sel vss vss sky130_fd_pr__nfet_01v8_lvt w=0.55 l=0.15
X542 t_Xpi_Xch_e_Xmixn_Xs5_drv t_Xpi_Xch_e_Xmixn_Xs5_sel vdd vdd sky130_fd_pr__pfet_01v8 w=2.3 l=0.15
X543 t_Xpi_Xch_e_Xmixn_Xs5_drv t_Xpi_Xch_e_mixn vss sky130_fd_pr__res_high_po_0p69 l=7.2
X544 t_Xpi_Xch_e_can f5 t_Xpi_Xch_e_Xmixn_Xs5_dum vss sky130_fd_pr__nfet_01v8_lvt w=0.5 l=0.15
X545 t_Xpi_Xch_e_can t_Xpi_fb5 t_Xpi_Xch_e_Xmixn_Xs5_dum vdd sky130_fd_pr__pfet_01v8_lvt w=0.9 l=0.35
X546 t_Xpi_Xch_e_cbn t_Xpi_fb5 t_Xpi_Xch_e_Xmixn_Xs5_dum vss sky130_fd_pr__nfet_01v8_lvt w=0.5 l=0.15
X547 t_Xpi_Xch_e_cbn f5 t_Xpi_Xch_e_Xmixn_Xs5_dum vdd sky130_fd_pr__pfet_01v8_lvt w=0.9 l=0.35
X548 vss t_Xpi_Xch_e_Xmixn_Xs5_dum vss vss sky130_fd_pr__nfet_01v8_lvt w=0.55 l=0.15
X549 vdd t_Xpi_Xch_e_Xmixn_Xs5_dum vdd vdd sky130_fd_pr__pfet_01v8 w=2.3 l=0.15
X550 t_Xpi_Xch_e_can t_Xpi_fb6 t_Xpi_Xch_e_Xmixn_Xs6_sel vss sky130_fd_pr__nfet_01v8_lvt w=0.5 l=0.15
X551 t_Xpi_Xch_e_can f6 t_Xpi_Xch_e_Xmixn_Xs6_sel vdd sky130_fd_pr__pfet_01v8_lvt w=0.9 l=0.35
X552 t_Xpi_Xch_e_cbn f6 t_Xpi_Xch_e_Xmixn_Xs6_sel vss sky130_fd_pr__nfet_01v8_lvt w=0.5 l=0.15
X553 t_Xpi_Xch_e_cbn t_Xpi_fb6 t_Xpi_Xch_e_Xmixn_Xs6_sel vdd sky130_fd_pr__pfet_01v8_lvt w=0.9 l=0.35
X554 t_Xpi_Xch_e_Xmixn_Xs6_drv t_Xpi_Xch_e_Xmixn_Xs6_sel vss vss sky130_fd_pr__nfet_01v8_lvt w=0.55 l=0.15
X555 t_Xpi_Xch_e_Xmixn_Xs6_drv t_Xpi_Xch_e_Xmixn_Xs6_sel vdd vdd sky130_fd_pr__pfet_01v8 w=2.3 l=0.15
X556 t_Xpi_Xch_e_Xmixn_Xs6_drv t_Xpi_Xch_e_mixn vss sky130_fd_pr__res_high_po_0p69 l=7.2
X557 t_Xpi_Xch_e_can f6 t_Xpi_Xch_e_Xmixn_Xs6_dum vss sky130_fd_pr__nfet_01v8_lvt w=0.5 l=0.15
X558 t_Xpi_Xch_e_can t_Xpi_fb6 t_Xpi_Xch_e_Xmixn_Xs6_dum vdd sky130_fd_pr__pfet_01v8_lvt w=0.9 l=0.35
X559 t_Xpi_Xch_e_cbn t_Xpi_fb6 t_Xpi_Xch_e_Xmixn_Xs6_dum vss sky130_fd_pr__nfet_01v8_lvt w=0.5 l=0.15
X560 t_Xpi_Xch_e_cbn f6 t_Xpi_Xch_e_Xmixn_Xs6_dum vdd sky130_fd_pr__pfet_01v8_lvt w=0.9 l=0.35
X561 vss t_Xpi_Xch_e_Xmixn_Xs6_dum vss vss sky130_fd_pr__nfet_01v8_lvt w=0.55 l=0.15
X562 vdd t_Xpi_Xch_e_Xmixn_Xs6_dum vdd vdd sky130_fd_pr__pfet_01v8 w=2.3 l=0.15
X563 t_Xpi_Xch_e_can t_Xpi_fb7 t_Xpi_Xch_e_Xmixn_Xs7_sel vss sky130_fd_pr__nfet_01v8_lvt w=0.5 l=0.15
X564 t_Xpi_Xch_e_can f7 t_Xpi_Xch_e_Xmixn_Xs7_sel vdd sky130_fd_pr__pfet_01v8_lvt w=0.9 l=0.35
X565 t_Xpi_Xch_e_cbn f7 t_Xpi_Xch_e_Xmixn_Xs7_sel vss sky130_fd_pr__nfet_01v8_lvt w=0.5 l=0.15
X566 t_Xpi_Xch_e_cbn t_Xpi_fb7 t_Xpi_Xch_e_Xmixn_Xs7_sel vdd sky130_fd_pr__pfet_01v8_lvt w=0.9 l=0.35
X567 t_Xpi_Xch_e_Xmixn_Xs7_drv t_Xpi_Xch_e_Xmixn_Xs7_sel vss vss sky130_fd_pr__nfet_01v8_lvt w=0.55 l=0.15
X568 t_Xpi_Xch_e_Xmixn_Xs7_drv t_Xpi_Xch_e_Xmixn_Xs7_sel vdd vdd sky130_fd_pr__pfet_01v8 w=2.3 l=0.15
X569 t_Xpi_Xch_e_Xmixn_Xs7_drv t_Xpi_Xch_e_mixn vss sky130_fd_pr__res_high_po_0p69 l=7.2
X570 t_Xpi_Xch_e_can f7 t_Xpi_Xch_e_Xmixn_Xs7_dum vss sky130_fd_pr__nfet_01v8_lvt w=0.5 l=0.15
X571 t_Xpi_Xch_e_can t_Xpi_fb7 t_Xpi_Xch_e_Xmixn_Xs7_dum vdd sky130_fd_pr__pfet_01v8_lvt w=0.9 l=0.35
X572 t_Xpi_Xch_e_cbn t_Xpi_fb7 t_Xpi_Xch_e_Xmixn_Xs7_dum vss sky130_fd_pr__nfet_01v8_lvt w=0.5 l=0.15
X573 t_Xpi_Xch_e_cbn f7 t_Xpi_Xch_e_Xmixn_Xs7_dum vdd sky130_fd_pr__pfet_01v8_lvt w=0.9 l=0.35
X574 vss t_Xpi_Xch_e_Xmixn_Xs7_dum vss vss sky130_fd_pr__nfet_01v8_lvt w=0.55 l=0.15
X575 vdd t_Xpi_Xch_e_Xmixn_Xs7_dum vdd vdd sky130_fd_pr__pfet_01v8 w=2.3 l=0.15
X576 t_Xpi_Xch_e_mixn vss sky130_fd_pr__cap_mim_m3_1 w=3.1 l=3.1
X577 t_Xpi_Xch_e_Xrec_acp t_Xpi_Xch_e_mixp sky130_fd_pr__cap_mim_m3_1 w=4.1 l=4.1
X578 t_Xpi_Xch_e_Xrec_acn t_Xpi_Xch_e_mixn sky130_fd_pr__cap_mim_m3_1 w=4.1 l=4.1
X579 t_Xpi_Xch_e_Xrec_acp t_Xpi_Xch_e_r1p vss sky130_fd_pr__res_high_po_0p35 l=10.5
X580 t_Xpi_Xch_e_Xrec_acn t_Xpi_Xch_e_r1n vss sky130_fd_pr__res_high_po_0p35 l=10.5
X581 t_Xpi_Xch_e_r1p t_Xpi_Xch_e_Xrec_acp vss vss sky130_fd_pr__nfet_01v8_lvt w=1.85 l=0.15
X582 t_Xpi_Xch_e_r1p t_Xpi_Xch_e_Xrec_acp vdd vdd sky130_fd_pr__pfet_01v8_lvt w=7.4 l=0.35
X583 t_Xpi_Xch_e_r1n t_Xpi_Xch_e_Xrec_acn vss vss sky130_fd_pr__nfet_01v8_lvt w=1.85 l=0.15
X584 t_Xpi_Xch_e_r1n t_Xpi_Xch_e_Xrec_acn vdd vdd sky130_fd_pr__pfet_01v8_lvt w=7.4 l=0.35
X585 ep t_Xpi_Xch_e_r1n vss vss sky130_fd_pr__nfet_01v8_lvt w=2.8 l=0.15
X586 ep t_Xpi_Xch_e_r1n vdd vdd sky130_fd_pr__pfet_01v8_lvt w=11.2 l=0.35
X587 en t_Xpi_Xch_e_r1p vss vss sky130_fd_pr__nfet_01v8_lvt w=2.8 l=0.15
X588 en t_Xpi_Xch_e_r1p vdd vdd sky130_fd_pr__pfet_01v8_lvt w=11.2 l=0.35
X589 t_Xdiv_rst rst_n vss vss sky130_fd_pr__nfet_01v8_lvt w=2 l=0.15
X590 t_Xdiv_rst rst_n vdd vdd sky130_fd_pr__pfet_01v8 w=8 l=0.15
X591 t_Xdiv_rst_n_lat t_Xdiv_rst vss vss sky130_fd_pr__nfet_01v8 w=0.6 l=0.18
X592 t_Xdiv_rst_n_lat t_Xdiv_rst vdd vdd sky130_fd_pr__pfet_01v8 w=1.5 l=0.18
X593 t_Xdiv_rst_lat t_Xdiv_rst_n_lat vss vss sky130_fd_pr__nfet_01v8 w=1.2 l=0.18
X594 t_Xdiv_rst_lat t_Xdiv_rst_n_lat vdd vdd sky130_fd_pr__pfet_01v8 w=3 l=0.18
X595 dp rst_n t_Xdiv_Xg_dpb_ck_g vss sky130_fd_pr__nfet_01v8_lvt w=2.6 l=0.15
X596 dp t_Xdiv_rst t_Xdiv_Xg_dpb_ck_g vdd sky130_fd_pr__pfet_01v8_lvt w=6.8 l=0.35
X597 t_Xdiv_Xg_dpb_ck_g t_Xdiv_rst vss vss sky130_fd_pr__nfet_01v8 w=0.8 l=0.18
X598 t_Xdiv_dp_ckb t_Xdiv_Xg_dpb_ck_g vss vss sky130_fd_pr__nfet_01v8_lvt w=1.5 l=0.15
X599 t_Xdiv_dp_ckb t_Xdiv_Xg_dpb_ck_g vdd vdd sky130_fd_pr__pfet_01v8 w=6.3 l=0.15
X600 dn rst_n t_Xdiv_Xg_dnb_ck_g vss sky130_fd_pr__nfet_01v8_lvt w=2.6 l=0.15
X601 dn t_Xdiv_rst t_Xdiv_Xg_dnb_ck_g vdd sky130_fd_pr__pfet_01v8_lvt w=6.8 l=0.35
X602 t_Xdiv_Xg_dnb_ck_g rst_n vdd vdd sky130_fd_pr__pfet_01v8 w=1.6 l=0.18
X603 t_Xdiv_dn_ckb t_Xdiv_Xg_dnb_ck_g vss vss sky130_fd_pr__nfet_01v8_lvt w=1.5 l=0.15
X604 t_Xdiv_dn_ckb t_Xdiv_Xg_dnb_ck_g vdd vdd sky130_fd_pr__pfet_01v8 w=6.3 l=0.15
X605 ep rst_n t_Xdiv_Xg_epb_ck_g vss sky130_fd_pr__nfet_01v8_lvt w=2.6 l=0.15
X606 ep t_Xdiv_rst t_Xdiv_Xg_epb_ck_g vdd sky130_fd_pr__pfet_01v8_lvt w=6.8 l=0.35
X607 t_Xdiv_Xg_epb_ck_g t_Xdiv_rst vss vss sky130_fd_pr__nfet_01v8 w=0.8 l=0.18
X608 t_Xdiv_ep_ckb t_Xdiv_Xg_epb_ck_g vss vss sky130_fd_pr__nfet_01v8_lvt w=1.5 l=0.15
X609 t_Xdiv_ep_ckb t_Xdiv_Xg_epb_ck_g vdd vdd sky130_fd_pr__pfet_01v8 w=6.3 l=0.15
X610 en rst_n t_Xdiv_Xg_enb_ck_g vss sky130_fd_pr__nfet_01v8_lvt w=2.6 l=0.15
X611 en t_Xdiv_rst t_Xdiv_Xg_enb_ck_g vdd sky130_fd_pr__pfet_01v8_lvt w=6.8 l=0.35
X612 t_Xdiv_Xg_enb_ck_g rst_n vdd vdd sky130_fd_pr__pfet_01v8 w=1.6 l=0.18
X613 t_Xdiv_en_ckb t_Xdiv_Xg_enb_ck_g vss vss sky130_fd_pr__nfet_01v8_lvt w=1.5 l=0.15
X614 t_Xdiv_en_ckb t_Xdiv_Xg_enb_ck_g vdd vdd sky130_fd_pr__pfet_01v8 w=6.3 l=0.15
X615 t_Xdiv_dn_ckb t_Xdiv_dp_ckb vss vss sky130_fd_pr__nfet_01v8_lvt w=0.45 l=0.15
X616 t_Xdiv_dn_ckb t_Xdiv_dp_ckb vdd vdd sky130_fd_pr__pfet_01v8 w=1.89 l=0.15
X617 t_Xdiv_dp_ckb t_Xdiv_dn_ckb vss vss sky130_fd_pr__nfet_01v8_lvt w=0.45 l=0.15
X618 t_Xdiv_dp_ckb t_Xdiv_dn_ckb vdd vdd sky130_fd_pr__pfet_01v8 w=1.89 l=0.15
X619 t_Xdiv_en_ckb t_Xdiv_ep_ckb vss vss sky130_fd_pr__nfet_01v8_lvt w=0.45 l=0.15
X620 t_Xdiv_en_ckb t_Xdiv_ep_ckb vdd vdd sky130_fd_pr__pfet_01v8 w=1.89 l=0.15
X621 t_Xdiv_ep_ckb t_Xdiv_en_ckb vss vss sky130_fd_pr__nfet_01v8_lvt w=0.45 l=0.15
X622 t_Xdiv_ep_ckb t_Xdiv_en_ckb vdd vdd sky130_fd_pr__pfet_01v8 w=1.89 l=0.15
X623 t_Xdiv_dp_ck t_Xdiv_dp_ckb vss vss sky130_fd_pr__nfet_01v8_lvt w=2.1 l=0.15
X624 t_Xdiv_dp_ck t_Xdiv_dp_ckb vdd vdd sky130_fd_pr__pfet_01v8 w=8.82 l=0.15
X625 t_Xdiv_dn_ck t_Xdiv_dn_ckb vss vss sky130_fd_pr__nfet_01v8_lvt w=2.1 l=0.15
X626 t_Xdiv_dn_ck t_Xdiv_dn_ckb vdd vdd sky130_fd_pr__pfet_01v8 w=8.82 l=0.15
X627 t_Xdiv_ep_ck t_Xdiv_ep_ckb vss vss sky130_fd_pr__nfet_01v8_lvt w=2.1 l=0.15
X628 t_Xdiv_ep_ck t_Xdiv_ep_ckb vdd vdd sky130_fd_pr__pfet_01v8 w=8.82 l=0.15
X629 t_Xdiv_en_ck t_Xdiv_en_ckb vss vss sky130_fd_pr__nfet_01v8_lvt w=2.1 l=0.15
X630 t_Xdiv_en_ck t_Xdiv_en_ckb vdd vdd sky130_fd_pr__pfet_01v8 w=8.82 l=0.15
X631 t_Xdiv_dn_ck t_Xdiv_dp_ck vss vss sky130_fd_pr__nfet_01v8_lvt w=0.45 l=0.15
X632 t_Xdiv_dn_ck t_Xdiv_dp_ck vdd vdd sky130_fd_pr__pfet_01v8 w=1.89 l=0.15
X633 t_Xdiv_dp_ck t_Xdiv_dn_ck vss vss sky130_fd_pr__nfet_01v8_lvt w=0.45 l=0.15
X634 t_Xdiv_dp_ck t_Xdiv_dn_ck vdd vdd sky130_fd_pr__pfet_01v8 w=1.89 l=0.15
X635 t_Xdiv_en_ck t_Xdiv_ep_ck vss vss sky130_fd_pr__nfet_01v8_lvt w=0.45 l=0.15
X636 t_Xdiv_en_ck t_Xdiv_ep_ck vdd vdd sky130_fd_pr__pfet_01v8 w=1.89 l=0.15
X637 t_Xdiv_ep_ck t_Xdiv_en_ck vss vss sky130_fd_pr__nfet_01v8_lvt w=0.45 l=0.15
X638 t_Xdiv_ep_ck t_Xdiv_en_ck vdd vdd sky130_fd_pr__pfet_01v8 w=1.89 l=0.15
X639 t_Xdiv_d3 t_Xdiv_dp_ck t_Xdiv_Xld0_int_p vss sky130_fd_pr__nfet_01v8_lvt w=2.8 l=0.15
X640 t_Xdiv_d3 t_Xdiv_dn_ck t_Xdiv_Xld0_int_p vdd sky130_fd_pr__pfet_01v8 w=6.8 l=0.15
X641 t_Xdiv_d1 t_Xdiv_dp_ck t_Xdiv_Xld0_int_n vss sky130_fd_pr__nfet_01v8_lvt w=2.8 l=0.15
X642 t_Xdiv_d1 t_Xdiv_dn_ck t_Xdiv_Xld0_int_n vdd sky130_fd_pr__pfet_01v8 w=6.8 l=0.15
X643 t_Xdiv_Xld0_int_p t_Xdiv_Xld0_int_n vdd vdd sky130_fd_pr__pfet_01v8 w=0.42 l=0.28
X644 t_Xdiv_Xld0_int_p t_Xdiv_Xld0_int_n vss vss sky130_fd_pr__nfet_01v8 w=0.42 l=0.28
X645 t_Xdiv_Xld0_int_n t_Xdiv_Xld0_int_p vdd vdd sky130_fd_pr__pfet_01v8 w=0.42 l=0.28
X646 t_Xdiv_Xld0_int_n t_Xdiv_Xld0_int_p vss vss sky130_fd_pr__nfet_01v8 w=0.42 l=0.28
X647 t_Xdiv_Xld0_int_p t_Xdiv_rst_lat vss vss sky130_fd_pr__nfet_01v8 w=1 l=0.18
X648 t_Xdiv_Xld0_int_n t_Xdiv_rst_n_lat vdd vdd sky130_fd_pr__pfet_01v8 w=1.8 l=0.18
X649 t_Xdiv_d0 t_Xdiv_Xld0_int_n vss vss sky130_fd_pr__nfet_01v8_lvt w=3.4 l=0.15
X650 t_Xdiv_d0 t_Xdiv_Xld0_int_n vdd vdd sky130_fd_pr__pfet_01v8 w=14.28 l=0.15
X651 t_Xdiv_d2 t_Xdiv_Xld0_int_p vss vss sky130_fd_pr__nfet_01v8_lvt w=3.4 l=0.15
X652 t_Xdiv_d2 t_Xdiv_Xld0_int_p vdd vdd sky130_fd_pr__pfet_01v8 w=14.28 l=0.15
X653 t_Xdiv_d2 t_Xdiv_d0 vss vss sky130_fd_pr__nfet_01v8_lvt w=0.42 l=0.15
X654 t_Xdiv_d2 t_Xdiv_d0 vdd vdd sky130_fd_pr__pfet_01v8 w=1.76 l=0.15
X655 t_Xdiv_d0 t_Xdiv_d2 vss vss sky130_fd_pr__nfet_01v8_lvt w=0.42 l=0.15
X656 t_Xdiv_d0 t_Xdiv_d2 vdd vdd sky130_fd_pr__pfet_01v8 w=1.76 l=0.15
X657 t_Xdiv_d0 t_Xdiv_dn_ck t_Xdiv_Xld1_int_p vss sky130_fd_pr__nfet_01v8_lvt w=2.8 l=0.15
X658 t_Xdiv_d0 t_Xdiv_dp_ck t_Xdiv_Xld1_int_p vdd sky130_fd_pr__pfet_01v8 w=6.8 l=0.15
X659 t_Xdiv_d2 t_Xdiv_dn_ck t_Xdiv_Xld1_int_n vss sky130_fd_pr__nfet_01v8_lvt w=2.8 l=0.15
X660 t_Xdiv_d2 t_Xdiv_dp_ck t_Xdiv_Xld1_int_n vdd sky130_fd_pr__pfet_01v8 w=6.8 l=0.15
X661 t_Xdiv_Xld1_int_p t_Xdiv_Xld1_int_n vdd vdd sky130_fd_pr__pfet_01v8 w=0.42 l=0.28
X662 t_Xdiv_Xld1_int_p t_Xdiv_Xld1_int_n vss vss sky130_fd_pr__nfet_01v8 w=0.42 l=0.28
X663 t_Xdiv_Xld1_int_n t_Xdiv_Xld1_int_p vdd vdd sky130_fd_pr__pfet_01v8 w=0.42 l=0.28
X664 t_Xdiv_Xld1_int_n t_Xdiv_Xld1_int_p vss vss sky130_fd_pr__nfet_01v8 w=0.42 l=0.28
X665 t_Xdiv_Xld1_int_p t_Xdiv_rst_lat vss vss sky130_fd_pr__nfet_01v8 w=1 l=0.18
X666 t_Xdiv_Xld1_int_n t_Xdiv_rst_n_lat vdd vdd sky130_fd_pr__pfet_01v8 w=1.8 l=0.18
X667 t_Xdiv_d1 t_Xdiv_Xld1_int_n vss vss sky130_fd_pr__nfet_01v8_lvt w=3.4 l=0.15
X668 t_Xdiv_d1 t_Xdiv_Xld1_int_n vdd vdd sky130_fd_pr__pfet_01v8 w=14.28 l=0.15
X669 t_Xdiv_d3 t_Xdiv_Xld1_int_p vss vss sky130_fd_pr__nfet_01v8_lvt w=3.4 l=0.15
X670 t_Xdiv_d3 t_Xdiv_Xld1_int_p vdd vdd sky130_fd_pr__pfet_01v8 w=14.28 l=0.15
X671 t_Xdiv_d3 t_Xdiv_d1 vss vss sky130_fd_pr__nfet_01v8_lvt w=0.42 l=0.15
X672 t_Xdiv_d3 t_Xdiv_d1 vdd vdd sky130_fd_pr__pfet_01v8 w=1.76 l=0.15
X673 t_Xdiv_d1 t_Xdiv_d3 vss vss sky130_fd_pr__nfet_01v8_lvt w=0.42 l=0.15
X674 t_Xdiv_d1 t_Xdiv_d3 vdd vdd sky130_fd_pr__pfet_01v8 w=1.76 l=0.15
X675 t_Xdiv_d0 t_Xdiv_ep_ck t_Xdiv_Xle0_int_p vss sky130_fd_pr__nfet_01v8_lvt w=2.8 l=0.15
X676 t_Xdiv_d0 t_Xdiv_en_ck t_Xdiv_Xle0_int_p vdd sky130_fd_pr__pfet_01v8 w=6.8 l=0.15
X677 t_Xdiv_d2 t_Xdiv_ep_ck t_Xdiv_Xle0_int_n vss sky130_fd_pr__nfet_01v8_lvt w=2.8 l=0.15
X678 t_Xdiv_d2 t_Xdiv_en_ck t_Xdiv_Xle0_int_n vdd sky130_fd_pr__pfet_01v8 w=6.8 l=0.15
X679 t_Xdiv_Xle0_int_p t_Xdiv_Xle0_int_n vdd vdd sky130_fd_pr__pfet_01v8 w=0.42 l=0.28
X680 t_Xdiv_Xle0_int_p t_Xdiv_Xle0_int_n vss vss sky130_fd_pr__nfet_01v8 w=0.42 l=0.28
X681 t_Xdiv_Xle0_int_n t_Xdiv_Xle0_int_p vdd vdd sky130_fd_pr__pfet_01v8 w=0.42 l=0.28
X682 t_Xdiv_Xle0_int_n t_Xdiv_Xle0_int_p vss vss sky130_fd_pr__nfet_01v8 w=0.42 l=0.28
X683 t_Xdiv_Xle0_int_p t_Xdiv_rst_lat vss vss sky130_fd_pr__nfet_01v8 w=1 l=0.18
X684 t_Xdiv_Xle0_int_n t_Xdiv_rst_n_lat vdd vdd sky130_fd_pr__pfet_01v8 w=1.8 l=0.18
X685 t_Xdiv_e0 t_Xdiv_Xle0_int_n vss vss sky130_fd_pr__nfet_01v8_lvt w=1.45 l=0.15
X686 t_Xdiv_e0 t_Xdiv_Xle0_int_n vdd vdd sky130_fd_pr__pfet_01v8 w=6.09 l=0.15
X687 t_Xdiv_e2 t_Xdiv_Xle0_int_p vss vss sky130_fd_pr__nfet_01v8_lvt w=1.45 l=0.15
X688 t_Xdiv_e2 t_Xdiv_Xle0_int_p vdd vdd sky130_fd_pr__pfet_01v8 w=6.09 l=0.15
X689 t_Xdiv_e2 t_Xdiv_e0 vss vss sky130_fd_pr__nfet_01v8_lvt w=0.42 l=0.15
X690 t_Xdiv_e2 t_Xdiv_e0 vdd vdd sky130_fd_pr__pfet_01v8 w=1.76 l=0.15
X691 t_Xdiv_e0 t_Xdiv_e2 vss vss sky130_fd_pr__nfet_01v8_lvt w=0.42 l=0.15
X692 t_Xdiv_e0 t_Xdiv_e2 vdd vdd sky130_fd_pr__pfet_01v8 w=1.76 l=0.15
X693 t_Xdiv_d1 t_Xdiv_en_ck t_Xdiv_Xle1_int_p vss sky130_fd_pr__nfet_01v8_lvt w=2.8 l=0.15
X694 t_Xdiv_d1 t_Xdiv_ep_ck t_Xdiv_Xle1_int_p vdd sky130_fd_pr__pfet_01v8 w=6.8 l=0.15
X695 t_Xdiv_d3 t_Xdiv_en_ck t_Xdiv_Xle1_int_n vss sky130_fd_pr__nfet_01v8_lvt w=2.8 l=0.15
X696 t_Xdiv_d3 t_Xdiv_ep_ck t_Xdiv_Xle1_int_n vdd sky130_fd_pr__pfet_01v8 w=6.8 l=0.15
X697 t_Xdiv_Xle1_int_p t_Xdiv_Xle1_int_n vdd vdd sky130_fd_pr__pfet_01v8 w=0.42 l=0.28
X698 t_Xdiv_Xle1_int_p t_Xdiv_Xle1_int_n vss vss sky130_fd_pr__nfet_01v8 w=0.42 l=0.28
X699 t_Xdiv_Xle1_int_n t_Xdiv_Xle1_int_p vdd vdd sky130_fd_pr__pfet_01v8 w=0.42 l=0.28
X700 t_Xdiv_Xle1_int_n t_Xdiv_Xle1_int_p vss vss sky130_fd_pr__nfet_01v8 w=0.42 l=0.28
X701 t_Xdiv_Xle1_int_p t_Xdiv_rst_lat vss vss sky130_fd_pr__nfet_01v8 w=1 l=0.18
X702 t_Xdiv_Xle1_int_n t_Xdiv_rst_n_lat vdd vdd sky130_fd_pr__pfet_01v8 w=1.8 l=0.18
X703 t_Xdiv_e1 t_Xdiv_Xle1_int_n vss vss sky130_fd_pr__nfet_01v8_lvt w=1.45 l=0.15
X704 t_Xdiv_e1 t_Xdiv_Xle1_int_n vdd vdd sky130_fd_pr__pfet_01v8 w=6.09 l=0.15
X705 t_Xdiv_e3 t_Xdiv_Xle1_int_p vss vss sky130_fd_pr__nfet_01v8_lvt w=1.45 l=0.15
X706 t_Xdiv_e3 t_Xdiv_Xle1_int_p vdd vdd sky130_fd_pr__pfet_01v8 w=6.09 l=0.15
X707 t_Xdiv_e3 t_Xdiv_e1 vss vss sky130_fd_pr__nfet_01v8_lvt w=0.42 l=0.15
X708 t_Xdiv_e3 t_Xdiv_e1 vdd vdd sky130_fd_pr__pfet_01v8 w=1.76 l=0.15
X709 t_Xdiv_e1 t_Xdiv_e3 vss vss sky130_fd_pr__nfet_01v8_lvt w=0.42 l=0.15
X710 t_Xdiv_e1 t_Xdiv_e3 vdd vdd sky130_fd_pr__pfet_01v8 w=1.76 l=0.15
X711 ckd0 t_Xdiv_d2 vss vss sky130_fd_pr__nfet_01v8_lvt w=2.4 l=0.15
X712 ckd0 t_Xdiv_d2 vdd vdd sky130_fd_pr__pfet_01v8 w=10.08 l=0.15
X713 ckd2 t_Xdiv_d0 vss vss sky130_fd_pr__nfet_01v8_lvt w=2.4 l=0.15
X714 ckd2 t_Xdiv_d0 vdd vdd sky130_fd_pr__pfet_01v8 w=10.08 l=0.15
X715 ckd1 t_Xdiv_d3 vss vss sky130_fd_pr__nfet_01v8_lvt w=2.4 l=0.15
X716 ckd1 t_Xdiv_d3 vdd vdd sky130_fd_pr__pfet_01v8 w=10.08 l=0.15
X717 ckd3 t_Xdiv_d1 vss vss sky130_fd_pr__nfet_01v8_lvt w=2.4 l=0.15
X718 ckd3 t_Xdiv_d1 vdd vdd sky130_fd_pr__pfet_01v8 w=10.08 l=0.15
X719 cke0 t_Xdiv_e2 vss vss sky130_fd_pr__nfet_01v8_lvt w=2.4 l=0.15
X720 cke0 t_Xdiv_e2 vdd vdd sky130_fd_pr__pfet_01v8 w=10.08 l=0.15
X721 cke2 t_Xdiv_e0 vss vss sky130_fd_pr__nfet_01v8_lvt w=2.4 l=0.15
X722 cke2 t_Xdiv_e0 vdd vdd sky130_fd_pr__pfet_01v8 w=10.08 l=0.15
X723 cke1 t_Xdiv_e3 vss vss sky130_fd_pr__nfet_01v8_lvt w=2.4 l=0.15
X724 cke1 t_Xdiv_e3 vdd vdd sky130_fd_pr__pfet_01v8 w=10.08 l=0.15
X725 cke3 t_Xdiv_e1 vss vss sky130_fd_pr__nfet_01v8_lvt w=2.4 l=0.15
X726 cke3 t_Xdiv_e1 vdd vdd sky130_fd_pr__pfet_01v8 w=10.08 l=0.15
X727 ckd2 ckd0 vss vss sky130_fd_pr__nfet_01v8_lvt w=0.45 l=0.15
X728 ckd2 ckd0 vdd vdd sky130_fd_pr__pfet_01v8 w=1.89 l=0.15
X729 ckd0 ckd2 vss vss sky130_fd_pr__nfet_01v8_lvt w=0.45 l=0.15
X730 ckd0 ckd2 vdd vdd sky130_fd_pr__pfet_01v8 w=1.89 l=0.15
X731 ckd3 ckd1 vss vss sky130_fd_pr__nfet_01v8_lvt w=0.45 l=0.15
X732 ckd3 ckd1 vdd vdd sky130_fd_pr__pfet_01v8 w=1.89 l=0.15
X733 ckd1 ckd3 vss vss sky130_fd_pr__nfet_01v8_lvt w=0.45 l=0.15
X734 ckd1 ckd3 vdd vdd sky130_fd_pr__pfet_01v8 w=1.89 l=0.15
X735 cke2 cke0 vss vss sky130_fd_pr__nfet_01v8_lvt w=0.45 l=0.15
X736 cke2 cke0 vdd vdd sky130_fd_pr__pfet_01v8 w=1.89 l=0.15
X737 cke0 cke2 vss vss sky130_fd_pr__nfet_01v8_lvt w=0.45 l=0.15
X738 cke0 cke2 vdd vdd sky130_fd_pr__pfet_01v8 w=1.89 l=0.15
X739 cke3 cke1 vss vss sky130_fd_pr__nfet_01v8_lvt w=0.45 l=0.15
X740 cke3 cke1 vdd vdd sky130_fd_pr__pfet_01v8 w=1.89 l=0.15
X741 cke1 cke3 vss vss sky130_fd_pr__nfet_01v8_lvt w=0.45 l=0.15
X742 cke1 cke3 vdd vdd sky130_fd_pr__pfet_01v8 w=1.89 l=0.15
.ends serdes_rx_cmos_pi_8ph_5g_pdk
