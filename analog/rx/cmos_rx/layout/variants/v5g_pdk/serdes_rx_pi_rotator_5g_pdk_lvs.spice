* NGSPICE file created from serdes_rx_pi_rotator_5g_pdk.ext - technology: sky130A

.subckt serdes_rx_pi_rotator_5g_pdk c0 c1 c2 c3 c4 c5 c6 c7 a0 a1 a2 a3 a4 a5 a6 a7
+ b0 b1 b2 b3 b4 b5 b6 b7 f0 f1 f2 f3 f4 f5 f6 f7 dp dn ep en vdd vss
X0 vdd a_9351_6170# vdd vdd sky130_fd_pr__pfet_01v8 ad=0.667 pd=5.18 as=115.03 ps=896.23999 w=2.3 l=0.15
X1 a_16191_3430# a_15733_3298# a_7971_1984# vss sky130_fd_pr__nfet_01v8_lvt ad=0.145 pd=1.58 as=0.145 ps=1.58 w=0.5 l=0.15
X2 a_363_6446# a4 a_3087_8796# vss sky130_fd_pr__nfet_01v8_lvt ad=0.248 pd=2.22 as=0.132 ps=1.13 w=0.8 l=0.15
X3 a_6247_7364# b7 a_363_4894# vss sky130_fd_pr__nfet_01v8_lvt ad=0.132 pd=1.13 as=0.248 ps=2.22 w=0.8 l=0.15
X4 a_11173_1814# f3 vdd vdd sky130_fd_pr__pfet_01v8 ad=0.261 pd=2.38 as=0.261 ps=2.38 w=0.9 l=0.18
X5 vdd a_13911_5530# vdd vdd sky130_fd_pr__pfet_01v8 ad=0.667 pd=5.18 as=0 ps=0 w=2.3 l=0.15
X6 a_10891_1645# a_8935_1650# vdd vdd sky130_fd_pr__pfet_01v8 ad=0.667 pd=5.18 as=0.667 ps=5.18 w=2.3 l=0.15
X7 a_13495_7950# a_13453_3298# a_7971_6504# vdd sky130_fd_pr__pfet_01v8_lvt ad=0.261 pd=2.38 as=0.261 ps=2.38 w=0.9 l=0.35
X8 a_9351_1650# a_8893_1814# a_4811_1984# vdd sky130_fd_pr__pfet_01v8_lvt ad=0.261 pd=2.38 as=0.261 ps=2.38 w=0.9 l=0.35
X9 vdd c0 a_363_2286# vdd sky130_fd_pr__pfet_01v8_lvt ad=0.493 pd=3.98 as=0.2465 ps=1.99 w=1.7 l=0.35
X10 a_8935_10050# a_8893_1814# a_4811_9376# vss sky130_fd_pr__nfet_01v8_lvt ad=0.145 pd=1.58 as=0.145 ps=1.58 w=0.5 l=0.15
X11 vss a_6247_8796# a_7971_9376# vss sky130_fd_pr__nfet_01v8_lvt ad=0.31 pd=2.62 as=0.165 ps=1.33 w=1 l=0.15
X12 vss a_21768_9194# dp vss sky130_fd_pr__nfet_01v8_lvt ad=0.434 pd=3.42 as=0.231 ps=1.73 w=1.4 l=0.15
X13 a_363_9054# c7 vdd vdd sky130_fd_pr__pfet_01v8_lvt ad=0.2465 pd=1.99 as=0.493 ps=3.98 w=1.7 l=0.35
X14 vdd a_21602_2174# en vdd sky130_fd_pr__pfet_01v8_lvt ad=0.406 pd=3.09 as=0.406 ps=3.09 w=2.8 l=0.35
X15 a_363_8526# a0 a_3087_2844# vss sky130_fd_pr__nfet_01v8_lvt ad=0.248 pd=2.22 as=0.132 ps=1.13 w=0.8 l=0.15
X16 a_13911_7950# f4 a_7971_6504# vdd sky130_fd_pr__pfet_01v8_lvt ad=0.261 pd=2.38 as=0.261 ps=2.38 w=0.9 l=0.35
X17 a_17731_3745# a_20664_3688# vss sky130_fd_pr__res_high_po_0p69 l=7.2
X18 a_11631_8270# a_11173_3298# a_4811_9376# vdd sky130_fd_pr__pfet_01v8_lvt ad=0.261 pd=2.38 as=0.261 ps=2.38 w=0.9 l=0.35
X19 a_6247_2844# a_6621_1968# a_363_2814# vdd sky130_fd_pr__pfet_01v8_lvt ad=0.3045 pd=2.39 as=0.609 ps=4.78 w=2.1 l=0.35
X20 a_4811_9376# a_3087_8796# vdd vdd sky130_fd_pr__pfet_01v8 ad=0.363 pd=2.53 as=0.682 ps=5.02 w=2.2 l=0.15
X21 a_363_2814# c1 vdd vdd sky130_fd_pr__pfet_01v8_lvt ad=0.2465 pd=1.99 as=0.493 ps=3.98 w=1.7 l=0.35
X22 a_15451_3745# a_13495_3750# vss vss sky130_fd_pr__nfet_01v8_lvt ad=0.1595 pd=1.68 as=0.1595 ps=1.68 w=0.55 l=0.15
X23 a_15451_2690# a_13495_3430# vdd vdd sky130_fd_pr__pfet_01v8 ad=0.667 pd=5.18 as=0.667 ps=5.18 w=2.3 l=0.15
X24 a_17731_3745# a_15775_3750# vdd vdd sky130_fd_pr__pfet_01v8 ad=0.667 pd=5.18 as=0.667 ps=5.18 w=2.3 l=0.15
X25 a_16191_1650# f7 a_4811_1984# vss sky130_fd_pr__nfet_01v8_lvt ad=0.145 pd=1.58 as=0.145 ps=1.58 w=0.5 l=0.15
X26 a_17731_4790# a_20664_3688# vss sky130_fd_pr__res_high_po_0p69 l=7.2
X27 a_13171_1645# a_11215_1650# vdd vdd sky130_fd_pr__pfet_01v8 ad=0.667 pd=5.18 as=0.667 ps=5.18 w=2.3 l=0.15
X28 a_16191_3750# a_15733_3298# a_4811_4856# vdd sky130_fd_pr__pfet_01v8_lvt ad=0.261 pd=2.38 as=0.261 ps=2.38 w=0.9 l=0.35
X29 a_363_9054# b3 a_6247_7364# vss sky130_fd_pr__nfet_01v8_lvt ad=0.248 pd=2.22 as=0.132 ps=1.13 w=0.8 l=0.15
X30 a_363_6974# b7 a_6247_2844# vss sky130_fd_pr__nfet_01v8_lvt ad=0.248 pd=2.22 as=0.132 ps=1.13 w=0.8 l=0.15
X31 a_13171_9310# a_20664_8208# vss sky130_fd_pr__res_high_po_0p69 l=7.2
X32 a_8935_7950# f0 a_4811_6504# vdd sky130_fd_pr__pfet_01v8_lvt ad=0.261 pd=2.38 as=0.261 ps=2.38 w=0.9 l=0.35
X33 a_11631_3430# a_11173_3298# a_7971_1984# vss sky130_fd_pr__nfet_01v8_lvt ad=0.145 pd=1.58 as=0.145 ps=1.58 w=0.5 l=0.15
X34 a_15451_8265# a_13495_8270# vdd vdd sky130_fd_pr__pfet_01v8 ad=0.667 pd=5.18 as=0.667 ps=5.18 w=2.3 l=0.15
X35 a_16191_7950# f6 a_7971_6504# vdd sky130_fd_pr__pfet_01v8_lvt ad=0.261 pd=2.38 as=0.261 ps=2.38 w=0.9 l=0.35
X36 a_6247_4276# b3 a_363_6974# vss sky130_fd_pr__nfet_01v8_lvt ad=0.132 pd=1.13 as=0.248 ps=2.22 w=0.8 l=0.15
X37 a_8935_7950# f0 a_7971_6504# vss sky130_fd_pr__nfet_01v8_lvt ad=0.145 pd=1.58 as=0.145 ps=1.58 w=0.5 l=0.15
X38 a_13911_8270# a_13453_3298# a_4811_9376# vdd sky130_fd_pr__pfet_01v8_lvt ad=0.261 pd=2.38 as=0.261 ps=2.38 w=0.9 l=0.35
X39 a_11215_8270# a_11173_3298# a_4811_9376# vss sky130_fd_pr__nfet_01v8_lvt ad=0.145 pd=1.58 as=0.145 ps=1.58 w=0.5 l=0.15
X40 a_11173_1814# f3 vss vss sky130_fd_pr__nfet_01v8 ad=0.1305 pd=1.48 as=0.1305 ps=1.48 w=0.45 l=0.18
X41 vdd a_11631_1650# vdd vdd sky130_fd_pr__pfet_01v8 ad=0.667 pd=5.18 as=0 ps=0 w=2.3 l=0.15
X42 a_13171_9310# a_11215_10050# vss vss sky130_fd_pr__nfet_01v8_lvt ad=0.1595 pd=1.68 as=0.1595 ps=1.68 w=0.55 l=0.15
X43 vdd a_21602_9194# a_21602_6694# vdd sky130_fd_pr__pfet_01v8_lvt ad=0.5365 pd=4.28 as=0.26825 ps=2.14 w=1.85 l=0.35
X44 a_15775_1650# a_15733_1814# a_4811_1984# vss sky130_fd_pr__nfet_01v8_lvt ad=0.145 pd=1.58 as=0.145 ps=1.58 w=0.5 l=0.15
X45 a_15775_3750# f6 a_4811_4856# vdd sky130_fd_pr__pfet_01v8_lvt ad=0.261 pd=2.38 as=0.261 ps=2.38 w=0.9 l=0.35
X46 a_3087_8796# a6 a_363_8526# vss sky130_fd_pr__nfet_01v8_lvt ad=0.132 pd=1.13 as=0.248 ps=2.22 w=0.8 l=0.15
X47 a_7971_6504# a_6247_7364# vdd vdd sky130_fd_pr__pfet_01v8 ad=0.363 pd=2.53 as=0.363 ps=2.53 w=2.2 l=0.15
X48 a_11215_1650# f3 a_4811_1984# vdd sky130_fd_pr__pfet_01v8_lvt ad=0.261 pd=2.38 as=0.261 ps=2.38 w=0.9 l=0.35
X49 vss a_21602_6694# dn vss sky130_fd_pr__nfet_01v8_lvt ad=0.434 pd=3.42 as=0.231 ps=1.73 w=1.4 l=0.15
X50 a_10891_8265# a_8935_8270# vss vss sky130_fd_pr__nfet_01v8_lvt ad=0.1595 pd=1.68 as=0.1595 ps=1.68 w=0.55 l=0.15
X51 a_13495_8270# f4 a_4811_9376# vdd sky130_fd_pr__pfet_01v8_lvt ad=0.261 pd=2.38 as=0.261 ps=2.38 w=0.9 l=0.35
X52 a_3087_2844# a2 a_363_2286# vss sky130_fd_pr__nfet_01v8_lvt ad=0.132 pd=1.13 as=0.248 ps=2.22 w=0.8 l=0.15
X53 a_11631_6170# f3 a_4811_6504# vss sky130_fd_pr__nfet_01v8_lvt ad=0.145 pd=1.58 as=0.145 ps=1.58 w=0.5 l=0.15
X54 vdd a_6247_2844# a_7971_1984# vdd sky130_fd_pr__pfet_01v8 ad=0.682 pd=5.02 as=0.363 ps=2.53 w=2.2 l=0.15
X55 vdd a_16191_3430# vdd vdd sky130_fd_pr__pfet_01v8 ad=0.667 pd=5.18 as=0 ps=0 w=2.3 l=0.15
X56 vss a_16191_3750# vss vss sky130_fd_pr__nfet_01v8_lvt ad=0.1595 pd=1.68 as=32.966 ps=315.04001 w=0.55 l=0.15
X57 a_15451_7210# a_20664_6336# vss sky130_fd_pr__res_high_po_0p69 l=7.2
X58 vdd a_13911_1650# vdd vdd sky130_fd_pr__pfet_01v8 ad=0.667 pd=5.18 as=0 ps=0 w=2.3 l=0.15
X59 a_9351_3430# a_8893_3298# a_4811_1984# vdd sky130_fd_pr__pfet_01v8_lvt ad=0.261 pd=2.38 as=0.261 ps=2.38 w=0.9 l=0.35
X60 a_9351_8270# f0 a_7971_9376# vdd sky130_fd_pr__pfet_01v8_lvt ad=0.261 pd=2.38 as=0.261 ps=2.38 w=0.9 l=0.35
X61 a_21602_4674# a_21602_2174# vss sky130_fd_pr__res_high_po_0p35 l=10.5
X62 a_6621_1968# b3 vdd vdd sky130_fd_pr__pfet_01v8 ad=0.261 pd=2.38 as=0.261 ps=2.38 w=0.9 l=0.18
X63 a_13495_10050# f5 a_7971_9376# vss sky130_fd_pr__nfet_01v8_lvt ad=0.145 pd=1.58 as=0.145 ps=1.58 w=0.5 l=0.15
X64 a_363_4366# a2 a_3087_8796# vss sky130_fd_pr__nfet_01v8_lvt ad=0.248 pd=2.22 as=0.132 ps=1.13 w=0.8 l=0.15
X65 vdd a_16191_8270# vdd vdd sky130_fd_pr__pfet_01v8 ad=0.667 pd=5.18 as=0 ps=0 w=2.3 l=0.15
X66 a_8935_10050# f1 a_7971_9376# vss sky130_fd_pr__nfet_01v8_lvt ad=0.145 pd=1.58 as=0.145 ps=1.58 w=0.5 l=0.15
X67 a_363_2286# c0 vss vss sky130_fd_pr__nfet_01v8_lvt ad=0.493 pd=3.98 as=0.493 ps=3.98 w=1.7 l=0.15
X68 a_13495_10050# a_13453_1814# a_4811_9376# vss sky130_fd_pr__nfet_01v8_lvt ad=0.145 pd=1.58 as=0.145 ps=1.58 w=0.5 l=0.15
X69 a_13171_8265# a_11215_8270# vss vss sky130_fd_pr__nfet_01v8_lvt ad=0.1595 pd=1.68 as=0.1595 ps=1.68 w=0.55 l=0.15
X70 a_3087_7364# a_3461_1968# a_363_8526# vdd sky130_fd_pr__pfet_01v8_lvt ad=0.3045 pd=2.39 as=0.609 ps=4.78 w=2.1 l=0.35
X71 a_13911_6170# f5 a_4811_6504# vss sky130_fd_pr__nfet_01v8_lvt ad=0.145 pd=1.58 as=0.145 ps=1.58 w=0.5 l=0.15
X72 a_17731_1645# a_15775_1650# vss vss sky130_fd_pr__nfet_01v8_lvt ad=0.1595 pd=1.68 as=0.1595 ps=1.68 w=0.55 l=0.15
X73 a_7718_205# b6 vdd vdd sky130_fd_pr__pfet_01v8 ad=0.261 pd=2.38 as=0.261 ps=2.38 w=0.9 l=0.18
X74 vdd a_21768_6694# a_21768_9194# vdd sky130_fd_pr__pfet_01v8_lvt ad=0.26825 pd=2.14 as=0.26825 ps=2.14 w=1.85 l=0.35
X75 a_11631_5530# f3 a_4811_4856# vss sky130_fd_pr__nfet_01v8_lvt ad=0.145 pd=1.58 as=0.145 ps=1.58 w=0.5 l=0.15
X76 a_7971_9376# a_6247_8796# vdd vdd sky130_fd_pr__pfet_01v8 ad=0.363 pd=2.53 as=0.363 ps=2.53 w=2.2 l=0.15
X77 a_16191_5530# a_15733_1814# a_4811_4856# vdd sky130_fd_pr__pfet_01v8_lvt ad=0.261 pd=2.38 as=0.261 ps=2.38 w=0.9 l=0.35
X78 a_363_9054# a_7061_1968# a_6247_4276# vdd sky130_fd_pr__pfet_01v8_lvt ad=0.609 pd=4.78 as=0.3045 ps=2.39 w=2.1 l=0.35
X79 a_363_4894# a_6068_205# a_6247_4276# vdd sky130_fd_pr__pfet_01v8_lvt ad=0.609 pd=4.78 as=0.3045 ps=2.39 w=2.1 l=0.35
X80 vdd c3 a_363_4894# vdd sky130_fd_pr__pfet_01v8_lvt ad=0.493 pd=3.98 as=0.2465 ps=1.99 w=1.7 l=0.35
X81 a_8893_3298# f0 vdd vdd sky130_fd_pr__pfet_01v8 ad=0.261 pd=2.38 as=0.261 ps=2.38 w=0.9 l=0.18
X82 a_21602_9194# a_20664_8208# sky130_fd_pr__cap_mim_m3_1 l=4.1 w=4.1
X83 a_363_6446# c4 vdd vdd sky130_fd_pr__pfet_01v8_lvt ad=0.2465 pd=1.99 as=0.2465 ps=1.99 w=1.7 l=0.35
X84 a_363_8526# c6 vdd vdd sky130_fd_pr__pfet_01v8_lvt ad=0.2465 pd=1.99 as=0.493 ps=3.98 w=1.7 l=0.35
X85 vss a_11631_8270# vss vss sky130_fd_pr__nfet_01v8_lvt ad=0.1595 pd=1.68 as=0 ps=0 w=0.55 l=0.15
X86 a_17731_6165# a_15775_6170# vdd vdd sky130_fd_pr__pfet_01v8 ad=0.667 pd=5.18 as=0.667 ps=5.18 w=2.3 l=0.15
X87 a_15451_1645# a_20664_1816# vss sky130_fd_pr__res_high_po_0p69 l=7.2
X88 a_16191_6170# a_15733_1814# a_4811_6504# vdd sky130_fd_pr__pfet_01v8_lvt ad=0.261 pd=2.38 as=0.261 ps=2.38 w=0.9 l=0.35
X89 a_13495_6170# a_13453_1814# a_4811_6504# vss sky130_fd_pr__nfet_01v8_lvt ad=0.145 pd=1.58 as=0.145 ps=1.58 w=0.5 l=0.15
X90 a_15775_3750# f6 a_7971_4856# vss sky130_fd_pr__nfet_01v8_lvt ad=0.145 pd=1.58 as=0.145 ps=1.58 w=0.5 l=0.15
X91 vdd a_9351_7950# vdd vdd sky130_fd_pr__pfet_01v8 ad=0.667 pd=5.18 as=0 ps=0 w=2.3 l=0.15
X92 vdd a_21602_4674# a_21602_2174# vdd sky130_fd_pr__pfet_01v8_lvt ad=0.26825 pd=2.14 as=0.26825 ps=2.14 w=1.85 l=0.35
X93 a_15775_5530# f7 a_4811_4856# vdd sky130_fd_pr__pfet_01v8_lvt ad=0.261 pd=2.38 as=0.261 ps=2.38 w=0.9 l=0.35
X94 a_363_2286# a_3901_1968# a_3087_7364# vdd sky130_fd_pr__pfet_01v8_lvt ad=0.609 pd=4.78 as=0.3045 ps=2.39 w=2.1 l=0.35
X95 a_11215_1650# f3 a_7971_1984# vss sky130_fd_pr__nfet_01v8_lvt ad=0.145 pd=1.58 as=0.145 ps=1.58 w=0.5 l=0.15
X96 a_13911_5530# f5 a_4811_4856# vss sky130_fd_pr__nfet_01v8_lvt ad=0.145 pd=1.58 as=0.145 ps=1.58 w=0.5 l=0.15
X97 a_11215_3430# f2 a_4811_1984# vdd sky130_fd_pr__pfet_01v8_lvt ad=0.261 pd=2.38 as=0.261 ps=2.38 w=0.9 l=0.35
X98 a_11215_3750# a_11173_3298# a_7971_4856# vdd sky130_fd_pr__pfet_01v8_lvt ad=0.261 pd=2.38 as=0.261 ps=2.38 w=0.9 l=0.35
X99 a_21768_4674# a_21768_2174# vss vss sky130_fd_pr__nfet_01v8_lvt ad=0.5365 pd=4.28 as=0.5365 ps=4.28 w=1.85 l=0.15
X100 a_6621_1968# b3 vss vss sky130_fd_pr__nfet_01v8 ad=0.1305 pd=1.48 as=0.1305 ps=1.48 w=0.45 l=0.18
X101 a_9351_6170# f1 a_4811_6504# vss sky130_fd_pr__nfet_01v8_lvt ad=0.145 pd=1.58 as=0.145 ps=1.58 w=0.5 l=0.15
X102 en a_21602_2174# vdd vdd sky130_fd_pr__pfet_01v8_lvt ad=0.406 pd=3.09 as=0.406 ps=3.09 w=2.8 l=0.35
X103 a_9351_6170# a_8893_1814# a_7971_6504# vss sky130_fd_pr__nfet_01v8_lvt ad=0.145 pd=1.58 as=0.145 ps=1.58 w=0.5 l=0.15
X104 a_363_2814# a_6621_1968# a_6247_2844# vdd sky130_fd_pr__pfet_01v8_lvt ad=0.609 pd=4.78 as=0.3045 ps=2.39 w=2.1 l=0.35
X105 a_11631_3750# f2 a_7971_4856# vdd sky130_fd_pr__pfet_01v8_lvt ad=0.261 pd=2.38 as=0.261 ps=2.38 w=0.9 l=0.35
X106 a_3087_8796# a_3461_1968# a_363_4366# vdd sky130_fd_pr__pfet_01v8_lvt ad=0.3045 pd=2.39 as=0.609 ps=4.78 w=2.1 l=0.35
X107 a_3087_4276# a_4341_1968# a_363_2286# vdd sky130_fd_pr__pfet_01v8_lvt ad=0.3045 pd=2.39 as=0.609 ps=4.78 w=2.1 l=0.35
X108 vss a_13911_8270# vss vss sky130_fd_pr__nfet_01v8_lvt ad=0.1595 pd=1.68 as=0 ps=0 w=0.55 l=0.15
X109 a_15775_6170# f7 a_4811_6504# vdd sky130_fd_pr__pfet_01v8_lvt ad=0.261 pd=2.38 as=0.261 ps=2.38 w=0.9 l=0.35
X110 a_363_2286# a6 a_3087_4276# vss sky130_fd_pr__nfet_01v8_lvt ad=0.248 pd=2.22 as=0.132 ps=1.13 w=0.8 l=0.15
X111 vdd c7 a_363_9054# vdd sky130_fd_pr__pfet_01v8_lvt ad=0.2465 pd=1.99 as=0.2465 ps=1.99 w=1.7 l=0.35
X112 a_11631_10050# a_11173_1814# a_4811_9376# vdd sky130_fd_pr__pfet_01v8_lvt ad=0.261 pd=2.38 as=0.261 ps=2.38 w=0.9 l=0.35
X113 a_21602_4674# a_20664_3688# sky130_fd_pr__cap_mim_m3_1 l=4.1 w=4.1
X114 a_8935_8270# a_8893_3298# a_7971_9376# vdd sky130_fd_pr__pfet_01v8_lvt ad=0.261 pd=2.38 as=0.261 ps=2.38 w=0.9 l=0.35
X115 a_7718_205# b6 vss vss sky130_fd_pr__nfet_01v8 ad=0.1305 pd=1.48 as=0.1305 ps=1.48 w=0.45 l=0.18
X116 vdd a_3087_7364# a_4811_6504# vdd sky130_fd_pr__pfet_01v8 ad=0.682 pd=5.02 as=0.363 ps=2.53 w=2.2 l=0.15
X117 vdd c1 a_363_2814# vdd sky130_fd_pr__pfet_01v8_lvt ad=0.2465 pd=1.99 as=0.2465 ps=1.99 w=1.7 l=0.35
X118 a_13495_5530# a_13453_1814# a_4811_4856# vss sky130_fd_pr__nfet_01v8_lvt ad=0.145 pd=1.58 as=0.145 ps=1.58 w=0.5 l=0.15
X119 vss a_9351_3430# vss vss sky130_fd_pr__nfet_01v8_lvt ad=0.1595 pd=1.68 as=0 ps=0 w=0.55 l=0.15
X120 a_8893_3298# f0 vss vss sky130_fd_pr__nfet_01v8 ad=0.1305 pd=1.48 as=0.1305 ps=1.48 w=0.45 l=0.18
X121 a_15451_6165# a_13495_6170# vss vss sky130_fd_pr__nfet_01v8_lvt ad=0.1595 pd=1.68 as=0.1595 ps=1.68 w=0.55 l=0.15
X122 a_9351_5530# f1 a_4811_4856# vss sky130_fd_pr__nfet_01v8_lvt ad=0.145 pd=1.58 as=0.145 ps=1.58 w=0.5 l=0.15
X123 a_15451_9310# a_13495_10050# vdd vdd sky130_fd_pr__pfet_01v8 ad=0.667 pd=5.18 as=0.667 ps=5.18 w=2.3 l=0.15
X124 a_9351_5530# a_8893_1814# a_7971_4856# vss sky130_fd_pr__nfet_01v8_lvt ad=0.145 pd=1.58 as=0.145 ps=1.58 w=0.5 l=0.15
X125 a_3087_2844# a_3901_1968# a_363_4366# vdd sky130_fd_pr__pfet_01v8_lvt ad=0.3045 pd=2.39 as=0.609 ps=4.78 w=2.1 l=0.35
X126 a_363_6446# a_3901_1968# a_3087_8796# vdd sky130_fd_pr__pfet_01v8_lvt ad=0.609 pd=4.78 as=0.3045 ps=2.39 w=2.1 l=0.35
X127 a_13911_10050# a_13453_1814# a_4811_9376# vdd sky130_fd_pr__pfet_01v8_lvt ad=0.261 pd=2.38 as=0.261 ps=2.38 w=0.9 l=0.35
X128 a_363_6974# c5 vss vss sky130_fd_pr__nfet_01v8_lvt ad=0.493 pd=3.98 as=0.493 ps=3.98 w=1.7 l=0.15
X129 vss a_9351_10050# vss vss sky130_fd_pr__nfet_01v8_lvt ad=0.1595 pd=1.68 as=0 ps=0 w=0.55 l=0.15
X130 a_11631_7950# f2 a_4811_6504# vss sky130_fd_pr__nfet_01v8_lvt ad=0.145 pd=1.58 as=0.145 ps=1.58 w=0.5 l=0.15
X131 a_13495_8270# f4 a_7971_9376# vss sky130_fd_pr__nfet_01v8_lvt ad=0.145 pd=1.58 as=0.145 ps=1.58 w=0.5 l=0.15
X132 vdd a_3087_8796# a_4811_9376# vdd sky130_fd_pr__pfet_01v8 ad=0.682 pd=5.02 as=0.363 ps=2.53 w=2.2 l=0.15
X133 a_13495_10050# f5 a_4811_9376# vdd sky130_fd_pr__pfet_01v8_lvt ad=0.261 pd=2.38 as=0.261 ps=2.38 w=0.9 l=0.35
X134 a_8935_1650# f1 a_7971_1984# vss sky130_fd_pr__nfet_01v8_lvt ad=0.145 pd=1.58 as=0.145 ps=1.58 w=0.5 l=0.15
X135 a_3087_4276# a4 a_363_8526# vss sky130_fd_pr__nfet_01v8_lvt ad=0.132 pd=1.13 as=0.248 ps=2.22 w=0.8 l=0.15
X136 a_15451_4790# a_13495_5530# vss vss sky130_fd_pr__nfet_01v8_lvt ad=0.1595 pd=1.68 as=0.1595 ps=1.68 w=0.55 l=0.15
X137 a_13911_8270# a_13453_3298# a_7971_9376# vss sky130_fd_pr__nfet_01v8_lvt ad=0.145 pd=1.58 as=0.145 ps=1.58 w=0.5 l=0.15
X138 a_6247_2844# a_7061_1968# a_363_4894# vdd sky130_fd_pr__pfet_01v8_lvt ad=0.3045 pd=2.39 as=0.609 ps=4.78 w=2.1 l=0.35
X139 a_13495_1650# a_13453_1814# a_7971_1984# vdd sky130_fd_pr__pfet_01v8_lvt ad=0.261 pd=2.38 as=0.261 ps=2.38 w=0.9 l=0.35
X140 a_16191_3430# f6 a_4811_1984# vss sky130_fd_pr__nfet_01v8_lvt ad=0.145 pd=1.58 as=0.145 ps=1.58 w=0.5 l=0.15
X141 a_11215_5530# a_11173_1814# a_7971_4856# vdd sky130_fd_pr__pfet_01v8_lvt ad=0.261 pd=2.38 as=0.261 ps=2.38 w=0.9 l=0.35
X142 a_17731_2690# a_20664_1816# vss sky130_fd_pr__res_high_po_0p69 l=7.2
X143 a_13911_1650# f5 a_7971_1984# vdd sky130_fd_pr__pfet_01v8_lvt ad=0.261 pd=2.38 as=0.261 ps=2.38 w=0.9 l=0.35
X144 a_11631_5530# f3 a_7971_4856# vdd sky130_fd_pr__pfet_01v8_lvt ad=0.261 pd=2.38 as=0.261 ps=2.38 w=0.9 l=0.35
X145 vss a_11631_10050# vss vss sky130_fd_pr__nfet_01v8_lvt ad=0.1595 pd=1.68 as=0 ps=0 w=0.55 l=0.15
X146 a_9351_10050# f1 a_7971_9376# vdd sky130_fd_pr__pfet_01v8_lvt ad=0.261 pd=2.38 as=0.261 ps=2.38 w=0.9 l=0.35
X147 a_15775_8270# a_15733_3298# a_7971_9376# vdd sky130_fd_pr__pfet_01v8_lvt ad=0.261 pd=2.38 as=0.261 ps=2.38 w=0.9 l=0.35
X148 vdd a_21602_6694# dn vdd sky130_fd_pr__pfet_01v8_lvt ad=0.812 pd=6.18 as=0.406 ps=3.09 w=2.8 l=0.35
X149 a_363_8526# a_3461_1968# a_3087_7364# vdd sky130_fd_pr__pfet_01v8_lvt ad=0.609 pd=4.78 as=0.3045 ps=2.39 w=2.1 l=0.35
X150 vss a_16191_6170# vss vss sky130_fd_pr__nfet_01v8_lvt ad=0.1595 pd=1.68 as=0 ps=0 w=0.55 l=0.15
X151 vdd a_16191_10050# vdd vdd sky130_fd_pr__pfet_01v8 ad=0.667 pd=5.18 as=0 ps=0 w=2.3 l=0.15
X152 a_13911_7950# f4 a_4811_6504# vss sky130_fd_pr__nfet_01v8_lvt ad=0.145 pd=1.58 as=0.145 ps=1.58 w=0.5 l=0.15
X153 a_363_6974# b1 a_6247_7364# vss sky130_fd_pr__nfet_01v8_lvt ad=0.248 pd=2.22 as=0.132 ps=1.13 w=0.8 l=0.15
X154 a_363_2814# b5 a_6247_7364# vss sky130_fd_pr__nfet_01v8_lvt ad=0.248 pd=2.22 as=0.132 ps=1.13 w=0.8 l=0.15
X155 a_11215_6170# a_11173_1814# a_7971_6504# vdd sky130_fd_pr__pfet_01v8_lvt ad=0.261 pd=2.38 as=0.261 ps=2.38 w=0.9 l=0.35
X156 a_21768_4674# a_21768_2174# vdd vdd sky130_fd_pr__pfet_01v8_lvt ad=0.26825 pd=2.14 as=0.26825 ps=2.14 w=1.85 l=0.35
X157 a_8935_3750# a_8893_3298# a_4811_4856# vss sky130_fd_pr__nfet_01v8_lvt ad=0.145 pd=1.58 as=0.145 ps=1.58 w=0.5 l=0.15
X158 a_15775_3430# a_15733_3298# a_4811_1984# vss sky130_fd_pr__nfet_01v8_lvt ad=0.145 pd=1.58 as=0.145 ps=1.58 w=0.5 l=0.15
X159 a_6247_4276# b1 a_363_4894# vss sky130_fd_pr__nfet_01v8_lvt ad=0.132 pd=1.13 as=0.248 ps=2.22 w=0.8 l=0.15
X160 a_11631_6170# f3 a_7971_6504# vdd sky130_fd_pr__pfet_01v8_lvt ad=0.261 pd=2.38 as=0.261 ps=2.38 w=0.9 l=0.35
X161 a_3928_205# a3 vdd vdd sky130_fd_pr__pfet_01v8 ad=0.261 pd=2.38 as=0.261 ps=2.38 w=0.9 l=0.18
X162 a_6247_4276# b5 a_363_9054# vss sky130_fd_pr__nfet_01v8_lvt ad=0.132 pd=1.13 as=0.248 ps=2.22 w=0.8 l=0.15
X163 a_16191_8270# a_15733_3298# a_7971_9376# vss sky130_fd_pr__nfet_01v8_lvt ad=0.145 pd=1.58 as=0.145 ps=1.58 w=0.5 l=0.15
X164 a_10891_9310# a_20664_8208# vss sky130_fd_pr__res_high_po_0p69 l=7.2
X165 a_4811_1984# a_3087_2844# vss vss sky130_fd_pr__nfet_01v8_lvt ad=0.165 pd=1.33 as=0.31 ps=2.62 w=1 l=0.15
X166 a_15451_9310# a_13495_10050# vss vss sky130_fd_pr__nfet_01v8_lvt ad=0.1595 pd=1.68 as=0.1595 ps=1.68 w=0.55 l=0.15
X167 a_8935_1650# f1 a_4811_1984# vdd sky130_fd_pr__pfet_01v8_lvt ad=0.261 pd=2.38 as=0.261 ps=2.38 w=0.9 l=0.35
X168 a_13495_7950# a_13453_3298# a_4811_6504# vss sky130_fd_pr__nfet_01v8_lvt ad=0.145 pd=1.58 as=0.145 ps=1.58 w=0.5 l=0.15
X169 a_16191_1650# f7 a_7971_1984# vdd sky130_fd_pr__pfet_01v8_lvt ad=0.261 pd=2.38 as=0.261 ps=2.38 w=0.9 l=0.35
X170 a_17731_7210# a_15775_7950# vdd vdd sky130_fd_pr__pfet_01v8 ad=0.667 pd=5.18 as=0.667 ps=5.18 w=2.3 l=0.15
X171 a_21602_2174# a_21602_4674# vss vss sky130_fd_pr__nfet_01v8_lvt ad=0.5365 pd=4.28 as=0.5365 ps=4.28 w=1.85 l=0.15
X172 a_4341_1968# a6 vdd vdd sky130_fd_pr__pfet_01v8 ad=0.261 pd=2.38 as=0.261 ps=2.38 w=0.9 l=0.18
X173 vdd c6 a_363_8526# vdd sky130_fd_pr__pfet_01v8_lvt ad=0.2465 pd=1.99 as=0.2465 ps=1.99 w=1.7 l=0.35
X174 a_16191_7950# a_15733_3298# a_4811_6504# vdd sky130_fd_pr__pfet_01v8_lvt ad=0.261 pd=2.38 as=0.261 ps=2.38 w=0.9 l=0.35
X175 vdd a_9351_5530# vdd vdd sky130_fd_pr__pfet_01v8 ad=0.667 pd=5.18 as=0 ps=0 w=2.3 l=0.15
X176 vss a_16191_5530# vss vss sky130_fd_pr__nfet_01v8_lvt ad=0.1595 pd=1.68 as=0 ps=0 w=0.55 l=0.15
X177 a_7971_9376# a_6247_8796# vss vss sky130_fd_pr__nfet_01v8_lvt ad=0.165 pd=1.33 as=0.31 ps=2.62 w=1 l=0.15
X178 dp a_21768_9194# vss vss sky130_fd_pr__nfet_01v8_lvt ad=0.231 pd=1.73 as=0.434 ps=3.42 w=1.4 l=0.15
X179 a_3087_2844# a0 a_363_8526# vss sky130_fd_pr__nfet_01v8_lvt ad=0.132 pd=1.13 as=0.248 ps=2.22 w=0.8 l=0.15
X180 vss a_3087_8796# a_4811_9376# vss sky130_fd_pr__nfet_01v8_lvt ad=0.31 pd=2.62 as=0.165 ps=1.33 w=1 l=0.15
X181 vdd a_21768_9194# dp vdd sky130_fd_pr__pfet_01v8_lvt ad=0.812 pd=6.18 as=0.406 ps=3.09 w=2.8 l=0.35
X182 a_9351_7950# f0 a_4811_6504# vss sky130_fd_pr__nfet_01v8_lvt ad=0.145 pd=1.58 as=0.145 ps=1.58 w=0.5 l=0.15
X183 a_6247_4276# a_6068_205# a_363_4894# vdd sky130_fd_pr__pfet_01v8_lvt ad=0.3045 pd=2.39 as=0.609 ps=4.78 w=2.1 l=0.35
X184 a_9351_7950# a_8893_3298# a_7971_6504# vss sky130_fd_pr__nfet_01v8_lvt ad=0.145 pd=1.58 as=0.145 ps=1.58 w=0.5 l=0.15
X185 vdd a_21768_4674# ep vdd sky130_fd_pr__pfet_01v8_lvt ad=0.406 pd=3.09 as=0.406 ps=3.09 w=2.8 l=0.35
X186 a_363_4366# a_3461_1968# a_3087_8796# vdd sky130_fd_pr__pfet_01v8_lvt ad=0.609 pd=4.78 as=0.3045 ps=2.39 w=2.1 l=0.35
X187 vdd c2 a_363_4366# vdd sky130_fd_pr__pfet_01v8_lvt ad=0.493 pd=3.98 as=0.2465 ps=1.99 w=1.7 l=0.35
X188 a_363_2286# a_4341_1968# a_3087_4276# vdd sky130_fd_pr__pfet_01v8_lvt ad=0.609 pd=4.78 as=0.3045 ps=2.39 w=2.1 l=0.35
X189 a_9351_10050# a_8893_1814# a_7971_9376# vss sky130_fd_pr__nfet_01v8_lvt ad=0.145 pd=1.58 as=0.145 ps=1.58 w=0.5 l=0.15
X190 a_363_9054# c7 vdd vdd sky130_fd_pr__pfet_01v8_lvt ad=0.2465 pd=1.99 as=0.2465 ps=1.99 w=1.7 l=0.35
X191 a_11631_8270# a_11173_3298# a_7971_9376# vss sky130_fd_pr__nfet_01v8_lvt ad=0.145 pd=1.58 as=0.145 ps=1.58 w=0.5 l=0.15
X192 a_15775_6170# f7 a_7971_6504# vss sky130_fd_pr__nfet_01v8_lvt ad=0.145 pd=1.58 as=0.145 ps=1.58 w=0.5 l=0.15
X193 a_15775_7950# f6 a_4811_6504# vdd sky130_fd_pr__pfet_01v8_lvt ad=0.261 pd=2.38 as=0.261 ps=2.38 w=0.9 l=0.35
X194 a_15775_10050# f7 a_7971_9376# vss sky130_fd_pr__nfet_01v8_lvt ad=0.145 pd=1.58 as=0.145 ps=1.58 w=0.5 l=0.15
X195 a_6247_2844# b7 a_363_6974# vss sky130_fd_pr__nfet_01v8_lvt ad=0.132 pd=1.13 as=0.248 ps=2.22 w=0.8 l=0.15
X196 a_17731_2690# a_15775_3430# vss vss sky130_fd_pr__nfet_01v8_lvt ad=0.1595 pd=1.68 as=0.1595 ps=1.68 w=0.55 l=0.15
X197 vss a_13911_10050# vss vss sky130_fd_pr__nfet_01v8_lvt ad=0.1595 pd=1.68 as=0 ps=0 w=0.55 l=0.15
X198 a_8935_10050# a_8893_1814# a_7971_9376# vdd sky130_fd_pr__pfet_01v8_lvt ad=0.261 pd=2.38 as=0.261 ps=2.38 w=0.9 l=0.35
X199 a_363_2286# a0 a_3087_8796# vss sky130_fd_pr__nfet_01v8_lvt ad=0.248 pd=2.22 as=0.132 ps=1.13 w=0.8 l=0.15
X200 a_6247_7364# b3 a_363_9054# vss sky130_fd_pr__nfet_01v8_lvt ad=0.132 pd=1.13 as=0.248 ps=2.22 w=0.8 l=0.15
X201 a_363_2814# c1 vdd vdd sky130_fd_pr__pfet_01v8_lvt ad=0.2465 pd=1.99 as=0.2465 ps=1.99 w=1.7 l=0.35
X202 a_3928_205# a3 vss vss sky130_fd_pr__nfet_01v8 ad=0.1305 pd=1.48 as=0.1305 ps=1.48 w=0.45 l=0.18
X203 a_15775_10050# a_15733_1814# a_4811_9376# vss sky130_fd_pr__nfet_01v8_lvt ad=0.145 pd=1.58 as=0.145 ps=1.58 w=0.5 l=0.15
X204 a_3087_7364# a_2938_205# a_363_6446# vdd sky130_fd_pr__pfet_01v8_lvt ad=0.3045 pd=2.39 as=0.609 ps=4.78 w=2.1 l=0.35
X205 a_10891_6165# a_20664_6336# vss sky130_fd_pr__res_high_po_0p69 l=7.2
X206 a_21768_9194# a_21768_6694# vss sky130_fd_pr__res_high_po_0p35 l=10.5
X207 a_13495_3430# a_13453_3298# a_7971_1984# vdd sky130_fd_pr__pfet_01v8_lvt ad=0.261 pd=2.38 as=0.261 ps=2.38 w=0.9 l=0.35
X208 a_13911_3430# f4 a_7971_1984# vdd sky130_fd_pr__pfet_01v8_lvt ad=0.261 pd=2.38 as=0.261 ps=2.38 w=0.9 l=0.35
X209 a_15451_7210# a_13495_7950# vss vss sky130_fd_pr__nfet_01v8_lvt ad=0.1595 pd=1.68 as=0.1595 ps=1.68 w=0.55 l=0.15
X210 a_4341_1968# a6 vss vss sky130_fd_pr__nfet_01v8 ad=0.1305 pd=1.48 as=0.1305 ps=1.48 w=0.45 l=0.18
X211 a_4811_4856# a_3087_4276# vdd vdd sky130_fd_pr__pfet_01v8 ad=0.363 pd=2.53 as=0.682 ps=5.02 w=2.2 l=0.15
X212 a_363_9054# b7 a_6247_8796# vss sky130_fd_pr__nfet_01v8_lvt ad=0.248 pd=2.22 as=0.132 ps=1.13 w=0.8 l=0.15
X213 vdd a_6247_7364# a_7971_6504# vdd sky130_fd_pr__pfet_01v8 ad=0.363 pd=2.53 as=0.363 ps=2.53 w=2.2 l=0.15
X214 a_15775_5530# f7 a_7971_4856# vss sky130_fd_pr__nfet_01v8_lvt ad=0.145 pd=1.58 as=0.145 ps=1.58 w=0.5 l=0.15
X215 a_6247_7364# a_7501_1968# a_363_4894# vdd sky130_fd_pr__pfet_01v8_lvt ad=0.3045 pd=2.39 as=0.609 ps=4.78 w=2.1 l=0.35
X216 a_4811_6504# a_3087_7364# vdd vdd sky130_fd_pr__pfet_01v8 ad=0.363 pd=2.53 as=0.363 ps=2.53 w=2.2 l=0.15
X217 dn a_21602_6694# vss vss sky130_fd_pr__nfet_01v8_lvt ad=0.231 pd=1.73 as=0.434 ps=3.42 w=1.4 l=0.15
X218 a_11215_3430# f2 a_7971_1984# vss sky130_fd_pr__nfet_01v8_lvt ad=0.145 pd=1.58 as=0.145 ps=1.58 w=0.5 l=0.15
X219 a_13171_4790# a_20664_3688# vss sky130_fd_pr__res_high_po_0p69 l=7.2
X220 a_363_2814# b3 a_6247_2844# vss sky130_fd_pr__nfet_01v8_lvt ad=0.248 pd=2.22 as=0.132 ps=1.13 w=0.8 l=0.15
X221 a_8935_3430# f0 a_4811_1984# vdd sky130_fd_pr__pfet_01v8_lvt ad=0.261 pd=2.38 as=0.261 ps=2.38 w=0.9 l=0.35
X222 a_16191_3430# f6 a_7971_1984# vdd sky130_fd_pr__pfet_01v8_lvt ad=0.261 pd=2.38 as=0.261 ps=2.38 w=0.9 l=0.35
X223 a_11215_3750# a_11173_3298# a_4811_4856# vss sky130_fd_pr__nfet_01v8_lvt ad=0.145 pd=1.58 as=0.145 ps=1.58 w=0.5 l=0.15
X224 a_363_9054# a_6068_205# a_6247_2844# vdd sky130_fd_pr__pfet_01v8_lvt ad=0.609 pd=4.78 as=0.3045 ps=2.39 w=2.1 l=0.35
X225 a_363_4894# a_7061_1968# a_6247_2844# vdd sky130_fd_pr__pfet_01v8_lvt ad=0.609 pd=4.78 as=0.3045 ps=2.39 w=2.1 l=0.35
X226 a_3087_8796# a_2938_205# a_363_2286# vdd sky130_fd_pr__pfet_01v8_lvt ad=0.3045 pd=2.39 as=0.609 ps=4.78 w=2.1 l=0.35
X227 vdd a_9351_1650# vdd vdd sky130_fd_pr__pfet_01v8 ad=0.667 pd=5.18 as=0 ps=0 w=2.3 l=0.15
X228 a_363_8526# a4 a_3087_4276# vss sky130_fd_pr__nfet_01v8_lvt ad=0.248 pd=2.22 as=0.132 ps=1.13 w=0.8 l=0.15
X229 a_3087_8796# a2 a_363_4366# vss sky130_fd_pr__nfet_01v8_lvt ad=0.132 pd=1.13 as=0.248 ps=2.22 w=0.8 l=0.15
X230 vss a_6247_4276# a_7971_4856# vss sky130_fd_pr__nfet_01v8_lvt ad=0.31 pd=2.62 as=0.165 ps=1.33 w=1 l=0.15
X231 vss a_16191_7950# vss vss sky130_fd_pr__nfet_01v8_lvt ad=0.1595 pd=1.68 as=0 ps=0 w=0.55 l=0.15
X232 a_10891_2690# a_8935_3430# vdd vdd sky130_fd_pr__pfet_01v8 ad=0.667 pd=5.18 as=0.667 ps=5.18 w=2.3 l=0.15
X233 a_10891_3745# a_8935_3750# vss vss sky130_fd_pr__nfet_01v8_lvt ad=0.1595 pd=1.68 as=0.1595 ps=1.68 w=0.55 l=0.15
X234 a_11631_1650# f3 a_4811_1984# vss sky130_fd_pr__nfet_01v8_lvt ad=0.145 pd=1.58 as=0.145 ps=1.58 w=0.5 l=0.15
X235 a_15775_10050# a_15733_1814# a_7971_9376# vdd sky130_fd_pr__pfet_01v8_lvt ad=0.261 pd=2.38 as=0.261 ps=2.38 w=0.9 l=0.35
X236 a_11631_3750# a_11173_3298# a_4811_4856# vdd sky130_fd_pr__pfet_01v8_lvt ad=0.261 pd=2.38 as=0.261 ps=2.38 w=0.9 l=0.35
X237 vdd a_6247_8796# a_7971_9376# vdd sky130_fd_pr__pfet_01v8 ad=0.363 pd=2.53 as=0.363 ps=2.53 w=2.2 l=0.15
X238 a_4811_9376# a_3087_8796# vdd vdd sky130_fd_pr__pfet_01v8 ad=0.363 pd=2.53 as=0.363 ps=2.53 w=2.2 l=0.15
X239 a_6247_8796# a_7501_1968# a_363_9054# vdd sky130_fd_pr__pfet_01v8_lvt ad=0.3045 pd=2.39 as=0.609 ps=4.78 w=2.1 l=0.35
X240 a_11215_7950# a_11173_3298# a_7971_6504# vdd sky130_fd_pr__pfet_01v8_lvt ad=0.261 pd=2.38 as=0.261 ps=2.38 w=0.9 l=0.35
X241 a_363_4366# c2 vss vss sky130_fd_pr__nfet_01v8_lvt ad=0.493 pd=3.98 as=0.493 ps=3.98 w=1.7 l=0.15
X242 a_10891_8265# a_8935_8270# vdd vdd sky130_fd_pr__pfet_01v8 ad=0.667 pd=5.18 as=0.667 ps=5.18 w=2.3 l=0.15
X243 a_5738_205# b0 vdd vdd sky130_fd_pr__pfet_01v8 ad=0.261 pd=2.38 as=0.261 ps=2.38 w=0.9 l=0.18
X244 a_11631_7950# f2 a_7971_6504# vdd sky130_fd_pr__pfet_01v8_lvt ad=0.261 pd=2.38 as=0.261 ps=2.38 w=0.9 l=0.35
X245 vdd a_21768_6694# a_21768_9194# vdd sky130_fd_pr__pfet_01v8_lvt ad=0.5365 pd=4.28 as=0.26825 ps=2.14 w=1.85 l=0.35
X246 a_9351_8270# a_8893_3298# a_4811_9376# vdd sky130_fd_pr__pfet_01v8_lvt ad=0.261 pd=2.38 as=0.261 ps=2.38 w=0.9 l=0.35
X247 a_3087_2844# a_4341_1968# a_363_6446# vdd sky130_fd_pr__pfet_01v8_lvt ad=0.3045 pd=2.39 as=0.609 ps=4.78 w=2.1 l=0.35
X248 vdd c5 a_363_6974# vdd sky130_fd_pr__pfet_01v8_lvt ad=0.493 pd=3.98 as=0.2465 ps=1.99 w=1.7 l=0.35
X249 a_17731_4790# a_15775_5530# vdd vdd sky130_fd_pr__pfet_01v8 ad=0.667 pd=5.18 as=0.667 ps=5.18 w=2.3 l=0.15
X250 a_363_8526# c6 vdd vdd sky130_fd_pr__pfet_01v8_lvt ad=0.2465 pd=1.99 as=0.2465 ps=1.99 w=1.7 l=0.35
X251 a_8935_6170# a_8893_1814# a_4811_6504# vss sky130_fd_pr__nfet_01v8_lvt ad=0.145 pd=1.58 as=0.145 ps=1.58 w=0.5 l=0.15
X252 a_13171_3745# a_11215_3750# vss vss sky130_fd_pr__nfet_01v8_lvt ad=0.1595 pd=1.68 as=0.1595 ps=1.68 w=0.55 l=0.15
X253 a_13171_2690# a_11215_3430# vdd vdd sky130_fd_pr__pfet_01v8 ad=0.667 pd=5.18 as=0.667 ps=5.18 w=2.3 l=0.15
X254 a_15451_3745# a_13495_3750# vdd vdd sky130_fd_pr__pfet_01v8 ad=0.667 pd=5.18 as=0.667 ps=5.18 w=2.3 l=0.15
X255 a_13911_1650# f5 a_4811_1984# vss sky130_fd_pr__nfet_01v8_lvt ad=0.145 pd=1.58 as=0.145 ps=1.58 w=0.5 l=0.15
X256 a_8935_3430# f0 a_7971_1984# vss sky130_fd_pr__nfet_01v8_lvt ad=0.145 pd=1.58 as=0.145 ps=1.58 w=0.5 l=0.15
X257 a_10891_8265# a_20664_8208# vss sky130_fd_pr__res_high_po_0p69 l=7.2
X258 dn a_21602_6694# vdd vdd sky130_fd_pr__pfet_01v8_lvt ad=0.406 pd=3.09 as=0.812 ps=6.18 w=2.8 l=0.35
X259 a_13911_3750# a_13453_3298# a_4811_4856# vdd sky130_fd_pr__pfet_01v8_lvt ad=0.261 pd=2.38 as=0.261 ps=2.38 w=0.9 l=0.35
X260 a_363_4366# a6 a_3087_7364# vss sky130_fd_pr__nfet_01v8_lvt ad=0.248 pd=2.22 as=0.132 ps=1.13 w=0.8 l=0.15
X261 vdd a_21768_2174# a_21768_4674# vdd sky130_fd_pr__pfet_01v8_lvt ad=0.26825 pd=2.14 as=0.26825 ps=2.14 w=1.85 l=0.35
X262 a_7971_4856# a_6247_4276# vdd vdd sky130_fd_pr__pfet_01v8 ad=0.363 pd=2.53 as=0.363 ps=2.53 w=2.2 l=0.15
X263 vdd a_21602_4674# a_21602_2174# vdd sky130_fd_pr__pfet_01v8_lvt ad=0.5365 pd=4.28 as=0.26825 ps=2.14 w=1.85 l=0.35
X264 a_13171_8265# a_11215_8270# vdd vdd sky130_fd_pr__pfet_01v8 ad=0.667 pd=5.18 as=0.667 ps=5.18 w=2.3 l=0.15
X265 ep a_21768_4674# vdd vdd sky130_fd_pr__pfet_01v8_lvt ad=0.406 pd=3.09 as=0.406 ps=3.09 w=2.8 l=0.35
X266 a_3087_4276# a6 a_363_2286# vss sky130_fd_pr__nfet_01v8_lvt ad=0.132 pd=1.13 as=0.248 ps=2.22 w=0.8 l=0.15
X267 vss a_11631_3750# vss vss sky130_fd_pr__nfet_01v8_lvt ad=0.1595 pd=1.68 as=0 ps=0 w=0.55 l=0.15
X268 vss a_9351_8270# vss vss sky130_fd_pr__nfet_01v8_lvt ad=0.1595 pd=1.68 as=0 ps=0 w=0.55 l=0.15
X269 a_15775_7950# f6 a_7971_6504# vss sky130_fd_pr__nfet_01v8_lvt ad=0.145 pd=1.58 as=0.145 ps=1.58 w=0.5 l=0.15
X270 vdd a_11631_3430# vdd vdd sky130_fd_pr__pfet_01v8 ad=0.667 pd=5.18 as=0 ps=0 w=2.3 l=0.15
X271 vss a_21602_2174# en vss sky130_fd_pr__nfet_01v8_lvt ad=0.434 pd=3.42 as=0.231 ps=1.73 w=1.4 l=0.15
X272 a_13495_1650# a_13453_1814# a_4811_1984# vss sky130_fd_pr__nfet_01v8_lvt ad=0.145 pd=1.58 as=0.145 ps=1.58 w=0.5 l=0.15
X273 a_13495_3750# f4 a_4811_4856# vdd sky130_fd_pr__pfet_01v8_lvt ad=0.261 pd=2.38 as=0.261 ps=2.38 w=0.9 l=0.35
X274 a_8935_5530# a_8893_1814# a_4811_4856# vss sky130_fd_pr__nfet_01v8_lvt ad=0.145 pd=1.58 as=0.145 ps=1.58 w=0.5 l=0.15
X275 vdd a_11631_8270# vdd vdd sky130_fd_pr__pfet_01v8 ad=0.667 pd=5.18 as=0 ps=0 w=2.3 l=0.15
X276 a_363_6446# a_2938_205# a_3087_7364# vdd sky130_fd_pr__pfet_01v8_lvt ad=0.609 pd=4.78 as=0.3045 ps=2.39 w=2.1 l=0.35
X277 a_5738_205# b0 vss vss sky130_fd_pr__nfet_01v8 ad=0.1305 pd=1.48 as=0.1305 ps=1.48 w=0.45 l=0.18
X278 a_15451_2690# a_20664_1816# vss sky130_fd_pr__res_high_po_0p69 l=7.2
X279 a_11215_8270# f2 a_4811_9376# vdd sky130_fd_pr__pfet_01v8_lvt ad=0.261 pd=2.38 as=0.261 ps=2.38 w=0.9 l=0.35
X280 a_10891_7210# a_20664_6336# vss sky130_fd_pr__res_high_po_0p69 l=7.2
X281 a_9351_1650# f1 a_4811_1984# vss sky130_fd_pr__nfet_01v8_lvt ad=0.145 pd=1.58 as=0.145 ps=1.58 w=0.5 l=0.15
X282 a_9351_1650# a_8893_1814# a_7971_1984# vss sky130_fd_pr__nfet_01v8_lvt ad=0.145 pd=1.58 as=0.145 ps=1.58 w=0.5 l=0.15
X283 a_9351_3750# f0 a_7971_4856# vdd sky130_fd_pr__pfet_01v8_lvt ad=0.261 pd=2.38 as=0.261 ps=2.38 w=0.9 l=0.35
X284 dp a_21768_9194# vdd vdd sky130_fd_pr__pfet_01v8_lvt ad=0.406 pd=3.09 as=0.812 ps=6.18 w=2.8 l=0.35
X285 a_3087_4276# a_3461_1968# a_363_6446# vdd sky130_fd_pr__pfet_01v8_lvt ad=0.3045 pd=2.39 as=0.609 ps=4.78 w=2.1 l=0.35
X286 vdd a_13911_3430# vdd vdd sky130_fd_pr__pfet_01v8 ad=0.667 pd=5.18 as=0 ps=0 w=2.3 l=0.15
X287 vss a_13911_3750# vss vss sky130_fd_pr__nfet_01v8_lvt ad=0.1595 pd=1.68 as=0 ps=0 w=0.55 l=0.15
X288 vdd a_16191_3750# vdd vdd sky130_fd_pr__pfet_01v8 ad=0.667 pd=5.18 as=0 ps=0 w=2.3 l=0.15
X289 a_363_6446# a2 a_3087_4276# vss sky130_fd_pr__nfet_01v8_lvt ad=0.248 pd=2.22 as=0.132 ps=1.13 w=0.8 l=0.15
X290 a_11631_5530# a_11173_1814# a_4811_4856# vdd sky130_fd_pr__pfet_01v8_lvt ad=0.261 pd=2.38 as=0.261 ps=2.38 w=0.9 l=0.35
X291 a_17731_9310# a_15775_10050# vss vss sky130_fd_pr__nfet_01v8_lvt ad=0.1595 pd=1.68 as=0.1595 ps=1.68 w=0.55 l=0.15
X292 a_13171_6165# a_20664_6336# vss sky130_fd_pr__res_high_po_0p69 l=7.2
X293 a_363_4894# a_7501_1968# a_6247_7364# vdd sky130_fd_pr__pfet_01v8_lvt ad=0.609 pd=4.78 as=0.3045 ps=2.39 w=2.1 l=0.35
X294 vdd a_13911_8270# vdd vdd sky130_fd_pr__pfet_01v8 ad=0.667 pd=5.18 as=0 ps=0 w=2.3 l=0.15
X295 a_3087_7364# a4 a_363_2286# vss sky130_fd_pr__nfet_01v8_lvt ad=0.132 pd=1.13 as=0.248 ps=2.22 w=0.8 l=0.15
X296 a_11631_6170# a_11173_1814# a_4811_6504# vdd sky130_fd_pr__pfet_01v8_lvt ad=0.261 pd=2.38 as=0.261 ps=2.38 w=0.9 l=0.35
X297 a_16191_8270# f6 a_4811_9376# vss sky130_fd_pr__nfet_01v8_lvt ad=0.145 pd=1.58 as=0.145 ps=1.58 w=0.5 l=0.15
X298 a_363_2286# c0 vdd vdd sky130_fd_pr__pfet_01v8_lvt ad=0.2465 pd=1.99 as=0.493 ps=3.98 w=1.7 l=0.35
X299 a_363_9054# c7 vss vss sky130_fd_pr__nfet_01v8_lvt ad=0.493 pd=3.98 as=0.493 ps=3.98 w=1.7 l=0.15
X300 a_15451_1645# a_13495_1650# vss vss sky130_fd_pr__nfet_01v8_lvt ad=0.1595 pd=1.68 as=0.1595 ps=1.68 w=0.55 l=0.15
X301 a_17731_1645# a_15775_1650# vdd vdd sky130_fd_pr__pfet_01v8 ad=0.667 pd=5.18 as=0.667 ps=5.18 w=2.3 l=0.15
X302 a_6068_205# b1 vdd vdd sky130_fd_pr__pfet_01v8 ad=0.261 pd=2.38 as=0.261 ps=2.38 w=0.9 l=0.18
X303 a_16191_1650# a_15733_1814# a_4811_1984# vdd sky130_fd_pr__pfet_01v8_lvt ad=0.261 pd=2.38 as=0.261 ps=2.38 w=0.9 l=0.35
X304 a_13911_5530# a_13453_1814# a_4811_4856# vdd sky130_fd_pr__pfet_01v8_lvt ad=0.261 pd=2.38 as=0.261 ps=2.38 w=0.9 l=0.35
X305 a_363_2286# a_2938_205# a_3087_8796# vdd sky130_fd_pr__pfet_01v8_lvt ad=0.609 pd=4.78 as=0.3045 ps=2.39 w=2.1 l=0.35
X306 a_13453_1814# f5 vdd vdd sky130_fd_pr__pfet_01v8 ad=0.261 pd=2.38 as=0.261 ps=2.38 w=0.9 l=0.18
X307 a_363_8526# a_3901_1968# a_3087_4276# vdd sky130_fd_pr__pfet_01v8_lvt ad=0.609 pd=4.78 as=0.3045 ps=2.39 w=2.1 l=0.35
X308 a_7971_6504# a_6247_7364# vdd vdd sky130_fd_pr__pfet_01v8 ad=0.363 pd=2.53 as=0.682 ps=5.02 w=2.2 l=0.15
X309 a_15451_6165# a_13495_6170# vdd vdd sky130_fd_pr__pfet_01v8 ad=0.667 pd=5.18 as=0.667 ps=5.18 w=2.3 l=0.15
X310 vss a_16191_10050# vss vss sky130_fd_pr__nfet_01v8_lvt ad=0.1595 pd=1.68 as=0 ps=0 w=0.55 l=0.15
X311 a_15775_8270# a_15733_3298# a_4811_9376# vss sky130_fd_pr__nfet_01v8_lvt ad=0.145 pd=1.58 as=0.145 ps=1.58 w=0.5 l=0.15
X312 a_6247_7364# b1 a_363_6974# vss sky130_fd_pr__nfet_01v8_lvt ad=0.132 pd=1.13 as=0.248 ps=2.22 w=0.8 l=0.15
X313 a_6247_7364# b5 a_363_2814# vss sky130_fd_pr__nfet_01v8_lvt ad=0.132 pd=1.13 as=0.248 ps=2.22 w=0.8 l=0.15
X314 a_13911_6170# a_13453_1814# a_4811_6504# vdd sky130_fd_pr__pfet_01v8_lvt ad=0.261 pd=2.38 as=0.261 ps=2.38 w=0.9 l=0.35
X315 a_7058_205# b4 vdd vdd sky130_fd_pr__pfet_01v8 ad=0.261 pd=2.38 as=0.261 ps=2.38 w=0.9 l=0.18
X316 a_11215_6170# a_11173_1814# a_4811_6504# vss sky130_fd_pr__nfet_01v8_lvt ad=0.145 pd=1.58 as=0.145 ps=1.58 w=0.5 l=0.15
X317 a_13495_3750# f4 a_7971_4856# vss sky130_fd_pr__nfet_01v8_lvt ad=0.145 pd=1.58 as=0.145 ps=1.58 w=0.5 l=0.15
X318 vdd a_3087_4276# a_4811_4856# vdd sky130_fd_pr__pfet_01v8 ad=0.682 pd=5.02 as=0.363 ps=2.53 w=2.2 l=0.15
X319 a_363_9054# a_7501_1968# a_6247_8796# vdd sky130_fd_pr__pfet_01v8_lvt ad=0.609 pd=4.78 as=0.3045 ps=2.39 w=2.1 l=0.35
X320 a_15775_1650# f7 a_4811_1984# vdd sky130_fd_pr__pfet_01v8_lvt ad=0.261 pd=2.38 as=0.261 ps=2.38 w=0.9 l=0.35
X321 a_13495_5530# f5 a_4811_4856# vdd sky130_fd_pr__pfet_01v8_lvt ad=0.261 pd=2.38 as=0.261 ps=2.38 w=0.9 l=0.35
X322 a_7501_1968# b7 vdd vdd sky130_fd_pr__pfet_01v8 ad=0.261 pd=2.38 as=0.261 ps=2.38 w=0.9 l=0.18
X323 a_6247_2844# a_6068_205# a_363_9054# vdd sky130_fd_pr__pfet_01v8_lvt ad=0.3045 pd=2.39 as=0.609 ps=4.78 w=2.1 l=0.35
X324 a_13911_3750# a_13453_3298# a_7971_4856# vss sky130_fd_pr__nfet_01v8_lvt ad=0.145 pd=1.58 as=0.145 ps=1.58 w=0.5 l=0.15
X325 a_8935_3750# a_8893_3298# a_7971_4856# vdd sky130_fd_pr__pfet_01v8_lvt ad=0.261 pd=2.38 as=0.261 ps=2.38 w=0.9 l=0.35
X326 a_13911_10050# a_13453_1814# a_7971_9376# vss sky130_fd_pr__nfet_01v8_lvt ad=0.145 pd=1.58 as=0.145 ps=1.58 w=0.5 l=0.15
X327 a_363_6446# a_4341_1968# a_3087_2844# vdd sky130_fd_pr__pfet_01v8_lvt ad=0.609 pd=4.78 as=0.3045 ps=2.39 w=2.1 l=0.35
X328 a_10891_9310# a_8935_10050# vdd vdd sky130_fd_pr__pfet_01v8 ad=0.667 pd=5.18 as=0.667 ps=5.18 w=2.3 l=0.15
X329 a_10891_6165# a_8935_6170# vss vss sky130_fd_pr__nfet_01v8_lvt ad=0.1595 pd=1.68 as=0.1595 ps=1.68 w=0.55 l=0.15
X330 a_13495_6170# f5 a_4811_6504# vdd sky130_fd_pr__pfet_01v8_lvt ad=0.261 pd=2.38 as=0.261 ps=2.38 w=0.9 l=0.35
X331 a_13171_2690# a_20664_1816# vss sky130_fd_pr__res_high_po_0p69 l=7.2
X332 a_9351_10050# a_8893_1814# a_4811_9376# vdd sky130_fd_pr__pfet_01v8_lvt ad=0.261 pd=2.38 as=0.261 ps=2.38 w=0.9 l=0.35
X333 a_8935_7950# a_8893_3298# a_4811_6504# vss sky130_fd_pr__nfet_01v8_lvt ad=0.145 pd=1.58 as=0.145 ps=1.58 w=0.5 l=0.15
X334 a_9351_5530# f1 a_7971_4856# vdd sky130_fd_pr__pfet_01v8_lvt ad=0.261 pd=2.38 as=0.261 ps=2.38 w=0.9 l=0.35
X335 a_21602_6694# a_21602_9194# vdd vdd sky130_fd_pr__pfet_01v8_lvt ad=0.26825 pd=2.14 as=0.5365 ps=4.28 w=1.85 l=0.35
X336 vss a_16191_1650# vss vss sky130_fd_pr__nfet_01v8_lvt ad=0.1595 pd=1.68 as=0 ps=0 w=0.55 l=0.15
X337 a_15451_4790# a_20664_3688# vss sky130_fd_pr__res_high_po_0p69 l=7.2
X338 a_363_9054# b1 a_6247_2844# vss sky130_fd_pr__nfet_01v8_lvt ad=0.248 pd=2.22 as=0.132 ps=1.13 w=0.8 l=0.15
X339 a_4811_9376# a_3087_8796# vss vss sky130_fd_pr__nfet_01v8_lvt ad=0.165 pd=1.33 as=0.31 ps=2.62 w=1 l=0.15
X340 a_363_4894# b5 a_6247_2844# vss sky130_fd_pr__nfet_01v8_lvt ad=0.248 pd=2.22 as=0.132 ps=1.13 w=0.8 l=0.15
X341 a_11215_5530# a_11173_1814# a_4811_4856# vss sky130_fd_pr__nfet_01v8_lvt ad=0.145 pd=1.58 as=0.145 ps=1.58 w=0.5 l=0.15
X342 a_6068_205# b1 vss vss sky130_fd_pr__nfet_01v8 ad=0.1305 pd=1.48 as=0.1305 ps=1.48 w=0.45 l=0.18
X343 a_7971_9376# a_6247_8796# vdd vdd sky130_fd_pr__pfet_01v8 ad=0.363 pd=2.53 as=0.682 ps=5.02 w=2.2 l=0.15
X344 a_2938_205# a0 vdd vdd sky130_fd_pr__pfet_01v8 ad=0.261 pd=2.38 as=0.261 ps=2.38 w=0.9 l=0.18
X345 a_13453_1814# f5 vss vss sky130_fd_pr__nfet_01v8 ad=0.1305 pd=1.48 as=0.1305 ps=1.48 w=0.45 l=0.18
X346 a_9351_6170# f1 a_7971_6504# vdd sky130_fd_pr__pfet_01v8_lvt ad=0.261 pd=2.38 as=0.261 ps=2.38 w=0.9 l=0.35
X347 a_10891_4790# a_20664_3688# vss sky130_fd_pr__res_high_po_0p69 l=7.2
X348 a_16191_3750# a_15733_3298# a_7971_4856# vss sky130_fd_pr__nfet_01v8_lvt ad=0.145 pd=1.58 as=0.145 ps=1.58 w=0.5 l=0.15
X349 a_17731_8265# a_15775_8270# vss vss sky130_fd_pr__nfet_01v8_lvt ad=0.1595 pd=1.68 as=0.1595 ps=1.68 w=0.55 l=0.15
X350 vdd a_16191_6170# vdd vdd sky130_fd_pr__pfet_01v8 ad=0.667 pd=5.18 as=0 ps=0 w=2.3 l=0.15
X351 a_13171_8265# a_20664_8208# vss sky130_fd_pr__res_high_po_0p69 l=7.2
X352 a_363_2814# c1 vss vss sky130_fd_pr__nfet_01v8_lvt ad=0.493 pd=3.98 as=0.493 ps=3.98 w=1.7 l=0.15
X353 a_4811_1984# a_3087_2844# vdd vdd sky130_fd_pr__pfet_01v8 ad=0.363 pd=2.53 as=0.682 ps=5.02 w=2.2 l=0.15
X354 a_13171_6165# a_11215_6170# vss vss sky130_fd_pr__nfet_01v8_lvt ad=0.1595 pd=1.68 as=0.1595 ps=1.68 w=0.55 l=0.15
X355 a_7058_205# b4 vss vss sky130_fd_pr__nfet_01v8 ad=0.1305 pd=1.48 as=0.1305 ps=1.48 w=0.45 l=0.18
X356 a_13171_9310# a_11215_10050# vdd vdd sky130_fd_pr__pfet_01v8 ad=0.667 pd=5.18 as=0.667 ps=5.18 w=2.3 l=0.15
X357 a_10891_4790# a_8935_5530# vss vss sky130_fd_pr__nfet_01v8_lvt ad=0.1595 pd=1.68 as=0.1595 ps=1.68 w=0.55 l=0.15
X358 a_3087_8796# a0 a_363_2286# vss sky130_fd_pr__nfet_01v8_lvt ad=0.132 pd=1.13 as=0.248 ps=2.22 w=0.8 l=0.15
X359 a_11631_3430# f2 a_4811_1984# vss sky130_fd_pr__nfet_01v8_lvt ad=0.145 pd=1.58 as=0.145 ps=1.58 w=0.5 l=0.15
X360 vdd c4 a_363_6446# vdd sky130_fd_pr__pfet_01v8_lvt ad=0.493 pd=3.98 as=0.2465 ps=1.99 w=1.7 l=0.35
X361 a_16191_3430# a_15733_3298# a_4811_1984# vdd sky130_fd_pr__pfet_01v8_lvt ad=0.261 pd=2.38 as=0.261 ps=2.38 w=0.9 l=0.35
X362 a_7501_1968# b7 vss vss sky130_fd_pr__nfet_01v8 ad=0.1305 pd=1.48 as=0.1305 ps=1.48 w=0.45 l=0.18
X363 a_11173_3298# f2 vdd vdd sky130_fd_pr__pfet_01v8 ad=0.261 pd=2.38 as=0.261 ps=2.38 w=0.9 l=0.18
X364 vss a_11631_6170# vss vss sky130_fd_pr__nfet_01v8_lvt ad=0.1595 pd=1.68 as=0 ps=0 w=0.55 l=0.15
X365 vdd a_11631_10050# vdd vdd sky130_fd_pr__pfet_01v8 ad=0.667 pd=5.18 as=0 ps=0 w=2.3 l=0.15
X366 a_16191_10050# a_15733_1814# a_7971_9376# vss sky130_fd_pr__nfet_01v8_lvt ad=0.145 pd=1.58 as=0.145 ps=1.58 w=0.5 l=0.15
X367 a_6247_8796# b7 a_363_9054# vss sky130_fd_pr__nfet_01v8_lvt ad=0.132 pd=1.13 as=0.248 ps=2.22 w=0.8 l=0.15
X368 a_11215_8270# f2 a_7971_9376# vss sky130_fd_pr__nfet_01v8_lvt ad=0.145 pd=1.58 as=0.145 ps=1.58 w=0.5 l=0.15
X369 a_363_6446# a_3461_1968# a_3087_4276# vdd sky130_fd_pr__pfet_01v8_lvt ad=0.609 pd=4.78 as=0.3045 ps=2.39 w=2.1 l=0.35
X370 a_11215_10050# f3 a_4811_9376# vdd sky130_fd_pr__pfet_01v8_lvt ad=0.261 pd=2.38 as=0.261 ps=2.38 w=0.9 l=0.35
X371 a_15775_1650# f7 a_7971_1984# vss sky130_fd_pr__nfet_01v8_lvt ad=0.145 pd=1.58 as=0.145 ps=1.58 w=0.5 l=0.15
X372 a_363_4894# c3 vdd vdd sky130_fd_pr__pfet_01v8_lvt ad=0.2465 pd=1.99 as=0.493 ps=3.98 w=1.7 l=0.35
X373 vdd a_21602_2174# en vdd sky130_fd_pr__pfet_01v8_lvt ad=0.812 pd=6.18 as=0.406 ps=3.09 w=2.8 l=0.35
X374 a_15775_3430# f6 a_4811_1984# vdd sky130_fd_pr__pfet_01v8_lvt ad=0.261 pd=2.38 as=0.261 ps=2.38 w=0.9 l=0.35
X375 a_11631_3750# a_11173_3298# a_7971_4856# vss sky130_fd_pr__nfet_01v8_lvt ad=0.145 pd=1.58 as=0.145 ps=1.58 w=0.5 l=0.15
X376 a_15775_3750# a_15733_3298# a_7971_4856# vdd sky130_fd_pr__pfet_01v8_lvt ad=0.261 pd=2.38 as=0.261 ps=2.38 w=0.9 l=0.35
X377 a_13171_4790# a_11215_5530# vss vss sky130_fd_pr__nfet_01v8_lvt ad=0.1595 pd=1.68 as=0.1595 ps=1.68 w=0.55 l=0.15
X378 vdd a_3087_7364# a_4811_6504# vdd sky130_fd_pr__pfet_01v8 ad=0.363 pd=2.53 as=0.363 ps=2.53 w=2.2 l=0.15
X379 vss a_21768_4674# ep vss sky130_fd_pr__nfet_01v8_lvt ad=0.434 pd=3.42 as=0.231 ps=1.73 w=1.4 l=0.15
X380 a_2938_205# a0 vss vss sky130_fd_pr__nfet_01v8 ad=0.1305 pd=1.48 as=0.1305 ps=1.48 w=0.45 l=0.18
X381 a_11215_1650# a_11173_1814# a_7971_1984# vdd sky130_fd_pr__pfet_01v8_lvt ad=0.261 pd=2.38 as=0.261 ps=2.38 w=0.9 l=0.35
X382 a_6247_2844# b3 a_363_2814# vss sky130_fd_pr__nfet_01v8_lvt ad=0.132 pd=1.13 as=0.248 ps=2.22 w=0.8 l=0.15
X383 a_13911_3430# f4 a_4811_1984# vss sky130_fd_pr__nfet_01v8_lvt ad=0.145 pd=1.58 as=0.145 ps=1.58 w=0.5 l=0.15
X384 a_8935_5530# a_8893_1814# a_7971_4856# vdd sky130_fd_pr__pfet_01v8_lvt ad=0.261 pd=2.38 as=0.261 ps=2.38 w=0.9 l=0.35
X385 a_21768_4674# a_21768_2174# vss sky130_fd_pr__res_high_po_0p35 l=10.5
X386 a_10891_1645# a_20664_1816# vss sky130_fd_pr__res_high_po_0p69 l=7.2
X387 a_11631_1650# f3 a_7971_1984# vdd sky130_fd_pr__pfet_01v8_lvt ad=0.261 pd=2.38 as=0.261 ps=2.38 w=0.9 l=0.35
X388 a_11631_10050# f3 a_4811_9376# vss sky130_fd_pr__nfet_01v8_lvt ad=0.145 pd=1.58 as=0.145 ps=1.58 w=0.5 l=0.15
X389 a_13495_8270# a_13453_3298# a_7971_9376# vdd sky130_fd_pr__pfet_01v8_lvt ad=0.261 pd=2.38 as=0.261 ps=2.38 w=0.9 l=0.35
X390 vss a_13911_6170# vss vss sky130_fd_pr__nfet_01v8_lvt ad=0.1595 pd=1.68 as=0 ps=0 w=0.55 l=0.15
X391 vdd a_13911_10050# vdd vdd sky130_fd_pr__pfet_01v8 ad=0.667 pd=5.18 as=0 ps=0 w=2.3 l=0.15
X392 a_363_2286# a4 a_3087_7364# vss sky130_fd_pr__nfet_01v8_lvt ad=0.248 pd=2.22 as=0.132 ps=1.13 w=0.8 l=0.15
X393 a_11631_7950# a_11173_3298# a_4811_6504# vdd sky130_fd_pr__pfet_01v8_lvt ad=0.261 pd=2.38 as=0.261 ps=2.38 w=0.9 l=0.35
X394 a_8935_6170# a_8893_1814# a_7971_6504# vdd sky130_fd_pr__pfet_01v8_lvt ad=0.261 pd=2.38 as=0.261 ps=2.38 w=0.9 l=0.35
X395 vss a_11631_5530# vss vss sky130_fd_pr__nfet_01v8_lvt ad=0.1595 pd=1.68 as=0 ps=0 w=0.55 l=0.15
X396 a_13911_8270# f4 a_7971_9376# vdd sky130_fd_pr__pfet_01v8_lvt ad=0.261 pd=2.38 as=0.261 ps=2.38 w=0.9 l=0.35
X397 a_363_4894# b3 a_6247_8796# vss sky130_fd_pr__nfet_01v8_lvt ad=0.248 pd=2.22 as=0.132 ps=1.13 w=0.8 l=0.15
X398 vss a_6247_7364# a_7971_6504# vss sky130_fd_pr__nfet_01v8_lvt ad=0.31 pd=2.62 as=0.165 ps=1.33 w=1 l=0.15
X399 a_13495_3430# a_13453_3298# a_4811_1984# vss sky130_fd_pr__nfet_01v8_lvt ad=0.145 pd=1.58 as=0.145 ps=1.58 w=0.5 l=0.15
X400 a_17731_8265# a_20664_8208# vss sky130_fd_pr__res_high_po_0p69 l=7.2
X401 vdd c0 a_363_2286# vdd sky130_fd_pr__pfet_01v8_lvt ad=0.2465 pd=1.99 as=0.2465 ps=1.99 w=1.7 l=0.35
X402 a_6247_7364# a_6621_1968# a_363_9054# vdd sky130_fd_pr__pfet_01v8_lvt ad=0.3045 pd=2.39 as=0.609 ps=4.78 w=2.1 l=0.35
X403 a_11173_3298# f2 vss vss sky130_fd_pr__nfet_01v8 ad=0.1305 pd=1.48 as=0.1305 ps=1.48 w=0.45 l=0.18
X404 a_7971_4856# a_6247_4276# vss vss sky130_fd_pr__nfet_01v8_lvt ad=0.165 pd=1.33 as=0.31 ps=2.62 w=1 l=0.15
X405 vss a_3087_4276# a_4811_4856# vss sky130_fd_pr__nfet_01v8_lvt ad=0.31 pd=2.62 as=0.165 ps=1.33 w=1 l=0.15
X406 a_11215_7950# a_11173_3298# a_4811_6504# vss sky130_fd_pr__nfet_01v8_lvt ad=0.145 pd=1.58 as=0.145 ps=1.58 w=0.5 l=0.15
X407 a_15451_7210# a_13495_7950# vdd vdd sky130_fd_pr__pfet_01v8 ad=0.667 pd=5.18 as=0.667 ps=5.18 w=2.3 l=0.15
X408 a_9351_3430# f0 a_4811_1984# vss sky130_fd_pr__nfet_01v8_lvt ad=0.145 pd=1.58 as=0.145 ps=1.58 w=0.5 l=0.15
X409 a_8935_8270# f0 a_4811_9376# vdd sky130_fd_pr__pfet_01v8_lvt ad=0.261 pd=2.38 as=0.261 ps=2.38 w=0.9 l=0.35
X410 a_9351_3430# a_8893_3298# a_7971_1984# vss sky130_fd_pr__nfet_01v8_lvt ad=0.145 pd=1.58 as=0.145 ps=1.58 w=0.5 l=0.15
X411 vdd a_3087_8796# a_4811_9376# vdd sky130_fd_pr__pfet_01v8 ad=0.363 pd=2.53 as=0.363 ps=2.53 w=2.2 l=0.15
X412 a_13911_7950# a_13453_3298# a_4811_6504# vdd sky130_fd_pr__pfet_01v8_lvt ad=0.261 pd=2.38 as=0.261 ps=2.38 w=0.9 l=0.35
X413 a_3268_205# a1 vdd vdd sky130_fd_pr__pfet_01v8 ad=0.261 pd=2.38 as=0.261 ps=2.38 w=0.9 l=0.18
X414 vss a_13911_5530# vss vss sky130_fd_pr__nfet_01v8_lvt ad=0.1595 pd=1.68 as=0 ps=0 w=0.55 l=0.15
X415 a_16191_8270# f6 a_7971_9376# vdd sky130_fd_pr__pfet_01v8_lvt ad=0.261 pd=2.38 as=0.261 ps=2.38 w=0.9 l=0.35
X416 a_7971_1984# a_6247_2844# vdd vdd sky130_fd_pr__pfet_01v8 ad=0.363 pd=2.53 as=0.363 ps=2.53 w=2.2 l=0.15
X417 a_3087_4276# a_2938_205# a_363_4366# vdd sky130_fd_pr__pfet_01v8_lvt ad=0.3045 pd=2.39 as=0.609 ps=4.78 w=2.1 l=0.35
X418 a_10891_7210# a_8935_7950# vss vss sky130_fd_pr__nfet_01v8_lvt ad=0.1595 pd=1.68 as=0.1595 ps=1.68 w=0.55 l=0.15
X419 a_363_4366# a0 a_3087_4276# vss sky130_fd_pr__nfet_01v8_lvt ad=0.248 pd=2.22 as=0.132 ps=1.13 w=0.8 l=0.15
X420 a_8935_8270# f0 a_7971_9376# vss sky130_fd_pr__nfet_01v8_lvt ad=0.145 pd=1.58 as=0.145 ps=1.58 w=0.5 l=0.15
X421 a_3901_1968# a4 vdd vdd sky130_fd_pr__pfet_01v8 ad=0.261 pd=2.38 as=0.261 ps=2.38 w=0.9 l=0.18
X422 a_363_6446# c4 vss vss sky130_fd_pr__nfet_01v8_lvt ad=0.493 pd=3.98 as=0.493 ps=3.98 w=1.7 l=0.15
X423 a_13495_6170# f5 a_7971_6504# vss sky130_fd_pr__nfet_01v8_lvt ad=0.145 pd=1.58 as=0.145 ps=1.58 w=0.5 l=0.15
X424 a_15733_1814# f7 vdd vdd sky130_fd_pr__pfet_01v8 ad=0.261 pd=2.38 as=0.261 ps=2.38 w=0.9 l=0.18
X425 a_13495_7950# f4 a_4811_6504# vdd sky130_fd_pr__pfet_01v8_lvt ad=0.261 pd=2.38 as=0.261 ps=2.38 w=0.9 l=0.35
X426 a_15451_2690# a_13495_3430# vss vss sky130_fd_pr__nfet_01v8_lvt ad=0.1595 pd=1.68 as=0.1595 ps=1.68 w=0.55 l=0.15
X427 a_15775_5530# a_15733_1814# a_7971_4856# vdd sky130_fd_pr__pfet_01v8_lvt ad=0.261 pd=2.38 as=0.261 ps=2.38 w=0.9 l=0.35
X428 a_3087_7364# a6 a_363_4366# vss sky130_fd_pr__nfet_01v8_lvt ad=0.132 pd=1.13 as=0.248 ps=2.22 w=0.8 l=0.15
X429 a_13911_6170# a_13453_1814# a_7971_6504# vss sky130_fd_pr__nfet_01v8_lvt ad=0.145 pd=1.58 as=0.145 ps=1.58 w=0.5 l=0.15
X430 a_5248_205# a7 vdd vdd sky130_fd_pr__pfet_01v8 ad=0.261 pd=2.38 as=0.261 ps=2.38 w=0.9 l=0.18
X431 vdd a_6247_4276# a_7971_4856# vdd sky130_fd_pr__pfet_01v8 ad=0.363 pd=2.53 as=0.363 ps=2.53 w=2.2 l=0.15
X432 a_13911_10050# f5 a_4811_9376# vss sky130_fd_pr__nfet_01v8_lvt ad=0.145 pd=1.58 as=0.145 ps=1.58 w=0.5 l=0.15
X433 a_6247_8796# a_6621_1968# a_363_4894# vdd sky130_fd_pr__pfet_01v8_lvt ad=0.3045 pd=2.39 as=0.609 ps=4.78 w=2.1 l=0.35
X434 a_6247_4276# a_7501_1968# a_363_2814# vdd sky130_fd_pr__pfet_01v8_lvt ad=0.3045 pd=2.39 as=0.609 ps=4.78 w=2.1 l=0.35
X435 a_11215_3430# a_11173_3298# a_7971_1984# vdd sky130_fd_pr__pfet_01v8_lvt ad=0.261 pd=2.38 as=0.261 ps=2.38 w=0.9 l=0.35
X436 a_4811_4856# a_3087_4276# vdd vdd sky130_fd_pr__pfet_01v8 ad=0.363 pd=2.53 as=0.363 ps=2.53 w=2.2 l=0.15
X437 a_363_2814# b7 a_6247_4276# vss sky130_fd_pr__nfet_01v8_lvt ad=0.248 pd=2.22 as=0.132 ps=1.13 w=0.8 l=0.15
X438 vdd a_21768_2174# a_21768_4674# vdd sky130_fd_pr__pfet_01v8_lvt ad=0.5365 pd=4.28 as=0.26825 ps=2.14 w=1.85 l=0.35
X439 a_11631_3430# f2 a_7971_1984# vdd sky130_fd_pr__pfet_01v8_lvt ad=0.261 pd=2.38 as=0.261 ps=2.38 w=0.9 l=0.35
X440 a_13171_7210# a_11215_7950# vss vss sky130_fd_pr__nfet_01v8_lvt ad=0.1595 pd=1.68 as=0.1595 ps=1.68 w=0.55 l=0.15
X441 a_9351_7950# f0 a_7971_6504# vdd sky130_fd_pr__pfet_01v8_lvt ad=0.261 pd=2.38 as=0.261 ps=2.38 w=0.9 l=0.35
X442 vdd a_6247_7364# a_7971_6504# vdd sky130_fd_pr__pfet_01v8 ad=0.682 pd=5.02 as=0.363 ps=2.53 w=2.2 l=0.15
X443 a_15775_6170# a_15733_1814# a_7971_6504# vdd sky130_fd_pr__pfet_01v8_lvt ad=0.261 pd=2.38 as=0.261 ps=2.38 w=0.9 l=0.35
X444 a_3087_2844# a_3461_1968# a_363_2286# vdd sky130_fd_pr__pfet_01v8_lvt ad=0.3045 pd=2.39 as=0.609 ps=4.78 w=2.1 l=0.35
X445 en a_21602_2174# vss vss sky130_fd_pr__nfet_01v8_lvt ad=0.231 pd=1.73 as=0.434 ps=3.42 w=1.4 l=0.15
X446 vdd a_16191_7950# vdd vdd sky130_fd_pr__pfet_01v8 ad=0.667 pd=5.18 as=0 ps=0 w=2.3 l=0.15
X447 a_3268_205# a1 vss vss sky130_fd_pr__nfet_01v8 ad=0.1305 pd=1.48 as=0.1305 ps=1.48 w=0.45 l=0.18
X448 a_8935_1650# a_8893_1814# a_4811_1984# vss sky130_fd_pr__nfet_01v8_lvt ad=0.145 pd=1.58 as=0.145 ps=1.58 w=0.5 l=0.15
X449 a_13495_5530# f5 a_7971_4856# vss sky130_fd_pr__nfet_01v8_lvt ad=0.145 pd=1.58 as=0.145 ps=1.58 w=0.5 l=0.15
X450 a_16191_6170# a_15733_1814# a_7971_6504# vss sky130_fd_pr__nfet_01v8_lvt ad=0.145 pd=1.58 as=0.145 ps=1.58 w=0.5 l=0.15
X451 vss a_11631_7950# vss vss sky130_fd_pr__nfet_01v8_lvt ad=0.1595 pd=1.68 as=0 ps=0 w=0.55 l=0.15
X452 a_363_8526# a2 a_3087_7364# vss sky130_fd_pr__nfet_01v8_lvt ad=0.248 pd=2.22 as=0.132 ps=1.13 w=0.8 l=0.15
X453 a_363_6446# a6 a_3087_2844# vss sky130_fd_pr__nfet_01v8_lvt ad=0.248 pd=2.22 as=0.132 ps=1.13 w=0.8 l=0.15
X454 a_13911_5530# a_13453_1814# a_7971_4856# vss sky130_fd_pr__nfet_01v8_lvt ad=0.145 pd=1.58 as=0.145 ps=1.58 w=0.5 l=0.15
X455 a_3901_1968# a4 vss vss sky130_fd_pr__nfet_01v8 ad=0.1305 pd=1.48 as=0.1305 ps=1.48 w=0.45 l=0.18
X456 a_3087_4276# a2 a_363_6446# vss sky130_fd_pr__nfet_01v8_lvt ad=0.132 pd=1.13 as=0.248 ps=2.22 w=0.8 l=0.15
X457 a_15733_1814# f7 vss vss sky130_fd_pr__nfet_01v8 ad=0.1305 pd=1.48 as=0.1305 ps=1.48 w=0.45 l=0.18
X458 vss a_9351_3750# vss vss sky130_fd_pr__nfet_01v8_lvt ad=0.1595 pd=1.68 as=0 ps=0 w=0.55 l=0.15
X459 a_11631_10050# a_11173_1814# a_7971_9376# vss sky130_fd_pr__nfet_01v8_lvt ad=0.145 pd=1.58 as=0.145 ps=1.58 w=0.5 l=0.15
X460 vdd a_9351_3430# vdd vdd sky130_fd_pr__pfet_01v8 ad=0.667 pd=5.18 as=0 ps=0 w=2.3 l=0.15
X461 a_363_4366# a_3901_1968# a_3087_2844# vdd sky130_fd_pr__pfet_01v8_lvt ad=0.609 pd=4.78 as=0.3045 ps=2.39 w=2.1 l=0.35
X462 vss a_16191_3430# vss vss sky130_fd_pr__nfet_01v8_lvt ad=0.1595 pd=1.68 as=0 ps=0 w=0.55 l=0.15
X463 a_5248_205# a7 vss vss sky130_fd_pr__nfet_01v8 ad=0.1305 pd=1.48 as=0.1305 ps=1.48 w=0.45 l=0.18
X464 vdd c7 a_363_9054# vdd sky130_fd_pr__pfet_01v8_lvt ad=0.493 pd=3.98 as=0.2465 ps=1.99 w=1.7 l=0.35
X465 vdd c3 a_363_4894# vdd sky130_fd_pr__pfet_01v8_lvt ad=0.2465 pd=1.99 as=0.2465 ps=1.99 w=1.7 l=0.35
X466 vdd a_6247_8796# a_7971_9376# vdd sky130_fd_pr__pfet_01v8 ad=0.682 pd=5.02 as=0.363 ps=2.53 w=2.2 l=0.15
X467 vdd a_9351_8270# vdd vdd sky130_fd_pr__pfet_01v8 ad=0.667 pd=5.18 as=0 ps=0 w=2.3 l=0.15
X468 a_16191_5530# a_15733_1814# a_7971_4856# vss sky130_fd_pr__nfet_01v8_lvt ad=0.145 pd=1.58 as=0.145 ps=1.58 w=0.5 l=0.15
X469 vss a_13911_7950# vss vss sky130_fd_pr__nfet_01v8_lvt ad=0.1595 pd=1.68 as=0 ps=0 w=0.55 l=0.15
X470 a_10891_2690# a_20664_1816# vss sky130_fd_pr__res_high_po_0p69 l=7.2
X471 vdd c1 a_363_2814# vdd sky130_fd_pr__pfet_01v8_lvt ad=0.493 pd=3.98 as=0.2465 ps=1.99 w=1.7 l=0.35
X472 a_10891_3745# a_8935_3750# vdd vdd sky130_fd_pr__pfet_01v8 ad=0.667 pd=5.18 as=0.667 ps=5.18 w=2.3 l=0.15
X473 a_13495_10050# a_13453_1814# a_7971_9376# vdd sky130_fd_pr__pfet_01v8_lvt ad=0.261 pd=2.38 as=0.261 ps=2.38 w=0.9 l=0.35
X474 a_11631_6170# a_11173_1814# a_7971_6504# vss sky130_fd_pr__nfet_01v8_lvt ad=0.145 pd=1.58 as=0.145 ps=1.58 w=0.5 l=0.15
X475 vdd a_3087_2844# a_4811_1984# vdd sky130_fd_pr__pfet_01v8 ad=0.682 pd=5.02 as=0.363 ps=2.53 w=2.2 l=0.15
X476 a_9351_3750# a_8893_3298# a_4811_4856# vdd sky130_fd_pr__pfet_01v8_lvt ad=0.261 pd=2.38 as=0.261 ps=2.38 w=0.9 l=0.35
X477 a_13453_3298# f4 vdd vdd sky130_fd_pr__pfet_01v8 ad=0.261 pd=2.38 as=0.261 ps=2.38 w=0.9 l=0.18
X478 a_20664_6336# vss sky130_fd_pr__cap_mim_m3_1 l=3.1 w=3.1
X479 a_8935_7950# a_8893_3298# a_7971_6504# vdd sky130_fd_pr__pfet_01v8_lvt ad=0.261 pd=2.38 as=0.261 ps=2.38 w=0.9 l=0.35
X480 a_13911_10050# f5 a_7971_9376# vdd sky130_fd_pr__pfet_01v8_lvt ad=0.261 pd=2.38 as=0.261 ps=2.38 w=0.9 l=0.35
X481 a_363_2286# c0 vdd vdd sky130_fd_pr__pfet_01v8_lvt ad=0.2465 pd=1.99 as=0.2465 ps=1.99 w=1.7 l=0.35
X482 a_363_9054# a_6621_1968# a_6247_7364# vdd sky130_fd_pr__pfet_01v8_lvt ad=0.609 pd=4.78 as=0.3045 ps=2.39 w=2.1 l=0.35
X483 a_363_4366# c2 vdd vdd sky130_fd_pr__pfet_01v8_lvt ad=0.2465 pd=1.99 as=0.493 ps=3.98 w=1.7 l=0.35
X484 en a_21602_2174# vdd vdd sky130_fd_pr__pfet_01v8_lvt ad=0.406 pd=3.09 as=0.812 ps=6.18 w=2.8 l=0.35
X485 a_15451_8265# a_20664_8208# vss sky130_fd_pr__res_high_po_0p69 l=7.2
X486 a_3087_2844# a4 a_363_4366# vss sky130_fd_pr__nfet_01v8_lvt ad=0.132 pd=1.13 as=0.248 ps=2.22 w=0.8 l=0.15
X487 a_15451_4790# a_13495_5530# vdd vdd sky130_fd_pr__pfet_01v8 ad=0.667 pd=5.18 as=0.667 ps=5.18 w=2.3 l=0.15
X488 a_16191_3750# f6 a_4811_4856# vss sky130_fd_pr__nfet_01v8_lvt ad=0.145 pd=1.58 as=0.145 ps=1.58 w=0.5 l=0.15
X489 a_13171_3745# a_11215_3750# vdd vdd sky130_fd_pr__pfet_01v8 ad=0.667 pd=5.18 as=0.667 ps=5.18 w=2.3 l=0.15
X490 a_11631_5530# a_11173_1814# a_7971_4856# vss sky130_fd_pr__nfet_01v8_lvt ad=0.145 pd=1.58 as=0.145 ps=1.58 w=0.5 l=0.15
X491 a_15775_3430# f6 a_7971_1984# vss sky130_fd_pr__nfet_01v8_lvt ad=0.145 pd=1.58 as=0.145 ps=1.58 w=0.5 l=0.15
X492 a_8935_10050# f1 a_4811_9376# vdd sky130_fd_pr__pfet_01v8_lvt ad=0.261 pd=2.38 as=0.261 ps=2.38 w=0.9 l=0.35
X493 a_363_4366# a_2938_205# a_3087_4276# vdd sky130_fd_pr__pfet_01v8_lvt ad=0.609 pd=4.78 as=0.3045 ps=2.39 w=2.1 l=0.35
X494 a_16191_10050# f7 a_7971_9376# vdd sky130_fd_pr__pfet_01v8_lvt ad=0.261 pd=2.38 as=0.261 ps=2.38 w=0.9 l=0.35
X495 a_20664_1816# vss sky130_fd_pr__cap_mim_m3_1 l=3.1 w=3.1
X496 a_13495_7950# f4 a_7971_6504# vss sky130_fd_pr__nfet_01v8_lvt ad=0.145 pd=1.58 as=0.145 ps=1.58 w=0.5 l=0.15
X497 a_3087_7364# a_3901_1968# a_363_2286# vdd sky130_fd_pr__pfet_01v8_lvt ad=0.3045 pd=2.39 as=0.609 ps=4.78 w=2.1 l=0.35
X498 a_6247_2844# b1 a_363_9054# vss sky130_fd_pr__nfet_01v8_lvt ad=0.132 pd=1.13 as=0.248 ps=2.22 w=0.8 l=0.15
X499 a_15775_3750# a_15733_3298# a_4811_4856# vss sky130_fd_pr__nfet_01v8_lvt ad=0.145 pd=1.58 as=0.145 ps=1.58 w=0.5 l=0.15
X500 vdd a_11631_3750# vdd vdd sky130_fd_pr__pfet_01v8 ad=0.667 pd=5.18 as=0 ps=0 w=2.3 l=0.15
X501 a_6247_2844# b5 a_363_4894# vss sky130_fd_pr__nfet_01v8_lvt ad=0.132 pd=1.13 as=0.248 ps=2.22 w=0.8 l=0.15
X502 a_13911_7950# a_13453_3298# a_7971_6504# vss sky130_fd_pr__nfet_01v8_lvt ad=0.145 pd=1.58 as=0.145 ps=1.58 w=0.5 l=0.15
X503 a_13453_3298# f4 vss vss sky130_fd_pr__nfet_01v8 ad=0.1305 pd=1.48 as=0.1305 ps=1.48 w=0.45 l=0.18
X504 a_11215_1650# a_11173_1814# a_4811_1984# vss sky130_fd_pr__nfet_01v8_lvt ad=0.145 pd=1.58 as=0.145 ps=1.58 w=0.5 l=0.15
X505 a_11215_3750# f2 a_4811_4856# vdd sky130_fd_pr__pfet_01v8_lvt ad=0.261 pd=2.38 as=0.261 ps=2.38 w=0.9 l=0.35
X506 a_21602_6694# a_21602_9194# vdd vdd sky130_fd_pr__pfet_01v8_lvt ad=0.26825 pd=2.14 as=0.26825 ps=2.14 w=1.85 l=0.35
X507 a_363_2814# a_7501_1968# a_6247_4276# vdd sky130_fd_pr__pfet_01v8_lvt ad=0.609 pd=4.78 as=0.3045 ps=2.39 w=2.1 l=0.35
X508 a_363_4894# a_6621_1968# a_6247_8796# vdd sky130_fd_pr__pfet_01v8_lvt ad=0.609 pd=4.78 as=0.3045 ps=2.39 w=2.1 l=0.35
X509 a_9351_10050# f1 a_4811_9376# vss sky130_fd_pr__nfet_01v8_lvt ad=0.145 pd=1.58 as=0.145 ps=1.58 w=0.5 l=0.15
X510 a_11631_8270# f2 a_4811_9376# vss sky130_fd_pr__nfet_01v8_lvt ad=0.145 pd=1.58 as=0.145 ps=1.58 w=0.5 l=0.15
X511 a_17731_6165# a_20664_6336# vss sky130_fd_pr__res_high_po_0p69 l=7.2
X512 a_363_2814# b1 a_6247_8796# vss sky130_fd_pr__nfet_01v8_lvt ad=0.248 pd=2.22 as=0.132 ps=1.13 w=0.8 l=0.15
X513 a_10891_1645# a_8935_1650# vss vss sky130_fd_pr__nfet_01v8_lvt ad=0.1595 pd=1.68 as=0.1595 ps=1.68 w=0.55 l=0.15
X514 a_363_2286# a_3461_1968# a_3087_2844# vdd sky130_fd_pr__pfet_01v8_lvt ad=0.609 pd=4.78 as=0.3045 ps=2.39 w=2.1 l=0.35
X515 vdd a_16191_5530# vdd vdd sky130_fd_pr__pfet_01v8 ad=0.667 pd=5.18 as=0 ps=0 w=2.3 l=0.15
X516 a_363_6974# b5 a_6247_8796# vss sky130_fd_pr__nfet_01v8_lvt ad=0.248 pd=2.22 as=0.132 ps=1.13 w=0.8 l=0.15
X517 a_15775_7950# a_15733_3298# a_7971_6504# vdd sky130_fd_pr__pfet_01v8_lvt ad=0.261 pd=2.38 as=0.261 ps=2.38 w=0.9 l=0.35
X518 a_11631_1650# a_11173_1814# a_4811_1984# vdd sky130_fd_pr__pfet_01v8_lvt ad=0.261 pd=2.38 as=0.261 ps=2.38 w=0.9 l=0.35
X519 vdd a_13911_3750# vdd vdd sky130_fd_pr__pfet_01v8 ad=0.667 pd=5.18 as=0 ps=0 w=2.3 l=0.15
X520 a_6247_7364# a_7061_1968# a_363_2814# vdd sky130_fd_pr__pfet_01v8_lvt ad=0.3045 pd=2.39 as=0.609 ps=4.78 w=2.1 l=0.35
X521 a_9351_5530# a_8893_1814# a_4811_4856# vdd sky130_fd_pr__pfet_01v8_lvt ad=0.261 pd=2.38 as=0.261 ps=2.38 w=0.9 l=0.35
X522 a_363_4894# c3 vss vss sky130_fd_pr__nfet_01v8_lvt ad=0.493 pd=3.98 as=0.493 ps=3.98 w=1.7 l=0.15
X523 a_16191_7950# a_15733_3298# a_7971_6504# vss sky130_fd_pr__nfet_01v8_lvt ad=0.145 pd=1.58 as=0.145 ps=1.58 w=0.5 l=0.15
X524 a_10891_6165# a_8935_6170# vdd vdd sky130_fd_pr__pfet_01v8 ad=0.667 pd=5.18 as=0.667 ps=5.18 w=2.3 l=0.15
X525 a_7971_4856# a_6247_4276# vdd vdd sky130_fd_pr__pfet_01v8 ad=0.363 pd=2.53 as=0.682 ps=5.02 w=2.2 l=0.15
X526 vdd c6 a_363_8526# vdd sky130_fd_pr__pfet_01v8_lvt ad=0.493 pd=3.98 as=0.2465 ps=1.99 w=1.7 l=0.35
X527 a_9351_6170# a_8893_1814# a_4811_6504# vdd sky130_fd_pr__pfet_01v8_lvt ad=0.261 pd=2.38 as=0.261 ps=2.38 w=0.9 l=0.35
X528 a_3087_8796# a_3901_1968# a_363_6446# vdd sky130_fd_pr__pfet_01v8_lvt ad=0.3045 pd=2.39 as=0.609 ps=4.78 w=2.1 l=0.35
X529 a_13911_8270# f4 a_4811_9376# vss sky130_fd_pr__nfet_01v8_lvt ad=0.145 pd=1.58 as=0.145 ps=1.58 w=0.5 l=0.15
X530 a_17731_3745# a_15775_3750# vss vss sky130_fd_pr__nfet_01v8_lvt ad=0.1595 pd=1.68 as=0.1595 ps=1.68 w=0.55 l=0.15
X531 vdd a_21602_6694# dn vdd sky130_fd_pr__pfet_01v8_lvt ad=0.406 pd=3.09 as=0.406 ps=3.09 w=2.8 l=0.35
X532 a_17731_2690# a_15775_3430# vdd vdd sky130_fd_pr__pfet_01v8 ad=0.667 pd=5.18 as=0.667 ps=5.18 w=2.3 l=0.15
X533 a_13171_1645# a_11215_1650# vss vss sky130_fd_pr__nfet_01v8_lvt ad=0.1595 pd=1.68 as=0.1595 ps=1.68 w=0.55 l=0.15
X534 a_15451_1645# a_13495_1650# vdd vdd sky130_fd_pr__pfet_01v8 ad=0.667 pd=5.18 as=0.667 ps=5.18 w=2.3 l=0.15
X535 ep a_21768_4674# vss vss sky130_fd_pr__nfet_01v8_lvt ad=0.231 pd=1.73 as=0.434 ps=3.42 w=1.4 l=0.15
X536 a_13911_1650# a_13453_1814# a_4811_1984# vdd sky130_fd_pr__pfet_01v8_lvt ad=0.261 pd=2.38 as=0.261 ps=2.38 w=0.9 l=0.35
X537 a_21768_9194# a_21768_6694# vdd vdd sky130_fd_pr__pfet_01v8_lvt ad=0.26825 pd=2.14 as=0.5365 ps=4.28 w=1.85 l=0.35
X538 vdd a_21768_4674# ep vdd sky130_fd_pr__pfet_01v8_lvt ad=0.812 pd=6.18 as=0.406 ps=3.09 w=2.8 l=0.35
X539 a_17731_8265# a_15775_8270# vdd vdd sky130_fd_pr__pfet_01v8 ad=0.667 pd=5.18 as=0.667 ps=5.18 w=2.3 l=0.15
X540 a_363_4894# c3 vdd vdd sky130_fd_pr__pfet_01v8_lvt ad=0.2465 pd=1.99 as=0.2465 ps=1.99 w=1.7 l=0.35
X541 a_363_6974# c5 vdd vdd sky130_fd_pr__pfet_01v8_lvt ad=0.2465 pd=1.99 as=0.493 ps=3.98 w=1.7 l=0.35
X542 a_16191_8270# a_15733_3298# a_4811_9376# vdd sky130_fd_pr__pfet_01v8_lvt ad=0.261 pd=2.38 as=0.261 ps=2.38 w=0.9 l=0.35
X543 a_13171_6165# a_11215_6170# vdd vdd sky130_fd_pr__pfet_01v8 ad=0.667 pd=5.18 as=0.667 ps=5.18 w=2.3 l=0.15
X544 a_17731_9310# a_20664_8208# vss sky130_fd_pr__res_high_po_0p69 l=7.2
X545 a_13495_8270# a_13453_3298# a_4811_9376# vss sky130_fd_pr__nfet_01v8_lvt ad=0.145 pd=1.58 as=0.145 ps=1.58 w=0.5 l=0.15
X546 a_16191_10050# f7 a_4811_9376# vss sky130_fd_pr__nfet_01v8_lvt ad=0.145 pd=1.58 as=0.145 ps=1.58 w=0.5 l=0.15
X547 vss a_9351_6170# vss vss sky130_fd_pr__nfet_01v8_lvt ad=0.1595 pd=1.68 as=0 ps=0 w=0.55 l=0.15
X548 vss a_11631_1650# vss vss sky130_fd_pr__nfet_01v8_lvt ad=0.1595 pd=1.68 as=0 ps=0 w=0.55 l=0.15
X549 vdd a_9351_10050# vdd vdd sky130_fd_pr__pfet_01v8 ad=0.667 pd=5.18 as=0 ps=0 w=2.3 l=0.15
X550 a_11631_7950# a_11173_3298# a_7971_6504# vss sky130_fd_pr__nfet_01v8_lvt ad=0.145 pd=1.58 as=0.145 ps=1.58 w=0.5 l=0.15
X551 a_6247_8796# a_7061_1968# a_363_6974# vdd sky130_fd_pr__pfet_01v8_lvt ad=0.3045 pd=2.39 as=0.609 ps=4.78 w=2.1 l=0.35
X552 a_6247_8796# b3 a_363_4894# vss sky130_fd_pr__nfet_01v8_lvt ad=0.132 pd=1.13 as=0.248 ps=2.22 w=0.8 l=0.15
X553 a_7971_6504# a_6247_7364# vss vss sky130_fd_pr__nfet_01v8_lvt ad=0.165 pd=1.33 as=0.31 ps=2.62 w=1 l=0.15
X554 a_11215_3750# f2 a_7971_4856# vss sky130_fd_pr__nfet_01v8_lvt ad=0.145 pd=1.58 as=0.145 ps=1.58 w=0.5 l=0.15
X555 vss a_3087_7364# a_4811_6504# vss sky130_fd_pr__nfet_01v8_lvt ad=0.31 pd=2.62 as=0.165 ps=1.33 w=1 l=0.15
X556 a_13495_1650# f5 a_4811_1984# vdd sky130_fd_pr__pfet_01v8_lvt ad=0.261 pd=2.38 as=0.261 ps=2.38 w=0.9 l=0.35
X557 a_11215_5530# f3 a_4811_4856# vdd sky130_fd_pr__pfet_01v8_lvt ad=0.261 pd=2.38 as=0.261 ps=2.38 w=0.9 l=0.35
X558 a_6398_205# b2 vdd vdd sky130_fd_pr__pfet_01v8 ad=0.261 pd=2.38 as=0.261 ps=2.38 w=0.9 l=0.18
X559 a_8935_3430# a_8893_3298# a_4811_1984# vss sky130_fd_pr__nfet_01v8_lvt ad=0.145 pd=1.58 as=0.145 ps=1.58 w=0.5 l=0.15
X560 a_9351_8270# f0 a_4811_9376# vss sky130_fd_pr__nfet_01v8_lvt ad=0.145 pd=1.58 as=0.145 ps=1.58 w=0.5 l=0.15
X561 a_21602_2174# a_21602_4674# vdd vdd sky130_fd_pr__pfet_01v8_lvt ad=0.26825 pd=2.14 as=0.5365 ps=4.28 w=1.85 l=0.35
X562 a_3087_2844# a_2938_205# a_363_8526# vdd sky130_fd_pr__pfet_01v8_lvt ad=0.3045 pd=2.39 as=0.609 ps=4.78 w=2.1 l=0.35
X563 a_9351_8270# a_8893_3298# a_7971_9376# vss sky130_fd_pr__nfet_01v8_lvt ad=0.145 pd=1.58 as=0.145 ps=1.58 w=0.5 l=0.15
X564 vdd a_11631_6170# vdd vdd sky130_fd_pr__pfet_01v8 ad=0.667 pd=5.18 as=0 ps=0 w=2.3 l=0.15
X565 a_15775_8270# f6 a_4811_9376# vdd sky130_fd_pr__pfet_01v8_lvt ad=0.261 pd=2.38 as=0.261 ps=2.38 w=0.9 l=0.35
X566 vdd a_21768_9194# dp vdd sky130_fd_pr__pfet_01v8_lvt ad=0.406 pd=3.09 as=0.406 ps=3.09 w=2.8 l=0.35
X567 a_4811_4856# a_3087_4276# vss vss sky130_fd_pr__nfet_01v8_lvt ad=0.165 pd=1.33 as=0.31 ps=2.62 w=1 l=0.15
X568 a_11215_6170# f3 a_4811_6504# vdd sky130_fd_pr__pfet_01v8_lvt ad=0.261 pd=2.38 as=0.261 ps=2.38 w=0.9 l=0.35
X569 a_7061_1968# b5 vdd vdd sky130_fd_pr__pfet_01v8 ad=0.261 pd=2.38 as=0.261 ps=2.38 w=0.9 l=0.18
X570 a_9351_1650# f1 a_7971_1984# vdd sky130_fd_pr__pfet_01v8_lvt ad=0.261 pd=2.38 as=0.261 ps=2.38 w=0.9 l=0.35
X571 vdd c2 a_363_4366# vdd sky130_fd_pr__pfet_01v8_lvt ad=0.2465 pd=1.99 as=0.2465 ps=1.99 w=1.7 l=0.35
X572 vss a_13911_1650# vss vss sky130_fd_pr__nfet_01v8_lvt ad=0.1595 pd=1.68 as=0 ps=0 w=0.55 l=0.15
X573 a_363_6446# a0 a_3087_7364# vss sky130_fd_pr__nfet_01v8_lvt ad=0.248 pd=2.22 as=0.132 ps=1.13 w=0.8 l=0.15
X574 a_13171_3745# a_20664_3688# vss sky130_fd_pr__res_high_po_0p69 l=7.2
X575 vdd a_16191_1650# vdd vdd sky130_fd_pr__pfet_01v8 ad=0.667 pd=5.18 as=0 ps=0 w=2.3 l=0.15
X576 a_11631_3430# a_11173_3298# a_4811_1984# vdd sky130_fd_pr__pfet_01v8_lvt ad=0.261 pd=2.38 as=0.261 ps=2.38 w=0.9 l=0.35
X577 a_363_4366# a4 a_3087_2844# vss sky130_fd_pr__nfet_01v8_lvt ad=0.248 pd=2.22 as=0.132 ps=1.13 w=0.8 l=0.15
X578 vss a_9351_5530# vss vss sky130_fd_pr__nfet_01v8_lvt ad=0.1595 pd=1.68 as=0 ps=0 w=0.55 l=0.15
X579 vdd a_6247_2844# a_7971_1984# vdd sky130_fd_pr__pfet_01v8 ad=0.363 pd=2.53 as=0.363 ps=2.53 w=2.2 l=0.15
X580 a_6247_2844# a_7501_1968# a_363_6974# vdd sky130_fd_pr__pfet_01v8_lvt ad=0.3045 pd=2.39 as=0.609 ps=4.78 w=2.1 l=0.35
X581 a_4811_1984# a_3087_2844# vdd vdd sky130_fd_pr__pfet_01v8 ad=0.363 pd=2.53 as=0.363 ps=2.53 w=2.2 l=0.15
X582 vss a_6247_2844# a_7971_1984# vss sky130_fd_pr__nfet_01v8_lvt ad=0.31 pd=2.62 as=0.165 ps=1.33 w=1 l=0.15
X583 a_3087_4276# a0 a_363_4366# vss sky130_fd_pr__nfet_01v8_lvt ad=0.132 pd=1.13 as=0.248 ps=2.22 w=0.8 l=0.15
X584 a_15451_8265# a_13495_8270# vss vss sky130_fd_pr__nfet_01v8_lvt ad=0.1595 pd=1.68 as=0.1595 ps=1.68 w=0.55 l=0.15
X585 vdd a_13911_6170# vdd vdd sky130_fd_pr__pfet_01v8 ad=0.667 pd=5.18 as=0 ps=0 w=2.3 l=0.15
X586 a_15733_3298# f6 vdd vdd sky130_fd_pr__pfet_01v8 ad=0.261 pd=2.38 as=0.261 ps=2.38 w=0.9 l=0.18
X587 a_16191_6170# f7 a_4811_6504# vss sky130_fd_pr__nfet_01v8_lvt ad=0.145 pd=1.58 as=0.145 ps=1.58 w=0.5 l=0.15
X588 a_21768_6694# a_20664_6336# sky130_fd_pr__cap_mim_m3_1 l=4.1 w=4.1
X589 a_363_4894# b7 a_6247_7364# vss sky130_fd_pr__nfet_01v8_lvt ad=0.248 pd=2.22 as=0.132 ps=1.13 w=0.8 l=0.15
X590 vdd a_3087_4276# a_4811_4856# vdd sky130_fd_pr__pfet_01v8 ad=0.363 pd=2.53 as=0.363 ps=2.53 w=2.2 l=0.15
X591 a_6398_205# b2 vss vss sky130_fd_pr__nfet_01v8 ad=0.1305 pd=1.48 as=0.1305 ps=1.48 w=0.45 l=0.18
X592 a_13911_3430# a_13453_3298# a_4811_1984# vdd sky130_fd_pr__pfet_01v8_lvt ad=0.261 pd=2.38 as=0.261 ps=2.38 w=0.9 l=0.35
X593 a_6247_4276# b7 a_363_2814# vss sky130_fd_pr__nfet_01v8_lvt ad=0.132 pd=1.13 as=0.248 ps=2.22 w=0.8 l=0.15
X594 a_15775_6170# a_15733_1814# a_4811_6504# vss sky130_fd_pr__nfet_01v8_lvt ad=0.145 pd=1.58 as=0.145 ps=1.58 w=0.5 l=0.15
X595 a_7061_1968# b5 vss vss sky130_fd_pr__nfet_01v8 ad=0.1305 pd=1.48 as=0.1305 ps=1.48 w=0.45 l=0.18
X596 a_8935_3750# f0 a_7971_4856# vss sky130_fd_pr__nfet_01v8_lvt ad=0.145 pd=1.58 as=0.145 ps=1.58 w=0.5 l=0.15
X597 a_363_6974# a_6068_205# a_6247_7364# vdd sky130_fd_pr__pfet_01v8_lvt ad=0.609 pd=4.78 as=0.3045 ps=2.39 w=2.1 l=0.35
X598 a_15451_6165# a_20664_6336# vss sky130_fd_pr__res_high_po_0p69 l=7.2
X599 a_13495_1650# f5 a_7971_1984# vss sky130_fd_pr__nfet_01v8_lvt ad=0.145 pd=1.58 as=0.145 ps=1.58 w=0.5 l=0.15
X600 a_16191_5530# f7 a_4811_4856# vss sky130_fd_pr__nfet_01v8_lvt ad=0.145 pd=1.58 as=0.145 ps=1.58 w=0.5 l=0.15
X601 a_363_2814# a_7061_1968# a_6247_7364# vdd sky130_fd_pr__pfet_01v8_lvt ad=0.609 pd=4.78 as=0.3045 ps=2.39 w=2.1 l=0.35
X602 a_13495_3430# f4 a_4811_1984# vdd sky130_fd_pr__pfet_01v8_lvt ad=0.261 pd=2.38 as=0.261 ps=2.38 w=0.9 l=0.35
X603 a_13495_3750# a_13453_3298# a_7971_4856# vdd sky130_fd_pr__pfet_01v8_lvt ad=0.261 pd=2.38 as=0.261 ps=2.38 w=0.9 l=0.35
X604 a_21768_2174# a_20664_1816# sky130_fd_pr__cap_mim_m3_1 l=4.1 w=4.1
X605 a_3087_7364# a2 a_363_8526# vss sky130_fd_pr__nfet_01v8_lvt ad=0.132 pd=1.13 as=0.248 ps=2.22 w=0.8 l=0.15
X606 a_8935_1650# a_8893_1814# a_7971_1984# vdd sky130_fd_pr__pfet_01v8_lvt ad=0.261 pd=2.38 as=0.261 ps=2.38 w=0.9 l=0.35
X607 a_3087_2844# a6 a_363_6446# vss sky130_fd_pr__nfet_01v8_lvt ad=0.132 pd=1.13 as=0.248 ps=2.22 w=0.8 l=0.15
X608 a_13911_1650# a_13453_1814# a_7971_1984# vss sky130_fd_pr__nfet_01v8_lvt ad=0.145 pd=1.58 as=0.145 ps=1.58 w=0.5 l=0.15
X609 a_13911_3750# f4 a_7971_4856# vdd sky130_fd_pr__pfet_01v8_lvt ad=0.261 pd=2.38 as=0.261 ps=2.38 w=0.9 l=0.35
X610 a_6247_4276# a_6621_1968# a_363_6974# vdd sky130_fd_pr__pfet_01v8_lvt ad=0.3045 pd=2.39 as=0.609 ps=4.78 w=2.1 l=0.35
X611 vss a_16191_8270# vss vss sky130_fd_pr__nfet_01v8_lvt ad=0.1595 pd=1.68 as=0 ps=0 w=0.55 l=0.15
X612 vdd a_21602_9194# a_21602_6694# vdd sky130_fd_pr__pfet_01v8_lvt ad=0.26825 pd=2.14 as=0.26825 ps=2.14 w=1.85 l=0.35
X613 a_363_6974# b3 a_6247_4276# vss sky130_fd_pr__nfet_01v8_lvt ad=0.248 pd=2.22 as=0.132 ps=1.13 w=0.8 l=0.15
X614 a_11215_8270# a_11173_3298# a_7971_9376# vdd sky130_fd_pr__pfet_01v8_lvt ad=0.261 pd=2.38 as=0.261 ps=2.38 w=0.9 l=0.35
X615 a_10891_7210# a_8935_7950# vdd vdd sky130_fd_pr__pfet_01v8 ad=0.667 pd=5.18 as=0.667 ps=5.18 w=2.3 l=0.15
X616 a_15733_3298# f6 vss vss sky130_fd_pr__nfet_01v8 ad=0.1305 pd=1.48 as=0.1305 ps=1.48 w=0.45 l=0.18
X617 a_9351_3430# f0 a_7971_1984# vdd sky130_fd_pr__pfet_01v8_lvt ad=0.261 pd=2.38 as=0.261 ps=2.38 w=0.9 l=0.35
X618 a_9351_7950# a_8893_3298# a_4811_6504# vdd sky130_fd_pr__pfet_01v8_lvt ad=0.261 pd=2.38 as=0.261 ps=2.38 w=0.9 l=0.35
X619 dn a_21602_6694# vdd vdd sky130_fd_pr__pfet_01v8_lvt ad=0.406 pd=3.09 as=0.406 ps=3.09 w=2.8 l=0.35
X620 a_11631_8270# f2 a_7971_9376# vdd sky130_fd_pr__pfet_01v8_lvt ad=0.261 pd=2.38 as=0.261 ps=2.38 w=0.9 l=0.35
X621 a_21602_9194# a_21602_6694# vss sky130_fd_pr__res_high_po_0p35 l=10.5
X622 a_15775_5530# a_15733_1814# a_4811_4856# vss sky130_fd_pr__nfet_01v8_lvt ad=0.145 pd=1.58 as=0.145 ps=1.58 w=0.5 l=0.15
X623 a_363_8526# a6 a_3087_8796# vss sky130_fd_pr__nfet_01v8_lvt ad=0.248 pd=2.22 as=0.132 ps=1.13 w=0.8 l=0.15
X624 a_11215_3430# a_11173_3298# a_4811_1984# vss sky130_fd_pr__nfet_01v8_lvt ad=0.145 pd=1.58 as=0.145 ps=1.58 w=0.5 l=0.15
X625 a_8935_3750# f0 a_4811_4856# vdd sky130_fd_pr__pfet_01v8_lvt ad=0.261 pd=2.38 as=0.261 ps=2.38 w=0.9 l=0.35
X626 a_363_8526# c6 vss vss sky130_fd_pr__nfet_01v8_lvt ad=0.493 pd=3.98 as=0.493 ps=3.98 w=1.7 l=0.15
X627 a_3087_7364# a_4341_1968# a_363_4366# vdd sky130_fd_pr__pfet_01v8_lvt ad=0.3045 pd=2.39 as=0.609 ps=4.78 w=2.1 l=0.35
X628 a_16191_1650# a_15733_1814# a_7971_1984# vss sky130_fd_pr__nfet_01v8_lvt ad=0.145 pd=1.58 as=0.145 ps=1.58 w=0.5 l=0.15
X629 a_17731_6165# a_15775_6170# vss vss sky130_fd_pr__nfet_01v8_lvt ad=0.1595 pd=1.68 as=0.1595 ps=1.68 w=0.55 l=0.15
X630 a_363_2286# a2 a_3087_2844# vss sky130_fd_pr__nfet_01v8_lvt ad=0.248 pd=2.22 as=0.132 ps=1.13 w=0.8 l=0.15
X631 a_16191_3750# f6 a_7971_4856# vdd sky130_fd_pr__pfet_01v8_lvt ad=0.261 pd=2.38 as=0.261 ps=2.38 w=0.9 l=0.35
X632 a_17731_9310# a_15775_10050# vdd vdd sky130_fd_pr__pfet_01v8 ad=0.667 pd=5.18 as=0.667 ps=5.18 w=2.3 l=0.15
X633 vss a_9351_7950# vss vss sky130_fd_pr__nfet_01v8_lvt ad=0.1595 pd=1.68 as=0 ps=0 w=0.55 l=0.15
X634 a_363_2814# a_6068_205# a_6247_8796# vdd sky130_fd_pr__pfet_01v8_lvt ad=0.609 pd=4.78 as=0.3045 ps=2.39 w=2.1 l=0.35
X635 a_16191_10050# a_15733_1814# a_4811_9376# vdd sky130_fd_pr__pfet_01v8_lvt ad=0.261 pd=2.38 as=0.261 ps=2.38 w=0.9 l=0.35
X636 vdd c5 a_363_6974# vdd sky130_fd_pr__pfet_01v8_lvt ad=0.2465 pd=1.99 as=0.2465 ps=1.99 w=1.7 l=0.35
X637 a_13171_7210# a_11215_7950# vdd vdd sky130_fd_pr__pfet_01v8 ad=0.667 pd=5.18 as=0.667 ps=5.18 w=2.3 l=0.15
X638 a_363_6974# a_7061_1968# a_6247_8796# vdd sky130_fd_pr__pfet_01v8_lvt ad=0.609 pd=4.78 as=0.3045 ps=2.39 w=2.1 l=0.35
X639 a_10891_2690# a_8935_3430# vss vss sky130_fd_pr__nfet_01v8_lvt ad=0.1595 pd=1.68 as=0.1595 ps=1.68 w=0.55 l=0.15
X640 a_8893_1814# f1 vdd vdd sky130_fd_pr__pfet_01v8 ad=0.261 pd=2.38 as=0.261 ps=2.38 w=0.9 l=0.18
X641 a_363_8526# a_2938_205# a_3087_2844# vdd sky130_fd_pr__pfet_01v8_lvt ad=0.609 pd=4.78 as=0.3045 ps=2.39 w=2.1 l=0.35
X642 dp a_21768_9194# vdd vdd sky130_fd_pr__pfet_01v8_lvt ad=0.406 pd=3.09 as=0.406 ps=3.09 w=2.8 l=0.35
X643 a_15775_8270# f6 a_7971_9376# vss sky130_fd_pr__nfet_01v8_lvt ad=0.145 pd=1.58 as=0.145 ps=1.58 w=0.5 l=0.15
X644 vdd a_11631_7950# vdd vdd sky130_fd_pr__pfet_01v8 ad=0.667 pd=5.18 as=0 ps=0 w=2.3 l=0.15
X645 vdd a_6247_4276# a_7971_4856# vdd sky130_fd_pr__pfet_01v8 ad=0.682 pd=5.02 as=0.363 ps=2.53 w=2.2 l=0.15
X646 a_15775_10050# f7 a_4811_9376# vdd sky130_fd_pr__pfet_01v8_lvt ad=0.261 pd=2.38 as=0.261 ps=2.38 w=0.9 l=0.35
X647 ep a_21768_4674# vdd vdd sky130_fd_pr__pfet_01v8_lvt ad=0.406 pd=3.09 as=0.812 ps=6.18 w=2.8 l=0.35
X648 a_363_4366# c2 vdd vdd sky130_fd_pr__pfet_01v8_lvt ad=0.2465 pd=1.99 as=0.2465 ps=1.99 w=1.7 l=0.35
X649 a_363_6446# c4 vdd vdd sky130_fd_pr__pfet_01v8_lvt ad=0.2465 pd=1.99 as=0.493 ps=3.98 w=1.7 l=0.35
X650 a_11215_6170# f3 a_7971_6504# vss sky130_fd_pr__nfet_01v8_lvt ad=0.145 pd=1.58 as=0.145 ps=1.58 w=0.5 l=0.15
X651 a_17731_4790# a_15775_5530# vss vss sky130_fd_pr__nfet_01v8_lvt ad=0.1595 pd=1.68 as=0.1595 ps=1.68 w=0.55 l=0.15
X652 a_11215_7950# f2 a_4811_6504# vdd sky130_fd_pr__pfet_01v8_lvt ad=0.261 pd=2.38 as=0.261 ps=2.38 w=0.9 l=0.35
X653 a_21768_9194# a_21768_6694# vss vss sky130_fd_pr__nfet_01v8_lvt ad=0.5365 pd=4.28 as=0.5365 ps=4.28 w=1.85 l=0.15
X654 a_3461_1968# a2 vdd vdd sky130_fd_pr__pfet_01v8 ad=0.261 pd=2.38 as=0.261 ps=2.38 w=0.9 l=0.18
X655 a_11631_1650# a_11173_1814# a_7971_1984# vss sky130_fd_pr__nfet_01v8_lvt ad=0.145 pd=1.58 as=0.145 ps=1.58 w=0.5 l=0.15
X656 a_15775_1650# a_15733_1814# a_7971_1984# vdd sky130_fd_pr__pfet_01v8_lvt ad=0.261 pd=2.38 as=0.261 ps=2.38 w=0.9 l=0.35
X657 a_13171_2690# a_11215_3430# vss vss sky130_fd_pr__nfet_01v8_lvt ad=0.1595 pd=1.68 as=0.1595 ps=1.68 w=0.55 l=0.15
X658 a_13495_5530# a_13453_1814# a_7971_4856# vdd sky130_fd_pr__pfet_01v8_lvt ad=0.261 pd=2.38 as=0.261 ps=2.38 w=0.9 l=0.35
X659 a_363_6974# a_7501_1968# a_6247_2844# vdd sky130_fd_pr__pfet_01v8_lvt ad=0.609 pd=4.78 as=0.3045 ps=2.39 w=2.1 l=0.35
X660 a_3087_8796# a_4341_1968# a_363_8526# vdd sky130_fd_pr__pfet_01v8_lvt ad=0.3045 pd=2.39 as=0.609 ps=4.78 w=2.1 l=0.35
X661 a_10891_3745# a_20664_3688# vss sky130_fd_pr__res_high_po_0p69 l=7.2
X662 a_8935_3430# a_8893_3298# a_7971_1984# vdd sky130_fd_pr__pfet_01v8_lvt ad=0.261 pd=2.38 as=0.261 ps=2.38 w=0.9 l=0.35
X663 a_3087_8796# a4 a_363_6446# vss sky130_fd_pr__nfet_01v8_lvt ad=0.132 pd=1.13 as=0.248 ps=2.22 w=0.8 l=0.15
X664 a_13911_5530# f5 a_7971_4856# vdd sky130_fd_pr__pfet_01v8_lvt ad=0.261 pd=2.38 as=0.261 ps=2.38 w=0.9 l=0.35
X665 a_4588_205# a5 vdd vdd sky130_fd_pr__pfet_01v8 ad=0.261 pd=2.38 as=0.261 ps=2.38 w=0.9 l=0.18
X666 a_16191_7950# f6 a_4811_6504# vss sky130_fd_pr__nfet_01v8_lvt ad=0.145 pd=1.58 as=0.145 ps=1.58 w=0.5 l=0.15
X667 a_13495_6170# a_13453_1814# a_7971_6504# vdd sky130_fd_pr__pfet_01v8_lvt ad=0.261 pd=2.38 as=0.261 ps=2.38 w=0.9 l=0.35
X668 a_15451_3745# a_20664_3688# vss sky130_fd_pr__res_high_po_0p69 l=7.2
X669 vdd a_13911_7950# vdd vdd sky130_fd_pr__pfet_01v8 ad=0.667 pd=5.18 as=0 ps=0 w=2.3 l=0.15
X670 vss a_11631_3430# vss vss sky130_fd_pr__nfet_01v8_lvt ad=0.1595 pd=1.68 as=0 ps=0 w=0.55 l=0.15
X671 a_17731_7210# a_20664_6336# vss sky130_fd_pr__res_high_po_0p69 l=7.2
X672 a_13911_6170# f5 a_7971_6504# vdd sky130_fd_pr__pfet_01v8_lvt ad=0.261 pd=2.38 as=0.261 ps=2.38 w=0.9 l=0.35
X673 a_11215_5530# f3 a_7971_4856# vss sky130_fd_pr__nfet_01v8_lvt ad=0.145 pd=1.58 as=0.145 ps=1.58 w=0.5 l=0.15
X674 a_8893_1814# f1 vss vss sky130_fd_pr__nfet_01v8 ad=0.1305 pd=1.48 as=0.1305 ps=1.48 w=0.45 l=0.18
X675 a_7971_1984# a_6247_2844# vdd vdd sky130_fd_pr__pfet_01v8 ad=0.363 pd=2.53 as=0.682 ps=5.02 w=2.2 l=0.15
X676 a_8935_5530# f1 a_4811_4856# vdd sky130_fd_pr__pfet_01v8_lvt ad=0.261 pd=2.38 as=0.261 ps=2.38 w=0.9 l=0.35
X677 a_6247_8796# b1 a_363_2814# vss sky130_fd_pr__nfet_01v8_lvt ad=0.132 pd=1.13 as=0.248 ps=2.22 w=0.8 l=0.15
X678 a_15775_7950# a_15733_3298# a_4811_6504# vss sky130_fd_pr__nfet_01v8_lvt ad=0.145 pd=1.58 as=0.145 ps=1.58 w=0.5 l=0.15
X679 a_16191_5530# f7 a_7971_4856# vdd sky130_fd_pr__pfet_01v8_lvt ad=0.261 pd=2.38 as=0.261 ps=2.38 w=0.9 l=0.35
X680 a_6247_8796# b5 a_363_6974# vss sky130_fd_pr__nfet_01v8_lvt ad=0.132 pd=1.13 as=0.248 ps=2.22 w=0.8 l=0.15
X681 a_15451_9310# a_20664_8208# vss sky130_fd_pr__res_high_po_0p69 l=7.2
X682 a_11215_10050# f3 a_7971_9376# vss sky130_fd_pr__nfet_01v8_lvt ad=0.145 pd=1.58 as=0.145 ps=1.58 w=0.5 l=0.15
X683 a_8935_6170# f1 a_4811_6504# vdd sky130_fd_pr__pfet_01v8_lvt ad=0.261 pd=2.38 as=0.261 ps=2.38 w=0.9 l=0.35
X684 a_3461_1968# a2 vss vss sky130_fd_pr__nfet_01v8 ad=0.1305 pd=1.48 as=0.1305 ps=1.48 w=0.45 l=0.18
X685 vdd a_9351_3750# vdd vdd sky130_fd_pr__pfet_01v8 ad=0.667 pd=5.18 as=0 ps=0 w=2.3 l=0.15
X686 a_11215_10050# a_11173_1814# a_4811_9376# vss sky130_fd_pr__nfet_01v8_lvt ad=0.145 pd=1.58 as=0.145 ps=1.58 w=0.5 l=0.15
X687 vss a_13911_3430# vss vss sky130_fd_pr__nfet_01v8_lvt ad=0.1595 pd=1.68 as=0 ps=0 w=0.55 l=0.15
X688 a_16191_6170# f7 a_7971_6504# vdd sky130_fd_pr__pfet_01v8_lvt ad=0.261 pd=2.38 as=0.261 ps=2.38 w=0.9 l=0.35
X689 a_21602_6694# a_21602_9194# vss vss sky130_fd_pr__nfet_01v8_lvt ad=0.5365 pd=4.28 as=0.5365 ps=4.28 w=1.85 l=0.15
X690 a_13171_1645# a_20664_1816# vss sky130_fd_pr__res_high_po_0p69 l=7.2
X691 a_363_6974# a_6621_1968# a_6247_4276# vdd sky130_fd_pr__pfet_01v8_lvt ad=0.609 pd=4.78 as=0.3045 ps=2.39 w=2.1 l=0.35
X692 a_8935_6170# f1 a_7971_6504# vss sky130_fd_pr__nfet_01v8_lvt ad=0.145 pd=1.58 as=0.145 ps=1.58 w=0.5 l=0.15
X693 a_4588_205# a5 vss vss sky130_fd_pr__nfet_01v8 ad=0.1305 pd=1.48 as=0.1305 ps=1.48 w=0.45 l=0.18
X694 a_10891_4790# a_8935_5530# vdd vdd sky130_fd_pr__pfet_01v8 ad=0.667 pd=5.18 as=0.667 ps=5.18 w=2.3 l=0.15
X695 a_11631_3750# f2 a_4811_4856# vss sky130_fd_pr__nfet_01v8_lvt ad=0.145 pd=1.58 as=0.145 ps=1.58 w=0.5 l=0.15
X696 a_17731_1645# a_20664_1816# vss sky130_fd_pr__res_high_po_0p69 l=7.2
X697 a_11215_10050# a_11173_1814# a_7971_9376# vdd sky130_fd_pr__pfet_01v8_lvt ad=0.261 pd=2.38 as=0.261 ps=2.38 w=0.9 l=0.35
X698 a_15775_3430# a_15733_3298# a_7971_1984# vdd sky130_fd_pr__pfet_01v8_lvt ad=0.261 pd=2.38 as=0.261 ps=2.38 w=0.9 l=0.35
X699 a_11631_10050# f3 a_7971_9376# vdd sky130_fd_pr__pfet_01v8_lvt ad=0.261 pd=2.38 as=0.261 ps=2.38 w=0.9 l=0.35
X700 a_6247_7364# a_6068_205# a_363_6974# vdd sky130_fd_pr__pfet_01v8_lvt ad=0.3045 pd=2.39 as=0.609 ps=4.78 w=2.1 l=0.35
X701 a_363_4366# a_4341_1968# a_3087_7364# vdd sky130_fd_pr__pfet_01v8_lvt ad=0.609 pd=4.78 as=0.3045 ps=2.39 w=2.1 l=0.35
X702 a_17731_7210# a_15775_7950# vss vss sky130_fd_pr__nfet_01v8_lvt ad=0.1595 pd=1.68 as=0.1595 ps=1.68 w=0.55 l=0.15
X703 a_20664_8208# vss sky130_fd_pr__cap_mim_m3_1 l=3.1 w=3.1
X704 a_8935_8270# a_8893_3298# a_4811_9376# vss sky130_fd_pr__nfet_01v8_lvt ad=0.145 pd=1.58 as=0.145 ps=1.58 w=0.5 l=0.15
X705 a_13171_7210# a_20664_6336# vss sky130_fd_pr__res_high_po_0p69 l=7.2
X706 a_21768_9194# a_21768_6694# vdd vdd sky130_fd_pr__pfet_01v8_lvt ad=0.26825 pd=2.14 as=0.26825 ps=2.14 w=1.85 l=0.35
X707 a_13171_4790# a_11215_5530# vdd vdd sky130_fd_pr__pfet_01v8 ad=0.667 pd=5.18 as=0.667 ps=5.18 w=2.3 l=0.15
X708 a_3087_4276# a_3901_1968# a_363_8526# vdd sky130_fd_pr__pfet_01v8_lvt ad=0.3045 pd=2.39 as=0.609 ps=4.78 w=2.1 l=0.35
X709 a_363_6974# c5 vdd vdd sky130_fd_pr__pfet_01v8_lvt ad=0.2465 pd=1.99 as=0.2465 ps=1.99 w=1.7 l=0.35
X710 a_8935_5530# f1 a_7971_4856# vss sky130_fd_pr__nfet_01v8_lvt ad=0.145 pd=1.58 as=0.145 ps=1.58 w=0.5 l=0.15
X711 a_13911_3750# f4 a_4811_4856# vss sky130_fd_pr__nfet_01v8_lvt ad=0.145 pd=1.58 as=0.145 ps=1.58 w=0.5 l=0.15
X712 a_4811_6504# a_3087_7364# vss vss sky130_fd_pr__nfet_01v8_lvt ad=0.165 pd=1.33 as=0.31 ps=2.62 w=1 l=0.15
X713 a_13495_3430# f4 a_7971_1984# vss sky130_fd_pr__nfet_01v8_lvt ad=0.145 pd=1.58 as=0.145 ps=1.58 w=0.5 l=0.15
X714 a_21768_4674# a_21768_2174# vdd vdd sky130_fd_pr__pfet_01v8_lvt ad=0.26825 pd=2.14 as=0.5365 ps=4.28 w=1.85 l=0.35
X715 a_13911_3430# a_13453_3298# a_7971_1984# vss sky130_fd_pr__nfet_01v8_lvt ad=0.145 pd=1.58 as=0.145 ps=1.58 w=0.5 l=0.15
X716 vdd a_11631_5530# vdd vdd sky130_fd_pr__pfet_01v8 ad=0.667 pd=5.18 as=0 ps=0 w=2.3 l=0.15
X717 a_4811_6504# a_3087_7364# vdd vdd sky130_fd_pr__pfet_01v8 ad=0.363 pd=2.53 as=0.682 ps=5.02 w=2.2 l=0.15
X718 a_21602_2174# a_21602_4674# vdd vdd sky130_fd_pr__pfet_01v8_lvt ad=0.26825 pd=2.14 as=0.26825 ps=2.14 w=1.85 l=0.35
X719 a_11215_7950# f2 a_7971_6504# vss sky130_fd_pr__nfet_01v8_lvt ad=0.145 pd=1.58 as=0.145 ps=1.58 w=0.5 l=0.15
X720 a_13495_3750# a_13453_3298# a_4811_4856# vss sky130_fd_pr__nfet_01v8_lvt ad=0.145 pd=1.58 as=0.145 ps=1.58 w=0.5 l=0.15
X721 a_3087_7364# a0 a_363_6446# vss sky130_fd_pr__nfet_01v8_lvt ad=0.132 pd=1.13 as=0.248 ps=2.22 w=0.8 l=0.15
X722 a_20664_3688# vss sky130_fd_pr__cap_mim_m3_1 l=3.1 w=3.1
X723 vss a_9351_1650# vss vss sky130_fd_pr__nfet_01v8_lvt ad=0.1595 pd=1.68 as=0 ps=0 w=0.55 l=0.15
X724 a_6247_8796# a_6068_205# a_363_2814# vdd sky130_fd_pr__pfet_01v8_lvt ad=0.3045 pd=2.39 as=0.609 ps=4.78 w=2.1 l=0.35
X725 vdd a_3087_2844# a_4811_1984# vdd sky130_fd_pr__pfet_01v8 ad=0.363 pd=2.53 as=0.363 ps=2.53 w=2.2 l=0.15
X726 a_6247_4276# a_7061_1968# a_363_9054# vdd sky130_fd_pr__pfet_01v8_lvt ad=0.3045 pd=2.39 as=0.609 ps=4.78 w=2.1 l=0.35
X727 a_7971_1984# a_6247_2844# vss vss sky130_fd_pr__nfet_01v8_lvt ad=0.165 pd=1.33 as=0.31 ps=2.62 w=1 l=0.15
X728 a_363_4894# b1 a_6247_4276# vss sky130_fd_pr__nfet_01v8_lvt ad=0.248 pd=2.22 as=0.132 ps=1.13 w=0.8 l=0.15
X729 vdd c4 a_363_6446# vdd sky130_fd_pr__pfet_01v8_lvt ad=0.2465 pd=1.99 as=0.2465 ps=1.99 w=1.7 l=0.35
X730 a_363_9054# b5 a_6247_4276# vss sky130_fd_pr__nfet_01v8_lvt ad=0.248 pd=2.22 as=0.132 ps=1.13 w=0.8 l=0.15
X731 a_363_8526# a_4341_1968# a_3087_8796# vdd sky130_fd_pr__pfet_01v8_lvt ad=0.609 pd=4.78 as=0.3045 ps=2.39 w=2.1 l=0.35
X732 vss a_3087_2844# a_4811_1984# vss sky130_fd_pr__nfet_01v8_lvt ad=0.31 pd=2.62 as=0.165 ps=1.33 w=1 l=0.15
X733 a_10891_9310# a_8935_10050# vss vss sky130_fd_pr__nfet_01v8_lvt ad=0.1595 pd=1.68 as=0.1595 ps=1.68 w=0.55 l=0.15
X734 a_9351_3750# f0 a_4811_4856# vss sky130_fd_pr__nfet_01v8_lvt ad=0.145 pd=1.58 as=0.145 ps=1.58 w=0.5 l=0.15
X735 a_9351_3750# a_8893_3298# a_7971_4856# vss sky130_fd_pr__nfet_01v8_lvt ad=0.145 pd=1.58 as=0.145 ps=1.58 w=0.5 l=0.15
.ends
