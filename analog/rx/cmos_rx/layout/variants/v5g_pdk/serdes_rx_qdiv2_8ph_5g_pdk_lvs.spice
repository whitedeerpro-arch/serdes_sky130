* NGSPICE file created from serdes_rx_qdiv2_8ph_5g_pdk.ext - technology: sky130A

.subckt serdes_rx_qdiv2_8ph_5g_pdk dp dn ep en rst_n ckd0 ckd1 ckd2 ckd3 cke0 cke1
+ cke2 cke3 vdd vss
X0 a_5719_n707# a_3421_n701# a_4622_n1478# vss sky130_fd_pr__nfet_01v8_lvt ad=0.231 pd=1.73 as=0.434 ps=3.42 w=1.4 l=0.15
X1 a_17221_80# a_16679_n707# vdd vdd sky130_fd_pr__pfet_01v8 ad=0.6293 pd=4.68 as=0.33495 ps=2.36 w=2.03 l=0.15
X2 vdd a_14547_n707# a_15469_n690# vdd sky130_fd_pr__pfet_01v8 ad=0.3465 pd=2.43 as=0.3465 ps=2.43 w=2.1 l=0.15
X3 ckd2 a_4651_80# vss vss sky130_fd_pr__nfet_01v8_lvt ad=0.198 pd=1.53 as=0.372 ps=3.02 w=1.2 l=0.15
X4 a_4119_n707# a_4089_n954# a_4027_n707# vdd sky130_fd_pr__pfet_01v8 ad=0.37455 pd=2.6 as=0.7037 ps=5.16 w=2.27 l=0.15
X5 a_17182_n1478# a_15981_n701# a_2901_80# vss sky130_fd_pr__nfet_01v8_lvt ad=0.434 pd=3.42 as=0.231 ps=1.73 w=1.4 l=0.15
X6 a_20827_n707# rst_n en vss sky130_fd_pr__nfet_01v8_lvt ad=0.2145 pd=1.63 as=0.403 ps=3.22 w=1.3 l=0.15
X7 a_5719_n707# a_4089_n954# a_4622_n1478# vdd sky130_fd_pr__pfet_01v8 ad=0.7037 pd=5.16 as=0.37455 ps=2.6 w=2.27 l=0.15
X8 a_5719_n707# a_10902_n1478# vdd vdd sky130_fd_pr__pfet_01v8 ad=0.58905 pd=3.9 as=1.1067 ps=7.76 w=3.57 l=0.15
X9 ckd0 ckd2 vss vss sky130_fd_pr__nfet_01v8_lvt ad=0.1305 pd=1.48 as=0.1305 ps=1.48 w=0.45 l=0.15
X10 a_4027_n707# a_15981_n701# a_23462_n1478# vdd sky130_fd_pr__pfet_01v8 ad=0.7037 pd=5.16 as=0.37455 ps=2.6 w=2.27 l=0.15
X11 a_16679_n707# a_16649_n954# a_4651_80# vdd sky130_fd_pr__pfet_01v8 ad=0.7037 pd=5.16 as=0.37455 ps=2.6 w=2.27 l=0.15
X12 a_17182_n1478# a_16649_n954# a_2901_80# vdd sky130_fd_pr__pfet_01v8 ad=0.37455 pd=2.6 as=0.37455 ps=2.6 w=2.27 l=0.15
X13 a_4089_n954# a_3421_n701# vss vss sky130_fd_pr__nfet_01v8_lvt ad=0.1305 pd=1.48 as=0.1305 ps=1.48 w=0.45 l=0.15
X14 a_18971_80# a_17182_n1478# vdd vdd sky130_fd_pr__pfet_01v8 ad=0.33495 pd=2.36 as=0.6293 ps=4.68 w=2.03 l=0.15
X15 vdd rst_n a_411_n680# vdd sky130_fd_pr__pfet_01v8 ad=0.62 pd=4.62 as=0.33 ps=2.33 w=2 l=0.15
X16 a_16649_n954# a_20335_171# vss vss sky130_fd_pr__nfet_01v8_lvt ad=0.17325 pd=1.38 as=0.3255 ps=2.72 w=1.05 l=0.15
X17 a_6055_171# a_2909_n690# vss vss sky130_fd_pr__nfet_01v8_lvt ad=0.1305 pd=1.48 as=0.1305 ps=1.48 w=0.45 l=0.15
X18 a_4622_n1478# a_4119_n707# vdd vdd sky130_fd_pr__pfet_01v8 ad=0.1218 pd=1.42 as=0.1218 ps=1.42 w=0.42 l=0.28
X19 a_5719_n707# a_16649_n954# a_22959_n707# vss sky130_fd_pr__nfet_01v8_lvt ad=0.434 pd=3.42 as=0.231 ps=1.73 w=1.4 l=0.15
X20 a_4027_n707# a_5719_n707# vss vss sky130_fd_pr__nfet_01v8_lvt ad=0.1218 pd=1.42 as=0.1218 ps=1.42 w=0.42 l=0.15
X21 a_16649_n954# a_15981_n701# vdd vdd sky130_fd_pr__pfet_01v8 ad=0.5481 pd=4.36 as=0.5481 ps=4.36 w=1.89 l=0.15
X22 a_3421_n701# a_2909_n690# vdd vdd sky130_fd_pr__pfet_01v8 ad=0.36465 pd=2.54 as=0.6851 ps=5.04 w=2.21 l=0.15
X23 a_6055_171# a_8267_n707# vdd vdd sky130_fd_pr__pfet_01v8 ad=0.3465 pd=2.43 as=0.651 ps=4.82 w=2.1 l=0.15
X24 a_22959_n707# a_16649_n954# a_5719_n707# vss sky130_fd_pr__nfet_01v8_lvt ad=0.231 pd=1.73 as=0.434 ps=3.42 w=1.4 l=0.15
X25 a_16649_n954# a_20335_171# vdd vdd sky130_fd_pr__pfet_01v8 ad=0.36465 pd=2.54 as=0.6851 ps=5.04 w=2.21 l=0.15
X26 ckd1 a_4027_n707# vdd vdd sky130_fd_pr__pfet_01v8 ad=0.4158 pd=2.85 as=0.7812 ps=5.66 w=2.52 l=0.15
X27 cke1 cke3 vdd vdd sky130_fd_pr__pfet_01v8 ad=0.5481 pd=4.36 as=0.5481 ps=4.36 w=1.89 l=0.15
X28 a_4622_n1478# a_3421_n701# a_5719_n707# vss sky130_fd_pr__nfet_01v8_lvt ad=0.434 pd=3.42 as=0.231 ps=1.73 w=1.4 l=0.15
X29 a_17221_80# a_16679_n707# vss vss sky130_fd_pr__nfet_01v8_lvt ad=0.4205 pd=3.48 as=0.4205 ps=3.48 w=1.45 l=0.15
X30 a_17221_80# a_16679_n707# vdd vdd sky130_fd_pr__pfet_01v8 ad=0.33495 pd=2.36 as=0.6293 ps=4.68 w=2.03 l=0.15
X31 ckd1 a_4027_n707# vdd vdd sky130_fd_pr__pfet_01v8 ad=0.4158 pd=2.85 as=0.4158 ps=2.85 w=2.52 l=0.15
X32 a_8267_n707# a_411_n680# dn vdd sky130_fd_pr__pfet_01v8_lvt ad=0.6583 pd=5.12 as=0.32915 ps=2.56 w=2.27 l=0.35
X33 a_15981_n701# a_16649_n954# vss vss sky130_fd_pr__nfet_01v8_lvt ad=0.1305 pd=1.48 as=0.1305 ps=1.48 w=0.45 l=0.15
X34 vdd a_10399_n707# a_4027_n707# vdd sky130_fd_pr__pfet_01v8 ad=1.1067 pd=7.76 as=0.58905 ps=3.9 w=3.57 l=0.15
X35 en rst_n a_20827_n707# vss sky130_fd_pr__nfet_01v8_lvt ad=0.403 pd=3.22 as=0.2145 ps=1.63 w=1.3 l=0.15
X36 a_16679_n707# a_17182_n1478# vss vss sky130_fd_pr__nfet_01v8 ad=0.1218 pd=1.42 as=0.1218 ps=1.42 w=0.42 l=0.28
X37 vdd a_4027_n707# ckd1 vdd sky130_fd_pr__pfet_01v8 ad=0.4158 pd=2.85 as=0.4158 ps=2.85 w=2.52 l=0.15
X38 vdd a_4027_n707# ckd1 vdd sky130_fd_pr__pfet_01v8 ad=0.7812 pd=5.66 as=0.4158 ps=2.85 w=2.52 l=0.15
X39 a_10399_n707# a_3421_n701# a_4651_80# vdd sky130_fd_pr__pfet_01v8 ad=0.37455 pd=2.6 as=0.7037 ps=5.16 w=2.27 l=0.15
X40 ckd1 ckd3 vss vss sky130_fd_pr__nfet_01v8_lvt ad=0.1305 pd=1.48 as=0.1305 ps=1.48 w=0.45 l=0.15
X41 a_2901_80# a_4119_n707# vdd vdd sky130_fd_pr__pfet_01v8 ad=0.58905 pd=3.9 as=1.1067 ps=7.76 w=3.57 l=0.15
X42 a_23221_80# a_24971_80# vdd vdd sky130_fd_pr__pfet_01v8 ad=0.5104 pd=4.1 as=0.5104 ps=4.1 w=1.76 l=0.15
X43 a_2901_80# a_4089_n954# a_10902_n1478# vss sky130_fd_pr__nfet_01v8_lvt ad=0.231 pd=1.73 as=0.434 ps=3.42 w=1.4 l=0.15
X44 vdd a_23462_n1478# a_24971_80# vdd sky130_fd_pr__pfet_01v8 ad=0.33495 pd=2.36 as=0.33495 ps=2.36 w=2.03 l=0.15
X45 a_6055_171# a_8267_n707# vss vss sky130_fd_pr__nfet_01v8_lvt ad=0.435 pd=3.58 as=0.435 ps=3.58 w=1.5 l=0.15
X46 vss a_20335_171# a_16649_n954# vss sky130_fd_pr__nfet_01v8_lvt ad=0.3255 pd=2.72 as=0.17325 ps=1.38 w=1.05 l=0.15
X47 a_15469_n690# a_20335_171# vdd vdd sky130_fd_pr__pfet_01v8 ad=0.5481 pd=4.36 as=0.5481 ps=4.36 w=1.89 l=0.15
X48 a_22959_n707# a_1418_n1530# vss vss sky130_fd_pr__nfet_01v8 ad=0.29 pd=2.58 as=0.29 ps=2.58 w=1 l=0.18
X49 a_20827_n707# rst_n vdd vdd sky130_fd_pr__pfet_01v8 ad=0.464 pd=3.78 as=0.464 ps=3.78 w=1.6 l=0.18
X50 a_15981_n701# a_15469_n690# vdd vdd sky130_fd_pr__pfet_01v8 ad=0.36465 pd=2.54 as=0.36465 ps=2.54 w=2.21 l=0.15
X51 a_4651_80# a_4622_n1478# vdd vdd sky130_fd_pr__pfet_01v8 ad=0.58905 pd=3.9 as=0.58905 ps=3.9 w=3.57 l=0.15
X52 vdd a_1987_n707# a_2909_n690# vdd sky130_fd_pr__pfet_01v8 ad=0.3465 pd=2.43 as=0.3465 ps=2.43 w=2.1 l=0.15
X53 a_2909_n690# a_1987_n707# vss vss sky130_fd_pr__nfet_01v8_lvt ad=0.435 pd=3.58 as=0.435 ps=3.58 w=1.5 l=0.15
X54 a_17182_n1478# a_1058_n1470# vdd vdd sky130_fd_pr__pfet_01v8 ad=0.522 pd=4.18 as=0.522 ps=4.18 w=1.8 l=0.18
X55 a_23221_80# a_22959_n707# vdd vdd sky130_fd_pr__pfet_01v8 ad=0.6293 pd=4.68 as=0.33495 ps=2.36 w=2.03 l=0.15
X56 vdd a_20827_n707# a_20335_171# vdd sky130_fd_pr__pfet_01v8 ad=0.3465 pd=2.43 as=0.3465 ps=2.43 w=2.1 l=0.15
X57 vdd a_2901_80# ckd0 vdd sky130_fd_pr__pfet_01v8 ad=0.4158 pd=2.85 as=0.4158 ps=2.85 w=2.52 l=0.15
X58 cke0 cke2 vdd vdd sky130_fd_pr__pfet_01v8 ad=0.5481 pd=4.36 as=0.5481 ps=4.36 w=1.89 l=0.15
X59 a_1418_n1530# a_1058_n1470# vdd vdd sky130_fd_pr__pfet_01v8 ad=0.87 pd=6.58 as=0.87 ps=6.58 w=3 l=0.18
X60 a_4119_n707# a_4622_n1478# vss vss sky130_fd_pr__nfet_01v8 ad=0.1218 pd=1.42 as=0.1218 ps=1.42 w=0.42 l=0.28
X61 a_10902_n1478# a_10399_n707# vdd vdd sky130_fd_pr__pfet_01v8 ad=0.1218 pd=1.42 as=0.1218 ps=1.42 w=0.42 l=0.28
X62 a_15469_n690# a_14547_n707# vdd vdd sky130_fd_pr__pfet_01v8 ad=0.3465 pd=2.43 as=0.651 ps=4.82 w=2.1 l=0.15
X63 vdd a_6055_171# a_4089_n954# vdd sky130_fd_pr__pfet_01v8 ad=0.6851 pd=5.04 as=0.36465 ps=2.54 w=2.21 l=0.15
X64 a_411_n680# rst_n vdd vdd sky130_fd_pr__pfet_01v8 ad=0.33 pd=2.33 as=0.62 ps=4.62 w=2 l=0.15
X65 a_8267_n707# rst_n dn vss sky130_fd_pr__nfet_01v8_lvt ad=0.2145 pd=1.63 as=0.403 ps=3.22 w=1.3 l=0.15
X66 cke1 a_23221_80# vdd vdd sky130_fd_pr__pfet_01v8 ad=0.4158 pd=2.85 as=0.7812 ps=5.66 w=2.52 l=0.15
X67 a_1058_n1470# a_411_n680# vss vss sky130_fd_pr__nfet_01v8 ad=0.174 pd=1.78 as=0.174 ps=1.78 w=0.6 l=0.18
X68 a_4622_n1478# a_4089_n954# a_5719_n707# vdd sky130_fd_pr__pfet_01v8 ad=0.37455 pd=2.6 as=0.37455 ps=2.6 w=2.27 l=0.15
X69 a_14547_n707# a_411_n680# ep vdd sky130_fd_pr__pfet_01v8_lvt ad=0.6583 pd=5.12 as=0.32915 ps=2.56 w=2.27 l=0.35
X70 a_23462_n1478# a_15981_n701# a_4027_n707# vdd sky130_fd_pr__pfet_01v8 ad=0.37455 pd=2.6 as=0.37455 ps=2.6 w=2.27 l=0.15
X71 a_4651_80# a_16649_n954# a_16679_n707# vdd sky130_fd_pr__pfet_01v8 ad=0.37455 pd=2.6 as=0.37455 ps=2.6 w=2.27 l=0.15
X72 cke1 a_23221_80# vdd vdd sky130_fd_pr__pfet_01v8 ad=0.4158 pd=2.85 as=0.4158 ps=2.85 w=2.52 l=0.15
X73 a_2901_80# a_16649_n954# a_17182_n1478# vdd sky130_fd_pr__pfet_01v8 ad=0.37455 pd=2.6 as=0.7037 ps=5.16 w=2.27 l=0.15
X74 a_10902_n1478# a_4089_n954# a_2901_80# vss sky130_fd_pr__nfet_01v8_lvt ad=0.434 pd=3.42 as=0.231 ps=1.73 w=1.4 l=0.15
X75 vdd a_23221_80# cke1 vdd sky130_fd_pr__pfet_01v8 ad=0.4158 pd=2.85 as=0.4158 ps=2.85 w=2.52 l=0.15
X76 vdd a_23221_80# cke1 vdd sky130_fd_pr__pfet_01v8 ad=0.7812 pd=5.66 as=0.4158 ps=2.85 w=2.52 l=0.15
X77 a_4027_n707# a_10399_n707# vdd vdd sky130_fd_pr__pfet_01v8 ad=0.58905 pd=3.9 as=1.1067 ps=7.76 w=3.57 l=0.15
X78 a_4651_80# a_2901_80# vdd vdd sky130_fd_pr__pfet_01v8 ad=0.5104 pd=4.1 as=0.5104 ps=4.1 w=1.76 l=0.15
X79 a_16649_n954# a_15981_n701# vss vss sky130_fd_pr__nfet_01v8_lvt ad=0.1305 pd=1.48 as=0.1305 ps=1.48 w=0.45 l=0.15
X80 a_24971_80# a_23221_80# vss vss sky130_fd_pr__nfet_01v8_lvt ad=0.1218 pd=1.42 as=0.1218 ps=1.42 w=0.42 l=0.15
X81 a_24971_80# a_23221_80# vdd vdd sky130_fd_pr__pfet_01v8 ad=0.5104 pd=4.1 as=0.5104 ps=4.1 w=1.76 l=0.15
X82 a_2909_n690# a_1987_n707# vdd vdd sky130_fd_pr__pfet_01v8 ad=0.651 pd=4.82 as=0.3465 ps=2.43 w=2.1 l=0.15
X83 a_3421_n701# a_2909_n690# vss vss sky130_fd_pr__nfet_01v8_lvt ad=0.17325 pd=1.38 as=0.3255 ps=2.72 w=1.05 l=0.15
X84 cke1 cke3 vss vss sky130_fd_pr__nfet_01v8_lvt ad=0.1305 pd=1.48 as=0.1305 ps=1.48 w=0.45 l=0.15
X85 a_23221_80# a_24971_80# vss vss sky130_fd_pr__nfet_01v8_lvt ad=0.1218 pd=1.42 as=0.1218 ps=1.42 w=0.42 l=0.15
X86 dn rst_n a_8267_n707# vss sky130_fd_pr__nfet_01v8_lvt ad=0.403 pd=3.22 as=0.2145 ps=1.63 w=1.3 l=0.15
X87 en a_411_n680# a_20827_n707# vdd sky130_fd_pr__pfet_01v8_lvt ad=0.32915 pd=2.56 as=0.32915 ps=2.56 w=2.27 l=0.35
X88 a_23462_n1478# a_22959_n707# vdd vdd sky130_fd_pr__pfet_01v8 ad=0.1218 pd=1.42 as=0.1218 ps=1.42 w=0.42 l=0.28
X89 vss a_2901_80# ckd0 vss sky130_fd_pr__nfet_01v8_lvt ad=0.372 pd=3.02 as=0.198 ps=1.53 w=1.2 l=0.15
X90 cke0 a_17221_80# vdd vdd sky130_fd_pr__pfet_01v8 ad=0.4158 pd=2.85 as=0.7812 ps=5.66 w=2.52 l=0.15
X91 a_4027_n707# a_5719_n707# vdd vdd sky130_fd_pr__pfet_01v8 ad=0.5104 pd=4.1 as=0.5104 ps=4.1 w=1.76 l=0.15
X92 cke0 a_17221_80# vdd vdd sky130_fd_pr__pfet_01v8 ad=0.4158 pd=2.85 as=0.4158 ps=2.85 w=2.52 l=0.15
X93 a_20335_171# a_15469_n690# vdd vdd sky130_fd_pr__pfet_01v8 ad=0.5481 pd=4.36 as=0.5481 ps=4.36 w=1.89 l=0.15
X94 a_3421_n701# a_2909_n690# vdd vdd sky130_fd_pr__pfet_01v8 ad=0.36465 pd=2.54 as=0.36465 ps=2.54 w=2.21 l=0.15
X95 a_24971_80# a_23462_n1478# vdd vdd sky130_fd_pr__pfet_01v8 ad=0.33495 pd=2.36 as=0.6293 ps=4.68 w=2.03 l=0.15
X96 vdd a_17221_80# cke0 vdd sky130_fd_pr__pfet_01v8 ad=0.4158 pd=2.85 as=0.4158 ps=2.85 w=2.52 l=0.15
X97 cke3 a_24971_80# vdd vdd sky130_fd_pr__pfet_01v8 ad=0.4158 pd=2.85 as=0.4158 ps=2.85 w=2.52 l=0.15
X98 a_16649_n954# a_20335_171# vdd vdd sky130_fd_pr__pfet_01v8 ad=0.36465 pd=2.54 as=0.36465 ps=2.54 w=2.21 l=0.15
X99 a_4089_n954# a_6055_171# vss vss sky130_fd_pr__nfet_01v8_lvt ad=0.17325 pd=1.38 as=0.3255 ps=2.72 w=1.05 l=0.15
X100 vdd a_15469_n690# a_15981_n701# vdd sky130_fd_pr__pfet_01v8 ad=0.36465 pd=2.54 as=0.36465 ps=2.54 w=2.21 l=0.15
X101 a_15469_n690# a_20335_171# vss vss sky130_fd_pr__nfet_01v8_lvt ad=0.1305 pd=1.48 as=0.1305 ps=1.48 w=0.45 l=0.15
X102 vdd a_17221_80# cke0 vdd sky130_fd_pr__pfet_01v8 ad=0.7812 pd=5.66 as=0.4158 ps=2.85 w=2.52 l=0.15
X103 vdd a_24971_80# cke3 vdd sky130_fd_pr__pfet_01v8 ad=0.4158 pd=2.85 as=0.4158 ps=2.85 w=2.52 l=0.15
X104 a_4622_n1478# a_1058_n1470# vdd vdd sky130_fd_pr__pfet_01v8 ad=0.522 pd=4.18 as=0.522 ps=4.18 w=1.8 l=0.18
X105 a_4089_n954# a_6055_171# vdd vdd sky130_fd_pr__pfet_01v8 ad=0.36465 pd=2.54 as=0.6851 ps=5.04 w=2.21 l=0.15
X106 a_4027_n707# a_16649_n954# a_23462_n1478# vss sky130_fd_pr__nfet_01v8_lvt ad=0.231 pd=1.73 as=0.434 ps=3.42 w=1.4 l=0.15
X107 vdd a_24971_80# cke3 vdd sky130_fd_pr__pfet_01v8 ad=0.7812 pd=5.66 as=0.4158 ps=2.85 w=2.52 l=0.15
X108 dp a_411_n680# a_1987_n707# vdd sky130_fd_pr__pfet_01v8_lvt ad=0.32915 pd=2.56 as=0.32915 ps=2.56 w=2.27 l=0.35
X109 vdd a_4622_n1478# a_4651_80# vdd sky130_fd_pr__pfet_01v8 ad=0.58905 pd=3.9 as=0.58905 ps=3.9 w=3.57 l=0.15
X110 a_23462_n1478# a_1058_n1470# vdd vdd sky130_fd_pr__pfet_01v8 ad=0.522 pd=4.18 as=0.522 ps=4.18 w=1.8 l=0.18
X111 a_2909_n690# a_1987_n707# vdd vdd sky130_fd_pr__pfet_01v8 ad=0.3465 pd=2.43 as=0.651 ps=4.82 w=2.1 l=0.15
X112 a_1418_n1530# a_1058_n1470# vss vss sky130_fd_pr__nfet_01v8 ad=0.348 pd=2.98 as=0.348 ps=2.98 w=1.2 l=0.18
X113 vss a_2909_n690# a_3421_n701# vss sky130_fd_pr__nfet_01v8_lvt ad=0.3255 pd=2.72 as=0.17325 ps=1.38 w=1.05 l=0.15
X114 a_4119_n707# a_1418_n1530# vss vss sky130_fd_pr__nfet_01v8 ad=0.29 pd=2.58 as=0.29 ps=2.58 w=1 l=0.18
X115 vdd a_22959_n707# a_23221_80# vdd sky130_fd_pr__pfet_01v8 ad=0.33495 pd=2.36 as=0.33495 ps=2.36 w=2.03 l=0.15
X116 a_20335_171# a_20827_n707# vdd vdd sky130_fd_pr__pfet_01v8 ad=0.3465 pd=2.43 as=0.651 ps=4.82 w=2.1 l=0.15
X117 vdd a_10902_n1478# a_5719_n707# vdd sky130_fd_pr__pfet_01v8 ad=1.1067 pd=7.76 as=0.58905 ps=3.9 w=3.57 l=0.15
X118 a_4119_n707# a_4622_n1478# vdd vdd sky130_fd_pr__pfet_01v8 ad=0.1218 pd=1.42 as=0.1218 ps=1.42 w=0.42 l=0.28
X119 a_2901_80# a_4119_n707# vss vss sky130_fd_pr__nfet_01v8_lvt ad=0.2805 pd=2.03 as=0.527 ps=4.02 w=1.7 l=0.15
X120 a_5719_n707# a_4027_n707# vdd vdd sky130_fd_pr__pfet_01v8 ad=0.5104 pd=4.1 as=0.5104 ps=4.1 w=1.76 l=0.15
X121 a_15469_n690# a_14547_n707# vss vss sky130_fd_pr__nfet_01v8_lvt ad=0.435 pd=3.58 as=0.435 ps=3.58 w=1.5 l=0.15
X122 vss a_10902_n1478# a_5719_n707# vss sky130_fd_pr__nfet_01v8_lvt ad=0.527 pd=4.02 as=0.2805 ps=2.03 w=1.7 l=0.15
X123 cke0 cke2 vss vss sky130_fd_pr__nfet_01v8_lvt ad=0.1305 pd=1.48 as=0.1305 ps=1.48 w=0.45 l=0.15
X124 ckd0 a_2901_80# vdd vdd sky130_fd_pr__pfet_01v8 ad=0.4158 pd=2.85 as=0.7812 ps=5.66 w=2.52 l=0.15
X125 a_5719_n707# a_10902_n1478# vss vss sky130_fd_pr__nfet_01v8_lvt ad=0.2805 pd=2.03 as=0.527 ps=4.02 w=1.7 l=0.15
X126 a_5719_n707# a_4089_n954# a_4622_n1478# vdd sky130_fd_pr__pfet_01v8 ad=0.37455 pd=2.6 as=0.7037 ps=5.16 w=2.27 l=0.15
X127 a_2901_80# a_4119_n707# vdd vdd sky130_fd_pr__pfet_01v8 ad=0.58905 pd=3.9 as=0.58905 ps=3.9 w=3.57 l=0.15
X128 a_4622_n1478# a_4119_n707# vss vss sky130_fd_pr__nfet_01v8 ad=0.1218 pd=1.42 as=0.1218 ps=1.42 w=0.42 l=0.28
X129 a_4027_n707# a_15981_n701# a_23462_n1478# vdd sky130_fd_pr__pfet_01v8 ad=0.37455 pd=2.6 as=0.7037 ps=5.16 w=2.27 l=0.15
X130 a_16679_n707# a_16649_n954# a_4651_80# vdd sky130_fd_pr__pfet_01v8 ad=0.37455 pd=2.6 as=0.7037 ps=5.16 w=2.27 l=0.15
X131 ckd3 a_5719_n707# vdd vdd sky130_fd_pr__pfet_01v8 ad=0.4158 pd=2.85 as=0.4158 ps=2.85 w=2.52 l=0.15
X132 a_18971_80# a_17182_n1478# vss vss sky130_fd_pr__nfet_01v8_lvt ad=0.4205 pd=3.48 as=0.4205 ps=3.48 w=1.45 l=0.15
X133 a_17182_n1478# a_16679_n707# vss vss sky130_fd_pr__nfet_01v8 ad=0.1218 pd=1.42 as=0.1218 ps=1.42 w=0.42 l=0.28
X134 vdd a_5719_n707# ckd3 vdd sky130_fd_pr__pfet_01v8 ad=0.4158 pd=2.85 as=0.4158 ps=2.85 w=2.52 l=0.15
X135 a_1987_n707# rst_n dp vss sky130_fd_pr__nfet_01v8_lvt ad=0.2145 pd=1.63 as=0.403 ps=3.22 w=1.3 l=0.15
X136 a_2901_80# a_3421_n701# a_10902_n1478# vdd sky130_fd_pr__pfet_01v8 ad=0.7037 pd=5.16 as=0.37455 ps=2.6 w=2.27 l=0.15
X137 a_10399_n707# a_10902_n1478# vss vss sky130_fd_pr__nfet_01v8 ad=0.1218 pd=1.42 as=0.1218 ps=1.42 w=0.42 l=0.28
X138 a_23221_80# a_22959_n707# vss vss sky130_fd_pr__nfet_01v8_lvt ad=0.4205 pd=3.48 as=0.4205 ps=3.48 w=1.45 l=0.15
X139 a_16679_n707# a_17182_n1478# vdd vdd sky130_fd_pr__pfet_01v8 ad=0.1218 pd=1.42 as=0.1218 ps=1.42 w=0.42 l=0.28
X140 vdd a_5719_n707# ckd3 vdd sky130_fd_pr__pfet_01v8 ad=0.7812 pd=5.66 as=0.4158 ps=2.85 w=2.52 l=0.15
X141 a_8267_n707# rst_n vdd vdd sky130_fd_pr__pfet_01v8 ad=0.464 pd=3.78 as=0.464 ps=3.78 w=1.6 l=0.18
X142 vss a_4027_n707# ckd1 vss sky130_fd_pr__nfet_01v8_lvt ad=0.372 pd=3.02 as=0.198 ps=1.53 w=1.2 l=0.15
X143 ckd2 ckd0 vdd vdd sky130_fd_pr__pfet_01v8 ad=0.5481 pd=4.36 as=0.5481 ps=4.36 w=1.89 l=0.15
X144 cke2 a_18971_80# vdd vdd sky130_fd_pr__pfet_01v8 ad=0.4158 pd=2.85 as=0.4158 ps=2.85 w=2.52 l=0.15
X145 vss a_6055_171# a_4089_n954# vss sky130_fd_pr__nfet_01v8_lvt ad=0.3255 pd=2.72 as=0.17325 ps=1.38 w=1.05 l=0.15
X146 a_23462_n1478# a_16649_n954# a_4027_n707# vss sky130_fd_pr__nfet_01v8_lvt ad=0.434 pd=3.42 as=0.231 ps=1.73 w=1.4 l=0.15
X147 a_14547_n707# rst_n ep vss sky130_fd_pr__nfet_01v8_lvt ad=0.2145 pd=1.63 as=0.403 ps=3.22 w=1.3 l=0.15
X148 ckd1 a_4027_n707# vss vss sky130_fd_pr__nfet_01v8_lvt ad=0.198 pd=1.53 as=0.372 ps=3.02 w=1.2 l=0.15
X149 a_4651_80# a_4622_n1478# vss vss sky130_fd_pr__nfet_01v8_lvt ad=0.2805 pd=2.03 as=0.527 ps=4.02 w=1.7 l=0.15
X150 vdd a_18971_80# cke2 vdd sky130_fd_pr__pfet_01v8 ad=0.4158 pd=2.85 as=0.4158 ps=2.85 w=2.52 l=0.15
X151 vdd a_18971_80# cke2 vdd sky130_fd_pr__pfet_01v8 ad=0.7812 pd=5.66 as=0.4158 ps=2.85 w=2.52 l=0.15
X152 a_411_n680# rst_n vdd vdd sky130_fd_pr__pfet_01v8 ad=0.33 pd=2.33 as=0.33 ps=2.33 w=2 l=0.15
X153 a_15981_n701# a_15469_n690# vdd vdd sky130_fd_pr__pfet_01v8 ad=0.36465 pd=2.54 as=0.6851 ps=5.04 w=2.21 l=0.15
X154 cke3 cke1 vdd vdd sky130_fd_pr__pfet_01v8 ad=0.5481 pd=4.36 as=0.5481 ps=4.36 w=1.89 l=0.15
X155 vss a_4119_n707# a_2901_80# vss sky130_fd_pr__nfet_01v8_lvt ad=0.527 pd=4.02 as=0.2805 ps=2.03 w=1.7 l=0.15
X156 a_4119_n707# a_3421_n701# a_4027_n707# vss sky130_fd_pr__nfet_01v8_lvt ad=0.231 pd=1.73 as=0.434 ps=3.42 w=1.4 l=0.15
X157 a_4651_80# a_2901_80# vss vss sky130_fd_pr__nfet_01v8_lvt ad=0.1218 pd=1.42 as=0.1218 ps=1.42 w=0.42 l=0.15
X158 a_24971_80# a_23462_n1478# vss vss sky130_fd_pr__nfet_01v8_lvt ad=0.4205 pd=3.48 as=0.4205 ps=3.48 w=1.45 l=0.15
X159 a_15981_n701# a_15469_n690# vss vss sky130_fd_pr__nfet_01v8_lvt ad=0.17325 pd=1.38 as=0.3255 ps=2.72 w=1.05 l=0.15
X160 a_4119_n707# a_4089_n954# a_4027_n707# vdd sky130_fd_pr__pfet_01v8 ad=0.7037 pd=5.16 as=0.37455 ps=2.6 w=2.27 l=0.15
X161 a_10399_n707# a_10902_n1478# vdd vdd sky130_fd_pr__pfet_01v8 ad=0.1218 pd=1.42 as=0.1218 ps=1.42 w=0.42 l=0.28
X162 a_22959_n707# a_15981_n701# a_5719_n707# vdd sky130_fd_pr__pfet_01v8 ad=0.7037 pd=5.16 as=0.37455 ps=2.6 w=2.27 l=0.15
X163 a_16679_n707# a_15981_n701# a_4651_80# vss sky130_fd_pr__nfet_01v8_lvt ad=0.231 pd=1.73 as=0.434 ps=3.42 w=1.4 l=0.15
X164 ckd2 a_4651_80# vdd vdd sky130_fd_pr__pfet_01v8 ad=0.4158 pd=2.85 as=0.7812 ps=5.66 w=2.52 l=0.15
X165 a_1058_n1470# a_411_n680# vdd vdd sky130_fd_pr__pfet_01v8 ad=0.435 pd=3.58 as=0.435 ps=3.58 w=1.5 l=0.18
X166 a_2901_80# a_3421_n701# a_10902_n1478# vdd sky130_fd_pr__pfet_01v8 ad=0.37455 pd=2.6 as=0.7037 ps=5.16 w=2.27 l=0.15
X167 a_4027_n707# a_10399_n707# vdd vdd sky130_fd_pr__pfet_01v8 ad=0.58905 pd=3.9 as=0.58905 ps=3.9 w=3.57 l=0.15
X168 a_10399_n707# a_1418_n1530# vss vss sky130_fd_pr__nfet_01v8 ad=0.29 pd=2.58 as=0.29 ps=2.58 w=1 l=0.18
X169 a_20335_171# a_15469_n690# vss vss sky130_fd_pr__nfet_01v8_lvt ad=0.1305 pd=1.48 as=0.1305 ps=1.48 w=0.45 l=0.15
X170 ckd2 a_4651_80# vdd vdd sky130_fd_pr__pfet_01v8 ad=0.4158 pd=2.85 as=0.4158 ps=2.85 w=2.52 l=0.15
X171 vdd a_2909_n690# a_3421_n701# vdd sky130_fd_pr__pfet_01v8 ad=0.36465 pd=2.54 as=0.36465 ps=2.54 w=2.21 l=0.15
X172 dp rst_n a_1987_n707# vss sky130_fd_pr__nfet_01v8_lvt ad=0.403 pd=3.22 as=0.2145 ps=1.63 w=1.3 l=0.15
X173 vdd a_4651_80# ckd2 vdd sky130_fd_pr__pfet_01v8 ad=0.4158 pd=2.85 as=0.4158 ps=2.85 w=2.52 l=0.15
X174 vdd a_20335_171# a_16649_n954# vdd sky130_fd_pr__pfet_01v8 ad=0.36465 pd=2.54 as=0.36465 ps=2.54 w=2.21 l=0.15
X175 ckd0 a_2901_80# vss vss sky130_fd_pr__nfet_01v8_lvt ad=0.198 pd=1.53 as=0.372 ps=3.02 w=1.2 l=0.15
X176 a_8267_n707# a_411_n680# dn vdd sky130_fd_pr__pfet_01v8_lvt ad=0.32915 pd=2.56 as=0.6583 ps=5.12 w=2.27 l=0.35
X177 a_18971_80# a_17182_n1478# vdd vdd sky130_fd_pr__pfet_01v8 ad=0.6293 pd=4.68 as=0.33495 ps=2.36 w=2.03 l=0.15
X178 ep rst_n a_14547_n707# vss sky130_fd_pr__nfet_01v8_lvt ad=0.403 pd=3.22 as=0.2145 ps=1.63 w=1.3 l=0.15
X179 vdd a_4651_80# ckd2 vdd sky130_fd_pr__pfet_01v8 ad=0.7812 pd=5.66 as=0.4158 ps=2.85 w=2.52 l=0.15
X180 a_3421_n701# a_4089_n954# vdd vdd sky130_fd_pr__pfet_01v8 ad=0.5481 pd=4.36 as=0.5481 ps=4.36 w=1.89 l=0.15
X181 cke3 a_24971_80# vdd vdd sky130_fd_pr__pfet_01v8 ad=0.4158 pd=2.85 as=0.7812 ps=5.66 w=2.52 l=0.15
X182 vss a_4622_n1478# a_4651_80# vss sky130_fd_pr__nfet_01v8_lvt ad=0.527 pd=4.02 as=0.2805 ps=2.03 w=1.7 l=0.15
X183 a_22959_n707# a_23462_n1478# vss vss sky130_fd_pr__nfet_01v8 ad=0.1218 pd=1.42 as=0.1218 ps=1.42 w=0.42 l=0.28
X184 a_6055_171# a_8267_n707# vdd vdd sky130_fd_pr__pfet_01v8 ad=0.651 pd=4.82 as=0.3465 ps=2.43 w=2.1 l=0.15
X185 vss a_23221_80# cke1 vss sky130_fd_pr__nfet_01v8_lvt ad=0.372 pd=3.02 as=0.198 ps=1.53 w=1.2 l=0.15
X186 a_23221_80# a_22959_n707# vdd vdd sky130_fd_pr__pfet_01v8 ad=0.33495 pd=2.36 as=0.6293 ps=4.68 w=2.03 l=0.15
X187 a_2909_n690# a_6055_171# vdd vdd sky130_fd_pr__pfet_01v8 ad=0.5481 pd=4.36 as=0.5481 ps=4.36 w=1.89 l=0.15
X188 cke1 a_23221_80# vss vss sky130_fd_pr__nfet_01v8_lvt ad=0.198 pd=1.53 as=0.372 ps=3.02 w=1.2 l=0.15
X189 ckd3 ckd1 vdd vdd sky130_fd_pr__pfet_01v8 ad=0.5481 pd=4.36 as=0.5481 ps=4.36 w=1.89 l=0.15
X190 cke2 cke0 vdd vdd sky130_fd_pr__pfet_01v8 ad=0.5481 pd=4.36 as=0.5481 ps=4.36 w=1.89 l=0.15
X191 a_4027_n707# a_3421_n701# a_4119_n707# vss sky130_fd_pr__nfet_01v8_lvt ad=0.434 pd=3.42 as=0.231 ps=1.73 w=1.4 l=0.15
X192 a_16679_n707# a_1418_n1530# vss vss sky130_fd_pr__nfet_01v8 ad=0.29 pd=2.58 as=0.29 ps=2.58 w=1 l=0.18
X193 vss a_15469_n690# a_15981_n701# vss sky130_fd_pr__nfet_01v8_lvt ad=0.3255 pd=2.72 as=0.17325 ps=1.38 w=1.05 l=0.15
X194 vdd a_4119_n707# a_2901_80# vdd sky130_fd_pr__pfet_01v8 ad=0.58905 pd=3.9 as=0.58905 ps=3.9 w=3.57 l=0.15
X195 a_22959_n707# a_15981_n701# a_5719_n707# vdd sky130_fd_pr__pfet_01v8 ad=0.37455 pd=2.6 as=0.7037 ps=5.16 w=2.27 l=0.15
X196 a_4651_80# a_15981_n701# a_16679_n707# vss sky130_fd_pr__nfet_01v8_lvt ad=0.434 pd=3.42 as=0.231 ps=1.73 w=1.4 l=0.15
X197 a_1987_n707# a_411_n680# vss vss sky130_fd_pr__nfet_01v8 ad=0.232 pd=2.18 as=0.232 ps=2.18 w=0.8 l=0.18
X198 a_1987_n707# a_411_n680# dp vdd sky130_fd_pr__pfet_01v8_lvt ad=0.32915 pd=2.56 as=0.6583 ps=5.12 w=2.27 l=0.35
X199 a_10399_n707# a_3421_n701# a_4651_80# vdd sky130_fd_pr__pfet_01v8 ad=0.7037 pd=5.16 as=0.37455 ps=2.6 w=2.27 l=0.15
X200 a_22959_n707# a_23462_n1478# vdd vdd sky130_fd_pr__pfet_01v8 ad=0.1218 pd=1.42 as=0.1218 ps=1.42 w=0.42 l=0.28
X201 vdd a_15469_n690# a_15981_n701# vdd sky130_fd_pr__pfet_01v8 ad=0.6851 pd=5.04 as=0.36465 ps=2.54 w=2.21 l=0.15
X202 ckd3 a_5719_n707# vdd vdd sky130_fd_pr__pfet_01v8 ad=0.4158 pd=2.85 as=0.7812 ps=5.66 w=2.52 l=0.15
X203 a_411_n680# rst_n vss vss sky130_fd_pr__nfet_01v8_lvt ad=0.165 pd=1.33 as=0.31 ps=2.62 w=1 l=0.15
X204 vdd a_4622_n1478# a_4651_80# vdd sky130_fd_pr__pfet_01v8 ad=1.1067 pd=7.76 as=0.58905 ps=3.9 w=3.57 l=0.15
X205 a_4089_n954# a_6055_171# vdd vdd sky130_fd_pr__pfet_01v8 ad=0.36465 pd=2.54 as=0.36465 ps=2.54 w=2.21 l=0.15
X206 a_10902_n1478# a_3421_n701# a_2901_80# vdd sky130_fd_pr__pfet_01v8 ad=0.37455 pd=2.6 as=0.37455 ps=2.6 w=2.27 l=0.15
X207 a_4027_n707# a_10399_n707# vss vss sky130_fd_pr__nfet_01v8_lvt ad=0.2805 pd=2.03 as=0.527 ps=4.02 w=1.7 l=0.15
X208 ckd2 ckd0 vss vss sky130_fd_pr__nfet_01v8_lvt ad=0.1305 pd=1.48 as=0.1305 ps=1.48 w=0.45 l=0.15
X209 dn a_411_n680# a_8267_n707# vdd sky130_fd_pr__pfet_01v8_lvt ad=0.32915 pd=2.56 as=0.32915 ps=2.56 w=2.27 l=0.35
X210 cke2 a_18971_80# vdd vdd sky130_fd_pr__pfet_01v8 ad=0.4158 pd=2.85 as=0.7812 ps=5.66 w=2.52 l=0.15
X211 a_10902_n1478# a_10399_n707# vss vss sky130_fd_pr__nfet_01v8 ad=0.1218 pd=1.42 as=0.1218 ps=1.42 w=0.42 l=0.28
X212 a_14547_n707# a_411_n680# ep vdd sky130_fd_pr__pfet_01v8_lvt ad=0.32915 pd=2.56 as=0.6583 ps=5.12 w=2.27 l=0.35
X213 vdd rst_n a_411_n680# vdd sky130_fd_pr__pfet_01v8 ad=0.33 pd=2.33 as=0.33 ps=2.33 w=2 l=0.15
X214 a_18971_80# a_17221_80# vdd vdd sky130_fd_pr__pfet_01v8 ad=0.5104 pd=4.1 as=0.5104 ps=4.1 w=1.76 l=0.15
X215 vss a_17221_80# cke0 vss sky130_fd_pr__nfet_01v8_lvt ad=0.372 pd=3.02 as=0.198 ps=1.53 w=1.2 l=0.15
X216 cke3 cke1 vss vss sky130_fd_pr__nfet_01v8_lvt ad=0.1305 pd=1.48 as=0.1305 ps=1.48 w=0.45 l=0.15
X217 cke0 a_17221_80# vss vss sky130_fd_pr__nfet_01v8_lvt ad=0.198 pd=1.53 as=0.372 ps=3.02 w=1.2 l=0.15
X218 vss a_24971_80# cke3 vss sky130_fd_pr__nfet_01v8_lvt ad=0.372 pd=3.02 as=0.198 ps=1.53 w=1.2 l=0.15
X219 a_1987_n707# a_411_n680# dp vdd sky130_fd_pr__pfet_01v8_lvt ad=0.6583 pd=5.12 as=0.32915 ps=2.56 w=2.27 l=0.35
X220 a_15469_n690# a_14547_n707# vdd vdd sky130_fd_pr__pfet_01v8 ad=0.651 pd=4.82 as=0.3465 ps=2.43 w=2.1 l=0.15
X221 a_4027_n707# a_4089_n954# a_4119_n707# vdd sky130_fd_pr__pfet_01v8 ad=0.37455 pd=2.6 as=0.37455 ps=2.6 w=2.27 l=0.15
X222 a_20827_n707# a_411_n680# en vdd sky130_fd_pr__pfet_01v8_lvt ad=0.6583 pd=5.12 as=0.32915 ps=2.56 w=2.27 l=0.35
X223 a_17182_n1478# a_16679_n707# vdd vdd sky130_fd_pr__pfet_01v8 ad=0.1218 pd=1.42 as=0.1218 ps=1.42 w=0.42 l=0.28
X224 cke3 a_24971_80# vss vss sky130_fd_pr__nfet_01v8_lvt ad=0.198 pd=1.53 as=0.372 ps=3.02 w=1.2 l=0.15
X225 vdd a_10902_n1478# a_5719_n707# vdd sky130_fd_pr__pfet_01v8 ad=0.58905 pd=3.9 as=0.58905 ps=3.9 w=3.57 l=0.15
X226 a_5719_n707# a_15981_n701# a_22959_n707# vdd sky130_fd_pr__pfet_01v8 ad=0.37455 pd=2.6 as=0.37455 ps=2.6 w=2.27 l=0.15
X227 ckd0 ckd2 vdd vdd sky130_fd_pr__pfet_01v8 ad=0.5481 pd=4.36 as=0.5481 ps=4.36 w=1.89 l=0.15
X228 vdd a_10399_n707# a_4027_n707# vdd sky130_fd_pr__pfet_01v8 ad=0.58905 pd=3.9 as=0.58905 ps=3.9 w=3.57 l=0.15
X229 a_4089_n954# a_3421_n701# vdd vdd sky130_fd_pr__pfet_01v8 ad=0.5481 pd=4.36 as=0.5481 ps=4.36 w=1.89 l=0.15
X230 vss rst_n a_411_n680# vss sky130_fd_pr__nfet_01v8_lvt ad=0.31 pd=2.62 as=0.165 ps=1.33 w=1 l=0.15
X231 a_17221_80# a_18971_80# vss vss sky130_fd_pr__nfet_01v8_lvt ad=0.1218 pd=1.42 as=0.1218 ps=1.42 w=0.42 l=0.15
X232 a_2901_80# a_16649_n954# a_17182_n1478# vdd sky130_fd_pr__pfet_01v8 ad=0.7037 pd=5.16 as=0.37455 ps=2.6 w=2.27 l=0.15
X233 vss a_10399_n707# a_4027_n707# vss sky130_fd_pr__nfet_01v8_lvt ad=0.527 pd=4.02 as=0.2805 ps=2.03 w=1.7 l=0.15
X234 vdd a_17182_n1478# a_18971_80# vdd sky130_fd_pr__pfet_01v8 ad=0.33495 pd=2.36 as=0.33495 ps=2.36 w=2.03 l=0.15
X235 a_5719_n707# a_4027_n707# vss vss sky130_fd_pr__nfet_01v8_lvt ad=0.1218 pd=1.42 as=0.1218 ps=1.42 w=0.42 l=0.15
X236 a_10399_n707# a_4089_n954# a_4651_80# vss sky130_fd_pr__nfet_01v8_lvt ad=0.231 pd=1.73 as=0.434 ps=3.42 w=1.4 l=0.15
X237 a_3421_n701# a_4089_n954# vss vss sky130_fd_pr__nfet_01v8_lvt ad=0.1305 pd=1.48 as=0.1305 ps=1.48 w=0.45 l=0.15
X238 a_6055_171# a_2909_n690# vdd vdd sky130_fd_pr__pfet_01v8 ad=0.5481 pd=4.36 as=0.5481 ps=4.36 w=1.89 l=0.15
X239 vdd a_8267_n707# a_6055_171# vdd sky130_fd_pr__pfet_01v8 ad=0.3465 pd=2.43 as=0.3465 ps=2.43 w=2.1 l=0.15
X240 vss a_5719_n707# ckd3 vss sky130_fd_pr__nfet_01v8_lvt ad=0.372 pd=3.02 as=0.198 ps=1.53 w=1.2 l=0.15
X241 ep a_411_n680# a_14547_n707# vdd sky130_fd_pr__pfet_01v8_lvt ad=0.32915 pd=2.56 as=0.32915 ps=2.56 w=2.27 l=0.35
X242 a_23462_n1478# a_22959_n707# vss vss sky130_fd_pr__nfet_01v8 ad=0.1218 pd=1.42 as=0.1218 ps=1.42 w=0.42 l=0.28
X243 a_2909_n690# a_6055_171# vss vss sky130_fd_pr__nfet_01v8_lvt ad=0.1305 pd=1.48 as=0.1305 ps=1.48 w=0.45 l=0.15
X244 ckd3 a_5719_n707# vss vss sky130_fd_pr__nfet_01v8_lvt ad=0.198 pd=1.53 as=0.372 ps=3.02 w=1.2 l=0.15
X245 a_10902_n1478# a_1058_n1470# vdd vdd sky130_fd_pr__pfet_01v8 ad=0.522 pd=4.18 as=0.522 ps=4.18 w=1.8 l=0.18
X246 vdd a_16679_n707# a_17221_80# vdd sky130_fd_pr__pfet_01v8 ad=0.33495 pd=2.36 as=0.33495 ps=2.36 w=2.03 l=0.15
X247 ckd3 ckd1 vss vss sky130_fd_pr__nfet_01v8_lvt ad=0.1305 pd=1.48 as=0.1305 ps=1.48 w=0.45 l=0.15
X248 cke2 cke0 vss vss sky130_fd_pr__nfet_01v8_lvt ad=0.1305 pd=1.48 as=0.1305 ps=1.48 w=0.45 l=0.15
X249 a_15981_n701# a_16649_n954# vdd vdd sky130_fd_pr__pfet_01v8 ad=0.5481 pd=4.36 as=0.5481 ps=4.36 w=1.89 l=0.15
X250 a_2901_80# a_4651_80# vdd vdd sky130_fd_pr__pfet_01v8 ad=0.5104 pd=4.1 as=0.5104 ps=4.1 w=1.76 l=0.15
X251 a_4651_80# a_4622_n1478# vdd vdd sky130_fd_pr__pfet_01v8 ad=0.58905 pd=3.9 as=1.1067 ps=7.76 w=3.57 l=0.15
X252 a_2901_80# a_15981_n701# a_17182_n1478# vss sky130_fd_pr__nfet_01v8_lvt ad=0.231 pd=1.73 as=0.434 ps=3.42 w=1.4 l=0.15
X253 vss a_18971_80# cke2 vss sky130_fd_pr__nfet_01v8_lvt ad=0.372 pd=3.02 as=0.198 ps=1.53 w=1.2 l=0.15
X254 vdd a_2909_n690# a_3421_n701# vdd sky130_fd_pr__pfet_01v8 ad=0.6851 pd=5.04 as=0.36465 ps=2.54 w=2.21 l=0.15
X255 cke2 a_18971_80# vss vss sky130_fd_pr__nfet_01v8_lvt ad=0.198 pd=1.53 as=0.372 ps=3.02 w=1.2 l=0.15
X256 a_18971_80# a_17221_80# vss vss sky130_fd_pr__nfet_01v8_lvt ad=0.1218 pd=1.42 as=0.1218 ps=1.42 w=0.42 l=0.15
X257 vdd a_20335_171# a_16649_n954# vdd sky130_fd_pr__pfet_01v8 ad=0.6851 pd=5.04 as=0.36465 ps=2.54 w=2.21 l=0.15
X258 a_4651_80# a_3421_n701# a_10399_n707# vdd sky130_fd_pr__pfet_01v8 ad=0.37455 pd=2.6 as=0.37455 ps=2.6 w=2.27 l=0.15
X259 a_2901_80# a_4651_80# vss vss sky130_fd_pr__nfet_01v8_lvt ad=0.1218 pd=1.42 as=0.1218 ps=1.42 w=0.42 l=0.15
X260 a_5719_n707# a_10902_n1478# vdd vdd sky130_fd_pr__pfet_01v8 ad=0.58905 pd=3.9 as=0.58905 ps=3.9 w=3.57 l=0.15
X261 ckd1 ckd3 vdd vdd sky130_fd_pr__pfet_01v8 ad=0.5481 pd=4.36 as=0.5481 ps=4.36 w=1.89 l=0.15
X262 vdd a_6055_171# a_4089_n954# vdd sky130_fd_pr__pfet_01v8 ad=0.36465 pd=2.54 as=0.36465 ps=2.54 w=2.21 l=0.15
X263 a_14547_n707# a_411_n680# vss vss sky130_fd_pr__nfet_01v8 ad=0.232 pd=2.18 as=0.232 ps=2.18 w=0.8 l=0.18
X264 a_4651_80# a_4089_n954# a_10399_n707# vss sky130_fd_pr__nfet_01v8_lvt ad=0.434 pd=3.42 as=0.231 ps=1.73 w=1.4 l=0.15
X265 a_24971_80# a_23462_n1478# vdd vdd sky130_fd_pr__pfet_01v8 ad=0.6293 pd=4.68 as=0.33495 ps=2.36 w=2.03 l=0.15
X266 a_20335_171# a_20827_n707# vss vss sky130_fd_pr__nfet_01v8_lvt ad=0.435 pd=3.58 as=0.435 ps=3.58 w=1.5 l=0.15
X267 a_17221_80# a_18971_80# vdd vdd sky130_fd_pr__pfet_01v8 ad=0.5104 pd=4.1 as=0.5104 ps=4.1 w=1.76 l=0.15
X268 ckd0 a_2901_80# vdd vdd sky130_fd_pr__pfet_01v8 ad=0.4158 pd=2.85 as=0.4158 ps=2.85 w=2.52 l=0.15
X269 a_20827_n707# a_411_n680# en vdd sky130_fd_pr__pfet_01v8_lvt ad=0.32915 pd=2.56 as=0.6583 ps=5.12 w=2.27 l=0.35
X270 vdd a_2901_80# ckd0 vdd sky130_fd_pr__pfet_01v8 ad=0.7812 pd=5.66 as=0.4158 ps=2.85 w=2.52 l=0.15
X271 vdd a_4119_n707# a_2901_80# vdd sky130_fd_pr__pfet_01v8 ad=1.1067 pd=7.76 as=0.58905 ps=3.9 w=3.57 l=0.15
X272 vss a_4651_80# ckd2 vss sky130_fd_pr__nfet_01v8_lvt ad=0.372 pd=3.02 as=0.198 ps=1.53 w=1.2 l=0.15
X273 a_20335_171# a_20827_n707# vdd vdd sky130_fd_pr__pfet_01v8 ad=0.651 pd=4.82 as=0.3465 ps=2.43 w=2.1 l=0.15
.ends
