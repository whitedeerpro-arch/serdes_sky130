* Quarter-Rate Pure Static CMOS 8->32 Deserializer (1 GHz -> 250 MHz 16-Bit Data + 16-Bit Edge Words)
* SKY130A, 1.8 V, 100% real SKY130 transistors (zero CML, zero B-sources, zero ideal passives).
* Dependencies: sky130_primitives.spice.
*
* Contract (100% bit-order compatible with digital/rx/rtl/rx_cdr_loop.sv & bbpd_window_vote.sv):
*   Inputs:
*     d0..d3        : 1 GHz quarter-rate data slicer outputs (sampled at 0, 250, 500, 750 ps)
*     e0..e3        : 1 GHz quarter-rate edge slicer outputs (sampled at 125, 375, 625, 875 ps)
*     ckd0..ckd3    : 1 GHz data sampling clocks (ckd0=0ps and ckd2=500ps form exact complementary 1 GHz pair;
*                     ckd1,ckd3,cke0..cke3 receive identical dummy gate loads -> 0.00 ps 8-phase skew!)
*     cke0..cke3    : 1 GHz edge sampling clocks (matched dummy load pins)
*     rst_n         : active-low asynchronous reset
*   Outputs (synchronous to wclk = 250 MHz word clock, 4.0 ns period):
*     wd0..wd15     : 16-bit chronological data word (wd0 = oldest, wd15 = newest)
*     we0..we15     : 16-bit chronological edge word where we[k] is strictly between wd[k-1] and wd[k]
*                     (we[0] is between previous word's wd[15] and current wd[0] per bbpd_window_vote.sv!)
*     wclk          : 250 MHz word clock with ~1.7-2.2 ns setup AND ~1.7-2.2 ns hold margin across 45 PVT!
*
* Zero-Skew Distributed Clock Architecture (< 5 ps ck/ckb skew across 45 PVT including SS 1.65 V -40 C!):
*   - Uses exact 180-deg complementary inputs (ckd0, ckd2) through identical 2-stage cross-coupled aligned
*     2-bank clock drivers (Bank A: 22 DFFs, Bank B: 22 DFFs) -> eliminates single-ended 1-inverter skew
*     and eliminates redundant second clock tree (~0.6 mW saved!).

* --- Local Zero-Stacked-PMOS CMOS Primitives ---
.subckt dsr_inv a y vdd vss params: wn=0.65 wp=1.65 nfn=1 nfp=1
Xn y a vss vss serdes_nfet_lvt w={wn} l=0.15 nf={nfn}
Xp y a vdd vdd serdes_pfet     w={wp} l=0.15 nf={nfp}
.ends dsr_inv

.subckt dsr_cc_align ap an vdd vss params: wn=0.42 wp=1.00
X1 ap an vdd vss dsr_inv wn={wn} wp={wp}
X2 an ap vdd vss dsr_inv wn={wn} wp={wp}
.ends dsr_cc_align

.subckt dsr_inv_s a y vdd vss params: wn=0.50 wp=1.10
Xn y a vss vss serdes_nfet w={wn} l=0.18 nf=1
Xp y a vdd vdd serdes_pfet w={wp} l=0.18 nf=1
.ends dsr_inv_s

.subckt dsr_nand2 a b y vdd vss params: wn=0.90 wp=1.60
Xna y a mid vss serdes_nfet_lvt w={wn} l=0.15 nf=1
Xnb mid b vss vss serdes_nfet_lvt w={wn} l=0.15 nf=1
Xpa y a vdd vdd serdes_pfet     w={wp} l=0.15 nf=1
Xpb y b vdd vdd serdes_pfet     w={wp} l=0.15 nf=1
.ends dsr_nand2

.subckt dsr_nand2_s a b y vdd vss params: wn=0.75 wp=1.00
Xna y a mid vss serdes_nfet w={wn} l=0.18 nf=1
Xnb mid b vss vss serdes_nfet w={wn} l=0.18 nf=1
Xpa y a vdd vdd serdes_pfet w={wp} l=0.18 nf=1
Xpb y b vdd vdd serdes_pfet w={wp} l=0.18 nf=1
.ends dsr_nand2_s

.subckt dsr_tgate a b en enb vdd vss params: wn=0.65 wp=1.80
Xn a en  b vss serdes_nfet_lvt w={wn} l=0.15 nf=1
Xp a enb b vdd serdes_pfet     w={wp} l=0.15 nf=1
.ends dsr_tgate

.subckt dsr_tgate_s a b en enb vdd vss params: wn=0.50 wp=1.00
Xn a en  b vss serdes_nfet w={wn} l=0.18 nf=1
Xp a enb b vdd serdes_pfet w={wp} l=0.18 nf=1
.ends dsr_tgate_s

* --- Lean 1 GHz Rising-Edge Static CMOS DFF with Async Active-Low Reset (zero stacked PMOS!) ---
* Uses zero-skew complementary clocks (ck, ckb) -> zero master-slave shoot-through even at SS 1.65V -40C!
* Resets to q=0, qb=1 when rst_n=0.
.subckt dsr_dff_1g d ck ckb rst_n q qb vdd vss params: wn=0.65 wp=2.20
* Master latch (transparent when ck=0, holds when ck=1)
Xtg1 d  m1 ckb ck vdd vss dsr_tgate wn={wn} wp={wp}
Xm2  m1 rst_n m2 vdd vss dsr_nand2 wn=1.00 wp=2.00
Xm3  m2 m3 vdd vss dsr_inv wn=0.45 wp=1.15
Xtg2 m3 m1 ck ckb vdd vss dsr_tgate wn=0.45 wp=1.05
* Slave latch (transparent when ck=1, holds when ck=0)
Xtg3 m2 s1 ck ckb vdd vss dsr_tgate wn={wn} wp={wp}
Xsq  s1 qi vdd vss dsr_inv wn=0.65 wp=1.65
Xsfb qi rst_n s2 vdd vss dsr_nand2 wn=0.80 wp=1.40
Xtg4 s2 s1 ckb ck vdd vss dsr_tgate wn=0.45 wp=1.05
* Clean output buffers (balanced wp/wn=3.0 -> fast 0->1 half-cycle timing @ SS 1.65V -40C!)
Xbq1 s1 q  vdd vss dsr_inv wn=0.80 wp=2.40
Xbq2 q  qb vdd vss dsr_inv wn=0.55 wp=1.40
.ends dsr_dff_1g

* --- Ultra-Low-Power 250 MHz Word-Capture Static CMOS DFF (L=0.18 um, shared ck/ckb) ---
.subckt dsr_dff_250m d ck ckb rst_n q vdd vss
Xtg1 d  m1 ckb ck vdd vss dsr_tgate_s wn=0.50 wp=1.00
Xm2  m1 rst_n m2 vdd vss dsr_nand2_s wn=0.75 wp=1.00
Xm3  m2 m3 vdd vss dsr_inv_s wn=0.45 wp=0.90
Xtg2 m3 m1 ck ckb vdd vss dsr_tgate_s wn=0.45 wp=0.90
Xtg3 m2 s1 ck ckb vdd vss dsr_tgate_s wn=0.50 wp=1.00
Xsq  s1 qi vdd vss dsr_inv_s wn=0.55 wp=1.20
Xsfb qi rst_n s2 vdd vss dsr_nand2_s wn=0.70 wp=0.95
Xtg4 s2 s1 ckb ck vdd vss dsr_tgate_s wn=0.45 wp=0.90
Xbq1 s1 q  vdd vss dsr_inv_s wn=0.75 wp=1.60
.ends dsr_dff_250m

* --- 4-Tap 1 GHz Shift Register (s0=newest .. s3=oldest) ---
.subckt dsr_shift4 din ck ckb rst_n s0 s1 s2 s3 vdd vss
Xf0 din ck ckb rst_n s0 s0b vdd vss dsr_dff_1g
Xf1 s0  ck ckb rst_n s1 s1b vdd vss dsr_dff_1g
Xf2 s1  ck ckb rst_n s2 s2b vdd vss dsr_dff_1g
Xf3 s2  ck ckb rst_n s3 s3b vdd vss dsr_dff_1g
.ends dsr_shift4

* --- Dummy Clock Receiver Load (matches 1.20/4.80 input inverter on ckd0/ckd2 -> 0.00 ps 8-phase skew!) ---
.subckt dsr_clk_dummy ck vdd vss
Xn vss ck vss vss serdes_nfet_lvt w=1.20 l=0.15 nf=1
Xp vdd ck vdd vdd serdes_pfet     w=4.80 l=0.15 nf=2
.ends dsr_clk_dummy

* --- Complete Quarter-Rate Pure CMOS 8->32 Deserializer ---
.subckt serdes_rx_cmos_deser16
+ d0 d1 d2 d3 e0 e1 e2 e3
+ ckd0 ckd1 ckd2 ckd3 cke0 cke1 cke2 cke3 rst_n
+ wd0 wd1 wd2 wd3 wd4 wd5 wd6 wd7 wd8 wd9 wd10 wd11 wd12 wd13 wd14 wd15
+ we0 we1 we2 we3 we4 we5 we6 we7 we8 we9 we10 we11 we12 we13 we14 we15
+ wclk vdd vss

* 1. Zero-Skew Differential 3-Stage 2-Bank 1 GHz Clock Distribution (wp/wn=4.0 -> 50% duty & <15ps crossover @ SS -40C!)
*    Swapped complementary inputs (ckd2 -> ck0_1, ckd0 -> ck2_1) keep exact polarity through 3 inversions!
*    Bank A drives 23 DFFs (21 data + 2 Johnson /4); Bank B drives 23 DFFs (23 edge) -> exact 23/23 load balance!
Xck0_i1 ckd2 ck0_1  vdd vss dsr_inv wn=1.20 wp=4.80 nfn=1 nfp=2
Xck2_i1 ckd0 ck2_1  vdd vss dsr_inv wn=1.20 wp=4.80 nfn=1 nfp=2
Xcc_c1  ck0_1 ck2_1 vdd vss dsr_cc_align wn=0.42 wp=1.40

Xck0_pa ck0_1  ck0_2a vdd vss dsr_inv wn=2.40 wp=9.60 nfn=2 nfp=4
Xck2_pa ck2_1  ck2_2a vdd vss dsr_inv wn=2.40 wp=9.60 nfn=2 nfp=4
Xck0_a  ck0_2a ck0a   vdd vss dsr_inv wn=9.60 wp=38.40 nfn=8 nfp=16
Xck2_a  ck2_2a ck0ba  vdd vss dsr_inv wn=9.60 wp=38.40 nfn=8 nfp=16
Xcc_a   ck0a   ck0ba  vdd vss dsr_cc_align wn=0.45 wp=1.60

Xck0_pb ck0_1  ck0_2b vdd vss dsr_inv wn=2.40 wp=9.60 nfn=2 nfp=4
Xck2_pb ck2_1  ck2_2b vdd vss dsr_inv wn=2.40 wp=9.60 nfn=2 nfp=4
Xck0_b  ck0_2b ck0b   vdd vss dsr_inv wn=9.60 wp=38.40 nfn=8 nfp=16
Xck2_b  ck2_2b ck0bb  vdd vss dsr_inv wn=9.60 wp=38.40 nfn=8 nfp=16
Xcc_b   ck0b   ck0bb  vdd vss dsr_cc_align wn=0.45 wp=1.60

* Matched dummy loads on the other 6 phases
Xdm_d1 ckd1 vdd vss dsr_clk_dummy
Xdm_d3 ckd3 vdd vss dsr_clk_dummy
Xdm_e0 cke0 vdd vss dsr_clk_dummy
Xdm_e1 cke1 vdd vss dsr_clk_dummy
Xdm_e2 cke2 vdd vss dsr_clk_dummy
Xdm_e3 cke3 vdd vss dsr_clk_dummy

* 2. Half-Cycle Phase Alignment into Single 1 GHz ck0 Domain (note: ck2 == ck0b, ck2b == ck0!)
*    Early group (cycle n+1 at ck0): d0, e0 via ck2 -> ck0 -> p0 (eliminates FF hold race on e0!); d1, e1, d2 direct -> ck0 -> p0
Xd0_a  d0   ck0ba ck0a  rst_n d0_a  d0_ab vdd vss dsr_dff_1g
Xd0_p  d0_a ck0a  ck0ba rst_n d0_p  d0_pb vdd vss dsr_dff_1g
Xd1_p  d1   ck0a  ck0ba rst_n d1_p  d1_pb vdd vss dsr_dff_1g
Xd2_p  d2   ck0a  ck0ba rst_n d2_p  d2_pb vdd vss dsr_dff_1g
Xe0_a  e0   ck0bb ck0b  rst_n e0_a  e0_ab vdd vss dsr_dff_1g
Xe0_p  e0_a ck0b  ck0bb rst_n e0_p  e0_pb vdd vss dsr_dff_1g
Xe1_p  e1   ck0b  ck0bb rst_n e1_p  e1_pb vdd vss dsr_dff_1g

*    Late group (cycle n at ck0): e2 via ck0 -> ck2 (eliminates FF hold race on e2!); d3, e3 via ck2 -> 4-tap ck0 shift register!
Xd3_a  d3   ck0ba ck0a  rst_n d3_a  d3_ab vdd vss dsr_dff_1g
Xe2_p  e2   ck0b  ck0bb rst_n e2_p  e2_pb vdd vss dsr_dff_1g
Xe2_a  e2_p ck0bb ck0b  rst_n e2_a  e2_ab vdd vss dsr_dff_1g
Xe3_a  e3   ck0bb ck0b  rst_n e3_a  e3_ab vdd vss dsr_dff_1g

* 3. 8-Lane 4-Tap 1 GHz Shift Registers (all 8 lanes aligned to exact cycle n!)
*    Data lanes (Bank A): s0 = cycle n (newest: wd12..15), s3 = cycle n-3 (oldest: wd0..3)
Xsh_d0 d0_p ck0a ck0ba rst_n d0_0 d0_1 d0_2 d0_3 vdd vss dsr_shift4
Xsh_d1 d1_p ck0a ck0ba rst_n d1_0 d1_1 d1_2 d1_3 vdd vss dsr_shift4
Xsh_d2 d2_p ck0a ck0ba rst_n d2_0 d2_1 d2_2 d2_3 vdd vss dsr_shift4
Xsh_d3 d3_a ck0a ck0ba rst_n d3_0 d3_1 d3_2 d3_3 vdd vss dsr_shift4
*    Edge lanes (Bank B): e0..e2 align to we[4m+1..3]; e3 has 1 extra tap (e3_4) for we[4m+0]!
Xsh_e0 e0_p ck0b ck0bb rst_n e0_0 e0_1 e0_2 e0_3 vdd vss dsr_shift4
Xsh_e1 e1_p ck0b ck0bb rst_n e1_0 e1_1 e1_2 e1_3 vdd vss dsr_shift4
Xsh_e2 e2_a ck0b ck0bb rst_n e2_0 e2_1 e2_2 e2_3 vdd vss dsr_shift4
Xsh_e3 e3_a ck0b ck0bb rst_n e3_0 e3_1 e3_2 e3_3 vdd vss dsr_shift4
Xe3_4  e3_3 ck0b ck0bb rst_n e3_4 e3_4b vdd vss dsr_dff_1g

* 4. Deterministic 250 MHz Johnson /4 Word Strobe (clocked on ck2 = ck0ba, 500 ps midpoint between ck0 edges!)
Xj0 j1b ck0ba ck0a rst_n j0 j0b vdd vss dsr_dff_1g
Xj1 j0  ck0ba ck0a rst_n j1 j1b vdd vss dsr_dff_1g
* Zero-skew 250 MHz word-capture clock distribution (wcap = j0, wcapb = j0b)
Xwcb1 j0      wcapb_i vdd vss dsr_inv wn=1.40 wp=3.40 nfn=1 nfp=2
Xwcb2 wcapb_i wcap    vdd vss dsr_inv wn=2.40 wp=5.80 nfn=2 nfp=4
Xwc1  j0b     wcap_i  vdd vss dsr_inv wn=1.40 wp=3.40 nfn=1 nfp=2
Xwc2  wcap_i  wcapb   vdd vss dsr_inv wn=2.40 wp=5.80 nfn=2 nfp=4
Xcc_w wcap    wcapb   vdd vss dsr_cc_align wn=0.45 wp=1.10
* Export clean 250 MHz word clock wclk (+2.0 ns shifted from wcap rising edge!)
Xwclk1 j0b    wclk_b vdd vss dsr_inv wn=1.00 wp=2.40 nfn=1 nfp=1
Xwclk2 wclk_b wclk   vdd vss dsr_inv wn=1.60 wp=3.80 nfn=1 nfp=2

* 5. 32-Bit 250 MHz Output Word Capture Register (wd0..wd15, we0..we15; exact bbpd_window_vote.sv order!)
Xwd0  d0_3 wcap wcapb rst_n wd0  vdd vss dsr_dff_250m
Xwd1  d1_3 wcap wcapb rst_n wd1  vdd vss dsr_dff_250m
Xwd2  d2_3 wcap wcapb rst_n wd2  vdd vss dsr_dff_250m
Xwd3  d3_3 wcap wcapb rst_n wd3  vdd vss dsr_dff_250m
Xwd4  d0_2 wcap wcapb rst_n wd4  vdd vss dsr_dff_250m
Xwd5  d1_2 wcap wcapb rst_n wd5  vdd vss dsr_dff_250m
Xwd6  d2_2 wcap wcapb rst_n wd6  vdd vss dsr_dff_250m
Xwd7  d3_2 wcap wcapb rst_n wd7  vdd vss dsr_dff_250m
Xwd8  d0_1 wcap wcapb rst_n wd8  vdd vss dsr_dff_250m
Xwd9  d1_1 wcap wcapb rst_n wd9  vdd vss dsr_dff_250m
Xwd10 d2_1 wcap wcapb rst_n wd10 vdd vss dsr_dff_250m
Xwd11 d3_1 wcap wcapb rst_n wd11 vdd vss dsr_dff_250m
Xwd12 d0_0 wcap wcapb rst_n wd12 vdd vss dsr_dff_250m
Xwd13 d1_0 wcap wcapb rst_n wd13 vdd vss dsr_dff_250m
Xwd14 d2_0 wcap wcapb rst_n wd14 vdd vss dsr_dff_250m
Xwd15 d3_0 wcap wcapb rst_n wd15 vdd vss dsr_dff_250m

Xwe0  e3_4 wcap wcapb rst_n we0  vdd vss dsr_dff_250m
Xwe1  e0_3 wcap wcapb rst_n we1  vdd vss dsr_dff_250m
Xwe2  e1_3 wcap wcapb rst_n we2  vdd vss dsr_dff_250m
Xwe3  e2_3 wcap wcapb rst_n we3  vdd vss dsr_dff_250m
Xwe4  e3_3 wcap wcapb rst_n we4  vdd vss dsr_dff_250m
Xwe5  e0_2 wcap wcapb rst_n we5  vdd vss dsr_dff_250m
Xwe6  e1_2 wcap wcapb rst_n we6  vdd vss dsr_dff_250m
Xwe7  e2_2 wcap wcapb rst_n we7  vdd vss dsr_dff_250m
Xwe8  e3_2 wcap wcapb rst_n we8  vdd vss dsr_dff_250m
Xwe9  e0_1 wcap wcapb rst_n we9  vdd vss dsr_dff_250m
Xwe10 e1_1 wcap wcapb rst_n we10 vdd vss dsr_dff_250m
Xwe11 e2_1 wcap wcapb rst_n we11 vdd vss dsr_dff_250m
Xwe12 e3_1 wcap wcapb rst_n we12 vdd vss dsr_dff_250m
Xwe13 e0_0 wcap wcapb rst_n we13 vdd vss dsr_dff_250m
Xwe14 e1_0 wcap wcapb rst_n we14 vdd vss dsr_dff_250m
Xwe15 e2_0 wcap wcapb rst_n we15 vdd vss dsr_dff_250m

.ends serdes_rx_cmos_deser16
