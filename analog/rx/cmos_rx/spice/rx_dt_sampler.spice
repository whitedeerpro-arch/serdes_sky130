* 1 GHz Quarter-Rate Zero-Stacked-PMOS Double-Tail Dynamic CMOS Comparator + Static SR Latch + 6-Bit Cap Trim
* SKY130A, 1.8 V, 100% real SKY130 transistors (zero B-sources, zero ideal passives).
* Dependencies: sky130_primitives.spice, sky130_pfet_lvt.spice.
*
* Architecture (optimized for SKY130 low-VDD cold speed < 220 ps @ SS 1.65V -40C & zero hysteresis):
*   1. Stage 1 (Dynamic Pre-amp, direct clk):
*      Clocked LVT NMOS tail + LVT NMOS input pair (accepts Vcm = 1.15-1.75 V directly from CTLE!) +
*      PMOS precharge & equalize switches on fn/fp.
*   2. 6-Bit Offset Trim (t5..t0, binary, centered at code 32 = 100000):
*      Pure single-sided binary-weighted L=0.18 um MOS gate-capacitor array on fn (63 switched units
*      + 1 OFF dummy, driven by weight-scaled low-Z static L=0.18 um inverters so R_drv*C << 5 ps),
*      balanced by an identical fixed 32-ON / 32-OFF reference bank on fp.
*      - Exact 32:32 symmetry at code 32 -> Vos(32) = 0.00 mV across PVT!
*      - Monotonic ~+/-40 mV range, ~1.25 mV/LSB step, zero extra power, 100% L=0.18 um clear of FS bin!
*   3. Stage 2 (Zero-Stacked-PMOS VDD-Precharged Dynamic Latch):
*      Clocked LVT NMOS tail2 + LVT NMOS intermediate gain transistors driven by fp/fn (Xmn2/Xmn1)
*      in parallel with single-stack cross-coupled LVT-NMOS/PMOS regenerative latch (outp_b/outn_b),
*      precharged & equalized to VDD when clk=0. Zero static crowbar current in both phases!
*   4. Isolated Zero-Stacked-PMOS Static SR Latch (serdes_rx_sr_latch):
*      Symmetric LVT-PMOS isolating inverters (sp=sn=0 during reset -> 0.000 fF state-dependent cap on
*      outp_b/outn_b -> zero hysteresis!) driving a fast 6T LVT-NMOS/LVT-PMOS SR latch (qp, qn).

* --- Local CMOS primitives ---
* Static L=0.18 um inverter for DC trim controls (clear of FS L=0.15 Pclm<0 bin, scaled for low Z)
.subckt dt_inv_static a y vdd vss params: wn=1.0 wp=2.0 nfn=1 nfp=1
Xn y a vss vss serdes_nfet w={wn} l=0.18 nf={nfn}
Xp y a vdd vdd serdes_pfet w={wp} l=0.18 nf={nfp}
.ends dt_inv_static

* --- Dynamic Double-Tail Comparator with 6-Bit Pure Capacitive Offset Trim ---
.subckt serdes_rx_dt_comp inp inn clk outp_b outn_b t5 t4 t3 t2 t1 t0 vdd vss
+ params: win=14.0 lin=0.18 nfin=4 wtail=7.0 wpre=5.1 wcap_u=0.45 lcap_u=0.18 wtail2=6.0 wmn=4.8 wln=8.0 wlp=9.0
* Weight-scaled low-Z static trim drivers (L=0.18 um) so S/D plates stay rock-solid during 50 ps ramp
Xt0   t0  tb0  vdd vss dt_inv_static wn=1.0  wp=2.0  nfn=1 nfp=1
Xt1   t1  tb1  vdd vss dt_inv_static wn=1.0  wp=2.0  nfn=1 nfp=1
Xt2   t2  tb2  vdd vss dt_inv_static wn=2.0  wp=4.0  nfn=1 nfp=2
Xt3   t3  tb3  vdd vss dt_inv_static wn=4.0  wp=8.0  nfn=2 nfp=4
Xt4   t4  tb4  vdd vss dt_inv_static wn=8.0  wp=16.0 nfn=4 nfp=8
Xt5   t5  tb5  vdd vss dt_inv_static wn=16.0 wp=32.0 nfn=8 nfp=16
* Matched static drivers for fp's fixed 32-ON / 32-OFF reference bank (exact impedance match at code 32!)
Xref_on  vdd r_on  vdd vss dt_inv_static wn=16.0 wp=32.0 nfn=8 nfp=16
Xref_off vss r_off vdd vss dt_inv_static wn=16.0 wp=32.0 nfn=8 nfp=16

* --- Stage 1: Dynamic Pre-Amplifier ---
Xtail tail clk vss vss serdes_nfet_lvt w={wtail} l=0.15 nf=2
Xinp  fn inp tail vss serdes_nfet_lvt w={win} l={lin} nf={nfin}
Xinn  fp inn tail vss serdes_nfet_lvt w={win} l={lin} nf={nfin}
* Precharge to VDD + equalize fn/fp when clk=0 (eliminates memory/hysteresis even @ SS 1.65V -40C!)
Xpf1  fn clk vdd vdd serdes_pfet w={wpre} l=0.15 nf=3
Xpf2  fp clk vdd vdd serdes_pfet w={wpre} l=0.15 nf=3
Xpfeq fn clk fp  vdd serdes_pfet w=2.1    l=0.18 nf=1

* --- 6-Bit Binary-Weighted MOS-Cap Offset Trim on fn (balanced by fixed 32:32 reference bank on fp) ---
* When t_k=1 -> tb_k=0 -> fn unit in strong inversion (high C) -> fn slows down -> positive Vos!
* Code 32 (t5=1, t4..t0=0): fn = 32 high-C + 32 low-C == fp = 32 high-C + 32 low-C -> 0.00 mV!
Xcn0 tb0   fn tb0   vss serdes_nfet w={1*wcap_u}  l={lcap_u} nf=1
Xcn1 tb1   fn tb1   vss serdes_nfet w={2*wcap_u}  l={lcap_u} nf=2
Xcn2 tb2   fn tb2   vss serdes_nfet w={4*wcap_u}  l={lcap_u} nf=4
Xcn3 tb3   fn tb3   vss serdes_nfet w={8*wcap_u}  l={lcap_u} nf=8
Xcn4 tb4   fn tb4   vss serdes_nfet w={16*wcap_u} l={lcap_u} nf=16
Xcn5 tb5   fn tb5   vss serdes_nfet w={32*wcap_u} l={lcap_u} nf=32
Xcnd r_off fn r_off vss serdes_nfet w={1*wcap_u}  l={lcap_u} nf=1
* Balanced fixed 32-ON / 32-OFF reference cap bank on fp (identical unit geometry!)
Xcp_on  r_on  fp r_on  vss serdes_nfet w={32*wcap_u} l={lcap_u} nf=32
Xcp_off r_off fp r_off vss serdes_nfet w={32*wcap_u} l={lcap_u} nf=32

* --- Stage 2: Zero-Stacked-PMOS VDD-Precharged Dynamic Regenerative Latch (L=0.18 um for low mismatch) ---
Xtail2 vbot2 clk vss vss serdes_nfet     w={wtail2} l=0.18 nf=4
Xmn2 outp_b fp vbot2 vss serdes_nfet_lvt w={wmn} l=0.18 nf=2
Xmn1 outn_b fn vbot2 vss serdes_nfet_lvt w={wmn} l=0.18 nf=2
Xln1 outp_b outn_b vbot2 vss serdes_nfet_lvt w={wln} l=0.18 nf=4
Xln2 outn_b outp_b vbot2 vss serdes_nfet_lvt w={wln} l=0.18 nf=4
Xlp1 outp_b outn_b vdd   vdd serdes_pfet     w={wlp} l=0.18 nf=4
Xlp2 outn_b outp_b vdd   vdd serdes_pfet     w={wlp} l=0.18 nf=4
* Precharge outp_b, outn_b to VDD + equalize when clk=0 (zero hysteresis @ SS 1.65V -40C CPEX!)
Xpo1  outp_b clk vdd    vdd serdes_pfet w={wpre} l=0.15 nf=3
Xpo2  outn_b clk vdd    vdd serdes_pfet w={wpre} l=0.15 nf=3
Xpoeq outp_b clk outn_b vdd serdes_pfet w=2.1    l=0.18 nf=1
.ends serdes_rx_dt_comp

* --- Symmetric Isolated Zero-Stacked-PMOS Static SR Latch ---
* Low-skewed isolating inverters (wn=2.4 LVT vs wp=2.2 pfet_lvt -> trip ~0.60 V) prevent sp/sn
* from turning ON during Stage-2 common-mode dip -> zero 6T shoot-through & 100% clean decisions @ SS cold!
.subckt serdes_rx_sr_latch sb rb qp qn vdd vss
Xisop_n sp sb vss vss serdes_nfet_lvt w=1.5 l=0.15 nf=1
Xisop_p sp sb vdd vdd serdes_pfet_lvt w=3.2 l=0.35 nf=2
Xison_n sn rb vss vss serdes_nfet_lvt w=1.5 l=0.15 nf=1
Xison_p sn rb vdd vdd serdes_pfet_lvt w=3.2 l=0.35 nf=2
Xset qn sp vss vss serdes_nfet_lvt w=4.8 l=0.15 nf=2
Xrst qp sn vss vss serdes_nfet_lvt w=4.8 l=0.15 nf=2
Xkp1 qp qn vdd vdd serdes_pfet_lvt w=2.8 l=0.35 nf=2
Xkn1 qp qn vss vss serdes_nfet_lvt w=1.0 l=0.15 nf=1
Xkp2 qn qp vdd vdd serdes_pfet_lvt w=2.8 l=0.35 nf=2
Xkn2 qn qp vss vss serdes_nfet_lvt w=1.0 l=0.15 nf=1
.ends serdes_rx_sr_latch

* --- Complete 1 GHz Quarter-Rate Double-Tail Slicer (Comparator + SR Latch + 6-Bit Trim) ---
.subckt serdes_rx_dt_slicer inp inn clk qp qn t5 t4 t3 t2 t1 t0 vdd vss
+ params: win=14.0 lin=0.18 nfin=4 wtail=7.0 wpre=5.1 wcap_u=0.45 lcap_u=0.18 wtail2=6.0 wmn=4.8 wln=8.0 wlp=9.0
Xcomp inp inn clk outp_b outn_b t5 t4 t3 t2 t1 t0 vdd vss serdes_rx_dt_comp
+ win={win} lin={lin} nfin={nfin} wtail={wtail} wpre={wpre} wcap_u={wcap_u} lcap_u={lcap_u}
+ wtail2={wtail2} wmn={wmn} wln={wln} wlp={wlp}
Xsr   outp_b outn_b qp qn vdd vss serdes_rx_sr_latch
.ends serdes_rx_dt_slicer
