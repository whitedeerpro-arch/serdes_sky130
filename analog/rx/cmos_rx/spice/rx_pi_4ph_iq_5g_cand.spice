* 2.5 GHz (5 Gb/s Half-Rate) 4-Phase I/Q-Input Pure CMOS Phase Interpolator + Deterministic 1.25 GHz Quadrature /2
* SKY130A, 1.8 V, 100% real SKY130 transistors, high_po resistors, and MIM capacitors (zero B-sources, zero ideal passives).
* Dependencies: sky130_primitives.spice, sky130_pfet_lvt.spice.
*
* Architecture (Track 3 — Sub-ps 5 GHz LC-VCO + /2 -> 4-Phase I/Q Bridge):
*   - Cuts top-level 2.5 GHz clock routing by 50%: takes ONLY 4 quadrature phases (ip, qp, in, qn = 0, 90, 180, 270 deg)
*     instead of 8 octature phases (c0..c7).
*   - Compact 4->8 Phase Slew-Shaped Active-Resistor Octature Stage (serdes_rx_octature_4to8_2p5g):
*       1. 4 matched slew-shaping LVT input buffers + real MIM slew caps shape 2.5 GHz edges into 100-180 ps linear ramps
*          across all PVT corners (in this regime 0.5*(I+Q) crosses VDD/2 at EXACT 45.0 deg = 50.0 ps independent of slew!).
*       2. 8 100%-identical 2-input resistor-linearized CMOS summing cells generate 0/45/90/135/180/225/270/315 deg
*          with perfectly balanced fanout (4 unit gates on every input) and matched parasitics on even & odd phases.
*       3. 8 AC-coupled self-biased LVT recovery stages (replacing Xin0..Xin7 of the 8-phase PI!) restore all 8 octature
*          anchors (cb0..cb7) to full rail-to-rail 2.5 GHz swing with 50% duty even at SS 1.65 V -40 C.
*   - 100% bit-exact port compatibility with digital/rx/rtl/pi_step_commutator.sv (a0..a7, b0..b7, f0..f7, 64 codes)
*     and existing 5G 8-phase PI core + deterministic 1.25 GHz quadrature /2 (ckd0..3, cke0..3 driving 40 fF each).

* --- Local CMOS primitives (all W/nf >= 0.42 um, L >= 0.15 um) ---
.subckt pi4_inv a y vdd vss params: wn=1.0 wp=4.2 nfn=1 nfp=2
Xn y a vss vss serdes_nfet_lvt w={wn} l=0.15 nf={nfn}
Xp y a vdd vdd serdes_pfet     w={wp} l=0.15 nf={nfp}
.ends pi4_inv

.subckt pi4_inv_lvt a y vdd vss params: wn=1.0 wp=4.0 nfn=1 nfp=2
Xn y a vss vss serdes_nfet_lvt w={wn} l=0.15 nf={nfn}
Xp y a vdd vdd serdes_pfet_lvt w={wp} l=0.35 nf={nfp}
.ends pi4_inv_lvt

.subckt pi4_inv_static a y vdd vss params: wn=0.45 wp=0.90
Xn y a vss vss serdes_nfet w={wn} l=0.18 nf=1
Xp y a vdd vdd serdes_pfet w={wp} l=0.18 nf=1
.ends pi4_inv_static

.subckt pi4_tgate_lvt a b en enb vdd vss params: wn=1.00 wp=2.00 nfn=1 nfp=1
Xn a en  b vss serdes_nfet_lvt w={wn} l=0.15 nf={nfn}
Xp a enb b vdd serdes_pfet_lvt w={wp} l=0.35 nf={nfp}
.ends pi4_tgate_lvt

.subckt pi4_cc_align ap an vdd vss params: wn=0.45 wp=1.80
X1 ap an vdd vss pi4_inv wn={wn} wp={wp} nfn=1 nfp=1
X2 an ap vdd vss pi4_inv wn={wn} wp={wp} nfn=1 nfp=1
.ends pi4_cc_align

.subckt pi4_clk_gate_lo ck_in rst_n rst ckb vdd vss params: wn=1.50 wp=6.30 nfn=1 nfp=3
Xtg   ck_in ck_g rst_n rst vdd vss pi4_tgate_lvt wn=2.60 wp=6.80 nfn=2 nfp=3
Xclmp ck_g  rst  vss   vss serdes_nfet w=0.80 l=0.18 nf=1
Xinv  ck_g  ckb  vdd   vss pi4_inv wn={wn} wp={wp} nfn={nfn} nfp={nfp}
.ends pi4_clk_gate_lo

.subckt pi4_clk_gate_hi ck_in rst_n rst ckb vdd vss params: wn=1.50 wp=6.30 nfn=1 nfp=3
Xtg   ck_in ck_g rst_n rst vdd vss pi4_tgate_lvt wn=2.60 wp=6.80 nfn=2 nfp=3
Xclmp ck_g  rst_n vdd  vdd serdes_pfet w=1.60 l=0.18 nf=1
Xinv  ck_g  ckb  vdd   vss pi4_inv wn={wn} wp={wp} nfn={nfn} nfp={nfp}
.ends pi4_clk_gate_hi

* --- 2-Input Symmetric Active-Resistor Octature Summing Cell ---
* Even phases connect (a, b) = (x, x); odd phases connect (a, b) = (x, y).
* Identical topology & parasitics on all 8 octature phases (no excess MIM shunt cap so SS 1.65V retains full swing!).
.subckt pi4_oct_sum a b y vdd vss params: wn_oct=0.80 wp_oct=3.20 lres_oct=1.6
Xa a da vdd vss pi4_inv_lvt wn={wn_oct} wp={wp_oct} nfn=1 nfp=2
Xb b db vdd vss pi4_inv_lvt wn={wn_oct} wp={wp_oct} nfn=1 nfp=2
Xra da y vss sky130_fd_pr__res_high_po_0p69 l={lres_oct}
Xrb db y vss sky130_fd_pr__res_high_po_0p69 l={lres_oct}
.ends pi4_oct_sum

* --- Zero-Static-DC AC-Coupled Self-Biased LVT CMOS Recovery Stage ---
.subckt pi4_ac_rec mixp mixn r1p r1n vdd vss params: wn=1.65 wp=6.60 cac_w=3.7 lrfb=8.0
Xcp acp mixp sky130_fd_pr__cap_mim_m3_1 w={cac_w} l={cac_w}
Xcn acn mixn sky130_fd_pr__cap_mim_m3_1 w={cac_w} l={cac_w}
Xrp acp r1p vss sky130_fd_pr__res_high_po_0p35 l={lrfb}
Xrn acn r1n vss sky130_fd_pr__res_high_po_0p35 l={lrfb}
Xip acp r1p vdd vss pi4_inv_lvt wn={wn} wp={wp} nfn=1 nfp=4
Xin acn r1n vdd vss pi4_inv_lvt wn={wn} wp={wp} nfn=1 nfp=4
.ends pi4_ac_rec

* --- 4->8 Phase Slew-Shaped Octature Interpolator (2.50 GHz) ---
* Takes 4 quadrature inputs (ip=0, qp=90, in=180, qn=270 deg) and outputs 8 balanced full-swing
* octature anchors (cb0..cb7 at 0, 45, 90, 135, 180, 225, 270, 315 deg) directly feeding Xch_d/Xch_e.
* AC-coupled self-biased LVT recovery (tight 46-53 ps dt45 across FF/TT/SS!) + high-f_T l=0.15 buffers (wp/wn=4.5).
.subckt serdes_rx_octature_4to8_2p5g ip qp in qn cb0 cb1 cb2 cb3 cb4 cb5 cb6 cb7 vdd vss
+ params: wn_sl=1.40 wp_sl=5.60 csl_w=1.75 wn_oct=1.10 wp_oct=4.40 lres_oct=1.5 wn_orec=1.65 cac_oct=4.2 lrfb_oct=9.5 wn_obuf=2.40 pn_obuf=4.50
* Stage 1: 4 matched slew-shaping input buffers (shapes 2.5 GHz edges for exact 45-deg crossing across PVT)
Xsl0 ip ips vdd vss pi4_inv_lvt wn={wn_sl} wp={wp_sl} nfn=1 nfp=3
Xsl1 qp qps vdd vss pi4_inv_lvt wn={wn_sl} wp={wp_sl} nfn=1 nfp=3
Xsl2 in ins vdd vss pi4_inv_lvt wn={wn_sl} wp={wp_sl} nfn=1 nfp=3
Xsl3 qn qns vdd vss pi4_inv_lvt wn={wn_sl} wp={wp_sl} nfn=1 nfp=3
Xcsl0 ips vss sky130_fd_pr__cap_mim_m3_1 w={csl_w} l={csl_w}
Xcsl1 qps vss sky130_fd_pr__cap_mim_m3_1 w={csl_w} l={csl_w}
Xcsl2 ins vss sky130_fd_pr__cap_mim_m3_1 w={csl_w} l={csl_w}
Xcsl3 qns vss sky130_fd_pr__cap_mim_m3_1 w={csl_w} l={csl_w}

* Stage 2: 8 identical 2-input resistor-linearized octature summing cells
* Each of ips, qps, ins, qns drives exactly 4 identical unit inverters (100% matched fanout)
Xo0 ips ips m0 vdd vss pi4_oct_sum wn_oct={wn_oct} wp_oct={wp_oct} lres_oct={lres_oct}
Xo1 ips qps m1 vdd vss pi4_oct_sum wn_oct={wn_oct} wp_oct={wp_oct} lres_oct={lres_oct}
Xo2 qps qps m2 vdd vss pi4_oct_sum wn_oct={wn_oct} wp_oct={wp_oct} lres_oct={lres_oct}
Xo3 qps ins m3 vdd vss pi4_oct_sum wn_oct={wn_oct} wp_oct={wp_oct} lres_oct={lres_oct}
Xo4 ins ins m4 vdd vss pi4_oct_sum wn_oct={wn_oct} wp_oct={wp_oct} lres_oct={lres_oct}
Xo5 ins qns m5 vdd vss pi4_oct_sum wn_oct={wn_oct} wp_oct={wp_oct} lres_oct={lres_oct}
Xo6 qns qns m6 vdd vss pi4_oct_sum wn_oct={wn_oct} wp_oct={wp_oct} lres_oct={lres_oct}
Xo7 qns ips m7 vdd vss pi4_oct_sum wn_oct={wn_oct} wp_oct={wp_oct} lres_oct={lres_oct}

* Stage 3A: Fast-settling AC-coupled self-biased LVT recovery (PVT-tracked dt45 = 50 +/- 3 ps across FF..SS!)
Xrec04 m0 m4 o0 o4 vdd vss pi4_ac_rec wn={wn_orec} wp={4.0*wn_orec} cac_w={cac_oct} lrfb={lrfb_oct}
Xrec15 m1 m5 o1 o5 vdd vss pi4_ac_rec wn={wn_orec} wp={4.0*wn_orec} cac_w={cac_oct} lrfb={lrfb_oct}
Xrec26 m2 m6 o2 o6 vdd vss pi4_ac_rec wn={wn_orec} wp={4.0*wn_orec} cac_w={cac_oct} lrfb={lrfb_oct}
Xrec37 m3 m7 o3 o7 vdd vss pi4_ac_rec wn={wn_orec} wp={4.0*wn_orec} cac_w={cac_oct} lrfb={lrfb_oct}

* Stage 3B: Crisp l=0.15 full-rail drivers (wp/wn=4.50 for 50% duty at SS -40 C!) + differential aligners
Xb0 o0 cb0 vdd vss pi4_inv wn={wn_obuf} wp={pn_obuf*wn_obuf} nfn=2 nfp=4
Xb1 o1 cb1 vdd vss pi4_inv wn={wn_obuf} wp={pn_obuf*wn_obuf} nfn=2 nfp=4
Xb2 o2 cb2 vdd vss pi4_inv wn={wn_obuf} wp={pn_obuf*wn_obuf} nfn=2 nfp=4
Xb3 o3 cb3 vdd vss pi4_inv wn={wn_obuf} wp={pn_obuf*wn_obuf} nfn=2 nfp=4
Xb4 o4 cb4 vdd vss pi4_inv wn={wn_obuf} wp={pn_obuf*wn_obuf} nfn=2 nfp=4
Xb5 o5 cb5 vdd vss pi4_inv wn={wn_obuf} wp={pn_obuf*wn_obuf} nfn=2 nfp=4
Xb6 o6 cb6 vdd vss pi4_inv wn={wn_obuf} wp={pn_obuf*wn_obuf} nfn=2 nfp=4
Xb7 o7 cb7 vdd vss pi4_inv wn={wn_obuf} wp={pn_obuf*wn_obuf} nfn=2 nfp=4
Xcc04 cb0 cb4 vdd vss pi4_cc_align wn=0.45 wp={0.45*pn_obuf}
Xcc15 cb1 cb5 vdd vss pi4_cc_align wn=0.45 wp={0.45*pn_obuf}
Xcc26 cb2 cb6 vdd vss pi4_cc_align wn=0.45 wp={0.45*pn_obuf}
Xcc37 cb3 cb7 vdd vss pi4_cc_align wn=0.45 wp={0.45*pn_obuf}
.ends serdes_rx_octature_4to8_2p5g

* --- Compact 1-Stage 4:1 LVT-TGate One-Hot Clock Mux + Crisp 2.5 GHz Output Inverter ---
.subckt pi4_mux4_tg i0 i1 i2 i3 s0 s1 s2 s3 sb0 sb1 sb2 sb3 y vdd vss params: wn_drv=2.00 wp_drv=8.80 wn_tg=1.60 wp_tg=4.20
Xt0 i0 m s0 sb0 vdd vss pi4_tgate_lvt wn={wn_tg} wp={wp_tg} nfn=2 nfp=2
Xt1 i1 m s1 sb1 vdd vss pi4_tgate_lvt wn={wn_tg} wp={wp_tg} nfn=2 nfp=2
Xt2 i2 m s2 sb2 vdd vss pi4_tgate_lvt wn={wn_tg} wp={wp_tg} nfn=2 nfp=2
Xt3 i3 m s3 sb3 vdd vss pi4_tgate_lvt wn={wn_tg} wp={wp_tg} nfn=2 nfp=2
Xout m y vdd vss pi4_inv wn={wn_drv} wp={wp_drv} nfn=2 nfp=4
.ends pi4_mux4_tg

* --- Constant-Load High-Impedance Resistor-Linearized 2.5 GHz Mixer Slice ---
.subckt pi4_slice_r ca cb f fb mix vdd vss params: wn=0.55 wp=2.30 lres=7.2
Xsa ca sel fb f  vdd vss pi4_tgate_lvt wn=0.50 wp=0.90 nfn=1 nfp=1
Xsb cb sel f  fb vdd vss pi4_tgate_lvt wn=0.50 wp=0.90 nfn=1 nfp=1
Xinv_n drv sel vss vss serdes_nfet_lvt w={wn} l=0.15 nf=1
Xinv_p drv sel vdd vdd serdes_pfet     w={wp} l=0.15 nf=1
Xres   drv mix vss sky130_fd_pr__res_high_po_0p69 l={lres}
Xda ca dum f  fb vdd vss pi4_tgate_lvt wn=0.50 wp=0.90 nfn=1 nfp=1
Xdb cb dum fb f  vdd vss pi4_tgate_lvt wn=0.50 wp=0.90 nfn=1 nfp=1
Xdn vss dum vss vss serdes_nfet_lvt w={wn} l=0.15 nf=1
Xdp vdd dum vdd vdd serdes_pfet     w={wp} l=0.15 nf=1
.ends pi4_slice_r

* --- 8-Slice 2.5 GHz High-Impedance Resistor-Linearized CMOS Phase Mixer ---
.subckt pi4_mixer8 ca cb f0 f1 f2 f3 f4 f5 f6 f7 fb0 fb1 fb2 fb3 fb4 fb5 fb6 fb7 mix vdd vss
+ params: wn_u=0.55 wp_u=2.30 lres=7.2 cmix_w=3.1
Xs0 ca cb f0 fb0 mix vdd vss pi4_slice_r wn={wn_u} wp={wp_u} lres={lres}
Xs1 ca cb f1 fb1 mix vdd vss pi4_slice_r wn={wn_u} wp={wp_u} lres={lres}
Xs2 ca cb f2 fb2 mix vdd vss pi4_slice_r wn={wn_u} wp={wp_u} lres={lres}
Xs3 ca cb f3 fb3 mix vdd vss pi4_slice_r wn={wn_u} wp={wp_u} lres={lres}
Xs4 ca cb f4 fb4 mix vdd vss pi4_slice_r wn={wn_u} wp={wp_u} lres={lres}
Xs5 ca cb f5 fb5 mix vdd vss pi4_slice_r wn={wn_u} wp={wp_u} lres={lres}
Xs6 ca cb f6 fb6 mix vdd vss pi4_slice_r wn={wn_u} wp={wp_u} lres={lres}
Xs7 ca cb f7 fb7 mix vdd vss pi4_slice_r wn={wn_u} wp={wp_u} lres={lres}
Xcmix mix vss sky130_fd_pr__cap_mim_m3_1 w={cmix_w} l={cmix_w}
.ends pi4_mixer8

* --- Differential 2.5 GHz CMOS PI Channel ---
.subckt pi4_diff_chan e0 e1 e2 e3 o0 o1 o2 o3
+ sa0 sa1 sa2 sa3 sab0 sab1 sab2 sab3
+ sb0 sb1 sb2 sb3 sbb0 sbb1 sbb2 sbb3
+ f0 f1 f2 f3 f4 f5 f6 f7 fb0 fb1 fb2 fb3 fb4 fb5 fb6 fb7
+ op on vdd vss
+ params: wn_drv=2.00 wp_drv=8.80 wn_u=0.55 wp_u=2.30 lres=6.4 cmix_w=2.8 wn_rec=1.65 cac_w=3.7 lrfb=8.0 wn_r2=2.60
Xmap e0 e1 e2 e3 sa0 sa1 sa2 sa3 sab0 sab1 sab2 sab3 cap vdd vss pi4_mux4_tg wn_drv={wn_drv} wp_drv={wp_drv}
Xman e2 e3 e0 e1 sa0 sa1 sa2 sa3 sab0 sab1 sab2 sab3 can vdd vss pi4_mux4_tg wn_drv={wn_drv} wp_drv={wp_drv}
Xmbp o0 o1 o2 o3 sb0 sb1 sb2 sb3 sbb0 sbb1 sbb2 sbb3 cbp vdd vss pi4_mux4_tg wn_drv={wn_drv} wp_drv={wp_drv}
Xmbn o2 o3 o0 o1 sb0 sb1 sb2 sb3 sbb0 sbb1 sbb2 sbb3 cbn vdd vss pi4_mux4_tg wn_drv={wn_drv} wp_drv={wp_drv}
Xmixp cap cbp f0 f1 f2 f3 f4 f5 f6 f7 fb0 fb1 fb2 fb3 fb4 fb5 fb6 fb7 mixp vdd vss pi4_mixer8 wn_u={wn_u} wp_u={wp_u} lres={lres} cmix_w={cmix_w}
Xmixn can cbn f0 f1 f2 f3 f4 f5 f6 f7 fb0 fb1 fb2 fb3 fb4 fb5 fb6 fb7 mixn vdd vss pi4_mixer8 wn_u={wn_u} wp_u={wp_u} lres={lres} cmix_w={cmix_w}
Xrec mixp mixn r1p r1n vdd vss pi4_ac_rec wn={wn_rec} wp={4.0*wn_rec} cac_w={cac_w} lrfb={lrfb}
Xr2p r1n  op   vdd vss pi4_inv_lvt wn={wn_r2} wp={4.0*wn_r2} nfn=2 nfp=4
Xr2n r1p  on   vdd vss pi4_inv_lvt wn={wn_r2} wp={4.0*wn_r2} nfn=2 nfp=4
.ends pi4_diff_chan

* --- Complete 2.5 GHz 4-Phase I/Q-Input 64-Code CMOS PI Rotator ---
.subckt serdes_rx_pi_rotator_4ph_2p5g ip qp in qn
+ a0 a1 a2 a3 a4 a5 a6 a7
+ b0 b1 b2 b3 b4 b5 b6 b7
+ f0 f1 f2 f3 f4 f5 f6 f7
+ dp dn ep en vdd vss
+ params: wn_sl=1.40 wp_sl=5.60 csl_w=1.75 wn_oct=1.10 wp_oct=4.40 lres_oct=1.5 wn_orec=1.65 cac_oct=4.2 lrfb_oct=9.5 wn_obuf=2.40 pn_obuf=4.50
+         wn_drv=2.00 wp_drv=8.80 wn_u=0.55 wp_u=2.30 lres=6.4 cmix_w=2.8 wn_rec=1.65 cac_w=3.7 lrfb=8.0 wn_r2=2.60
* Static DC control inversions
Xia0 a0 ab0 vdd vss pi4_inv_static
Xia1 a1 ab1 vdd vss pi4_inv_static
Xia2 a2 ab2 vdd vss pi4_inv_static
Xia3 a3 ab3 vdd vss pi4_inv_static
Xia4 a4 ab4 vdd vss pi4_inv_static
Xia5 a5 ab5 vdd vss pi4_inv_static
Xia6 a6 ab6 vdd vss pi4_inv_static
Xia7 a7 ab7 vdd vss pi4_inv_static
Xib0 b0 bb0 vdd vss pi4_inv_static
Xib1 b1 bb1 vdd vss pi4_inv_static
Xib2 b2 bb2 vdd vss pi4_inv_static
Xib3 b3 bb3 vdd vss pi4_inv_static
Xib4 b4 bb4 vdd vss pi4_inv_static
Xib5 b5 bb5 vdd vss pi4_inv_static
Xib6 b6 bb6 vdd vss pi4_inv_static
Xib7 b7 bb7 vdd vss pi4_inv_static
Xif0 f0 fb0 vdd vss pi4_inv_static
Xif1 f1 fb1 vdd vss pi4_inv_static
Xif2 f2 fb2 vdd vss pi4_inv_static
Xif3 f3 fb3 vdd vss pi4_inv_static
Xif4 f4 fb4 vdd vss pi4_inv_static
Xif5 f5 fb5 vdd vss pi4_inv_static
Xif6 f6 fb6 vdd vss pi4_inv_static
Xif7 f7 fb7 vdd vss pi4_inv_static

* 4->8 Phase Slew-Shaped Octature Front-End (generates matched cb0..cb7 at 0..315 deg)
Xoct ip qp in qn cb0 cb1 cb2 cb3 cb4 cb5 cb6 cb7 vdd vss serdes_rx_octature_4to8_2p5g
+ wn_sl={wn_sl} wp_sl={wp_sl} csl_w={csl_w} wn_oct={wn_oct} wp_oct={wp_oct}
+ lres_oct={lres_oct} wn_orec={wn_orec} cac_oct={cac_oct} lrfb_oct={lrfb_oct} wn_obuf={wn_obuf} pn_obuf={pn_obuf}

* Data channel (0 / 180 deg)
Xch_d cb0 cb2 cb4 cb6 cb1 cb3 cb5 cb7
+ a0 a2 a4 a6 ab0 ab2 ab4 ab6
+ b1 b3 b5 b7 bb1 bb3 bb5 bb7
+ f0 f1 f2 f3 f4 f5 f6 f7 fb0 fb1 fb2 fb3 fb4 fb5 fb6 fb7
+ dp dn vdd vss pi4_diff_chan wn_drv={wn_drv} wp_drv={wp_drv} wn_u={wn_u} wp_u={wp_u} lres={lres} cmix_w={cmix_w} wn_rec={wn_rec} cac_w={cac_w} lrfb={lrfb} wn_r2={wn_r2}

* Edge channel (+90 / +270 deg)
Xch_e cb2 cb4 cb6 cb0 cb3 cb5 cb7 cb1
+ a0 a2 a4 a6 ab0 ab2 ab4 ab6
+ b1 b3 b5 b7 bb1 bb3 bb5 bb7
+ f0 f1 f2 f3 f4 f5 f6 f7 fb0 fb1 fb2 fb3 fb4 fb5 fb6 fb7
+ ep en vdd vss pi4_diff_chan wn_drv={wn_drv} wp_drv={wp_drv} wn_u={wn_u} wp_u={wp_u} lres={lres} cmix_w={cmix_w} wn_rec={wn_rec} cac_w={cac_w} lrfb={lrfb} wn_r2={wn_r2}
.ends serdes_rx_pi_rotator_4ph_2p5g

* --- High-Speed 2.5 GHz Differential Resettable TG Latch ---
.subckt pi4_diff_latch dp_in dn_in ck ckb rst_n rst qp qn vdd vss
+ params: wn_out=3.40 wp_out=14.28 nfn_out=2 nfp_out=4
Xtgp_n dp_in ck  int_p vss serdes_nfet_lvt w=2.80 l=0.15 nf=2
Xtgp_p dp_in ckb int_p vdd serdes_pfet     w=6.80 l=0.15 nf=3
Xtgn_n dn_in ck  int_n vss serdes_nfet_lvt w=2.80 l=0.15 nf=2
Xtgn_p dn_in ckb int_n vdd serdes_pfet     w=6.80 l=0.15 nf=3
Xkp1 int_p int_n vdd vdd serdes_pfet w=0.42 l=0.28 nf=1
Xkn1 int_p int_n vss vss serdes_nfet w=0.42 l=0.28 nf=1
Xkp2 int_n int_p vdd vdd serdes_pfet w=0.42 l=0.28 nf=1
Xkn2 int_n int_p vss vss serdes_nfet w=0.42 l=0.28 nf=1
Xrp int_p rst   vss vss serdes_nfet w=1.0 l=0.18 nf=1
Xrn int_n rst_n vdd vdd serdes_pfet w=1.8 l=0.18 nf=1
Xop int_n qp vdd vss pi4_inv wn={wn_out} wp={wp_out} nfn={nfn_out} nfp={nfp_out}
Xon int_p qn vdd vss pi4_inv wn={wn_out} wp={wp_out} nfn={nfn_out} nfp={nfp_out}
Xcc qp    qn vdd vss pi4_cc_align wn=0.42 wp=1.76
.ends pi4_diff_latch

* --- Deterministic Quadrature CMOS /2 (8-Phase 1.25 GHz Clock Generator for 5 Gb/s) ---
.subckt serdes_rx_qdiv2_8ph_4iq dp dn ep en rst_n ckd0 ckd1 ckd2 ckd3 cke0 cke1 cke2 cke3 vdd vss
+ params: wn_ld=3.40 wn_le=1.45 pn_div=4.20 pn_ck=4.20 wn_buf=2.40
Xrst rst_n rst vdd vss pi4_inv_static wn=0.6 wp=1.2
Xg_dpb dp rst_n rst dp_ckb vdd vss pi4_clk_gate_lo wn=1.50 wp={1.50*pn_ck} nfn=1 nfp=3
Xg_dnb dn rst_n rst dn_ckb vdd vss pi4_clk_gate_hi wn=1.50 wp={1.50*pn_ck} nfn=1 nfp=3
Xg_epb ep rst_n rst ep_ckb vdd vss pi4_clk_gate_lo wn=1.50 wp={1.50*pn_ck} nfn=1 nfp=3
Xg_enb en rst_n rst en_ckb vdd vss pi4_clk_gate_hi wn=1.50 wp={1.50*pn_ck} nfn=1 nfp=3
Xcc_dckb dp_ckb dn_ckb vdd vss pi4_cc_align wn=0.45 wp={0.45*pn_ck}
Xcc_eckb ep_ckb en_ckb vdd vss pi4_cc_align wn=0.45 wp={0.45*pn_ck}
Xg_dp  dp_ckb dp_ck vdd vss pi4_inv wn=2.10 wp={2.10*pn_ck} nfn=2 nfp=4
Xg_dn  dn_ckb dn_ck vdd vss pi4_inv wn=2.10 wp={2.10*pn_ck} nfn=2 nfp=4
Xg_ep  ep_ckb ep_ck vdd vss pi4_inv wn=2.10 wp={2.10*pn_ck} nfn=2 nfp=4
Xg_en  en_ckb en_ck vdd vss pi4_inv wn=2.10 wp={2.10*pn_ck} nfn=2 nfp=4
Xcc_dck  dp_ck  dn_ck  vdd vss pi4_cc_align wn=0.45 wp={0.45*pn_ck}
Xcc_eck  ep_ck  en_ck  vdd vss pi4_cc_align wn=0.45 wp={0.45*pn_ck}

Xld0 d3 d1 dp_ck dn_ck rst_n rst d0 d2 vdd vss pi4_diff_latch wn_out={wn_ld} wp_out={wn_ld*pn_div} nfn_out=2 nfp_out=4
Xld1 d0 d2 dn_ck dp_ck rst_n rst d1 d3 vdd vss pi4_diff_latch wn_out={wn_ld} wp_out={wn_ld*pn_div} nfn_out=2 nfp_out=4

Xle0 d0 d2 ep_ck en_ck rst_n rst e0 e2 vdd vss pi4_diff_latch wn_out={wn_le} wp_out={wn_le*pn_div} nfn_out=1 nfp_out=3
Xle1 d1 d3 en_ck ep_ck rst_n rst e1 e3 vdd vss pi4_diff_latch wn_out={wn_le} wp_out={wn_le*pn_div} nfn_out=1 nfp_out=3

Xbd0 d2 ckd0 vdd vss pi4_inv wn={wn_buf} wp={wn_buf*pn_div} nfn=2 nfp=4
Xbd2 d0 ckd2 vdd vss pi4_inv wn={wn_buf} wp={wn_buf*pn_div} nfn=2 nfp=4
Xbd1 d3 ckd1 vdd vss pi4_inv wn={wn_buf} wp={wn_buf*pn_div} nfn=2 nfp=4
Xbd3 d1 ckd3 vdd vss pi4_inv wn={wn_buf} wp={wn_buf*pn_div} nfn=2 nfp=4
Xbe0 e2 cke0 vdd vss pi4_inv wn={wn_buf} wp={wn_buf*pn_div} nfn=2 nfp=4
Xbe2 e0 cke2 vdd vss pi4_inv wn={wn_buf} wp={wn_buf*pn_div} nfn=2 nfp=4
Xbe1 e3 cke1 vdd vss pi4_inv wn={wn_buf} wp={wn_buf*pn_div} nfn=2 nfp=4
Xbe3 e1 cke3 vdd vss pi4_inv wn={wn_buf} wp={wn_buf*pn_div} nfn=2 nfp=4
Xccd0 ckd0 ckd2 vdd vss pi4_cc_align wn=0.45 wp={0.45*pn_div}
Xccd1 ckd1 ckd3 vdd vss pi4_cc_align wn=0.45 wp={0.45*pn_div}
Xcce0 cke0 cke2 vdd vss pi4_cc_align wn=0.45 wp={0.45*pn_div}
Xcce1 cke1 cke3 vdd vss pi4_cc_align wn=0.45 wp={0.45*pn_div}
.ends serdes_rx_qdiv2_8ph_4iq

* --- Integrated 2.5 GHz 4-Phase I/Q CMOS PI + Deterministic 8-Phase 1.25 GHz Clock Generator ---
.subckt serdes_rx_pi_4ph_iq_8ph ip qp in qn
+ a0 a1 a2 a3 a4 a5 a6 a7
+ b0 b1 b2 b3 b4 b5 b6 b7
+ f0 f1 f2 f3 f4 f5 f6 f7
+ rst_n dp dn ep en ckd0 ckd1 ckd2 ckd3 cke0 cke1 cke2 cke3 vdd vss
+ params: wn_sl=1.40 wp_sl=5.60 csl_w=1.75 wn_oct=1.10 wp_oct=4.40 lres_oct=1.5 wn_orec=1.65 cac_oct=4.2 lrfb_oct=9.5 wn_obuf=2.40 pn_obuf=4.50
+         wn_drv=2.00 wp_drv=8.80 wn_u=0.55 wp_u=2.30 lres=6.4 cmix_w=2.8 wn_rec=1.65 cac_w=3.7 lrfb=8.0 wn_r2=2.60
+         wn_ld=3.40 wn_le=1.45 pn_div=4.20 pn_ck=4.20 wn_buf=2.40
Xpi ip qp in qn
+ a0 a1 a2 a3 a4 a5 a6 a7
+ b0 b1 b2 b3 b4 b5 b6 b7
+ f0 f1 f2 f3 f4 f5 f6 f7
+ dp dn ep en vdd vss serdes_rx_pi_rotator_4ph_2p5g
+ wn_sl={wn_sl} wp_sl={wp_sl} csl_w={csl_w} wn_oct={wn_oct} wp_oct={wp_oct}
+ lres_oct={lres_oct} wn_orec={wn_orec} cac_oct={cac_oct} lrfb_oct={lrfb_oct} wn_obuf={wn_obuf} pn_obuf={pn_obuf}
+ wn_drv={wn_drv} wp_drv={wp_drv} wn_u={wn_u} wp_u={wp_u} lres={lres} cmix_w={cmix_w} wn_rec={wn_rec} cac_w={cac_w} lrfb={lrfb} wn_r2={wn_r2}
Xdiv dp dn ep en rst_n ckd0 ckd1 ckd2 ckd3 cke0 cke1 cke2 cke3 vdd vss serdes_rx_qdiv2_8ph_4iq
+ wn_ld={wn_ld} wn_le={wn_le} pn_div={pn_div} pn_ck={pn_ck} wn_buf={wn_buf}
.ends serdes_rx_pi_4ph_iq_8ph
