* 5G (2.5 GHz) 4-Phase I/Q Pure CMOS Phase Interpolator + Cold-MC-Hardened 1.25 GHz Quadrature /2 (v3)
* SKY130A, 1.8 V, 100% real SKY130 transistors, high_po resistors, and MIM capacitors (zero B-sources, zero ideal passives).
* Dependencies: sky130_primitives.spice, sky130_pfet_lvt.spice.
*
* Architecture hardening over v2 (`rx_pi_4ph_iq_5g_v2.spice`):
*   - Octature (`serdes_rx_octature_4to8_2p5g`) and PI Rotator (`pi4_diff_chan`) are 100% IDENTICAL to v2
*     (already 24/24 100% cold-MC + 6/6 PVT corner CPEX verified).
*   - `serdes_rx_qdiv2_8ph_4iq` is cold-MC-hardened to eliminate the SKY130 SVT-PMOS cold overdrive cliff at SS 1.65 V -40 C:
*       1. Full-Strength Composite Hybrid-PMOS (`pi4_inv_hyb`: SVT-P l=0.15 || LVT-P l=0.35) in clock buffers
*          (`Xg_dp..en`), differential latch TGs (`Xtgp/Xtgn`) & output drivers (`Xop/Xon`), and 1.25 GHz output
*          buffers (`Xbd/Xbe`), plus LVT-PMOS (`l=0.35`) in keepers (`Xkp1/2`), differential aligners (`Xcc*`),
*          reset inverter (`Xrst`), and lock detector thresholds (`Xdet1/Xdet2/Xdet2_e1`).
*       2. Balanced fast CMOS XNOR(d2, e0) (`P_LVT 2.20/0.35`, `N_STD 0.85/0.35`, `Xlpf_cap 0.95/0.95`) + centered
*          LVT-PMOS `Xdet1` (`N_STD 1.40/0.18 + P_LVT 1.60/0.35`) eliminating 180-deg false-Hi-Z and FF ripple.
*       3. Unidirectional 2-FET `N_LVT` pull-down D->E phase injector (`pi4_gated_inj`, `2x N_LVT 2.60/0.15 nf=2`)
*          driven from D-latch outputs (`d2->e0_intn, d0->e0_intp, d3->e1_intn, d1->e1_intp`):
*          ZERO back-injection into D, temperature-flat -40..+85 C pull-down (no PMOS cold cliff or +85 C sag),
*          eliminates `inj_off`/`Xdet2`/`Xdet2_e1` completely, and turns 100% Hi-Z in steady state (`inj_en = 0 V`).
*       4. PVT-balanced D vs E Hybrid-PMOS TGs (`D: 2.65/5.10+2.05`, `E: 4.00/7.00+3.20`) + matched load dummies
*          (`pi4_xnor_dum`, `pi4_e_dum`) for <= 7 ps nominal 8-phase error across all 6 PVT corners and 96/96 (100%)
*          cold+hot MC yield.
*
* Port compatibility (1:1 drop-in with `rx_pi_4ph_iq_5g_cand.spice`, `rx_pi_4ph_iq_5g_v2.spice`, and `serdes_rx_cmos_top_5g_pdk`):
*   - `serdes_rx_octature_4to8_2p5g` : 14 ports (ip qp in qn cb0..cb7 vdd vss)
*   - `serdes_rx_pi_4ph_iq_8ph`      : 43 ports (ip qp in qn a0..a7 b0..b7 f0..f7 rst_n dp dn ep en ckd0..3 cke0..3 vdd vss)

* --- Local CMOS Primitives (every W/nf on exact 0.005 um SKY130 grid, W/nf >= 0.42 um) ---
* Balanced LVT-NMOS (l=0.15) + LVT-PMOS (l=0.35) inverter
.subckt pi4_inv_lvt a y vdd vss params: wn=1.00 wp=3.75 nfn=1 nfp=2
Xn y a vss vss serdes_nfet_lvt w={wn} l=0.15 nf={nfn}
Xp y a vdd vdd serdes_pfet_lvt w={wp} l=0.35 nf={nfp}
.ends pi4_inv_lvt

* Composite Hybrid-PMOS inverter: parallel SVT-P (l=0.15, high f_T at +85 C) || LVT-P (l=0.35, low |Vthp| at -40 C)
.subckt pi4_inv_hyb a y vdd vss params: wn=1.60 wps=5.40 wpl=2.20 nfn=1 nfps=2 nfpl=1
Xn  y a vss vss serdes_nfet_lvt w={wn}  l=0.15 nf={nfn}
Xps y a vdd vdd serdes_pfet     w={wps} l=0.15 nf={nfps}
Xpl y a vdd vdd serdes_pfet_lvt w={wpl} l=0.35 nf={nfpl}
.ends pi4_inv_hyb

* High-f_T LVT-NMOS + SVT-PMOS inverter (preserved for PI rotator `Xcco` identical to v2)
.subckt pi4_inv_q a y vdd vss params: wn=1.00 wp=5.00 nfn=1 nfp=2
Xn y a vss vss serdes_nfet_lvt w={wn} l=0.15 nf={nfn}
Xp y a vdd vdd serdes_pfet     w={wp} l=0.15 nf={nfp}
.ends pi4_inv_q

* Static DC control / staged reset inverter (L=0.18, 0 uW dynamic)
.subckt pi4_inv_static a y vdd vss params: wn=0.45 wp=0.90
Xn y a vss vss serdes_nfet w={wn} l=0.18 nf=1
Xp y a vdd vdd serdes_pfet w={wp} l=0.18 nf=1
.ends pi4_inv_static

* Staged reset delay inverter (delays rst_n_lat & rst_lat together past initial clock-gate unclamp across all codes)
.subckt pi4_inv_rstdly a y vdd vss params: wn=0.65 wp=1.60
Xn y a vss vss serdes_nfet     w={wn} l=0.35 nf=1
Xp y a vdd vdd serdes_pfet_lvt w={wp} l=0.35 nf=1
.ends pi4_inv_rstdly

* Static-DC-gated LVT transmission gate (conducts cleanly at VDD/2 even at SS 1.65 V -40 C)
.subckt pi4_tgate_lvt a b en enb vdd vss params: wn=1.00 wp=2.00 nfn=1 nfp=1
Xn a en  b vss serdes_nfet_lvt w={wn} l=0.15 nf={nfn}
Xp a enb b vdd serdes_pfet_lvt w={wp} l=0.35 nf={nfp}
.ends pi4_tgate_lvt

* Cross-coupled differential aligner (LVT-PMOS for octature and v3 QDiv2)
.subckt pi4_cc_align ap an vdd vss params: wn=0.45 wp=1.71 nfn=1 nfp=1
X1 ap an vdd vss pi4_inv_lvt wn={wn} wp={wp} nfn={nfn} nfp={nfp}
X2 an ap vdd vss pi4_inv_lvt wn={wn} wp={wp} nfn={nfn} nfp={nfp}
.ends pi4_cc_align

* Cross-coupled differential aligner (SVT-PMOS preserved for PI rotator `Xcco` identical to v2)
.subckt pi4_cc_align_q ap an vdd vss params: wn=0.45 wp=2.16 nfn=1 nfp=1
X1 ap an vdd vss pi4_inv_q wn={wn} wp={wp} nfn={nfn} nfp={nfp}
X2 an ap vdd vss pi4_inv_q wn={wn} wp={wp} nfn={nfn} nfp={nfp}
.ends pi4_cc_align_q

* 100% Symmetric TG-isolated resettable 2.5 GHz clock gates with Composite Hybrid-PMOS receiver (v3 boosted)
.subckt pi4_clk_gate_lo ck_in rst_n rst ckb vdd vss
Xtg   ck_in ck_g rst_n rst vdd vss pi4_tgate_lvt wn=2.60 wp=6.80 nfn=2 nfp=3
Xclmp ck_g  rst  vss   vss serdes_nfet w=0.80 l=0.18 nf=1
Xinv  ck_g  ckb  vdd   vss pi4_inv_hyb wn=2.50 wps=7.00 wpl=3.50 nfn=2 nfps=2 nfpl=1
.ends pi4_clk_gate_lo

.subckt pi4_clk_gate_hi ck_in rst_n rst ckb vdd vss
Xtg   ck_in ck_g rst_n rst vdd vss pi4_tgate_lvt wn=2.60 wp=6.80 nfn=2 nfp=3
Xclmp ck_g  rst_n vdd  vdd serdes_pfet w=1.60 l=0.18 nf=1
Xinv  ck_g  ckb  vdd   vss pi4_inv_hyb wn=2.50 wps=7.00 wpl=3.50 nfn=2 nfps=2 nfpl=1
.ends pi4_clk_gate_hi

* Cold-MC-hardened CMOS XNOR(d2, e0) lock detector + MOSCAP LPF + centered LVT-PMOS threshold buffer:
*   - Balanced XNOR (P_LVT 2.20/0.35, N_STD 0.85/0.35) + Xlpf_cap 0.95/0.95: fast lock settling & tiny FF ripple.
*   - Crisp LVT-PMOS Xdet1 (N_STD 2.80/0.18 nf=2 + P_LVT 2.00/0.35 nf=1) places V_M ~ 0.42*VDD across all PVT & MC.
.subckt pi4_e_lock_ctrl d2 d0 e0 e2 rst_lat inj_en vdd vss
Xxnor_p1a v_lpf d2  sp1 vdd serdes_pfet_lvt w=2.20 l=0.35 nf=1
Xxnor_p1b sp1   e0  vdd vdd serdes_pfet_lvt w=2.20 l=0.35 nf=1
Xxnor_p2a v_lpf d0  sp2 vdd serdes_pfet_lvt w=2.20 l=0.35 nf=1
Xxnor_p2b sp2   e2  vdd vdd serdes_pfet_lvt w=2.20 l=0.35 nf=1
Xxnor_n1a v_lpf d2  sn1 vss serdes_nfet     w=0.85 l=0.35 nf=1
Xxnor_n1b sn1   e2  vss vss serdes_nfet     w=0.85 l=0.35 nf=1
Xxnor_n2a v_lpf d0  sn2 vss serdes_nfet     w=0.85 l=0.35 nf=1
Xxnor_n2b sn2   e0  vss vss serdes_nfet     w=0.85 l=0.35 nf=1
Xlpf_rst  v_lpf rst_lat vss vss serdes_nfet w=1.00 l=0.18 nf=1
Xlpf_cap  vss   v_lpf   vss vss serdes_nfet w=0.95 l=0.95 nf=1
Xdet1_n   inj_en  v_lpf  vss vss serdes_nfet     w=2.80 l=0.18 nf=2
Xdet1_p   inj_en  v_lpf  vdd vdd serdes_pfet_lvt w=2.00 l=0.35 nf=1
.ends pi4_e_lock_ctrl

* Unidirectional 2-FET N_LVT pull-down D->E phase injector (ZERO back-injection into D, 100% Hi-Z when inj_en=0 V)
.subckt pi4_gated_inj a y inj_en vss
Xne y  inj_en sn vss serdes_nfet_lvt w=3.00 l=0.15 nf=2
Xni sn a      vss vss serdes_nfet_lvt w=3.00 l=0.15 nf=2
.ends pi4_gated_inj

* Matched off-state capacitive load dummies (ensures 100% balanced 8-phase fanout across d0..d3 and e0..e3)
.subckt pi4_xnor_dum a vdd vss
Xdp vdd a vdd vdd serdes_pfet_lvt w=2.20 l=0.35 nf=1
Xdn vss a vss vss serdes_nfet     w=0.85 l=0.35 nf=1
.ends pi4_xnor_dum

.subckt pi4_e_dum a vdd vss
Xdp vdd a vdd vdd serdes_pfet     w=1.40 l=0.15 nf=1
Xdn vss a vss vss serdes_nfet_lvt w=0.42 l=0.15 nf=1
.ends pi4_e_dum

* ===========================================================================
* 1. 2.5 GHz Slew-Shaped Resistor-Linearized 4 -> 8 Octature Stage (100% v2)
* ===========================================================================
.subckt pi4_oct_sum a b y vdd vss params: wn_oct=1.10 wp_oct=4.40 lres_oct=1.5
Xa a da vdd vss pi4_inv_lvt wn={wn_oct} wp={wp_oct} nfn=1 nfp=4
Xb b db vdd vss pi4_inv_lvt wn={wn_oct} wp={wp_oct} nfn=1 nfp=4
Xra da y vss sky130_fd_pr__res_high_po_0p69 l={lres_oct}
Xrb db y vss sky130_fd_pr__res_high_po_0p69 l={lres_oct}
.ends pi4_oct_sum

.subckt pi4_ac_rec mixp mixn r1p r1n vdd vss params: wn=1.80 wp=6.84 cac_w=4.2 lrfb=9.5
Xcp acp mixp sky130_fd_pr__cap_mim_m3_1 w={cac_w} l={cac_w}
Xcn acn mixn sky130_fd_pr__cap_mim_m3_1 w={cac_w} l={cac_w}
Xrp acp r1p vss sky130_fd_pr__res_high_po_0p35 l={lrfb}
Xrn acn r1n vss sky130_fd_pr__res_high_po_0p35 l={lrfb}
Xip acp r1p vdd vss pi4_inv_lvt wn={wn} wp={wp} nfn=2 nfp=4
Xin acn r1n vdd vss pi4_inv_lvt wn={wn} wp={wp} nfn=2 nfp=4
.ends pi4_ac_rec

.subckt serdes_rx_octature_4to8_2p5g ip qp in qn cb0 cb1 cb2 cb3 cb4 cb5 cb6 cb7 vdd vss
Xsl0 ip ips vdd vss pi4_inv_lvt wn=1.40 wp=5.60 nfn=2 nfp=4
Xsl1 qp qps vdd vss pi4_inv_lvt wn=1.40 wp=5.60 nfn=2 nfp=4
Xsl2 in ins vdd vss pi4_inv_lvt wn=1.40 wp=5.60 nfn=2 nfp=4
Xsl3 qn qns vdd vss pi4_inv_lvt wn=1.40 wp=5.60 nfn=2 nfp=4
Xcsl0 ips vss sky130_fd_pr__cap_mim_m3_1 w=1.75 l=1.75
Xcsl1 qps vss sky130_fd_pr__cap_mim_m3_1 w=1.75 l=1.75
Xcsl2 ins vss sky130_fd_pr__cap_mim_m3_1 w=1.75 l=1.75
Xcsl3 qns vss sky130_fd_pr__cap_mim_m3_1 w=1.75 l=1.75

Xo0 ips ips m0 vdd vss pi4_oct_sum wn_oct=1.10 wp_oct=4.40 lres_oct=1.5
Xo1 ips qps m1 vdd vss pi4_oct_sum wn_oct=1.10 wp_oct=4.40 lres_oct=1.5
Xo2 qps qps m2 vdd vss pi4_oct_sum wn_oct=1.10 wp_oct=4.40 lres_oct=1.5
Xo3 qps ins m3 vdd vss pi4_oct_sum wn_oct=1.10 wp_oct=4.40 lres_oct=1.5
Xo4 ins ins m4 vdd vss pi4_oct_sum wn_oct=1.10 wp_oct=4.40 lres_oct=1.5
Xo5 ins qns m5 vdd vss pi4_oct_sum wn_oct=1.10 wp_oct=4.40 lres_oct=1.5
Xo6 qns qns m6 vdd vss pi4_oct_sum wn_oct=1.10 wp_oct=4.40 lres_oct=1.5
Xo7 qns ips m7 vdd vss pi4_oct_sum wn_oct=1.10 wp_oct=4.40 lres_oct=1.5

Xrec04 m0 m4 o0 o4 vdd vss pi4_ac_rec wn=2.20 wp=8.40 cac_w=4.2 lrfb=9.5
Xrec15 m1 m5 o1 o5 vdd vss pi4_ac_rec wn=2.20 wp=8.40 cac_w=4.2 lrfb=9.5
Xrec26 m2 m6 o2 o6 vdd vss pi4_ac_rec wn=2.20 wp=8.40 cac_w=4.2 lrfb=9.5
Xrec37 m3 m7 o3 o7 vdd vss pi4_ac_rec wn=2.20 wp=8.40 cac_w=4.2 lrfb=9.5

Xb0 o0 cb0 vdd vss pi4_inv_lvt wn=3.40 wp=12.60 nfn=2 nfp=6
Xb1 o1 cb1 vdd vss pi4_inv_lvt wn=3.40 wp=12.60 nfn=2 nfp=6
Xb2 o2 cb2 vdd vss pi4_inv_lvt wn=3.40 wp=12.60 nfn=2 nfp=6
Xb3 o3 cb3 vdd vss pi4_inv_lvt wn=3.40 wp=12.60 nfn=2 nfp=6
Xb4 o4 cb4 vdd vss pi4_inv_lvt wn=3.40 wp=12.60 nfn=2 nfp=6
Xb5 o5 cb5 vdd vss pi4_inv_lvt wn=3.40 wp=12.60 nfn=2 nfp=6
Xb6 o6 cb6 vdd vss pi4_inv_lvt wn=3.40 wp=12.60 nfn=2 nfp=6
Xb7 o7 cb7 vdd vss pi4_inv_lvt wn=3.40 wp=12.60 nfn=2 nfp=6

Xcc04 cb0 cb4 vdd vss pi4_cc_align wn=0.45 wp=2.10
Xcc15 cb1 cb5 vdd vss pi4_cc_align wn=0.45 wp=2.10
Xcc26 cb2 cb6 vdd vss pi4_cc_align wn=0.45 wp=2.10
Xcc37 cb3 cb7 vdd vss pi4_cc_align wn=0.45 wp=2.10
.ends serdes_rx_octature_4to8_2p5g

* ===========================================================================
* 2. Hardened 2.5 GHz 64-Code Pure CMOS PI Rotator Channel (100% v2)
* ===========================================================================
.subckt pi4_mux4_tg i0 i1 i2 i3 s0 s1 s2 s3 sb0 sb1 sb2 sb3 y vdd vss
Xt0 i0 m s0 sb0 vdd vss pi4_tgate_lvt wn=1.50 wp=4.60 nfn=2 nfp=2
Xt1 i1 m s1 sb1 vdd vss pi4_tgate_lvt wn=1.50 wp=4.60 nfn=2 nfp=2
Xt2 i2 m s2 sb2 vdd vss pi4_tgate_lvt wn=1.50 wp=4.60 nfn=2 nfp=2
Xt3 i3 m s3 sb3 vdd vss pi4_tgate_lvt wn=1.50 wp=4.60 nfn=2 nfp=2
Xcm ma m sky130_fd_pr__cap_mim_m3_1 w=4.3 l=4.2
Xrm ma y vss sky130_fd_pr__res_high_po_0p35 l=6.5
Xout ma y vdd vss pi4_inv_hyb wn=3.40 wps=11.20 wpl=5.60 nfn=2 nfps=4 nfpl=2
.ends pi4_mux4_tg

.subckt pi4_slice_r ca cb f fb mix vdd vss
Xsa ca sel fb f  vdd vss pi4_tgate_lvt wn=0.65 wp=2.10 nfn=1 nfp=1
Xsb cb sel f  fb vdd vss pi4_tgate_lvt wn=0.65 wp=2.10 nfn=1 nfp=1
Xinv_n drv sel vss vss serdes_nfet_lvt w=0.70 l=0.15 nf=1
Xinv_p drv sel vdd vdd serdes_pfet     w=3.40 l=0.15 nf=2
Xres   drv mix vss sky130_fd_pr__res_high_po_0p69 l=2.2
Xda ca dum f  fb vdd vss pi4_tgate_lvt wn=0.65 wp=2.10 nfn=1 nfp=1
Xdb cb dum fb f  vdd vss pi4_tgate_lvt wn=0.65 wp=2.10 nfn=1 nfp=1
Xdn vss dum vss vss serdes_nfet_lvt w=0.70 l=0.15 nf=1
Xdp vdd dum vdd vdd serdes_pfet     w=3.40 l=0.15 nf=2
.ends pi4_slice_r

.subckt pi4_mixer8 ca cb f0 f1 f2 f3 f4 f5 f6 f7 fb0 fb1 fb2 fb3 fb4 fb5 fb6 fb7 mix vdd vss
Xs0 ca cb f0 fb0 mix vdd vss pi4_slice_r
Xs1 ca cb f1 fb1 mix vdd vss pi4_slice_r
Xs2 ca cb f2 fb2 mix vdd vss pi4_slice_r
Xs3 ca cb f3 fb3 mix vdd vss pi4_slice_r
Xs4 ca cb f4 fb4 mix vdd vss pi4_slice_r
Xs5 ca cb f5 fb5 mix vdd vss pi4_slice_r
Xs6 ca cb f6 fb6 mix vdd vss pi4_slice_r
Xs7 ca cb f7 fb7 mix vdd vss pi4_slice_r
Xcmix mix vss sky130_fd_pr__cap_mim_m3_1 w=1.6 l=1.6
.ends pi4_mixer8

.subckt pi4_diff_rec mixp mixn op on vdd vss
Xcp1 ac1p mixp sky130_fd_pr__cap_mim_m3_1 w=4.8 l=4.8
Xcn1 ac1n mixn sky130_fd_pr__cap_mim_m3_1 w=4.8 l=4.8
Xrp1 ac1p r1n vss sky130_fd_pr__res_high_po_0p35 l=6.5
Xrn1 ac1n r1p vss sky130_fd_pr__res_high_po_0p35 l=6.5
Xmn1p r1n ac1p tail1 vss serdes_nfet_lvt w=7.20 l=0.15 nf=3
Xmn1n r1p ac1n tail1 vss serdes_nfet_lvt w=7.20 l=0.15 nf=3
Xmt1  tail1 vdd vss vss serdes_nfet w=4.60 l=0.20 nf=4
Xmp1p r1n vss vdd vdd serdes_pfet w=3.80 l=0.15 nf=2
Xmp1n r1p vss vdd vdd serdes_pfet w=3.80 l=0.15 nf=2
Xmc1p r1n r1p vdd vdd serdes_pfet w=2.88 l=0.15 nf=2
Xmc1n r1p r1n vdd vdd serdes_pfet w=2.88 l=0.15 nf=2
Xmn2p r2n r1p tail2 vss serdes_nfet_lvt w=12.00 l=0.15 nf=5
Xmn2n r2p r1n tail2 vss serdes_nfet_lvt w=12.00 l=0.15 nf=5
Xmt2  tail2 vdd vss vss serdes_nfet w=9.80 l=0.20 nf=8
Xmp2p r2n vss vdd vdd serdes_pfet w=6.30 l=0.15 nf=4
Xmp2n r2p vss vdd vdd serdes_pfet w=6.30 l=0.15 nf=4
Xmc2p r2n r2p vdd vdd serdes_pfet w=5.04 l=0.15 nf=4
Xmc2n r2p r2n vdd vdd serdes_pfet w=5.04 l=0.15 nf=4
Xr2p r2n op vdd vss pi4_inv_hyb wn=4.20 wps=18.00 wpl=5.60 nfn=2 nfps=6 nfpl=2
Xr2n r2p on vdd vss pi4_inv_hyb wn=4.20 wps=18.00 wpl=5.60 nfn=2 nfps=6 nfpl=2
Xcco op  on vdd vss pi4_cc_align_q wn=0.90 wp=3.80 nfn=1 nfp=2
.ends pi4_diff_rec

.subckt pi4_diff_chan e0 e1 e2 e3 o0 o1 o2 o3
+ sa0 sa1 sa2 sa3 sab0 sab1 sab2 sab3
+ sb0 sb1 sb2 sb3 sbb0 sbb1 sbb2 sbb3
+ f0 f1 f2 f3 f4 f5 f6 f7 fb0 fb1 fb2 fb3 fb4 fb5 fb6 fb7
+ op on vdd vss
Xmap e0 e1 e2 e3 sa0 sa1 sa2 sa3 sab0 sab1 sab2 sab3 cap vdd vss pi4_mux4_tg
Xman e2 e3 e0 e1 sa0 sa1 sa2 sa3 sab0 sab1 sab2 sab3 can vdd vss pi4_mux4_tg
Xmbp o0 o1 o2 o3 sb0 sb1 sb2 sb3 sbb0 sbb1 sbb2 sbb3 cbp vdd vss pi4_mux4_tg
Xmbn o2 o3 o0 o1 sb0 sb1 sb2 sb3 sbb0 sbb1 sbb2 sbb3 cbn vdd vss pi4_mux4_tg
Xmixp cap cbp f0 f1 f2 f3 f4 f5 f6 f7 fb0 fb1 fb2 fb3 fb4 fb5 fb6 fb7 mixp vdd vss pi4_mixer8
Xmixn can cbn f0 f1 f2 f3 f4 f5 f6 f7 fb0 fb1 fb2 fb3 fb4 fb5 fb6 fb7 mixn vdd vss pi4_mixer8
Xrec mixp mixn op on vdd vss pi4_diff_rec
.ends pi4_diff_chan

* ===========================================================================
* 3. Cold-MC-Hardened 1.25 GHz Hybrid-PMOS Dual-Johnson Quadrature /2 (v3)
* ===========================================================================
.subckt pi4_diff_latch dp_in dn_in ck ckb rst_n rst qp qn vdd vss params: wn_tg=2.90 wps_tg=5.60 wpl_tg=2.25 wn_out=3.80 wps_out=10.50 wpl_out=3.50
Xtgp_n  dp_in ck  int_p vss serdes_nfet_lvt w={wn_tg}  l=0.15 nf=2
Xtgp_ps dp_in ckb int_p vdd serdes_pfet     w={wps_tg} l=0.15 nf=2
Xtgp_pl dp_in ckb int_p vdd serdes_pfet_lvt w={wpl_tg} l=0.35 nf=1
Xtgn_n  dn_in ck  int_n vss serdes_nfet_lvt w={wn_tg}  l=0.15 nf=2
Xtgn_ps dn_in ckb int_n vdd serdes_pfet     w={wps_tg} l=0.15 nf=2
Xtgn_pl dn_in ckb int_n vdd serdes_pfet_lvt w={wpl_tg} l=0.35 nf=1
Xkp1 int_p int_n vdd vdd serdes_pfet_lvt w=0.60 l=0.35 nf=1
Xkn1 int_p int_n vss vss serdes_nfet     w=0.60 l=0.28 nf=1
Xkp2 int_n int_p vdd vdd serdes_pfet_lvt w=0.60 l=0.35 nf=1
Xkn2 int_n int_p vss vss serdes_nfet     w=0.60 l=0.28 nf=1
Xrp int_p rst   vss vss serdes_nfet w=1.00 l=0.18 nf=1
Xrn int_n rst_n vdd vdd serdes_pfet w=1.80 l=0.18 nf=1
Xop int_n qp vdd vss pi4_inv_hyb wn={wn_out} wps={wps_out} wpl={wpl_out} nfn=2 nfps=3 nfpl=1
Xon int_p qn vdd vss pi4_inv_hyb wn={wn_out} wps={wps_out} wpl={wpl_out} nfn=2 nfps=3 nfpl=1
Xcc qp    qn vdd vss pi4_cc_align wn=0.65 wp=2.10 nfn=1 nfp=1
.ends pi4_diff_latch

.subckt pi4_diff_latch_e dp_in dn_in ck ckb rst_n rst qp qn int_p int_n vdd vss params: wn_tg=4.00 wps_tg=7.00 wpl_tg=3.20 wn_out=3.80 wps_out=10.50 wpl_out=3.50
Xtgp_n  dp_in ck  int_p vss serdes_nfet_lvt w={wn_tg}  l=0.15 nf=2
Xtgp_ps dp_in ckb int_p vdd serdes_pfet     w={wps_tg} l=0.15 nf=2
Xtgp_pl dp_in ckb int_p vdd serdes_pfet_lvt w={wpl_tg} l=0.35 nf=1
Xtgn_n  dn_in ck  int_n vss serdes_nfet_lvt w={wn_tg}  l=0.15 nf=2
Xtgn_ps dn_in ckb int_n vdd serdes_pfet     w={wps_tg} l=0.15 nf=2
Xtgn_pl dn_in ckb int_n vdd serdes_pfet_lvt w={wpl_tg} l=0.35 nf=1
Xkp1 int_p int_n vdd vdd serdes_pfet_lvt w=0.60 l=0.35 nf=1
Xkn1 int_p int_n vss vss serdes_nfet     w=0.60 l=0.28 nf=1
Xkp2 int_n int_p vdd vdd serdes_pfet_lvt w=0.60 l=0.35 nf=1
Xkn2 int_n int_p vss vss serdes_nfet     w=0.60 l=0.28 nf=1
Xrp int_p rst   vss vss serdes_nfet w=1.00 l=0.18 nf=1
Xrn int_n rst_n vdd vdd serdes_pfet w=1.80 l=0.18 nf=1
Xop int_n qp vdd vss pi4_inv_hyb wn={wn_out} wps={wps_out} wpl={wpl_out} nfn=2 nfps=3 nfpl=1
Xon int_p qn vdd vss pi4_inv_hyb wn={wn_out} wps={wps_out} wpl={wpl_out} nfn=2 nfps=3 nfpl=1
Xcc qp    qn vdd vss pi4_cc_align wn=0.65 wp=2.10 nfn=1 nfp=1
.ends pi4_diff_latch_e

.subckt serdes_rx_qdiv2_8ph_4iq dp dn ep en rst_n ckd0 ckd1 ckd2 ckd3 cke0 cke1 cke2 cke3 vdd vss
* Shared 3-stage staged reset chain (delayed Xrst_d1 clears initial clk-gate unclamp; sharp LVT Xrst_d2 keeps Xrn/Xrp simultaneous)
Xrst      rst_n      rst       vdd vss pi4_inv_lvt wn=2.00 wp=6.00 nfn=2 nfp=3
Xrst_d1   rst        rst_n_lat vdd vss pi4_inv_rstdly wn=0.65 wp=1.60
Xrst_d2   rst_n_lat  rst_lat   vdd vss pi4_inv_lvt wn=2.20 wp=5.40 nfn=2 nfp=3
Xlock     d2 d0 e0 e2 rst_lat inj_en vdd vss pi4_e_lock_ctrl
* Centered 2-stage symmetric TG-isolated reset-gated 2.5 GHz Hybrid-PMOS clock buffers + balanced LVT-PMOS aligners
Xg_dpb dp rst_n rst dp_ckb vdd vss pi4_clk_gate_lo
Xg_dnb dn rst_n rst dn_ckb vdd vss pi4_clk_gate_hi
Xg_epb ep rst_n rst ep_ckb vdd vss pi4_clk_gate_lo
Xg_enb en rst_n rst en_ckb vdd vss pi4_clk_gate_hi
Xg_dp  dp_ckb dp_ck vdd vss pi4_inv_hyb wn=3.50 wps=14.00 wpl=3.50 nfn=2 nfps=4 nfpl=1
Xg_dn  dn_ckb dn_ck vdd vss pi4_inv_hyb wn=3.50 wps=14.00 wpl=3.50 nfn=2 nfps=4 nfpl=1
Xg_ep  ep_ckb ep_ck vdd vss pi4_inv_hyb wn=3.50 wps=14.00 wpl=3.50 nfn=2 nfps=4 nfpl=1
Xg_en  en_ckb en_ck vdd vss pi4_inv_hyb wn=3.50 wps=14.00 wpl=3.50 nfn=2 nfps=4 nfpl=1
Xcc_dck dp_ck dn_ck vdd vss pi4_cc_align wn=0.45 wp=2.30 nfn=1 nfp=2
Xcc_eck ep_ck en_ck vdd vss pi4_cc_align wn=0.45 wp=2.30 nfn=1 nfp=2
* Matched Hybrid-PMOS Dual 1.25 GHz Johnson /2 on D (dp/dn) and E (ep/en)
Xld0 d3 d1 dp_ck dn_ck rst_n_lat rst_lat d0 d2 vdd vss pi4_diff_latch wn_tg=2.90 wps_tg=5.60 wpl_tg=2.25 wn_out=3.80 wps_out=10.50 wpl_out=3.50
Xld1 d0 d2 dn_ck dp_ck rst_n_lat rst_lat d1 d3 vdd vss pi4_diff_latch wn_tg=2.90 wps_tg=5.60 wpl_tg=2.25 wn_out=3.80 wps_out=10.50 wpl_out=3.50
Xle0 e3 e1 ep_ck en_ck rst_n_lat rst_lat e0 e2 e0_intp e0_intn vdd vss pi4_diff_latch_e wn_tg=4.00 wps_tg=7.00 wpl_tg=3.20 wn_out=3.80 wps_out=10.50 wpl_out=3.50
Xle1 e0 e2 en_ck ep_ck rst_n_lat rst_lat e1 e3 e1_intp e1_intn vdd vss pi4_diff_latch_e wn_tg=4.00 wps_tg=7.00 wpl_tg=3.20 wn_out=3.80 wps_out=10.50 wpl_out=3.50
* Unidirectional 2-FET N_LVT pull-down D->E phase injectors (auto-Hi-Z once 0-deg locked) + 8-phase load-matching dummies
Xinj_e0n d2 e0_intn inj_en vss pi4_gated_inj
Xinj_e0p d0 e0_intp inj_en vss pi4_gated_inj
Xinj_e1n d3 e1_intn inj_en vss pi4_gated_inj
Xinj_e1p d1 e1_intp inj_en vss pi4_gated_inj
Xxd_d1   d1 vdd vss pi4_xnor_dum
Xxd_d3   d3 vdd vss pi4_xnor_dum
Xxd_e1   e1 vdd vss pi4_xnor_dum
Xxd_e3   e3 vdd vss pi4_xnor_dum
Xdum_e1  e1 vdd vss pi4_e_dum
Xdum_e3  e3 vdd vss pi4_e_dum
* Hybrid-PMOS 1.25 GHz Output Buffers driving 40 fF Double-Tail slicer + deser16 loads + LVT-PMOS output aligners
Xbd0 d2 ckd0 vdd vss pi4_inv_hyb wn=2.60 wps=9.00 wpl=3.00 nfn=2 nfps=3 nfpl=1
Xbd2 d0 ckd2 vdd vss pi4_inv_hyb wn=2.60 wps=9.00 wpl=3.00 nfn=2 nfps=3 nfpl=1
Xbd1 d3 ckd1 vdd vss pi4_inv_hyb wn=2.60 wps=9.00 wpl=3.00 nfn=2 nfps=3 nfpl=1
Xbd3 d1 ckd3 vdd vss pi4_inv_hyb wn=2.60 wps=9.00 wpl=3.00 nfn=2 nfps=3 nfpl=1
Xbe0 e0 cke0 vdd vss pi4_inv_hyb wn=2.60 wps=9.00 wpl=3.00 nfn=2 nfps=3 nfpl=1
Xbe2 e2 cke2 vdd vss pi4_inv_hyb wn=2.60 wps=9.00 wpl=3.00 nfn=2 nfps=3 nfpl=1
Xbe1 e1 cke1 vdd vss pi4_inv_hyb wn=2.60 wps=9.00 wpl=3.00 nfn=2 nfps=3 nfpl=1
Xbe3 e3 cke3 vdd vss pi4_inv_hyb wn=2.60 wps=9.00 wpl=3.00 nfn=2 nfps=3 nfpl=1
Xccd0 ckd0 ckd2 vdd vss pi4_cc_align wn=0.45 wp=1.40 nfn=1 nfp=1
Xccd1 ckd1 ckd3 vdd vss pi4_cc_align wn=0.45 wp=1.40 nfn=1 nfp=1
Xcce0 cke0 cke2 vdd vss pi4_cc_align wn=0.45 wp=1.40 nfn=1 nfp=1
Xcce1 cke1 cke3 vdd vss pi4_cc_align wn=0.45 wp=1.40 nfn=1 nfp=1
.ends serdes_rx_qdiv2_8ph_4iq

* ===========================================================================
* 4. Integrated 5G 4-Phase I/Q Pure CMOS PI + 8-Phase 1.25 GHz /2 (v3)
* ===========================================================================
.subckt serdes_rx_pi_4ph_iq_8ph ip qp in qn
+ a0 a1 a2 a3 a4 a5 a6 a7
+ b0 b1 b2 b3 b4 b5 b6 b7
+ f0 f1 f2 f3 f4 f5 f6 f7
+ rst_n dp dn ep en ckd0 ckd1 ckd2 ckd3 cke0 cke1 cke2 cke3 vdd vss
Xia0 a0 ab0 vdd vss pi4_inv_static
Xia1 a1 ab1 vdd vss pi4_inv_static
Xia2 a2 ab2 vdd vss pi4_inv_static
Xia3 a3 ab3 vdd vss pi4_inv_static
Xia4 a4 ab4 vdd vss pi4_inv_static
Xia5 a5 ab5 vdd vss pi4_inv_static
Xia6 a6 ab6 vdd vss pi4_inv_static
Xia7 a7 ab7 vdd vss pi4_inv_static
Xib0 b0 bb0 vdd vss pi4_inv_static
Xib1 b1 bb1 vdd vss pi4_inv_static
Xib2 b2 bb2 vdd vss pi4_inv_static
Xib3 b3 bb3 vdd vss pi4_inv_static
Xib4 b4 bb4 vdd vss pi4_inv_static
Xib5 b5 bb5 vdd vss pi4_inv_static
Xib6 b6 bb6 vdd vss pi4_inv_static
Xib7 b7 bb7 vdd vss pi4_inv_static
Xif0 f0 fb0 vdd vss pi4_inv_static
Xif1 f1 fb1 vdd vss pi4_inv_static
Xif2 f2 fb2 vdd vss pi4_inv_static
Xif3 f3 fb3 vdd vss pi4_inv_static
Xif4 f4 fb4 vdd vss pi4_inv_static
Xif5 f5 fb5 vdd vss pi4_inv_static
Xif6 f6 fb6 vdd vss pi4_inv_static
Xif7 f7 fb7 vdd vss pi4_inv_static

Xoct ip qp in qn cb0 cb1 cb2 cb3 cb4 cb5 cb6 cb7 vdd vss serdes_rx_octature_4to8_2p5g

Xch_d cb0 cb2 cb4 cb6 cb1 cb3 cb5 cb7
+ a0 a2 a4 a6 ab0 ab2 ab4 ab6
+ b1 b3 b5 b7 bb1 bb3 bb5 bb7
+ f0 f1 f2 f3 f4 f5 f6 f7 fb0 fb1 fb2 fb3 fb4 fb5 fb6 fb7
+ dp dn vdd vss pi4_diff_chan

Xch_e cb2 cb4 cb6 cb0 cb3 cb5 cb7 cb1
+ a0 a2 a4 a6 ab0 ab2 ab4 ab6
+ b1 b3 b5 b7 bb1 bb3 bb5 bb7
+ f0 f1 f2 f3 f4 f5 f6 f7 fb0 fb1 fb2 fb3 fb4 fb5 fb6 fb7
+ ep en vdd vss pi4_diff_chan

Xdiv dp dn ep en rst_n ckd0 ckd1 ckd2 ckd3 cke0 cke1 cke2 cke3 vdd vss serdes_rx_qdiv2_8ph_4iq
.ends serdes_rx_pi_4ph_iq_8ph
