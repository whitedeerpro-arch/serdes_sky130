* Single-stage differential CTLE prototype for low input common mode.
* Dependencies: sky130_primitives.spice and cmos_logic.spice.
* Positive input differential -> positive output differential.
* Two separate real LVT bias sinks avoid a DC drop across the bridge Rdeg.
* eq0/eq1 are1.8V static controls of actual transmission gates.
* 00 = minimum-peaking mode, NOT a physical signal-path bypass.
* Capacitors are ideal nominal values; input/output parasitics are MOS models.
.subckt serdes_rx_ctle_rc inp inn outp outn eq0 eq1 vbias vdd vss
+ params: win=24 nfin=8 wtail=48 nftail=8 rload=600 rdeg=600 cunit=200f wsw=4
Rp vdd outp {rload}
Rn vdd outn {rload}
Xip outn inp sp vss serdes_nfet_lvt w={win} nf={nfin}
Xin outp inn sn vss serdes_nfet_lvt w={win} nf={nfin}
Xtp sp vbias vss vss serdes_nfet_lvt w={wtail} l=0.5 nf={nftail}
Xtn sn vbias vss vss serdes_nfet_lvt w={wtail} l=0.5 nf={nftail}
Rdeg sp sn {rdeg}
Xeq0 eq0 eq0_b vdd vss serdes_cmos_inv wn=1 wp=2
Xeq1 eq1 eq1_b vdd vss serdes_cmos_inv wn=1 wp=2
Ceq0 sp cap0 {cunit}
Ceq1 sp cap1 {2*cunit}
Xsw0 cap0 sn eq0 eq0_b vdd vss serdes_cmos_tgate wn={wsw} wp={2*wsw}
Xsw1 cap1 sn eq1 eq1_b vdd vss serdes_cmos_tgate wn={wsw} wp={2*wsw}
* Establish DC plate voltage with disabled switches; not an ideal floating node.
Rbleed0 cap0 sn 1G
Rbleed1 cap1 sn 1G
.ends serdes_rx_ctle_rc
