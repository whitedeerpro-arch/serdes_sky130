* Current-steered unit for adjacent-phase CML interpolation.
* A/B input pairs share output loads. One real tail always biases the selected pair.
* enb chooses B; ena chooses A. Controls are CMOS levels.
.subckt serdes_pi_unit ap an bp bn qp qn ena enb vbias vdd vss
+ params: win=4 wsel=4 wtail=1.5
Xap qn ap ta vss serdes_nfet_lvt w={win} nf=2
Xan qp an ta vss serdes_nfet_lvt w={win} nf=2
Xbp qn bp tb vss serdes_nfet_lvt w={win} nf=2
Xbn qp bn tb vss serdes_nfet_lvt w={win} nf=2
Xsa ta ena tc vss serdes_nfet_lvt w={wsel} nf=2
Xsb tb enb tc vss serdes_nfet_lvt w={wsel} nf=2
Xt tc vbias vss vss serdes_nfet w={wtail} l=0.5 nf=1
Rba ta tc 1G
Rbb tb tc 1G
.ends serdes_pi_unit
