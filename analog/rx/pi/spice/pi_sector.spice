* Eight equal current units, B count0..8, total current held by real MOS sinks.
* Weights select which input pair receives each unit current, not output voltage mixing.
* A/B are adjacent phases. 00..00 is pure A;11..11 is pure B.
.subckt serdes_pi_sector ap an bp bn b0 b1 b2 b3 b4 b5 b6 b7 op on vbias vdd vss
+ params: win=4 wsel=4 wtail=1.5 rload=600 cmix=200f out_w=24 out_wt=6 out_r=800
Rp vdd mp {rload}
Rn vdd mn {rload}
Cmp mp vss {cmix}
Cmn mn vss {cmix}
Xi0 b0 ab0 vdd vss serdes_cmos_inv wn=1 wp=2
Xca0 b0 a0 vdd vss serdes_cmos_inv wn=4 wp=8
Xcb0 ab0 bb0 vdd vss serdes_cmos_inv wn=4 wp=8
Xu0 ap an bp bn mp mn a0 bb0 vbias vdd vss serdes_pi_unit win={win} wsel={wsel} wtail={wtail}
Xi1 b1 ab1 vdd vss serdes_cmos_inv wn=1 wp=2
Xca1 b1 a1 vdd vss serdes_cmos_inv wn=4 wp=8
Xcb1 ab1 bb1 vdd vss serdes_cmos_inv wn=4 wp=8
Xu1 ap an bp bn mp mn a1 bb1 vbias vdd vss serdes_pi_unit win={win} wsel={wsel} wtail={wtail}
Xi2 b2 ab2 vdd vss serdes_cmos_inv wn=1 wp=2
Xca2 b2 a2 vdd vss serdes_cmos_inv wn=4 wp=8
Xcb2 ab2 bb2 vdd vss serdes_cmos_inv wn=4 wp=8
Xu2 ap an bp bn mp mn a2 bb2 vbias vdd vss serdes_pi_unit win={win} wsel={wsel} wtail={wtail}
Xi3 b3 ab3 vdd vss serdes_cmos_inv wn=1 wp=2
Xca3 b3 a3 vdd vss serdes_cmos_inv wn=4 wp=8
Xcb3 ab3 bb3 vdd vss serdes_cmos_inv wn=4 wp=8
Xu3 ap an bp bn mp mn a3 bb3 vbias vdd vss serdes_pi_unit win={win} wsel={wsel} wtail={wtail}
Xi4 b4 ab4 vdd vss serdes_cmos_inv wn=1 wp=2
Xca4 b4 a4 vdd vss serdes_cmos_inv wn=4 wp=8
Xcb4 ab4 bb4 vdd vss serdes_cmos_inv wn=4 wp=8
Xu4 ap an bp bn mp mn a4 bb4 vbias vdd vss serdes_pi_unit win={win} wsel={wsel} wtail={wtail}
Xi5 b5 ab5 vdd vss serdes_cmos_inv wn=1 wp=2
Xca5 b5 a5 vdd vss serdes_cmos_inv wn=4 wp=8
Xcb5 ab5 bb5 vdd vss serdes_cmos_inv wn=4 wp=8
Xu5 ap an bp bn mp mn a5 bb5 vbias vdd vss serdes_pi_unit win={win} wsel={wsel} wtail={wtail}
Xi6 b6 ab6 vdd vss serdes_cmos_inv wn=1 wp=2
Xca6 b6 a6 vdd vss serdes_cmos_inv wn=4 wp=8
Xcb6 ab6 bb6 vdd vss serdes_cmos_inv wn=4 wp=8
Xu6 ap an bp bn mp mn a6 bb6 vbias vdd vss serdes_pi_unit win={win} wsel={wsel} wtail={wtail}
Xi7 b7 ab7 vdd vss serdes_cmos_inv wn=1 wp=2
Xca7 b7 a7 vdd vss serdes_cmos_inv wn=4 wp=8
Xcb7 ab7 bb7 vdd vss serdes_cmos_inv wn=4 wp=8
Xu7 ap an bp bn mp mn a7 bb7 vbias vdd vss serdes_pi_unit win={win} wsel={wsel} wtail={wtail}
Xrestore mp mn op on vbias vdd vss serdes_cml_buffer wn={out_w} wt={out_wt} rload={out_r}
.ends serdes_pi_sector
