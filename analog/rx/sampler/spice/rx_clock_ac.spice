* AC-coupled CML clock interface for the RX sample DFFs (replaces the source-follower shift).
* A resistive CML gain stage restores the PI clock swing; series capacitors cc block its DC level,
* and the latch clock gates are biased through rb from a shared reference vck (serdes_rx_clock_ref).
* Mean gate level = v(vck) exactly in periodic steady state (no DC path but rb); upstream static
* differential offset (offset-induced duty-cycle error) is removed.  Ideal C/R: cbp models the MIM
* bottom-plate parasitic on the driver side (10 % of cc).  High-pass corner 1/(2 pi rb (cc + Cgate)).
* Dependencies: common/cml_buffer/spice/cml_delay_resistive.spice.
.subckt serdes_rx_clock_ac cp cn gp gn vck vbias vdd vss
+ params: wn=40 nfin=8 wt=24 rload=300 cc=0.6p rb=50k
* inverting delay cell with swapped outputs: bp follows cp
Xbuf cp cn bn bp vbias vdd vss serdes_cml_delay wn={wn} nfin={nfin} wt={wt} lt=0.5 rload={rload}
Ccp bp gp {cc}
Ccn bn gn {cc}
Cbp bp vss {0.1*cc}
Cbn bn vss {0.1*cc}
Rbp gp vck {rb}
Rbn gn vck {rb}
.ends serdes_rx_clock_ac

* Clock-gate bias reference: vck = k * VDD from a resistive divider, decoupled.
* k = 0.634 centres the 45-condition clock common-mode window of the low-overdrive sample DFF
* (analog/rx/sampler/theory/clock_interface_plan.py).
.subckt serdes_rx_clock_ref vck vdd vss
+ params: k=0.634 rtot=100k cdec=2p
Rtop vdd vck {(1-k)*rtot}
Rbot vck vss {k*rtot}
Cdec vck vss {cdec}
.ends serdes_rx_clock_ref

* Same interface with the buffer outputs bp/bn brought out (readout clock tap, 2026-11-02).
.subckt serdes_rx_clock_ac_tap cp cn gp gn bp bn vck vbias vdd vss
+ params: wn=40 nfin=8 wt=24 rload=300 cc=0.6p rb=50k
Xbuf cp cn bn bp vbias vdd vss serdes_cml_delay wn={wn} nfin={nfin} wt={wt} lt=0.5 rload={rload}
Ccp bp gp {cc}
Ccn bn gn {cc}
Cbp bp vss {0.1*cc}
Cbn bn vss {0.1*cc}
Rbp gp vck {rb}
Rbn gn vck {rb}
.ends serdes_rx_clock_ac_tap
