* Half-rate CML samplers, variant AC (2026-11-01): low-overdrive latch tails + AC-coupled clocks.
* Same ports, sampling order and internal node names (bp/bn, cdp/cdn, cep/cen) as
* serdes_rx_half_rate_samples; differences:
*  - latch tails W72 x 24 fingers on a local low-overdrive reference (PLL r2 pll_cml_tail_bias,
*    ~510 uA nominal, Vdsat ~0.18 V instead of ~0.38 V);
*  - clocks: CML gain stage + series cc + rb to vck = k*VDD (serdes_rx_clock_ac/_ref) instead of
*    the LVT source followers; the gate common mode no longer depends on the PI output level.
* Clock buffer c2 (2026-11-02, sizing iteration 2): 600 ohm, 1.53 mA (wt 36), cc 0.45 pF, gate clock
* >= 300 mVpp over 45 conditions; r1 (2026-11-01) was 300 ohm, 1.02 mA (wt 24), cc 0.6 pF.
* Dependencies: cml_buffer.spice, cml_delay_resistive.spice, pll/divider cml_latch.spice and
* cml_div2.spice (pll_cml_tail_bias), rx_sample_dff.spice, rx_clock_ac.spice.
.subckt serdes_rx_half_rate_samples_ac ip in dp dn ep en
+ d0p d0n d1p d1n e0p e0n e1p e1n vbias vdd vss
+ params: wdata=16 whold=48 wclock=32 wtail=72 nftail=24 rload=600
+ ck_wn=40 ck_nfin=8 ck_wt=36 ck_rload=600 cc=0.45p rb=50k k=0.634
Xinput ip in bp bn vbias vdd vss serdes_cml_buffer wn=24 wt=12 rload=600
Xlb vbias vbias_logic vdd vss pll_cml_tail_bias
Xref vck vdd vss serdes_rx_clock_ref k={k}
Xcd dp dn cdp cdn vck vbias vdd vss serdes_rx_clock_ac
+ wn={ck_wn} nfin={ck_nfin} wt={ck_wt} rload={ck_rload} cc={cc} rb={rb}
Xce ep en cep cen vck vbias vdd vss serdes_rx_clock_ac
+ wn={ck_wn} nfin={ck_nfin} wt={ck_wt} rload={ck_rload} cc={cc} rb={rb}
Xd0 bp bn cdp cdn d0p d0n vbias_logic vdd vss serdes_rx_sample_dff
+ wdata={wdata} whold={whold} wclock={wclock} wtail={wtail} nftail={nftail} rload={rload}
Xd1 bp bn cdn cdp d1p d1n vbias_logic vdd vss serdes_rx_sample_dff
+ wdata={wdata} whold={whold} wclock={wclock} wtail={wtail} nftail={nftail} rload={rload}
Xe0 bp bn cep cen e0p e0n vbias_logic vdd vss serdes_rx_sample_dff
+ wdata={wdata} whold={whold} wclock={wclock} wtail={wtail} nftail={nftail} rload={rload}
Xe1 bp bn cen cep e1p e1n vbias_logic vdd vss serdes_rx_sample_dff
+ wdata={wdata} whold={whold} wclock={wclock} wtail={wtail} nftail={nftail} rload={rload}
.ends serdes_rx_half_rate_samples_ac

* Variant ac_rk (2026-11-02): serdes_rx_half_rate_samples_ac plus a CML readout clock rkp/rkn.
* A small CML buffer taps the edge-clock buffer output (large swing, VDD - I R / 2 common mode) and
* restores the PLL standard clock input: common mode VDD - 0.15 V, swing limited by its I R (the
* boundary at which serdes_cml_to_cmos_r4 and pll_cml_div2 were verified).  Same internal names.
.subckt serdes_rx_half_rate_samples_ac_rk ip in dp dn ep en
+ d0p d0n d1p d1n e0p e0n e1p e1n rkp rkn vbias vdd vss
+ params: wdata=16 whold=48 wclock=32 wtail=72 nftail=24 rload=600
+ ck_wn=40 ck_nfin=8 ck_wt=36 ck_rload=600 cc=0.45p rb=50k k=0.634
+ rk_wn=16 rk_nfin=4 rk_wt=24 rk_rload=300
Xinput ip in bp bn vbias vdd vss serdes_cml_buffer wn=24 wt=12 rload=600
Xlb vbias vbias_logic vdd vss pll_cml_tail_bias
Xref vck vdd vss serdes_rx_clock_ref k={k}
Xcd dp dn cdp cdn vck vbias vdd vss serdes_rx_clock_ac
+ wn={ck_wn} nfin={ck_nfin} wt={ck_wt} rload={ck_rload} cc={cc} rb={rb}
Xce ep en cep cen tbp tbn vck vbias vdd vss serdes_rx_clock_ac_tap
+ wn={ck_wn} nfin={ck_nfin} wt={ck_wt} rload={ck_rload} cc={cc} rb={rb}
Xrk tbp tbn rkp rkn vbias vdd vss serdes_cml_buffer wn={rk_wn} nfin={rk_nfin} wt={rk_wt} rload={rk_rload}
Xd0 bp bn cdp cdn d0p d0n vbias_logic vdd vss serdes_rx_sample_dff
+ wdata={wdata} whold={whold} wclock={wclock} wtail={wtail} nftail={nftail} rload={rload}
Xd1 bp bn cdn cdp d1p d1n vbias_logic vdd vss serdes_rx_sample_dff
+ wdata={wdata} whold={whold} wclock={wclock} wtail={wtail} nftail={nftail} rload={rload}
Xe0 bp bn cep cen e0p e0n vbias_logic vdd vss serdes_rx_sample_dff
+ wdata={wdata} whold={whold} wclock={wclock} wtail={wtail} nftail={nftail} rload={rload}
Xe1 bp bn cen cep e1p e1n vbias_logic vdd vss serdes_rx_sample_dff
+ wdata={wdata} whold={whold} wclock={wclock} wtail={wtail} nftail={nftail} rload={rload}
.ends serdes_rx_half_rate_samples_ac_rk

* Variant ac_cal (2026-11-03): serdes_rx_half_rate_samples_ac with a 6-bit offset trim DAC per sample
* DFF (rx_offset_dac.spice, on the master latch nodes); code bits <lane>b0..b5 are static CMOS levels,
* after vss in the port list (the ac ports first, so benches written for ac only append them).
* Same internal names as ac (bp/bn, cdp/cdn, cep/cen, x<lane>.mp/mn).
.subckt serdes_rx_half_rate_samples_ac_cal ip in dp dn ep en
+ d0p d0n d1p d1n e0p e0n e1p e1n vbias vdd vss
+ d0b0 d0b1 d0b2 d0b3 d0b4 d0b5 d1b0 d1b1 d1b2 d1b3 d1b4 d1b5
+ e0b0 e0b1 e0b2 e0b3 e0b4 e0b5 e1b0 e1b1 e1b2 e1b3 e1b4 e1b5
+ params: wdata=16 whold=48 wclock=32 wtail=72 nftail=24 rload=600
+ ck_wn=40 ck_nfin=8 ck_wt=36 ck_rload=600 cc=0.45p rb=50k k=0.634 wu=1 lu=2 ws=0.42 dac_k=8
Xinput ip in bp bn vbias vdd vss serdes_cml_buffer wn=24 wt=12 rload=600
Xlb vbias vbias_logic vdd vss pll_cml_tail_bias
Xdb vbias_logic vbd vdd vss serdes_rx_offset_dac_bias wu={wu} lu={lu} k={dac_k}
Xref vck vdd vss serdes_rx_clock_ref k={k}
Xcd dp dn cdp cdn vck vbias vdd vss serdes_rx_clock_ac
+ wn={ck_wn} nfin={ck_nfin} wt={ck_wt} rload={ck_rload} cc={cc} rb={rb}
Xce ep en cep cen vck vbias vdd vss serdes_rx_clock_ac
+ wn={ck_wn} nfin={ck_nfin} wt={ck_wt} rload={ck_rload} cc={cc} rb={rb}
Xd0 bp bn cdp cdn d0p d0n d0b0 d0b1 d0b2 d0b3 d0b4 d0b5 vbd vbias_logic vdd vss serdes_rx_sample_dff_cal
+ wdata={wdata} whold={whold} wclock={wclock} wtail={wtail} nftail={nftail} rload={rload} wu={wu} lu={lu} ws={ws}
Xd1 bp bn cdn cdp d1p d1n d1b0 d1b1 d1b2 d1b3 d1b4 d1b5 vbd vbias_logic vdd vss serdes_rx_sample_dff_cal
+ wdata={wdata} whold={whold} wclock={wclock} wtail={wtail} nftail={nftail} rload={rload} wu={wu} lu={lu} ws={ws}
Xe0 bp bn cep cen e0p e0n e0b0 e0b1 e0b2 e0b3 e0b4 e0b5 vbd vbias_logic vdd vss serdes_rx_sample_dff_cal
+ wdata={wdata} whold={whold} wclock={wclock} wtail={wtail} nftail={nftail} rload={rload} wu={wu} lu={lu} ws={ws}
Xe1 bp bn cen cep e1p e1n e1b0 e1b1 e1b2 e1b3 e1b4 e1b5 vbd vbias_logic vdd vss serdes_rx_sample_dff_cal
+ wdata={wdata} whold={whold} wclock={wclock} wtail={wtail} nftail={nftail} rload={rload} wu={wu} lu={lu} ws={ws}
.ends serdes_rx_half_rate_samples_ac_cal

* Variant ac_trim (2026-11-03): serdes_rx_half_rate_samples_ac with the voltage-mode offset trim
* (rx_offset_trim.spice: auxiliary pair in each master latch, 6-bit DAC into a resistor tee, unit
* current from one input-buffer tail finger).  Ports and code bits as ac_cal.
* Same internal names as ac (bp/bn, cdp/cdn, cep/cen, x<lane>.mp/mn).
.subckt serdes_rx_half_rate_samples_ac_trim ip in dp dn ep en
+ d0p d0n d1p d1n e0p e0n e1p e1n vbias vdd vss
+ d0b0 d0b1 d0b2 d0b3 d0b4 d0b5 d1b0 d1b1 d1b2 d1b3 d1b4 d1b5
+ e0b0 e0b1 e0b2 e0b3 e0b4 e0b5 e1b0 e1b1 e1b2 e1b3 e1b4 e1b5
+ params: wdata=16 whold=48 wclock=32 wtail=72 nftail=24 rload=600
+ ck_wn=40 ck_nfin=8 ck_wt=36 ck_rload=600 cc=0.45p rb=50k k=0.634 waux=8 nfaux=2 rt=2.45k rc=1.21k dtail=8
Xinput ip in bp bn vbias vdd vss serdes_cml_buffer wn=24 wt=12 rload=600
Xlb vbias vbias_logic vdd vss pll_cml_tail_bias
Xdb vbias vbd vdd vss serdes_rx_offset_trim_bias
Xref vck vdd vss serdes_rx_clock_ref k={k}
Xcd dp dn cdp cdn vck vbias vdd vss serdes_rx_clock_ac
+ wn={ck_wn} nfin={ck_nfin} wt={ck_wt} rload={ck_rload} cc={cc} rb={rb}
Xce ep en cep cen vck vbias vdd vss serdes_rx_clock_ac
+ wn={ck_wn} nfin={ck_nfin} wt={ck_wt} rload={ck_rload} cc={cc} rb={rb}
Xd0 bp bn cdp cdn d0p d0n d0b0 d0b1 d0b2 d0b3 d0b4 d0b5 vbd vbias_logic vdd vss serdes_rx_sample_dff_trim
+ wdata={wdata} whold={whold} wclock={wclock} wtail={wtail} nftail={nftail} rload={rload} waux={waux} nfaux={nfaux} rt={rt} rc={rc} dtail={dtail}
Xd1 bp bn cdn cdp d1p d1n d1b0 d1b1 d1b2 d1b3 d1b4 d1b5 vbd vbias_logic vdd vss serdes_rx_sample_dff_trim
+ wdata={wdata} whold={whold} wclock={wclock} wtail={wtail} nftail={nftail} rload={rload} waux={waux} nfaux={nfaux} rt={rt} rc={rc} dtail={dtail}
Xe0 bp bn cep cen e0p e0n e0b0 e0b1 e0b2 e0b3 e0b4 e0b5 vbd vbias_logic vdd vss serdes_rx_sample_dff_trim
+ wdata={wdata} whold={whold} wclock={wclock} wtail={wtail} nftail={nftail} rload={rload} waux={waux} nfaux={nfaux} rt={rt} rc={rc} dtail={dtail}
Xe1 bp bn cen cep e1p e1n e1b0 e1b1 e1b2 e1b3 e1b4 e1b5 vbd vbias_logic vdd vss serdes_rx_sample_dff_trim
+ wdata={wdata} whold={whold} wclock={wclock} wtail={wtail} nftail={nftail} rload={rload} waux={waux} nfaux={nfaux} rt={rt} rc={rc} dtail={dtail}
.ends serdes_rx_half_rate_samples_ac_trim

* Variant ac_trim_rk (2026-11-03): ac_trim plus the CML readout clock rkp/rkn of ac_rk; serdes_rx_half_rate_samples_ac with the voltage-mode offset trim
* (rx_offset_trim.spice: auxiliary pair in each master latch, 6-bit DAC into a resistor tee, unit
* current from one input-buffer tail finger).  Ports and code bits as ac_cal.
* Same internal names as ac (bp/bn, cdp/cdn, cep/cen, x<lane>.mp/mn).
.subckt serdes_rx_half_rate_samples_ac_trim_rk ip in dp dn ep en
+ d0p d0n d1p d1n e0p e0n e1p e1n rkp rkn vbias vdd vss
+ d0b0 d0b1 d0b2 d0b3 d0b4 d0b5 d1b0 d1b1 d1b2 d1b3 d1b4 d1b5
+ e0b0 e0b1 e0b2 e0b3 e0b4 e0b5 e1b0 e1b1 e1b2 e1b3 e1b4 e1b5
+ params: wdata=16 whold=48 wclock=32 wtail=72 nftail=24 rload=600
+ ck_wn=40 ck_nfin=8 ck_wt=36 ck_rload=600 cc=0.45p rb=50k k=0.634 waux=8 nfaux=2 rt=2.45k rc=1.21k dtail=8
+ rk_wn=16 rk_nfin=4 rk_wt=24 rk_rload=300
Xinput ip in bp bn vbias vdd vss serdes_cml_buffer wn=24 wt=12 rload=600
Xlb vbias vbias_logic vdd vss pll_cml_tail_bias
Xdb vbias vbd vdd vss serdes_rx_offset_trim_bias
Xref vck vdd vss serdes_rx_clock_ref k={k}
Xcd dp dn cdp cdn vck vbias vdd vss serdes_rx_clock_ac
+ wn={ck_wn} nfin={ck_nfin} wt={ck_wt} rload={ck_rload} cc={cc} rb={rb}
Xce ep en cep cen tbp tbn vck vbias vdd vss serdes_rx_clock_ac_tap
+ wn={ck_wn} nfin={ck_nfin} wt={ck_wt} rload={ck_rload} cc={cc} rb={rb}
Xrk tbp tbn rkp rkn vbias vdd vss serdes_cml_buffer wn={rk_wn} nfin={rk_nfin} wt={rk_wt} rload={rk_rload}
Xd0 bp bn cdp cdn d0p d0n d0b0 d0b1 d0b2 d0b3 d0b4 d0b5 vbd vbias_logic vdd vss serdes_rx_sample_dff_trim
+ wdata={wdata} whold={whold} wclock={wclock} wtail={wtail} nftail={nftail} rload={rload} waux={waux} nfaux={nfaux} rt={rt} rc={rc} dtail={dtail}
Xd1 bp bn cdn cdp d1p d1n d1b0 d1b1 d1b2 d1b3 d1b4 d1b5 vbd vbias_logic vdd vss serdes_rx_sample_dff_trim
+ wdata={wdata} whold={whold} wclock={wclock} wtail={wtail} nftail={nftail} rload={rload} waux={waux} nfaux={nfaux} rt={rt} rc={rc} dtail={dtail}
Xe0 bp bn cep cen e0p e0n e0b0 e0b1 e0b2 e0b3 e0b4 e0b5 vbd vbias_logic vdd vss serdes_rx_sample_dff_trim
+ wdata={wdata} whold={whold} wclock={wclock} wtail={wtail} nftail={nftail} rload={rload} waux={waux} nfaux={nfaux} rt={rt} rc={rc} dtail={dtail}
Xe1 bp bn cen cep e1p e1n e1b0 e1b1 e1b2 e1b3 e1b4 e1b5 vbd vbias_logic vdd vss serdes_rx_sample_dff_trim
+ wdata={wdata} whold={whold} wclock={wclock} wtail={wtail} nftail={nftail} rload={rload} waux={waux} nfaux={nfaux} rt={rt} rc={rc} dtail={dtail}
.ends serdes_rx_half_rate_samples_ac_trim_rk
