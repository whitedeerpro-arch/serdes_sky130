* Sampler offset trim (2026-11-03): 6-bit current-steering DAC on the master latch nodes.
* Bit k = 2^k unit sinks (one device, 2^k fingers of wu x lu, gate vbd) and a switch pair that steers
* them to op (code bit 1) or on (code bit 0).  The total sink current is 63 units at every code, so the
* node common mode does not move with the code; the differential sink is (2c - 63) units,
* c = sum b_k 2^k.  The switch that conducts sits in saturation (cascode): the node sees only its
* drain capacitance.  Code bits are static CMOS levels (set by the calibration logic); the complements
* come from local inverters.
* Input-referred offset shift ~ gain * (2c - 63) * Iu, gain ~ 1/gm of the master input pair
* (tb/offset_dac); a larger sink on op needs a more positive input to flip the latch.
* Unit current: serdes_rx_offset_dac_bias copies one latch-tail finger (W3 L0.5 on the tail bias, so
* it tracks the tail current) through a PMOS mirror into a diode of k units of the DAC geometry; the
* units mirror that diode exactly, Iu = I(tail finger) / k.  First version (units W0.42 L0.5 straight
* on the tail bias): the narrow unit did not track the 3-5 um fingers, total current 68-260 uA over
* the MOS corners (slow NMOS low, fast high).
.subckt serdes_rx_offset_dac op on b0 b1 b2 b3 b4 b5 vbd vdd vss
+ params: wu=1 lu=2 ws=0.42 ls=0.15
Xi0 s0 vbd vss vss serdes_nfet w={wu} l={lu} nf=1
Xi1 s1 vbd vss vss serdes_nfet w={2*wu} l={lu} nf=2
Xi2 s2 vbd vss vss serdes_nfet w={4*wu} l={lu} nf=4
Xi3 s3 vbd vss vss serdes_nfet w={8*wu} l={lu} nf=8
Xi4 s4 vbd vss vss serdes_nfet w={16*wu} l={lu} nf=16
Xi5 s5 vbd vss vss serdes_nfet w={32*wu} l={lu} nf=32
Xv0 b0 n0 vdd vss serdes_cmos_inv
Xv1 b1 n1 vdd vss serdes_cmos_inv
Xv2 b2 n2 vdd vss serdes_cmos_inv
Xv3 b3 n3 vdd vss serdes_cmos_inv
Xv4 b4 n4 vdd vss serdes_cmos_inv
Xv5 b5 n5 vdd vss serdes_cmos_inv
Xp0 op b0 s0 vss serdes_nfet w={ws} l={ls}
Xn0 on n0 s0 vss serdes_nfet w={ws} l={ls}
Xp1 op b1 s1 vss serdes_nfet w={ws} l={ls}
Xn1 on n1 s1 vss serdes_nfet w={ws} l={ls}
Xp2 op b2 s2 vss serdes_nfet w={ws} l={ls}
Xn2 on n2 s2 vss serdes_nfet w={ws} l={ls}
Xp3 op b3 s3 vss serdes_nfet w={ws} l={ls}
Xn3 on n3 s3 vss serdes_nfet w={ws} l={ls}
Xp4 op b4 s4 vss serdes_nfet w={2*ws} l={ls} nf=2
Xn4 on n4 s4 vss serdes_nfet w={2*ws} l={ls} nf=2
Xp5 op b5 s5 vss serdes_nfet w={4*ws} l={ls} nf=4
Xn5 on n5 s5 vss serdes_nfet w={4*ws} l={ls} nf=4
.ends serdes_rx_offset_dac

* Unit-current reference for the trim DACs of one sampler block (gate line vbd, shared).
.subckt serdes_rx_offset_dac_bias vbias vbd vdd vss params: wu=1 lu=2 k=8 wc=3 lc=0.5 wp=4 lp=0.5
Xc pd vbias vss vss serdes_nfet w={wc} l={lc} nf=1
Xpd pd pd vdd vdd serdes_pfet w={wp} l={lp} nf=1
Xpm vbd pd vdd vdd serdes_pfet w={wp} l={lp} nf=1
Xnd vbd vbd vss vss serdes_nfet w={k*wu} l={lu} nf={k}
Cvbd vbd vss 0.2p
.ends serdes_rx_offset_dac_bias

* Sample DFF with the trim DAC on its master latch outputs (mp / mn); otherwise serdes_rx_sample_dff.
.subckt serdes_rx_sample_dff_cal dp dn cp cn qp qn b0 b1 b2 b3 b4 b5 vbd vbias vdd vss
+ params: wdata=16 whold=48 wclock=32 wtail=12 nftail=4 rload=600 wu=1 lu=2 ws=0.42
Xm dp dn mp mn cn cp vbias vdd vss pll_cml_latch
+ wdata={wdata} whold={whold} wclock={wclock} wtail={wtail} nftail={nftail} rload={rload}
Xs mp mn qp qn cp cn vbias vdd vss pll_cml_latch
+ wdata={wdata} whold={whold} wclock={wclock} wtail={wtail} nftail={nftail} rload={rload}
Xdac mp mn b0 b1 b2 b3 b4 b5 vbd vdd vss serdes_rx_offset_dac wu={wu} lu={lu} ws={ws}
.ends serdes_rx_sample_dff_cal
