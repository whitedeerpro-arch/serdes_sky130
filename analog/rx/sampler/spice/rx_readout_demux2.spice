* RX readout: CML 1:2 demux + matched CML->CMOS conversion (exploratory, 2026-11-02).
* Inputs: the four half-rate sampler lanes (2 Gb/s, CML) and the readout CML clock rkp/rkn (2 GHz,
* PLL standard level) of serdes_rx_half_rate_samples_ac_rk.
* Clocks: pll_cml_div2 on rk gives two 1 GHz clocks 250 ps apart, m (master, toggles on rk rising)
* and q (slave, toggles on rk falling).  Domain Q captures D0 and E1, domain M captures D1 and E0:
* the sampler lanes change 125 ps apart (D0, E1, D1, E0); at TT the Q instant sits ~315 ps after the
* D0 change (E1 ~190 ps after its change), M likewise for D1 / E0 (tb/readout_demux; the first
* assignment D0+E0 / D1+E1 left the edge lanes 52 ps of hold).
* The divider outputs are buffered (one CML buffer each for q and m): driven directly, the eight
* demux DFF clock inputs and the clock receivers slowed the divider loop (m is inside it) until it
* mis-divided at SS/FS 1.65 V (stress run 2026-11-02).
* Demux: per lane two CML DFFs on the two edges of the domain clock -> two 1 Gb/s lanes held 1 ns.
* The DFF is the PLL r2 divider structure with external data (low-overdrive tails on the local
* reference, W80 clock source followers); it triggers on the falling edge of its clkp input.
* Conversion: every CML lane and both domain clocks go through the same static receiver
* (serdes_cml_to_cmos_data), so the converter delay cancels between data and clock; each CMOS lane
* is captured on the opposite edge of its converted domain clock (mid-window, ~0.5 ns either side).
* Sizes are block parameters (dd_*: demux DFFs, cv_*: the receivers, data and clock alike so the
* conversion stays matched, cb_*: divider isolation buffers).  Defaults p2 (2026-11-02): constant-tau
* half scale of the first 45/45 version (DFF widths and tails halved, loads doubled; receivers and
* isolation-buffer currents halved), readout ~10 mA instead of ~18 mA.  First version: dd_wsf=40
* dd_wclock=32 dd_wsf_sink=4 dd_wdata=20 dd_whold=80 dd_wtail=72 dd_nftail=24 dd_rload=600 cb_wt=24
* cb_rload=300 cv_wsf=20 cv_wsink=2 cv_win=6 cv_wload=8 cv_wtail=6.
* Dependencies: sky130_primitives, cmos_logic, cmos_dff_reset, cml_to_cmos (helpers),
* cml_to_cmos_data, pll/divider cml_latch and cml_div2.

.subckt serdes_rx_demux_dff dp dn clkp clkn qp qn vbias vbias_logic vdd vss
+ params: wsf=80 wsf_sink=4 wdata=20 whold=80 wclock=64 wtail=72 nftail=24 rload=600
Xfp vdd clkp ckp vss serdes_nfet_lvt w={wsf} nf=4
Xfn vdd clkn ckn vss serdes_nfet_lvt w={wsf} nf=4
Xsp ckp vbias vss vss serdes_nfet w={wsf_sink} l=.5
Xsn ckn vbias vss vss serdes_nfet w={wsf_sink} l=.5
Xmaster dp dn mp mn ckp ckn vbias_logic vdd vss pll_cml_latch
+ wdata={wdata} whold={whold} wclock={wclock} wtail={wtail} nftail={nftail} rload={rload}
Xslave mp mn qp qn ckn ckp vbias_logic vdd vss pll_cml_latch
+ wdata={wdata} whold={whold} wclock={wclock} wtail={wtail} nftail={nftail} rload={rload}
.ends serdes_rx_demux_dff

.subckt serdes_rx_readout_front d0p d0n d1p d1n e0p e0n e1p e1n rkp rkn
+ ra0 rb0 rae1 rbe1 ra1 rb1 rae0 rbe0 ckq ckqb ckm ckmb vbias vdd vss
+ params: dd_wsf=20 dd_wclock=16 cb_wn=24 cb_nfin=4 cb_wt=12 cb_rload=600
+ dd_wsf_sink=2 dd_wdata=10 dd_whold=40 dd_wtail=36 dd_nftail=12 dd_rload=1200
+ cv_wsf=10 cv_wsink=1 cv_win=3 cv_wload=4 cv_wtail=3
+ ck1_wn=2 ck1_wp=4 ck2_wn=4 ck2_wp=8 ck3_wn=4 ck3_wp=8 div_whold=40
Xlb vbias vbias_logic vdd vss pll_cml_tail_bias
* Hold pair W 40: this divider only ever sees 2 GHz, see pll_cml_prescaler8.  With W 80 it stops at FS 1.65 V 85 C hh.
Xdiv rkp rkn dqp dqn dmp dmn vbias vdd vss pll_cml_div2 whold={div_whold}
* divider isolation buffers (non-inverting): qp/qn, mp/mn are the domain clocks
Xbq dqp dqn qp qn vbias vdd vss serdes_cml_buffer wn={cb_wn} nfin={cb_nfin} wt={cb_wt} rload={cb_rload}
Xbm dmp dmn mp mn vbias vdd vss serdes_cml_buffer wn={cb_wn} nfin={cb_nfin} wt={cb_wt} rload={cb_rload}
* domain Q (qp/qn): D0 and E1; "a" changes on q falling, "b" on q rising
Xa0 d0p d0n qp qn a0p a0n vbias vbias_logic vdd vss serdes_rx_demux_dff wsf={dd_wsf} wclock={dd_wclock}
+ wsf_sink={dd_wsf_sink} wdata={dd_wdata} whold={dd_whold} wtail={dd_wtail} nftail={dd_nftail} rload={dd_rload}
Xb0 d0p d0n qn qp b0p b0n vbias vbias_logic vdd vss serdes_rx_demux_dff wsf={dd_wsf} wclock={dd_wclock}
+ wsf_sink={dd_wsf_sink} wdata={dd_wdata} whold={dd_whold} wtail={dd_wtail} nftail={dd_nftail} rload={dd_rload}
Xae1 e1p e1n qp qn ae1p ae1n vbias vbias_logic vdd vss serdes_rx_demux_dff wsf={dd_wsf} wclock={dd_wclock}
+ wsf_sink={dd_wsf_sink} wdata={dd_wdata} whold={dd_whold} wtail={dd_wtail} nftail={dd_nftail} rload={dd_rload}
Xbe1 e1p e1n qn qp be1p be1n vbias vbias_logic vdd vss serdes_rx_demux_dff wsf={dd_wsf} wclock={dd_wclock}
+ wsf_sink={dd_wsf_sink} wdata={dd_wdata} whold={dd_whold} wtail={dd_wtail} nftail={dd_nftail} rload={dd_rload}
* domain M (mp/mn): D1 and E0
Xa1 d1p d1n mp mn a1p a1n vbias vbias_logic vdd vss serdes_rx_demux_dff wsf={dd_wsf} wclock={dd_wclock}
+ wsf_sink={dd_wsf_sink} wdata={dd_wdata} whold={dd_whold} wtail={dd_wtail} nftail={dd_nftail} rload={dd_rload}
Xb1 d1p d1n mn mp b1p b1n vbias vbias_logic vdd vss serdes_rx_demux_dff wsf={dd_wsf} wclock={dd_wclock}
+ wsf_sink={dd_wsf_sink} wdata={dd_wdata} whold={dd_whold} wtail={dd_wtail} nftail={dd_nftail} rload={dd_rload}
Xae0 e0p e0n mp mn ae0p ae0n vbias vbias_logic vdd vss serdes_rx_demux_dff wsf={dd_wsf} wclock={dd_wclock}
+ wsf_sink={dd_wsf_sink} wdata={dd_wdata} whold={dd_whold} wtail={dd_wtail} nftail={dd_nftail} rload={dd_rload}
Xbe0 e0p e0n mn mp be0p be0n vbias vbias_logic vdd vss serdes_rx_demux_dff wsf={dd_wsf} wclock={dd_wclock}
+ wsf_sink={dd_wsf_sink} wdata={dd_wdata} whold={dd_whold} wtail={dd_wtail} nftail={dd_nftail} rload={dd_rload}
* matched conversion: data lanes and domain clocks through the same receiver
Xca0 a0p a0n ra0 vbias vdd vss serdes_cml_to_cmos_data
+ wsf={cv_wsf} wsink={cv_wsink} win={cv_win} wload={cv_wload} wtail={cv_wtail}
Xcb0 b0p b0n rb0 vbias vdd vss serdes_cml_to_cmos_data
+ wsf={cv_wsf} wsink={cv_wsink} win={cv_win} wload={cv_wload} wtail={cv_wtail}
Xcae0 ae0p ae0n rae0 vbias vdd vss serdes_cml_to_cmos_data
+ wsf={cv_wsf} wsink={cv_wsink} win={cv_win} wload={cv_wload} wtail={cv_wtail}
Xcbe0 be0p be0n rbe0 vbias vdd vss serdes_cml_to_cmos_data
+ wsf={cv_wsf} wsink={cv_wsink} win={cv_win} wload={cv_wload} wtail={cv_wtail}
Xca1 a1p a1n ra1 vbias vdd vss serdes_cml_to_cmos_data
+ wsf={cv_wsf} wsink={cv_wsink} win={cv_win} wload={cv_wload} wtail={cv_wtail}
Xcb1 b1p b1n rb1 vbias vdd vss serdes_cml_to_cmos_data
+ wsf={cv_wsf} wsink={cv_wsink} win={cv_win} wload={cv_wload} wtail={cv_wtail}
Xcae1 ae1p ae1n rae1 vbias vdd vss serdes_cml_to_cmos_data
+ wsf={cv_wsf} wsink={cv_wsink} win={cv_win} wload={cv_wload} wtail={cv_wtail}
Xcbe1 be1p be1n rbe1 vbias vdd vss serdes_cml_to_cmos_data
+ wsf={cv_wsf} wsink={cv_wsink} win={cv_win} wload={cv_wload} wtail={cv_wtail}
Xcq qp qn rq vbias vdd vss serdes_cml_to_cmos_data
+ wsf={cv_wsf} wsink={cv_wsink} win={cv_win} wload={cv_wload} wtail={cv_wtail}
Xcm mp mn rm vbias vdd vss serdes_cml_to_cmos_data
+ wsf={cv_wsf} wsink={cv_wsink} win={cv_win} wload={cv_wload} wtail={cv_wtail}
* domain clock buffers: ck* follows the CML clock p side, ck*b is its complement
Xiq1 rq nq vdd vss serdes_cmos_inv wn={ck1_wn} wp={ck1_wp}
Xiq2 nq ckq vdd vss serdes_cmos_inv wn={ck2_wn} wp={ck2_wp}
Xiq3 ckq ckqb vdd vss serdes_cmos_inv wn={ck3_wn} wp={ck3_wp}
Xim1 rm nm vdd vss serdes_cmos_inv wn={ck1_wn} wp={ck1_wp}
Xim2 nm ckm vdd vss serdes_cmos_inv wn={ck2_wn} wp={ck2_wp}
Xim3 ckm ckmb vdd vss serdes_cmos_inv wn={ck3_wn} wp={ck3_wp}
.ends serdes_rx_readout_front

.subckt serdes_rx_readout_demux2 d0p d0n d1p d1n e0p e0n e1p e1n rkp rkn
+ qa0 qb0 qa1 qb1 qae0 qbe0 qae1 qbe1 ckq ckm rst_b vbias vdd vss
+ params: dd_wsf=20 dd_wclock=16 cb_wn=24 cb_nfin=4 cb_wt=12 cb_rload=600
+ dd_wsf_sink=2 dd_wdata=10 dd_whold=40 dd_wtail=36 dd_nftail=12 dd_rload=1200
+ cv_wsf=10 cv_wsink=1 cv_win=3 cv_wload=4 cv_wtail=3
Xf d0p d0n d1p d1n e0p e0n e1p e1n rkp rkn ra0 rb0 rae1 rbe1 ra1 rb1 rae0 rbe0 ckq ckqb ckm ckmb vbias vdd vss
+ serdes_rx_readout_front dd_wsf={dd_wsf} dd_wclock={dd_wclock} cb_wn={cb_wn} cb_nfin={cb_nfin} cb_wt={cb_wt} cb_rload={cb_rload}
+ dd_wsf_sink={dd_wsf_sink} dd_wdata={dd_wdata} dd_whold={dd_whold} dd_wtail={dd_wtail} dd_nftail={dd_nftail} dd_rload={dd_rload}
+ cv_wsf={cv_wsf} cv_wsink={cv_wsink} cv_win={cv_win} cv_wload={cv_wload} cv_wtail={cv_wtail}
* CMOS capture mid-window: "a" lanes (changed on the clock falling edge) on the rising edge, "b" lanes on the falling
Xfa0 ra0 ckq rst_b qa0 vdd vss serdes_cmos_dff_reset
Xfb0 rb0 ckqb rst_b qb0 vdd vss serdes_cmos_dff_reset
Xfae1 rae1 ckq rst_b qae1 vdd vss serdes_cmos_dff_reset
Xfbe1 rbe1 ckqb rst_b qbe1 vdd vss serdes_cmos_dff_reset
Xfa1 ra1 ckm rst_b qa1 vdd vss serdes_cmos_dff_reset
Xfb1 rb1 ckmb rst_b qb1 vdd vss serdes_cmos_dff_reset
Xfae0 rae0 ckm rst_b qae0 vdd vss serdes_cmos_dff_reset
Xfbe0 rbe0 ckmb rst_b qbe0 vdd vss serdes_cmos_dff_reset
.ends serdes_rx_readout_demux2
