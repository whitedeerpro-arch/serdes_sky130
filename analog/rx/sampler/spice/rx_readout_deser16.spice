* RX readout to 16-UI words: CML 1:2 demux + matched conversion (serdes_rx_readout_front) and a CMOS
* 1:4 per lane (exploratory, 2026-11-02).
* Inputs: the four half-rate sampler lanes and the readout CML clock rk of serdes_rx_half_rate_samples_ac_rk.
* Outputs: 8 lanes x 4 bits (<lane>_<k>, k = 0 newest .. 3 oldest of the lane in the word) held 4 ns,
* and the word clock w (250 MHz).  Lane names as in the front: a0 / b0 (D0), ae1 / be1 (E1) on the
* q domain, a1 / b1 (D1), ae0 / be0 (E0) on the m domain.  The chronological order of the 32 bits
* (16 data, 16 edge) is fixed by the structure; tb/readout_deser derives it and checks it is the same
* contiguous 16-UI window on every PVT condition.
* Per lane (serdes_rx_cmos_lane4): stage 0 captures the converted lane on its clock phase X (ckq for
* "a" lanes of q, ckqb for "b", ckm / ckmb likewise), stages 1-3 shift on the same edge, and a word
* register takes all four on the strobe of X, which rises half a clock period after X.
* Word clock (serdes_rx_cmos_wordclk): a 2-bit Johnson counter on ckq (no reset; all four states are
* valid, so it self-starts).  Strobes: kq = J0 @ ckqb (ckq lanes, ~0.5 ns after J0), km = J0 @ ckm
* (ckmb lanes, 0.75 ns), J1 (ckqb lanes, 1 ns), kmb = km @ ckmb (ckm lanes, ~1.3 ns); every retiming
* path is >= ~500 ps.  The ckqb lanes load on J1, not J0: loaded on J0 they would be one capture
* behind the ckm lanes and the 16 data bits would not be one contiguous window.  w = not J1 rises
* ~1.7 ns after the last load and ~1.5 ns before the next (plan: theory/readout_deser_plan.py).
* All flops are the lean serdes_cmos_dff (cmos_dff.spice): the reset flop's clk->q (171-635 ps over
* PVT) exceeds half a 1 GHz period, the lean flop's is 37-159 ps (devices/tb/cmos_dff_card).
* Dependencies: everything of rx_readout_demux2.spice plus cmos_dff.spice.

.subckt serdes_rx_cmos_lane4 r ck st o0 o1 o2 o3 vdd vss
Xs0 r ck s0 vdd vss serdes_cmos_dff
Xs1 s0 ck s1 vdd vss serdes_cmos_dff
Xs2 s1 ck s2 vdd vss serdes_cmos_dff
Xs3 s2 ck s3 vdd vss serdes_cmos_dff
Xl0 s0 st o0 vdd vss serdes_cmos_dff
Xl1 s1 st o1 vdd vss serdes_cmos_dff
Xl2 s2 st o2 vdd vss serdes_cmos_dff
Xl3 s3 st o3 vdd vss serdes_cmos_dff
.ends serdes_rx_cmos_lane4

.subckt serdes_rx_cmos_buf a y vdd vss params: wn1=1 wp1=2 wn2=4 wp2=8
Xi1 a n vdd vss serdes_cmos_inv wn={wn1} wp={wp1}
Xi2 n y vdd vss serdes_cmos_inv wn={wn2} wp={wp2}
.ends serdes_rx_cmos_buf

.subckt serdes_rx_cmos_wordclk ckq ckqb ckm ckmb st_q st_qb st_m st_mb w vdd vss
* 2-bit Johnson counter on ckq: J0 <- not J1, J1 <- J0 (period 4 cycles)
Xj0 j1b ckq j0 vdd vss serdes_cmos_dff
Xj1 j0 ckq j1 vdd vss serdes_cmos_dff
Xjb j1 j1b vdd vss serdes_cmos_inv
* strobe retiming
Xkq j0 ckqb kq vdd vss serdes_cmos_dff
Xkm j0 ckm km vdd vss serdes_cmos_dff
Xkmb km ckmb kmb vdd vss serdes_cmos_dff
* strobe buffers (each drives the 8 word-register clocks of two lanes)
Xbqb j1 st_qb vdd vss serdes_rx_cmos_buf
Xbq kq st_q vdd vss serdes_rx_cmos_buf
Xbmb km st_mb vdd vss serdes_rx_cmos_buf
Xbm kmb st_m vdd vss serdes_rx_cmos_buf
Xbw j1b w vdd vss serdes_rx_cmos_buf wn1=2 wp1=4 wn2=6 wp2=12
.ends serdes_rx_cmos_wordclk

.subckt serdes_rx_readout_deser16 d0p d0n d1p d1n e0p e0n e1p e1n rkp rkn
+ a0_0 a0_1 a0_2 a0_3 b0_0 b0_1 b0_2 b0_3 ae1_0 ae1_1 ae1_2 ae1_3 be1_0 be1_1 be1_2 be1_3
+ a1_0 a1_1 a1_2 a1_3 b1_0 b1_1 b1_2 b1_3 ae0_0 ae0_1 ae0_2 ae0_3 be0_0 be0_1 be0_2 be0_3
+ w vbias vdd vss
+ params: dd_wsf=20 dd_wclock=16 cb_wn=24 cb_nfin=4 cb_wt=12 cb_rload=600
+ dd_wsf_sink=2 dd_wdata=10 dd_whold=40 dd_wtail=36 dd_nftail=12 dd_rload=1200
+ cv_wsf=10 cv_wsink=1 cv_win=3 cv_wload=4 cv_wtail=3
+ ck1_wn=2 ck1_wp=4 ck2_wn=8 ck2_wp=16 ck3_wn=6 ck3_wp=12 div_whold=40
Xf d0p d0n d1p d1n e0p e0n e1p e1n rkp rkn ra0 rb0 rae1 rbe1 ra1 rb1 rae0 rbe0 ckq ckqb ckm ckmb vbias vdd vss
+ serdes_rx_readout_front dd_wsf={dd_wsf} dd_wclock={dd_wclock} cb_wn={cb_wn} cb_nfin={cb_nfin} cb_wt={cb_wt} cb_rload={cb_rload}
+ dd_wsf_sink={dd_wsf_sink} dd_wdata={dd_wdata} dd_whold={dd_whold} dd_wtail={dd_wtail} dd_nftail={dd_nftail} dd_rload={dd_rload}
+ cv_wsf={cv_wsf} cv_wsink={cv_wsink} cv_win={cv_win} cv_wload={cv_wload} cv_wtail={cv_wtail}
+ ck1_wn={ck1_wn} ck1_wp={ck1_wp} ck2_wn={ck2_wn} ck2_wp={ck2_wp} ck3_wn={ck3_wn} ck3_wp={ck3_wp} div_whold={div_whold}
Xwc ckq ckqb ckm ckmb st_q st_qb st_m st_mb w vdd vss serdes_rx_cmos_wordclk
Xla0 ra0 ckq st_q a0_0 a0_1 a0_2 a0_3 vdd vss serdes_rx_cmos_lane4
Xlae1 rae1 ckq st_q ae1_0 ae1_1 ae1_2 ae1_3 vdd vss serdes_rx_cmos_lane4
Xlb0 rb0 ckqb st_qb b0_0 b0_1 b0_2 b0_3 vdd vss serdes_rx_cmos_lane4
Xlbe1 rbe1 ckqb st_qb be1_0 be1_1 be1_2 be1_3 vdd vss serdes_rx_cmos_lane4
Xla1 ra1 ckm st_m a1_0 a1_1 a1_2 a1_3 vdd vss serdes_rx_cmos_lane4
Xlae0 rae0 ckm st_m ae0_0 ae0_1 ae0_2 ae0_3 vdd vss serdes_rx_cmos_lane4
Xlb1 rb1 ckmb st_mb b1_0 b1_1 b1_2 b1_3 vdd vss serdes_rx_cmos_lane4
Xlbe0 rbe0 ckmb st_mb be0_0 be0_1 be0_2 be0_3 vdd vss serdes_rx_cmos_lane4
.ends serdes_rx_readout_deser16
