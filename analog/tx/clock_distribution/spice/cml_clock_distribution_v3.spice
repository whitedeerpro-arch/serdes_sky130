* TX clock distribution v3 (S4: synchronous counter + 2G clk->q replica), generated by variants/dist_v3.py
* cfg: {'dummy': {'250': (20, 12, 400), '500': (20, 12, 600), '1g': (20, 12, 600)}, 'spine': ((20, 12, 400), (24, 16, 400)), 'kc': (72, 48, 133), 'kr': (24, 16, 400), 'iso': (24, 16, 400), 'stage': (24, 16, 400), 'extra': {'250': 0, '500': 2, '1g': 4, '2g': 5}, 'out': {'250': (64, 64, 100), '500': (40, 32, 200), '1g': (24, 16, 400), '2g': (32, 24, 300)}, 'invert': {'250': False, '500': False, '1g': False, '2g': False}, 'tie': (4, 4, 2000), 'reset_ic': None}
.subckt serdes_cml_clock_distribution_tx_lowov s250p s250n s500p s500n s1gp s1gn s2gp s2gn
+ c250p c250n c500p c500n c1gp c1gn c2gp c2gn vbias vdd vss
+ params: trim250=0 trim500=0 trim1g=0 trim2g=0
Xrtbias vbias vbias_rt vdd vss pll_cml_tail_bias
Xpre250_0 s250p s250n a250p a250n vbias vdd vss serdes_cml_buffer wn=20 wt=12 rload=400
Xpre500_0 s500p s500n a500p a500n vbias vdd vss serdes_cml_buffer wn=20 wt=12 rload=600
Xpre1g_0 s1gp s1gn a1gp a1gn vbias vdd vss serdes_cml_buffer wn=20 wt=12 rload=600
Xch_a2g s2gp s2gn a2gp a2gn vbias vdd vss serdes_cml_buffer wn=20 wt=12 rload=400
Xch_e1 a2gp a2gn e1p e1n vbias vdd vss serdes_cml_buffer wn=24 wt=16 rload=400
Xkc e1p e1n kcp kcn vbias vdd vss serdes_cml_buffer wn=72 wt=48 rload=133
Xkr e1p e1n krp krn vbias vdd vss serdes_cml_buffer wn=24 wt=16 rload=400
Xtie vdd vss hip hin vbias vdd vss serdes_cml_buffer wn=4 wt=4 rload=2000
Xcnt kcp kcn q0p q0n q1p q1n q2p q2n vbias vbias_rt vdd vss serdes_tx_sync_counter8
Xrep krp krn r2gp r2gn hip hin vbias vbias_rt vdd vss serdes_cml_clk_replica_lowov
Xiso250 q2p q2n i250p i250n vbias vdd vss serdes_cml_buffer wn=24 wt=16 rload=400
Xout250 i250p i250n c250p c250n vbias vdd vss serdes_cml_buffer wn=64 wt=64 rload=100
Xiso500 q1p q1n i500p i500n vbias vdd vss serdes_cml_buffer wn=24 wt=16 rload=400
Xe500_0 i500p i500n e500_0p e500_0n vbias vdd vss serdes_cml_buffer wn=24 wt=16 rload=400
Xe500_1 e500_0p e500_0n e500_1p e500_1n vbias vdd vss serdes_cml_buffer wn=24 wt=16 rload=400
Xout500 e500_1p e500_1n c500p c500n vbias vdd vss serdes_cml_buffer wn=40 wt=32 rload=200
Xiso1g q0p q0n i1gp i1gn vbias vdd vss serdes_cml_buffer wn=24 wt=16 rload=400
Xe1g_0 i1gp i1gn e1g_0p e1g_0n vbias vdd vss serdes_cml_buffer wn=24 wt=16 rload=400
Xe1g_1 e1g_0p e1g_0n e1g_1p e1g_1n vbias vdd vss serdes_cml_buffer wn=24 wt=16 rload=400
Xe1g_2 e1g_1p e1g_1n e1g_2p e1g_2n vbias vdd vss serdes_cml_buffer wn=24 wt=16 rload=400
Xe1g_3 e1g_2p e1g_2n e1g_3p e1g_3n vbias vdd vss serdes_cml_buffer wn=24 wt=16 rload=400
Xout1g e1g_3p e1g_3n c1gp c1gn vbias vdd vss serdes_cml_buffer wn=24 wt=16 rload=400
Xiso2g r2gp r2gn i2gp i2gn vbias vdd vss serdes_cml_buffer wn=24 wt=16 rload=400
Xe2g_0 i2gp i2gn e2g_0p e2g_0n vbias vdd vss serdes_cml_buffer wn=24 wt=16 rload=400
Xe2g_1 e2g_0p e2g_0n e2g_1p e2g_1n vbias vdd vss serdes_cml_buffer wn=24 wt=16 rload=400
Xe2g_2 e2g_1p e2g_1n e2g_2p e2g_2n vbias vdd vss serdes_cml_buffer wn=24 wt=16 rload=400
Xe2g_3 e2g_2p e2g_2n e2g_3p e2g_3n vbias vdd vss serdes_cml_buffer wn=24 wt=16 rload=400
Xe2g_4 e2g_3p e2g_3n e2g_4p e2g_4n vbias vdd vss serdes_cml_buffer wn=24 wt=16 rload=400
Xout2g e2g_4p e2g_4n c2gp c2gn vbias vdd vss serdes_cml_buffer wn=32 wt=24 rload=300
.ends serdes_cml_clock_distribution_tx_lowov
