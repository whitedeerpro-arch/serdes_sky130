* Synchronous 3-bit CML binary counter for the TX select clocks (structure S4).
* q0 = clk/2 (1 GHz), q1 = clk/4 (500 MHz), q2 = clk/8 (250 MHz).  All three
* bits are master/slave flip-flops on ONE shared pair of clock followers, so
* every output is "the same clock edge + one clk->q": the divided clocks have
* no relative drift by construction.  All 8 states are valid and the bits keep
* the binary relation, so the select-clock phase relation (and the serializer
* bit order) is the same at every start-up.
*
* Next state (slave updates on the falling crossing of ckp - ckn):
*   d0 = /q0                      (cross-wired)
*   d1 = q1 xor q0                = mux(sel q0: q1, /q1)
*   d2 = q2 xor (q1 and q0)       = mux(sel q0: q2, q2 xor q1)
* Only 2:1 muxes (pll_cml_mux2: select ? B : A); no static logic levels needed.
* Critical path: clk->q(q1) -> xor -> mux data -> master setup.
*
* Dependencies: sky130_primitives.spice, cml_latch.spice, cml_logic.spice.
.subckt serdes_tx_sync_counter8 clkp clkn q0p q0n q1p q1n q2p q2n vbias vbias_logic vdd vss
+ params: wsf=240 wsf_sink=12 wdata=20 whold=20 wclock=64 wtail=72 nftail=24 rload=600
+ gdata=12 gselect=24 gtail=9.6 grload=1000 gsf=20 gsf_sink=2
* shared clock followers for all six latches
Xfp vdd clkp ckp vss serdes_nfet_lvt w={wsf} nf=12
Xfn vdd clkn ckn vss serdes_nfet_lvt w={wsf} nf=12
Xsp ckp vbias vss vss serdes_nfet w={wsf_sink} l=.5
Xsn ckn vbias vss vss serdes_nfet w={wsf_sink} l=.5
* bit 0: d0 = /q0
Xm0 q0n q0p m0p m0n ckp ckn vbias_logic vdd vss pll_cml_latch
+ wdata={wdata} whold={whold} wclock={wclock} wtail={wtail} nftail={nftail} rload={rload}
Xs0 m0p m0n q0p q0n ckn ckp vbias_logic vdd vss pll_cml_latch
+ wdata={wdata} whold={whold} wclock={wclock} wtail={wtail} nftail={nftail} rload={rload}
* bit 1: d1 = q0 ? /q1 : q1
Xx1 q1p q1n q1n q1p q0p q0n d1p d1n vbias vdd vss pll_cml_mux2
+ wdata={gdata} wselect={gselect} wtail={gtail} rload={grload} wsf={gsf} wsf_sink={gsf_sink}
Xm1 d1p d1n m1p m1n ckp ckn vbias_logic vdd vss pll_cml_latch
+ wdata={wdata} whold={whold} wclock={wclock} wtail={wtail} nftail={nftail} rload={rload}
Xs1 m1p m1n q1p q1n ckn ckp vbias_logic vdd vss pll_cml_latch
+ wdata={wdata} whold={whold} wclock={wclock} wtail={wtail} nftail={nftail} rload={rload}
* bit 2: t = q1 ? /q2 : q2 ; d2 = q0 ? t : q2
Xt2 q2p q2n q2n q2p q1p q1n t2p t2n vbias vdd vss pll_cml_mux2
+ wdata={gdata} wselect={gselect} wtail={gtail} rload={grload} wsf={gsf} wsf_sink={gsf_sink}
Xx2 q2p q2n t2p t2n q0p q0n d2p d2n vbias vdd vss pll_cml_mux2
+ wdata={gdata} wselect={gselect} wtail={gtail} rload={grload} wsf={gsf} wsf_sink={gsf_sink}
Xm2 d2p d2n m2p m2n ckp ckn vbias_logic vdd vss pll_cml_latch
+ wdata={wdata} whold={whold} wclock={wclock} wtail={wtail} nftail={nftail} rload={rload}
Xs2 m2p m2n q2p q2n ckn ckp vbias_logic vdd vss pll_cml_latch
+ wdata={wdata} whold={whold} wclock={wclock} wtail={wtail} nftail={nftail} rload={rload}
.ends serdes_tx_sync_counter8
