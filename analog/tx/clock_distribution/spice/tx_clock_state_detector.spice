* Start-up state detector for the TX divider clocks (open issue I-01).
* The 500 MHz (/4 of branch 2) and 1 GHz (/2 of branch 3) dividers start in an
* unknown state relative to the branch-0 chain that also makes the 250 MHz
* word clock. Branch-2/3 divider edges sample the branch-0 /4 and /2 outputs;
* the VCO phase offset (125 / 187.5 ps) puts each sample between reference
* transitions, so every output is a static level:
*   a = branch-0 /4 at branch-2 /4 edge  \  4 states of the 500 MHz divider
*   b = branch-0 /2 at branch-2 /4 edge  /
*   c = branch-0 /2 at branch-3 /2 edge     2 states of the 1 GHz divider
* Static CMOS bits leave through slow data receivers. Light clock followers
* (wsf) keep the load on the TX clock taps small.
* Dependencies: sky130_primitives, cml_latch, cml_div2 (tail bias),
* tx_clock_retime (flip-flop), cml_buffer, cml_to_cmos (helpers), cml_to_cmos_data.
.subckt serdes_tx_clock_state_detector r4p r4n r2p r2n c22p c22n c24p c24n c32p c32n a b c vbias vdd vss
+ params: wsf=80 whold=80 wclock=64
Xbias vbias vbias_logic vdd vss pll_cml_tail_bias
Xk22 c22p c22n k22p k22n vbias vdd vss serdes_cml_buffer
Xk24 c24p c24n k24p k24n vbias vdd vss serdes_cml_buffer
Xk32 c32p c32n k32p k32n vbias vdd vss serdes_cml_buffer
Xa r4p r4n k24p k24n ap an vbias vbias_logic vdd vss serdes_cml_dff_lowov wsf={wsf} whold={whold} wclock={wclock}
Xb r2p r2n k22p k22n bp bn vbias vbias_logic vdd vss serdes_cml_dff_lowov wsf={wsf} whold={whold} wclock={wclock}
Xc r2p r2n k32p k32n cp cn vbias vbias_logic vdd vss serdes_cml_dff_lowov wsf={wsf} whold={whold} wclock={wclock}
Xra ap an a vbias vdd vss serdes_cml_to_cmos_data
Xrb bp bn b vbias vdd vss serdes_cml_to_cmos_data
Xrc cp cn c vbias vdd vss serdes_cml_to_cmos_data
.ends serdes_tx_clock_state_detector
