* Local integration candidate: actual word-clock receiver, 16-bit capture /
* complementary launch, converters, complete r2 serializer. Select clocks and
* output driver remain separate physical modules. No behavioral data in DUT.
.subckt serdes_tx_capture_serializer16
+ d0 d1 d2 d3 d4 d5 d6 d7 d8 d9 d10 d11 d12 d13 d14 d15
+ c250p c250n c500p c500n c1gp c1gn c2gp c2gn qp qn vbias vdd vss
Xwordclock c250p c250n word_clk vbias vdd vss serdes_tx_word_clock
Xcap d0 d1 d2 d3 d4 d5 d6 d7 d8 d9 d10 d11 d12 d13 d14 d15 word_clk
+ q0 q1 q2 q3 q4 q5 q6 q7 q8 q9 q10 q11 q12 q13 q14 q15 vdd vss serdes_tx_word_capture16_staggered
Xc0 q0 p0 n0 vbias vdd vss serdes_cmos_to_cml_data
Xc1 q1 p1 n1 vbias vdd vss serdes_cmos_to_cml_data
Xc2 q2 p2 n2 vbias vdd vss serdes_cmos_to_cml_data
Xc3 q3 p3 n3 vbias vdd vss serdes_cmos_to_cml_data
Xc4 q4 p4 n4 vbias vdd vss serdes_cmos_to_cml_data
Xc5 q5 p5 n5 vbias vdd vss serdes_cmos_to_cml_data
Xc6 q6 p6 n6 vbias vdd vss serdes_cmos_to_cml_data
Xc7 q7 p7 n7 vbias vdd vss serdes_cmos_to_cml_data
Xc8 q8 p8 n8 vbias vdd vss serdes_cmos_to_cml_data
Xc9 q9 p9 n9 vbias vdd vss serdes_cmos_to_cml_data
Xc10 q10 p10 n10 vbias vdd vss serdes_cmos_to_cml_data
Xc11 q11 p11 n11 vbias vdd vss serdes_cmos_to_cml_data
Xc12 q12 p12 n12 vbias vdd vss serdes_cmos_to_cml_data
Xc13 q13 p13 n13 vbias vdd vss serdes_cmos_to_cml_data
Xc14 q14 p14 n14 vbias vdd vss serdes_cmos_to_cml_data
Xc15 q15 p15 n15 vbias vdd vss serdes_cmos_to_cml_data
Xtree p0 n0 p1 n1 p2 n2 p3 n3 p4 n4 p5 n5 p6 n6 p7 n7 p8 n8 p9 n9 p10 n10 p11 n11 p12 n12 p13 n13 p14 n14 p15 n15
+ c250p c250n c500p c500n c1gp c1gn c2gp c2gn qp qn vbias vdd vdd vss serdes16_cml_tree_retimed_lowov
+ wdata=40 wselect=96 wtail=12 rload=500 rout=400 tail_scale=6 wsf=80
.ends serdes_tx_capture_serializer16
