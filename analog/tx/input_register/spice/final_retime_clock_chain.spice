* v3 r2g cut. Counts are extra stages between iso2g and out2g.
* Each variant exposes the same first-stage source load.
.subckt serdes_tx_final_clock_1 rp rn cp cn vbias vdd vss
Xiso rp rn ip in vbias vdd vss serdes_cml_buffer wn=24 wt=16 rload=400
Xe1 ip in e1p e1n vbias vdd vss serdes_cml_buffer wn=24 wt=16 rload=400
Xout e1p e1n cp cn vbias vdd vss serdes_cml_buffer wn=32 wt=24 rload=300
.ends serdes_tx_final_clock_1
.subckt serdes_tx_final_clock_2 rp rn cp cn vbias vdd vss
Xiso rp rn ip in vbias vdd vss serdes_cml_buffer wn=24 wt=16 rload=400
Xe1 ip in e1p e1n vbias vdd vss serdes_cml_buffer wn=24 wt=16 rload=400
Xe2 e1p e1n e2p e2n vbias vdd vss serdes_cml_buffer wn=24 wt=16 rload=400
Xout e2p e2n cp cn vbias vdd vss serdes_cml_buffer wn=32 wt=24 rload=300
.ends serdes_tx_final_clock_2
.subckt serdes_tx_final_clock_3 rp rn cp cn vbias vdd vss
Xiso rp rn ip in vbias vdd vss serdes_cml_buffer wn=24 wt=16 rload=400
Xe1 ip in e1p e1n vbias vdd vss serdes_cml_buffer wn=24 wt=16 rload=400
Xe2 e1p e1n e2p e2n vbias vdd vss serdes_cml_buffer wn=24 wt=16 rload=400
Xe3 e2p e2n e3p e3n vbias vdd vss serdes_cml_buffer wn=24 wt=16 rload=400
Xout e3p e3n cp cn vbias vdd vss serdes_cml_buffer wn=32 wt=24 rload=300
.ends serdes_tx_final_clock_3
