* Retimed variant: two CML data latches before final selector; no ingress word register.
* Four-rank 16:1 tree with final-rank retiming; d0 first with binary-correlated selects.
* Cross-half pairing preserves consecutive bit order. Clock phase/ingress timing are external.
* Two data latches precede the final selector; the ingress word-capture register is still absent.
.subckt serdes16_cml_tree_retimed_lowov d0p d0n d1p d1n d2p d2n d3p d3n d4p d4n d5p d5n d6p d6n d7p d7n d8p d8n d9p d9n d10p d10n d11p d11n d12p d12n d13p d13n d14p d14n d15p d15n c250p c250n c500p c500n c1gp c1gn c2gp c2gn qp qn vbias vdd_bias vdd vss
+ params: wdata=40 wselect=96 wtail=12 rload=500 rout=400 tail_scale=6 wsf=80 wsf_sink=4
Xlogic_bias vbias vbias_logic vdd_bias vss serdes_tx_logic_bias ref_scale={tail_scale}
Xr1_0 d0p d0n d8p d8n c250p c250n g1_0p g1_0n vbias vbias_logic vdd vss serdes_cml_mux2_lowov
+ wdata={wdata} wselect={wselect} wtail={tail_scale*wtail} nftail={4*tail_scale} wsf={wsf} wsf_sink={wsf_sink} rload={rload}
Xr1_1 d1p d1n d9p d9n c250p c250n g1_1p g1_1n vbias vbias_logic vdd vss serdes_cml_mux2_lowov
+ wdata={wdata} wselect={wselect} wtail={tail_scale*wtail} nftail={4*tail_scale} wsf={wsf} wsf_sink={wsf_sink} rload={rload}
Xr1_2 d2p d2n d10p d10n c250p c250n g1_2p g1_2n vbias vbias_logic vdd vss serdes_cml_mux2_lowov
+ wdata={wdata} wselect={wselect} wtail={tail_scale*wtail} nftail={4*tail_scale} wsf={wsf} wsf_sink={wsf_sink} rload={rload}
Xr1_3 d3p d3n d11p d11n c250p c250n g1_3p g1_3n vbias vbias_logic vdd vss serdes_cml_mux2_lowov
+ wdata={wdata} wselect={wselect} wtail={tail_scale*wtail} nftail={4*tail_scale} wsf={wsf} wsf_sink={wsf_sink} rload={rload}
Xr1_4 d4p d4n d12p d12n c250p c250n g1_4p g1_4n vbias vbias_logic vdd vss serdes_cml_mux2_lowov
+ wdata={wdata} wselect={wselect} wtail={tail_scale*wtail} nftail={4*tail_scale} wsf={wsf} wsf_sink={wsf_sink} rload={rload}
Xr1_5 d5p d5n d13p d13n c250p c250n g1_5p g1_5n vbias vbias_logic vdd vss serdes_cml_mux2_lowov
+ wdata={wdata} wselect={wselect} wtail={tail_scale*wtail} nftail={4*tail_scale} wsf={wsf} wsf_sink={wsf_sink} rload={rload}
Xr1_6 d6p d6n d14p d14n c250p c250n g1_6p g1_6n vbias vbias_logic vdd vss serdes_cml_mux2_lowov
+ wdata={wdata} wselect={wselect} wtail={tail_scale*wtail} nftail={4*tail_scale} wsf={wsf} wsf_sink={wsf_sink} rload={rload}
Xr1_7 d7p d7n d15p d15n c250p c250n g1_7p g1_7n vbias vbias_logic vdd vss serdes_cml_mux2_lowov
+ wdata={wdata} wselect={wselect} wtail={tail_scale*wtail} nftail={4*tail_scale} wsf={wsf} wsf_sink={wsf_sink} rload={rload}
Xr2_0 g1_0p g1_0n g1_4p g1_4n c500p c500n g2_0p g2_0n vbias vbias_logic vdd vss serdes_cml_mux2_lowov
+ wdata={wdata} wselect={wselect} wtail={tail_scale*wtail} nftail={4*tail_scale} wsf={wsf} wsf_sink={wsf_sink} rload={rload}
Xr2_1 g1_1p g1_1n g1_5p g1_5n c500p c500n g2_1p g2_1n vbias vbias_logic vdd vss serdes_cml_mux2_lowov
+ wdata={wdata} wselect={wselect} wtail={tail_scale*wtail} nftail={4*tail_scale} wsf={wsf} wsf_sink={wsf_sink} rload={rload}
Xr2_2 g1_2p g1_2n g1_6p g1_6n c500p c500n g2_2p g2_2n vbias vbias_logic vdd vss serdes_cml_mux2_lowov
+ wdata={wdata} wselect={wselect} wtail={tail_scale*wtail} nftail={4*tail_scale} wsf={wsf} wsf_sink={wsf_sink} rload={rload}
Xr2_3 g1_3p g1_3n g1_7p g1_7n c500p c500n g2_3p g2_3n vbias vbias_logic vdd vss serdes_cml_mux2_lowov
+ wdata={wdata} wselect={wselect} wtail={tail_scale*wtail} nftail={4*tail_scale} wsf={wsf} wsf_sink={wsf_sink} rload={rload}
Xr3_0 g2_0p g2_0n g2_2p g2_2n c1gp c1gn g3_0p g3_0n vbias vbias_logic vdd vss serdes_cml_mux2_lowov
+ wdata={wdata} wselect={wselect} wtail={tail_scale*wtail} nftail={4*tail_scale} wsf={wsf} wsf_sink={wsf_sink} rload={rload}
Xr3_1 g2_1p g2_1n g2_3p g2_3n c1gp c1gn g3_1p g3_1n vbias vbias_logic vdd vss serdes_cml_mux2_lowov
+ wdata={wdata} wselect={wselect} wtail={tail_scale*wtail} nftail={4*tail_scale} wsf={wsf} wsf_sink={wsf_sink} rload={rload}
Xr4_0 g3_0p g3_0n g3_1p g3_1n c2gp c2gn qp qn vbias vbias_logic vdd vss serdes_cml_latched_mux2_lowov
+ wdata={wdata} wselect={wselect} wtail={tail_scale*wtail} nftail={4*tail_scale} wsf={wsf} wsf_sink={wsf_sink} rload={rout}
.ends serdes16_cml_tree_retimed_lowov
