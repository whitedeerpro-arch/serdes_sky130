* Experimental TX clock distribution v1 (clock_replay; not adopted yet).
* Same ports/name as serdes_cml_clock_distribution_tx_lowov so it drops into
* the r2 bench.  Changes from r2:
*  - 500 MHz and 1 GHz: input stage load 400 -> 600 ohm, plus one extra stage
*    (Wn 40 / Wtail 16 / 600 ohm) before the r2 fanout driver.  Restores the
*    weak hot-corner divider taps (FS 85 C 1 GHz tap ~151 mVpp).
*  - Trim capacitors stay as parameters; run with trims 0 (position is set by
*    the replay alignment, not by RC loading).
.subckt serdes_cml_clock_distribution_tx_lowov s250p s250n s500p s500n s1gp s1gn s2gp s2gn
+ c250p c250n c500p c500n c1gp c1gn c2gp c2gn vbias vdd vss
+ params: trim250=0 trim500=0 trim1g=0 trim2g=0
Xa250 s250p s250n a250p a250n vbias vdd vss serdes_cml_buffer wn=20 wt=12 rload=400
Ca250p a250p vss {2f+trim250}
Ca250n a250n vss {2f+trim250}
Xb250 a250p a250n c250p c250n vbias vdd vss serdes_cml_buffer wn=64 wt=64 rload=100
Xa500 s500p s500n a500p a500n vbias vdd vss serdes_cml_buffer wn=20 wt=12 rload=600
Ca500p a500p vss {2f+trim500}
Ca500n a500n vss {2f+trim500}
Xe500 a500p a500n e500p e500n vbias vdd vss serdes_cml_buffer wn=40 wt=16 rload=600
Xb500 e500p e500n c500p c500n vbias vdd vss serdes_cml_buffer wn=40 wt=32 rload=200
Xa1g s1gp s1gn a1gp a1gn vbias vdd vss serdes_cml_buffer wn=20 wt=12 rload=600
Ca1gp a1gp vss {2f+trim1g}
Ca1gn a1gn vss {2f+trim1g}
Xe1g a1gp a1gn e1gp e1gn vbias vdd vss serdes_cml_buffer wn=40 wt=16 rload=600
Xb1g e1gp e1gn c1gp c1gn vbias vdd vss serdes_cml_buffer wn=24 wt=16 rload=400
Xa2g s2gp s2gn a2gp a2gn vbias vdd vss serdes_cml_buffer wn=20 wt=12 rload=400
Ca2gp a2gp vss {2f+trim2g}
Ca2gn a2gn vss {2f+trim2g}
Xextra1 a2gp a2gn e1p e1n vbias vdd vss serdes_cml_buffer wn=24 wt=16 rload=400
Xextra2 e1p e1n e2p e2n vbias vdd vss serdes_cml_buffer wn=24 wt=16 rload=400
Xb2g e2p e2n c2gp c2gn vbias vdd vss serdes_cml_buffer wn=32 wt=24 rload=300
.ends serdes_cml_clock_distribution_tx_lowov
