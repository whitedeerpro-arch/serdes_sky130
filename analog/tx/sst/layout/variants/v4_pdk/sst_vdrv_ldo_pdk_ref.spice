* Exact flattened LVS reference netlist for sst_vdrv_ldo_pdk
* Source subckt: sst_vdrv_ldo (frozen analog/tx/sst/spice/*.spice)
.subckt sst_vdrv_ldo_pdk vbg vdrv vdd vss
X1 vbg t_vref vss sky130_fd_pr__res_high_po_1p41 l=63
X2 t_vref vss vss sky130_fd_pr__res_high_po_1p41 l=37
X3 t_vbp t_vbp vdd vdd sky130_fd_pr__pfet_01v8 w=20 l=0.35
X4 t_vbp vss vss sky130_fd_pr__res_high_po_1p41 l=80
X5 t_tail t_vbp vdd vdd sky130_fd_pr__pfet_01v8 w=40 l=0.35
X6 t_nd t_vref t_tail vdd sky130_fd_pr__pfet_01v8 w=48 l=0.35
X7 t_vgate vdrv t_tail vdd sky130_fd_pr__pfet_01v8 w=48 l=0.35
X8 t_nd t_nd vss vss sky130_fd_pr__nfet_01v8 w=16 l=0.5
X9 t_vgate t_nd vss vss sky130_fd_pr__nfet_01v8 w=16 l=0.5
X10 t_vgate vss sky130_fd_pr__cap_mim_m3_1 w=17 l=17
X11 vss t_vgate sky130_fd_pr__cap_mim_m3_2 w=17 l=17
X12 vdd t_vgate vdrv vss sky130_fd_pr__nfet_01v8_lvt w=240 l=0.15
X13 vdrv vss vss sky130_fd_pr__res_high_po_1p41 l=38
X14 vdrv vss sky130_fd_pr__cap_mim_m3_1 w=24.8 l=24.8
X15 vss vdrv sky130_fd_pr__cap_mim_m3_2 w=24.8 l=24.8
X16 vdrv vss sky130_fd_pr__cap_mim_m3_1 w=24.8 l=24.8
X17 vss vdrv sky130_fd_pr__cap_mim_m3_2 w=24.8 l=24.8
X18 vdrv vss sky130_fd_pr__cap_mim_m3_1 w=24.8 l=24.8
X19 vss vdrv sky130_fd_pr__cap_mim_m3_2 w=24.8 l=24.8
X20 vdrv vss sky130_fd_pr__cap_mim_m3_1 w=24.8 l=24.8
X21 vss vdrv sky130_fd_pr__cap_mim_m3_2 w=24.8 l=24.8
X22 vdrv vss sky130_fd_pr__cap_mim_m3_1 w=24.8 l=24.8
X23 vss vdrv sky130_fd_pr__cap_mim_m3_2 w=24.8 l=24.8
X24 vdrv vss sky130_fd_pr__cap_mim_m3_1 w=24.8 l=24.8
X25 vss vdrv sky130_fd_pr__cap_mim_m3_2 w=24.8 l=24.8
.ends sst_vdrv_ldo_pdk
