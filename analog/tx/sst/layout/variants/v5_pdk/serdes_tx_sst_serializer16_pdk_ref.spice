* Exact flattened LVS reference netlist for serdes_tx_sst_serializer16_pdk
* Source subckt: serdes_tx_sst_serializer16_5g (v5_5g hardened analog/tx/sst/spice/*_5g.spice)
.subckt serdes_tx_sst_serializer16_pdk din0 din1 din2 din3 din4 din5 din6 din7 din8 din9 din10 din11 din12 din13 din14 din15 phi0 phi90 phi180 phi270 rst_n d0 d1 d2 d3 db0 db1 db2 db3 clk500_out clk250_out vdd vss
X1 t_c0b phi0 vss vss sky130_fd_pr__nfet_01v8_lvt w=2.6 l=0.15
X2 t_c0b phi0 vdd vdd sky130_fd_pr__pfet_01v8 w=6 l=0.15
X3 t_c0 t_c0b vss vss sky130_fd_pr__nfet_01v8_lvt w=5 l=0.15
X4 t_c0 t_c0b vdd vdd sky130_fd_pr__pfet_01v8 w=12.5 l=0.15
X5 t_c90b phi90 vss vss sky130_fd_pr__nfet_01v8_lvt w=2 l=0.15
X6 t_c90b phi90 vdd vdd sky130_fd_pr__pfet_01v8 w=4.8 l=0.15
X7 t_c90 t_c90b vss vss sky130_fd_pr__nfet_01v8_lvt w=3.6 l=0.15
X8 t_c90 t_c90b vdd vdd sky130_fd_pr__pfet_01v8 w=9 l=0.15
X9 t_c18b phi180 vss vss sky130_fd_pr__nfet_01v8_lvt w=2.2 l=0.15
X10 t_c18b phi180 vdd vdd sky130_fd_pr__pfet_01v8 w=5.4 l=0.15
X11 t_c180 t_c18b vss vss sky130_fd_pr__nfet_01v8_lvt w=4.2 l=0.15
X12 t_c180 t_c18b vdd vdd sky130_fd_pr__pfet_01v8 w=10.5 l=0.15
X13 t_c27b phi270 vss vss sky130_fd_pr__nfet_01v8_lvt w=2 l=0.15
X14 t_c27b phi270 vdd vdd sky130_fd_pr__pfet_01v8 w=4.8 l=0.15
X15 t_c270 t_c27b vss vss sky130_fd_pr__nfet_01v8_lvt w=3.6 l=0.15
X16 t_c270 t_c27b vdd vdd sky130_fd_pr__pfet_01v8 w=9 l=0.15
X17 t_Xdiv500_clkb t_c0 vss vss sky130_fd_pr__nfet_01v8_lvt w=1.2 l=0.15
X18 t_Xdiv500_clkb t_c0 vdd vdd sky130_fd_pr__pfet_01v8 w=2.4 l=0.15
X19 t_Xdiv500_clki t_Xdiv500_clkb vss vss sky130_fd_pr__nfet_01v8_lvt w=1.2 l=0.15
X20 t_Xdiv500_clki t_Xdiv500_clkb vdd vdd sky130_fd_pr__pfet_01v8 w=2.4 l=0.15
X21 t_clk500b_i t_Xdiv500_clkb t_Xdiv500_m1 vss sky130_fd_pr__nfet_01v8_lvt w=1.5 l=0.15
X22 t_clk500b_i t_Xdiv500_clki t_Xdiv500_m1 vdd sky130_fd_pr__pfet_01v8 w=3 l=0.15
X23 t_Xdiv500_m2 t_Xdiv500_m1 t_Xdiv500_Xm2_mid vss sky130_fd_pr__nfet_01v8_lvt w=2.25 l=0.15
X24 t_Xdiv500_Xm2_mid rst_n vss vss sky130_fd_pr__nfet_01v8_lvt w=2.25 l=0.15
X25 t_Xdiv500_m2 t_Xdiv500_m1 vdd vdd sky130_fd_pr__pfet_01v8 w=3 l=0.15
X26 t_Xdiv500_m2 rst_n vdd vdd sky130_fd_pr__pfet_01v8 w=3 l=0.15
X27 t_Xdiv500_m3 t_Xdiv500_m2 vss vss sky130_fd_pr__nfet_01v8_lvt w=0.8 l=0.15
X28 t_Xdiv500_m3 t_Xdiv500_m2 vdd vdd sky130_fd_pr__pfet_01v8 w=1.6 l=0.15
X29 t_Xdiv500_m3 t_Xdiv500_clki t_Xdiv500_m1 vss sky130_fd_pr__nfet_01v8_lvt w=0.8 l=0.15
X30 t_Xdiv500_m3 t_Xdiv500_clkb t_Xdiv500_m1 vdd sky130_fd_pr__pfet_01v8 w=1.6 l=0.15
X31 t_Xdiv500_m2 t_Xdiv500_clki t_Xdiv500_s1 vss sky130_fd_pr__nfet_01v8_lvt w=1.5 l=0.15
X32 t_Xdiv500_m2 t_Xdiv500_clkb t_Xdiv500_s1 vdd sky130_fd_pr__pfet_01v8 w=3 l=0.15
X33 t_Xdiv500_qi t_Xdiv500_s1 vss vss sky130_fd_pr__nfet_01v8_lvt w=1.8 l=0.15
X34 t_Xdiv500_qi t_Xdiv500_s1 vdd vdd sky130_fd_pr__pfet_01v8 w=3.6 l=0.15
X35 t_Xdiv500_s2 t_Xdiv500_qi t_Xdiv500_Xsfb_mid vss sky130_fd_pr__nfet_01v8_lvt w=1.2 l=0.15
X36 t_Xdiv500_Xsfb_mid rst_n vss vss sky130_fd_pr__nfet_01v8_lvt w=1.2 l=0.15
X37 t_Xdiv500_s2 t_Xdiv500_qi vdd vdd sky130_fd_pr__pfet_01v8 w=1.6 l=0.15
X38 t_Xdiv500_s2 rst_n vdd vdd sky130_fd_pr__pfet_01v8 w=1.6 l=0.15
X39 t_Xdiv500_s2 t_Xdiv500_clkb t_Xdiv500_s1 vss sky130_fd_pr__nfet_01v8_lvt w=0.8 l=0.15
X40 t_Xdiv500_s2 t_Xdiv500_clki t_Xdiv500_s1 vdd sky130_fd_pr__pfet_01v8 w=1.6 l=0.15
X41 t_clk500_i t_Xdiv500_s1 vss vss sky130_fd_pr__nfet_01v8_lvt w=2.25 l=0.15
X42 t_clk500_i t_Xdiv500_s1 vdd vdd sky130_fd_pr__pfet_01v8 w=4.5 l=0.15
X43 t_clk500b_i t_Xdiv500_qi vss vss sky130_fd_pr__nfet_01v8_lvt w=2.25 l=0.15
X44 t_clk500b_i t_Xdiv500_qi vdd vdd sky130_fd_pr__pfet_01v8 w=4.5 l=0.15
X45 t_Xdiv250_clkb t_clk500_i vss vss sky130_fd_pr__nfet_01v8_lvt w=1.2 l=0.15
X46 t_Xdiv250_clkb t_clk500_i vdd vdd sky130_fd_pr__pfet_01v8 w=2.4 l=0.15
X47 t_Xdiv250_clki t_Xdiv250_clkb vss vss sky130_fd_pr__nfet_01v8_lvt w=1.2 l=0.15
X48 t_Xdiv250_clki t_Xdiv250_clkb vdd vdd sky130_fd_pr__pfet_01v8 w=2.4 l=0.15
X49 t_clk250b_i t_Xdiv250_clkb t_Xdiv250_m1 vss sky130_fd_pr__nfet_01v8_lvt w=1.5 l=0.15
X50 t_clk250b_i t_Xdiv250_clki t_Xdiv250_m1 vdd sky130_fd_pr__pfet_01v8 w=3 l=0.15
X51 t_Xdiv250_m2 t_Xdiv250_m1 t_Xdiv250_Xm2_mid vss sky130_fd_pr__nfet_01v8_lvt w=2.25 l=0.15
X52 t_Xdiv250_Xm2_mid rst_n vss vss sky130_fd_pr__nfet_01v8_lvt w=2.25 l=0.15
X53 t_Xdiv250_m2 t_Xdiv250_m1 vdd vdd sky130_fd_pr__pfet_01v8 w=3 l=0.15
X54 t_Xdiv250_m2 rst_n vdd vdd sky130_fd_pr__pfet_01v8 w=3 l=0.15
X55 t_Xdiv250_m3 t_Xdiv250_m2 vss vss sky130_fd_pr__nfet_01v8_lvt w=0.8 l=0.15
X56 t_Xdiv250_m3 t_Xdiv250_m2 vdd vdd sky130_fd_pr__pfet_01v8 w=1.6 l=0.15
X57 t_Xdiv250_m3 t_Xdiv250_clki t_Xdiv250_m1 vss sky130_fd_pr__nfet_01v8_lvt w=0.8 l=0.15
X58 t_Xdiv250_m3 t_Xdiv250_clkb t_Xdiv250_m1 vdd sky130_fd_pr__pfet_01v8 w=1.6 l=0.15
X59 t_Xdiv250_m2 t_Xdiv250_clki t_Xdiv250_s1 vss sky130_fd_pr__nfet_01v8_lvt w=1.5 l=0.15
X60 t_Xdiv250_m2 t_Xdiv250_clkb t_Xdiv250_s1 vdd sky130_fd_pr__pfet_01v8 w=3 l=0.15
X61 t_Xdiv250_qi t_Xdiv250_s1 vss vss sky130_fd_pr__nfet_01v8_lvt w=1.8 l=0.15
X62 t_Xdiv250_qi t_Xdiv250_s1 vdd vdd sky130_fd_pr__pfet_01v8 w=3.6 l=0.15
X63 t_Xdiv250_s2 t_Xdiv250_qi t_Xdiv250_Xsfb_mid vss sky130_fd_pr__nfet_01v8_lvt w=1.2 l=0.15
X64 t_Xdiv250_Xsfb_mid rst_n vss vss sky130_fd_pr__nfet_01v8_lvt w=1.2 l=0.15
X65 t_Xdiv250_s2 t_Xdiv250_qi vdd vdd sky130_fd_pr__pfet_01v8 w=1.6 l=0.15
X66 t_Xdiv250_s2 rst_n vdd vdd sky130_fd_pr__pfet_01v8 w=1.6 l=0.15
X67 t_Xdiv250_s2 t_Xdiv250_clkb t_Xdiv250_s1 vss sky130_fd_pr__nfet_01v8_lvt w=0.8 l=0.15
X68 t_Xdiv250_s2 t_Xdiv250_clki t_Xdiv250_s1 vdd sky130_fd_pr__pfet_01v8 w=1.6 l=0.15
X69 t_clk250_i t_Xdiv250_s1 vss vss sky130_fd_pr__nfet_01v8_lvt w=2.25 l=0.15
X70 t_clk250_i t_Xdiv250_s1 vdd vdd sky130_fd_pr__pfet_01v8 w=4.5 l=0.15
X71 t_clk250b_i t_Xdiv250_qi vss vss sky130_fd_pr__nfet_01v8_lvt w=2.25 l=0.15
X72 t_clk250b_i t_Xdiv250_qi vdd vdd sky130_fd_pr__pfet_01v8 w=4.5 l=0.15
X73 t_clk500b t_clk500_i vss vss sky130_fd_pr__nfet_01v8_lvt w=4 l=0.15
X74 t_clk500b t_clk500_i vdd vdd sky130_fd_pr__pfet_01v8 w=8 l=0.15
X75 t_clk500 t_clk500b_i vss vss sky130_fd_pr__nfet_01v8_lvt w=4 l=0.15
X76 t_clk500 t_clk500b_i vdd vdd sky130_fd_pr__pfet_01v8 w=8 l=0.15
X77 t_clk250b t_clk250_i vss vss sky130_fd_pr__nfet_01v8_lvt w=4 l=0.15
X78 t_clk250b t_clk250_i vdd vdd sky130_fd_pr__pfet_01v8 w=8 l=0.15
X79 t_clk250 t_clk250b_i vss vss sky130_fd_pr__nfet_01v8_lvt w=3 l=0.15
X80 t_clk250 t_clk250b_i vdd vdd sky130_fd_pr__pfet_01v8 w=6 l=0.15
X81 clk500_out t_clk500b vss vss sky130_fd_pr__nfet_01v8_lvt w=1.5 l=0.15
X82 clk500_out t_clk500b vdd vdd sky130_fd_pr__pfet_01v8 w=3 l=0.15
X83 clk250_out t_clk250 vss vss sky130_fd_pr__nfet_01v8_lvt w=1.5 l=0.15
X84 clk250_out t_clk250 vdd vdd sky130_fd_pr__pfet_01v8 w=3 l=0.15
X85 t_Xlane0_Xr0_clkb t_clk250b vss vss sky130_fd_pr__nfet_01v8_lvt w=1.2 l=0.15
X86 t_Xlane0_Xr0_clkb t_clk250b vdd vdd sky130_fd_pr__pfet_01v8 w=2.4 l=0.15
X87 t_Xlane0_Xr0_clki t_Xlane0_Xr0_clkb vss vss sky130_fd_pr__nfet_01v8_lvt w=1.2 l=0.15
X88 t_Xlane0_Xr0_clki t_Xlane0_Xr0_clkb vdd vdd sky130_fd_pr__pfet_01v8 w=2.4 l=0.15
X89 din0 t_Xlane0_Xr0_clkb t_Xlane0_Xr0_m1 vss sky130_fd_pr__nfet_01v8_lvt w=0.8 l=0.15
X90 din0 t_Xlane0_Xr0_clki t_Xlane0_Xr0_m1 vdd sky130_fd_pr__pfet_01v8 w=1.6 l=0.15
X91 t_Xlane0_Xr0_m2 t_Xlane0_Xr0_m1 t_Xlane0_Xr0_Xm2_mid vss sky130_fd_pr__nfet_01v8_lvt w=1.2 l=0.15
X92 t_Xlane0_Xr0_Xm2_mid rst_n vss vss sky130_fd_pr__nfet_01v8_lvt w=1.2 l=0.15
X93 t_Xlane0_Xr0_m2 t_Xlane0_Xr0_m1 vdd vdd sky130_fd_pr__pfet_01v8 w=1.6 l=0.15
X94 t_Xlane0_Xr0_m2 rst_n vdd vdd sky130_fd_pr__pfet_01v8 w=1.6 l=0.15
X95 t_Xlane0_Xr0_m3 t_Xlane0_Xr0_m2 vss vss sky130_fd_pr__nfet_01v8_lvt w=0.8 l=0.15
X96 t_Xlane0_Xr0_m3 t_Xlane0_Xr0_m2 vdd vdd sky130_fd_pr__pfet_01v8 w=1.6 l=0.15
X97 t_Xlane0_Xr0_m3 t_Xlane0_Xr0_clki t_Xlane0_Xr0_m1 vss sky130_fd_pr__nfet_01v8_lvt w=0.8 l=0.15
X98 t_Xlane0_Xr0_m3 t_Xlane0_Xr0_clkb t_Xlane0_Xr0_m1 vdd sky130_fd_pr__pfet_01v8 w=1.6 l=0.15
X99 t_Xlane0_Xr0_m2 t_Xlane0_Xr0_clki t_Xlane0_Xr0_s1 vss sky130_fd_pr__nfet_01v8_lvt w=0.8 l=0.15
X100 t_Xlane0_Xr0_m2 t_Xlane0_Xr0_clkb t_Xlane0_Xr0_s1 vdd sky130_fd_pr__pfet_01v8 w=1.6 l=0.15
X101 t_Xlane0_Xr0_qi t_Xlane0_Xr0_s1 vss vss sky130_fd_pr__nfet_01v8_lvt w=0.96 l=0.15
X102 t_Xlane0_Xr0_qi t_Xlane0_Xr0_s1 vdd vdd sky130_fd_pr__pfet_01v8 w=1.92 l=0.15
X103 t_Xlane0_Xr0_s2 t_Xlane0_Xr0_qi t_Xlane0_Xr0_Xsfb_mid vss sky130_fd_pr__nfet_01v8_lvt w=1.2 l=0.15
X104 t_Xlane0_Xr0_Xsfb_mid rst_n vss vss sky130_fd_pr__nfet_01v8_lvt w=1.2 l=0.15
X105 t_Xlane0_Xr0_s2 t_Xlane0_Xr0_qi vdd vdd sky130_fd_pr__pfet_01v8 w=1.6 l=0.15
X106 t_Xlane0_Xr0_s2 rst_n vdd vdd sky130_fd_pr__pfet_01v8 w=1.6 l=0.15
X107 t_Xlane0_Xr0_s2 t_Xlane0_Xr0_clkb t_Xlane0_Xr0_s1 vss sky130_fd_pr__nfet_01v8_lvt w=0.8 l=0.15
X108 t_Xlane0_Xr0_s2 t_Xlane0_Xr0_clki t_Xlane0_Xr0_s1 vdd sky130_fd_pr__pfet_01v8 w=1.6 l=0.15
X109 t_Xlane0_r0 t_Xlane0_Xr0_s1 vss vss sky130_fd_pr__nfet_01v8_lvt w=1.2 l=0.15
X110 t_Xlane0_r0 t_Xlane0_Xr0_s1 vdd vdd sky130_fd_pr__pfet_01v8 w=2.4 l=0.15
X111 t_Xlane0_r0b t_Xlane0_Xr0_qi vss vss sky130_fd_pr__nfet_01v8_lvt w=1.2 l=0.15
X112 t_Xlane0_r0b t_Xlane0_Xr0_qi vdd vdd sky130_fd_pr__pfet_01v8 w=2.4 l=0.15
X113 t_Xlane0_Xr1_clkb t_clk250b vss vss sky130_fd_pr__nfet_01v8_lvt w=1.2 l=0.15
X114 t_Xlane0_Xr1_clkb t_clk250b vdd vdd sky130_fd_pr__pfet_01v8 w=2.4 l=0.15
X115 t_Xlane0_Xr1_clki t_Xlane0_Xr1_clkb vss vss sky130_fd_pr__nfet_01v8_lvt w=1.2 l=0.15
X116 t_Xlane0_Xr1_clki t_Xlane0_Xr1_clkb vdd vdd sky130_fd_pr__pfet_01v8 w=2.4 l=0.15
X117 din4 t_Xlane0_Xr1_clkb t_Xlane0_Xr1_m1 vss sky130_fd_pr__nfet_01v8_lvt w=0.8 l=0.15
X118 din4 t_Xlane0_Xr1_clki t_Xlane0_Xr1_m1 vdd sky130_fd_pr__pfet_01v8 w=1.6 l=0.15
X119 t_Xlane0_Xr1_m2 t_Xlane0_Xr1_m1 t_Xlane0_Xr1_Xm2_mid vss sky130_fd_pr__nfet_01v8_lvt w=1.2 l=0.15
X120 t_Xlane0_Xr1_Xm2_mid rst_n vss vss sky130_fd_pr__nfet_01v8_lvt w=1.2 l=0.15
X121 t_Xlane0_Xr1_m2 t_Xlane0_Xr1_m1 vdd vdd sky130_fd_pr__pfet_01v8 w=1.6 l=0.15
X122 t_Xlane0_Xr1_m2 rst_n vdd vdd sky130_fd_pr__pfet_01v8 w=1.6 l=0.15
X123 t_Xlane0_Xr1_m3 t_Xlane0_Xr1_m2 vss vss sky130_fd_pr__nfet_01v8_lvt w=0.8 l=0.15
X124 t_Xlane0_Xr1_m3 t_Xlane0_Xr1_m2 vdd vdd sky130_fd_pr__pfet_01v8 w=1.6 l=0.15
X125 t_Xlane0_Xr1_m3 t_Xlane0_Xr1_clki t_Xlane0_Xr1_m1 vss sky130_fd_pr__nfet_01v8_lvt w=0.8 l=0.15
X126 t_Xlane0_Xr1_m3 t_Xlane0_Xr1_clkb t_Xlane0_Xr1_m1 vdd sky130_fd_pr__pfet_01v8 w=1.6 l=0.15
X127 t_Xlane0_Xr1_m2 t_Xlane0_Xr1_clki t_Xlane0_Xr1_s1 vss sky130_fd_pr__nfet_01v8_lvt w=0.8 l=0.15
X128 t_Xlane0_Xr1_m2 t_Xlane0_Xr1_clkb t_Xlane0_Xr1_s1 vdd sky130_fd_pr__pfet_01v8 w=1.6 l=0.15
X129 t_Xlane0_Xr1_qi t_Xlane0_Xr1_s1 vss vss sky130_fd_pr__nfet_01v8_lvt w=0.96 l=0.15
X130 t_Xlane0_Xr1_qi t_Xlane0_Xr1_s1 vdd vdd sky130_fd_pr__pfet_01v8 w=1.92 l=0.15
X131 t_Xlane0_Xr1_s2 t_Xlane0_Xr1_qi t_Xlane0_Xr1_Xsfb_mid vss sky130_fd_pr__nfet_01v8_lvt w=1.2 l=0.15
X132 t_Xlane0_Xr1_Xsfb_mid rst_n vss vss sky130_fd_pr__nfet_01v8_lvt w=1.2 l=0.15
X133 t_Xlane0_Xr1_s2 t_Xlane0_Xr1_qi vdd vdd sky130_fd_pr__pfet_01v8 w=1.6 l=0.15
X134 t_Xlane0_Xr1_s2 rst_n vdd vdd sky130_fd_pr__pfet_01v8 w=1.6 l=0.15
X135 t_Xlane0_Xr1_s2 t_Xlane0_Xr1_clkb t_Xlane0_Xr1_s1 vss sky130_fd_pr__nfet_01v8_lvt w=0.8 l=0.15
X136 t_Xlane0_Xr1_s2 t_Xlane0_Xr1_clki t_Xlane0_Xr1_s1 vdd sky130_fd_pr__pfet_01v8 w=1.6 l=0.15
X137 t_Xlane0_r1 t_Xlane0_Xr1_s1 vss vss sky130_fd_pr__nfet_01v8_lvt w=1.2 l=0.15
X138 t_Xlane0_r1 t_Xlane0_Xr1_s1 vdd vdd sky130_fd_pr__pfet_01v8 w=2.4 l=0.15
X139 t_Xlane0_r1b t_Xlane0_Xr1_qi vss vss sky130_fd_pr__nfet_01v8_lvt w=1.2 l=0.15
X140 t_Xlane0_r1b t_Xlane0_Xr1_qi vdd vdd sky130_fd_pr__pfet_01v8 w=2.4 l=0.15
X141 t_Xlane0_Xr2_clkb t_clk250b vss vss sky130_fd_pr__nfet_01v8_lvt w=1.2 l=0.15
X142 t_Xlane0_Xr2_clkb t_clk250b vdd vdd sky130_fd_pr__pfet_01v8 w=2.4 l=0.15
X143 t_Xlane0_Xr2_clki t_Xlane0_Xr2_clkb vss vss sky130_fd_pr__nfet_01v8_lvt w=1.2 l=0.15
X144 t_Xlane0_Xr2_clki t_Xlane0_Xr2_clkb vdd vdd sky130_fd_pr__pfet_01v8 w=2.4 l=0.15
X145 din8 t_Xlane0_Xr2_clkb t_Xlane0_Xr2_m1 vss sky130_fd_pr__nfet_01v8_lvt w=0.8 l=0.15
X146 din8 t_Xlane0_Xr2_clki t_Xlane0_Xr2_m1 vdd sky130_fd_pr__pfet_01v8 w=1.6 l=0.15
X147 t_Xlane0_Xr2_m2 t_Xlane0_Xr2_m1 t_Xlane0_Xr2_Xm2_mid vss sky130_fd_pr__nfet_01v8_lvt w=1.2 l=0.15
X148 t_Xlane0_Xr2_Xm2_mid rst_n vss vss sky130_fd_pr__nfet_01v8_lvt w=1.2 l=0.15
X149 t_Xlane0_Xr2_m2 t_Xlane0_Xr2_m1 vdd vdd sky130_fd_pr__pfet_01v8 w=1.6 l=0.15
X150 t_Xlane0_Xr2_m2 rst_n vdd vdd sky130_fd_pr__pfet_01v8 w=1.6 l=0.15
X151 t_Xlane0_Xr2_m3 t_Xlane0_Xr2_m2 vss vss sky130_fd_pr__nfet_01v8_lvt w=0.8 l=0.15
X152 t_Xlane0_Xr2_m3 t_Xlane0_Xr2_m2 vdd vdd sky130_fd_pr__pfet_01v8 w=1.6 l=0.15
X153 t_Xlane0_Xr2_m3 t_Xlane0_Xr2_clki t_Xlane0_Xr2_m1 vss sky130_fd_pr__nfet_01v8_lvt w=0.8 l=0.15
X154 t_Xlane0_Xr2_m3 t_Xlane0_Xr2_clkb t_Xlane0_Xr2_m1 vdd sky130_fd_pr__pfet_01v8 w=1.6 l=0.15
X155 t_Xlane0_Xr2_m2 t_Xlane0_Xr2_clki t_Xlane0_Xr2_s1 vss sky130_fd_pr__nfet_01v8_lvt w=0.8 l=0.15
X156 t_Xlane0_Xr2_m2 t_Xlane0_Xr2_clkb t_Xlane0_Xr2_s1 vdd sky130_fd_pr__pfet_01v8 w=1.6 l=0.15
X157 t_Xlane0_Xr2_qi t_Xlane0_Xr2_s1 vss vss sky130_fd_pr__nfet_01v8_lvt w=0.96 l=0.15
X158 t_Xlane0_Xr2_qi t_Xlane0_Xr2_s1 vdd vdd sky130_fd_pr__pfet_01v8 w=1.92 l=0.15
X159 t_Xlane0_Xr2_s2 t_Xlane0_Xr2_qi t_Xlane0_Xr2_Xsfb_mid vss sky130_fd_pr__nfet_01v8_lvt w=1.2 l=0.15
X160 t_Xlane0_Xr2_Xsfb_mid rst_n vss vss sky130_fd_pr__nfet_01v8_lvt w=1.2 l=0.15
X161 t_Xlane0_Xr2_s2 t_Xlane0_Xr2_qi vdd vdd sky130_fd_pr__pfet_01v8 w=1.6 l=0.15
X162 t_Xlane0_Xr2_s2 rst_n vdd vdd sky130_fd_pr__pfet_01v8 w=1.6 l=0.15
X163 t_Xlane0_Xr2_s2 t_Xlane0_Xr2_clkb t_Xlane0_Xr2_s1 vss sky130_fd_pr__nfet_01v8_lvt w=0.8 l=0.15
X164 t_Xlane0_Xr2_s2 t_Xlane0_Xr2_clki t_Xlane0_Xr2_s1 vdd sky130_fd_pr__pfet_01v8 w=1.6 l=0.15
X165 t_Xlane0_r2 t_Xlane0_Xr2_s1 vss vss sky130_fd_pr__nfet_01v8_lvt w=1.2 l=0.15
X166 t_Xlane0_r2 t_Xlane0_Xr2_s1 vdd vdd sky130_fd_pr__pfet_01v8 w=2.4 l=0.15
X167 t_Xlane0_r2b t_Xlane0_Xr2_qi vss vss sky130_fd_pr__nfet_01v8_lvt w=1.2 l=0.15
X168 t_Xlane0_r2b t_Xlane0_Xr2_qi vdd vdd sky130_fd_pr__pfet_01v8 w=2.4 l=0.15
X169 t_Xlane0_Xr3_m_clkb t_clk250b vss vss sky130_fd_pr__nfet_01v8_lvt w=1.2 l=0.15
X170 t_Xlane0_Xr3_m_clkb t_clk250b vdd vdd sky130_fd_pr__pfet_01v8 w=2.4 l=0.15
X171 t_Xlane0_Xr3_m_clki t_Xlane0_Xr3_m_clkb vss vss sky130_fd_pr__nfet_01v8_lvt w=1.2 l=0.15
X172 t_Xlane0_Xr3_m_clki t_Xlane0_Xr3_m_clkb vdd vdd sky130_fd_pr__pfet_01v8 w=2.4 l=0.15
X173 din12 t_Xlane0_Xr3_m_clkb t_Xlane0_Xr3_m_m1 vss sky130_fd_pr__nfet_01v8_lvt w=0.8 l=0.15
X174 din12 t_Xlane0_Xr3_m_clki t_Xlane0_Xr3_m_m1 vdd sky130_fd_pr__pfet_01v8 w=1.6 l=0.15
X175 t_Xlane0_Xr3_m_m2 t_Xlane0_Xr3_m_m1 t_Xlane0_Xr3_m_Xm2_mid vss sky130_fd_pr__nfet_01v8_lvt w=1.2 l=0.15
X176 t_Xlane0_Xr3_m_Xm2_mid rst_n vss vss sky130_fd_pr__nfet_01v8_lvt w=1.2 l=0.15
X177 t_Xlane0_Xr3_m_m2 t_Xlane0_Xr3_m_m1 vdd vdd sky130_fd_pr__pfet_01v8 w=1.6 l=0.15
X178 t_Xlane0_Xr3_m_m2 rst_n vdd vdd sky130_fd_pr__pfet_01v8 w=1.6 l=0.15
X179 t_Xlane0_Xr3_m_m3 t_Xlane0_Xr3_m_m2 vss vss sky130_fd_pr__nfet_01v8_lvt w=0.8 l=0.15
X180 t_Xlane0_Xr3_m_m3 t_Xlane0_Xr3_m_m2 vdd vdd sky130_fd_pr__pfet_01v8 w=1.6 l=0.15
X181 t_Xlane0_Xr3_m_m3 t_Xlane0_Xr3_m_clki t_Xlane0_Xr3_m_m1 vss sky130_fd_pr__nfet_01v8_lvt w=0.8 l=0.15
X182 t_Xlane0_Xr3_m_m3 t_Xlane0_Xr3_m_clkb t_Xlane0_Xr3_m_m1 vdd sky130_fd_pr__pfet_01v8 w=1.6 l=0.15
X183 t_Xlane0_Xr3_m_m2 t_Xlane0_Xr3_m_clki t_Xlane0_Xr3_m_s1 vss sky130_fd_pr__nfet_01v8_lvt w=0.8 l=0.15
X184 t_Xlane0_Xr3_m_m2 t_Xlane0_Xr3_m_clkb t_Xlane0_Xr3_m_s1 vdd sky130_fd_pr__pfet_01v8 w=1.6 l=0.15
X185 t_Xlane0_Xr3_m_qi t_Xlane0_Xr3_m_s1 vss vss sky130_fd_pr__nfet_01v8_lvt w=0.96 l=0.15
X186 t_Xlane0_Xr3_m_qi t_Xlane0_Xr3_m_s1 vdd vdd sky130_fd_pr__pfet_01v8 w=1.92 l=0.15
X187 t_Xlane0_Xr3_m_s2 t_Xlane0_Xr3_m_qi t_Xlane0_Xr3_m_Xsfb_mid vss sky130_fd_pr__nfet_01v8_lvt w=1.2 l=0.15
X188 t_Xlane0_Xr3_m_Xsfb_mid rst_n vss vss sky130_fd_pr__nfet_01v8_lvt w=1.2 l=0.15
X189 t_Xlane0_Xr3_m_s2 t_Xlane0_Xr3_m_qi vdd vdd sky130_fd_pr__pfet_01v8 w=1.6 l=0.15
X190 t_Xlane0_Xr3_m_s2 rst_n vdd vdd sky130_fd_pr__pfet_01v8 w=1.6 l=0.15
X191 t_Xlane0_Xr3_m_s2 t_Xlane0_Xr3_m_clkb t_Xlane0_Xr3_m_s1 vss sky130_fd_pr__nfet_01v8_lvt w=0.8 l=0.15
X192 t_Xlane0_Xr3_m_s2 t_Xlane0_Xr3_m_clki t_Xlane0_Xr3_m_s1 vdd sky130_fd_pr__pfet_01v8 w=1.6 l=0.15
X193 t_Xlane0_r3_m t_Xlane0_Xr3_m_s1 vss vss sky130_fd_pr__nfet_01v8_lvt w=1.2 l=0.15
X194 t_Xlane0_r3_m t_Xlane0_Xr3_m_s1 vdd vdd sky130_fd_pr__pfet_01v8 w=2.4 l=0.15
X195 t_Xlane0_r3_mb t_Xlane0_Xr3_m_qi vss vss sky130_fd_pr__nfet_01v8_lvt w=1.2 l=0.15
X196 t_Xlane0_r3_mb t_Xlane0_Xr3_m_qi vdd vdd sky130_fd_pr__pfet_01v8 w=2.4 l=0.15
X197 t_Xlane0_Xr3_clkb t_clk250 vss vss sky130_fd_pr__nfet_01v8_lvt w=1.2 l=0.15
X198 t_Xlane0_Xr3_clkb t_clk250 vdd vdd sky130_fd_pr__pfet_01v8 w=2.4 l=0.15
X199 t_Xlane0_Xr3_clki t_Xlane0_Xr3_clkb vss vss sky130_fd_pr__nfet_01v8_lvt w=1.2 l=0.15
X200 t_Xlane0_Xr3_clki t_Xlane0_Xr3_clkb vdd vdd sky130_fd_pr__pfet_01v8 w=2.4 l=0.15
X201 t_Xlane0_r3_m t_Xlane0_Xr3_clkb t_Xlane0_Xr3_m1 vss sky130_fd_pr__nfet_01v8_lvt w=0.8 l=0.15
X202 t_Xlane0_r3_m t_Xlane0_Xr3_clki t_Xlane0_Xr3_m1 vdd sky130_fd_pr__pfet_01v8 w=1.6 l=0.15
X203 t_Xlane0_Xr3_m2 t_Xlane0_Xr3_m1 t_Xlane0_Xr3_Xm2_mid vss sky130_fd_pr__nfet_01v8_lvt w=1.2 l=0.15
X204 t_Xlane0_Xr3_Xm2_mid rst_n vss vss sky130_fd_pr__nfet_01v8_lvt w=1.2 l=0.15
X205 t_Xlane0_Xr3_m2 t_Xlane0_Xr3_m1 vdd vdd sky130_fd_pr__pfet_01v8 w=1.6 l=0.15
X206 t_Xlane0_Xr3_m2 rst_n vdd vdd sky130_fd_pr__pfet_01v8 w=1.6 l=0.15
X207 t_Xlane0_Xr3_m3 t_Xlane0_Xr3_m2 vss vss sky130_fd_pr__nfet_01v8_lvt w=0.8 l=0.15
X208 t_Xlane0_Xr3_m3 t_Xlane0_Xr3_m2 vdd vdd sky130_fd_pr__pfet_01v8 w=1.6 l=0.15
X209 t_Xlane0_Xr3_m3 t_Xlane0_Xr3_clki t_Xlane0_Xr3_m1 vss sky130_fd_pr__nfet_01v8_lvt w=0.8 l=0.15
X210 t_Xlane0_Xr3_m3 t_Xlane0_Xr3_clkb t_Xlane0_Xr3_m1 vdd sky130_fd_pr__pfet_01v8 w=1.6 l=0.15
X211 t_Xlane0_Xr3_m2 t_Xlane0_Xr3_clki t_Xlane0_Xr3_s1 vss sky130_fd_pr__nfet_01v8_lvt w=0.8 l=0.15
X212 t_Xlane0_Xr3_m2 t_Xlane0_Xr3_clkb t_Xlane0_Xr3_s1 vdd sky130_fd_pr__pfet_01v8 w=1.6 l=0.15
X213 t_Xlane0_Xr3_qi t_Xlane0_Xr3_s1 vss vss sky130_fd_pr__nfet_01v8_lvt w=0.96 l=0.15
X214 t_Xlane0_Xr3_qi t_Xlane0_Xr3_s1 vdd vdd sky130_fd_pr__pfet_01v8 w=1.92 l=0.15
X215 t_Xlane0_Xr3_s2 t_Xlane0_Xr3_qi t_Xlane0_Xr3_Xsfb_mid vss sky130_fd_pr__nfet_01v8_lvt w=1.2 l=0.15
X216 t_Xlane0_Xr3_Xsfb_mid rst_n vss vss sky130_fd_pr__nfet_01v8_lvt w=1.2 l=0.15
X217 t_Xlane0_Xr3_s2 t_Xlane0_Xr3_qi vdd vdd sky130_fd_pr__pfet_01v8 w=1.6 l=0.15
X218 t_Xlane0_Xr3_s2 rst_n vdd vdd sky130_fd_pr__pfet_01v8 w=1.6 l=0.15
X219 t_Xlane0_Xr3_s2 t_Xlane0_Xr3_clkb t_Xlane0_Xr3_s1 vss sky130_fd_pr__nfet_01v8_lvt w=0.8 l=0.15
X220 t_Xlane0_Xr3_s2 t_Xlane0_Xr3_clki t_Xlane0_Xr3_s1 vdd sky130_fd_pr__pfet_01v8 w=1.6 l=0.15
X221 t_Xlane0_r3 t_Xlane0_Xr3_s1 vss vss sky130_fd_pr__nfet_01v8_lvt w=1.2 l=0.15
X222 t_Xlane0_r3 t_Xlane0_Xr3_s1 vdd vdd sky130_fd_pr__pfet_01v8 w=2.4 l=0.15
X223 t_Xlane0_r3b t_Xlane0_Xr3_qi vss vss sky130_fd_pr__nfet_01v8_lvt w=1.2 l=0.15
X224 t_Xlane0_r3b t_Xlane0_Xr3_qi vdd vdd sky130_fd_pr__pfet_01v8 w=2.4 l=0.15
X225 t_Xlane0_r2 t_clk250 t_Xlane0_Xma_mid vss sky130_fd_pr__nfet_01v8_lvt w=0.9 l=0.15
X226 t_Xlane0_r2 t_clk250b t_Xlane0_Xma_mid vdd sky130_fd_pr__pfet_01v8 w=1.8 l=0.15
X227 t_Xlane0_r0 t_clk250b t_Xlane0_Xma_mid vss sky130_fd_pr__nfet_01v8_lvt w=0.9 l=0.15
X228 t_Xlane0_r0 t_clk250 t_Xlane0_Xma_mid vdd sky130_fd_pr__pfet_01v8 w=1.8 l=0.15
X229 t_Xlane0_Xma_yb t_Xlane0_Xma_mid vss vss sky130_fd_pr__nfet_01v8_lvt w=0.9 l=0.15
X230 t_Xlane0_Xma_yb t_Xlane0_Xma_mid vdd vdd sky130_fd_pr__pfet_01v8 w=1.8 l=0.15
X231 t_Xlane0_ma t_Xlane0_Xma_yb vss vss sky130_fd_pr__nfet_01v8_lvt w=0.9 l=0.15
X232 t_Xlane0_ma t_Xlane0_Xma_yb vdd vdd sky130_fd_pr__pfet_01v8 w=1.8 l=0.15
X233 t_Xlane0_r1 t_clk250 t_Xlane0_Xmb_mid vss sky130_fd_pr__nfet_01v8_lvt w=0.9 l=0.15
X234 t_Xlane0_r1 t_clk250b t_Xlane0_Xmb_mid vdd sky130_fd_pr__pfet_01v8 w=1.8 l=0.15
X235 t_Xlane0_r3 t_clk250b t_Xlane0_Xmb_mid vss sky130_fd_pr__nfet_01v8_lvt w=0.9 l=0.15
X236 t_Xlane0_r3 t_clk250 t_Xlane0_Xmb_mid vdd sky130_fd_pr__pfet_01v8 w=1.8 l=0.15
X237 t_Xlane0_Xmb_yb t_Xlane0_Xmb_mid vss vss sky130_fd_pr__nfet_01v8_lvt w=0.9 l=0.15
X238 t_Xlane0_Xmb_yb t_Xlane0_Xmb_mid vdd vdd sky130_fd_pr__pfet_01v8 w=1.8 l=0.15
X239 t_Xlane0_mb t_Xlane0_Xmb_yb vss vss sky130_fd_pr__nfet_01v8_lvt w=0.9 l=0.15
X240 t_Xlane0_mb t_Xlane0_Xmb_yb vdd vdd sky130_fd_pr__pfet_01v8 w=1.8 l=0.15
X241 t_Xlane0_Xda_clkb t_clk500 vss vss sky130_fd_pr__nfet_01v8_lvt w=1.2 l=0.15
X242 t_Xlane0_Xda_clkb t_clk500 vdd vdd sky130_fd_pr__pfet_01v8 w=2.4 l=0.15
X243 t_Xlane0_Xda_clki t_Xlane0_Xda_clkb vss vss sky130_fd_pr__nfet_01v8_lvt w=1.2 l=0.15
X244 t_Xlane0_Xda_clki t_Xlane0_Xda_clkb vdd vdd sky130_fd_pr__pfet_01v8 w=2.4 l=0.15
X245 t_Xlane0_ma t_Xlane0_Xda_clkb t_Xlane0_Xda_m1 vss sky130_fd_pr__nfet_01v8_lvt w=1.2 l=0.15
X246 t_Xlane0_ma t_Xlane0_Xda_clki t_Xlane0_Xda_m1 vdd sky130_fd_pr__pfet_01v8 w=2.4 l=0.15
X247 t_Xlane0_Xda_m2 t_Xlane0_Xda_m1 t_Xlane0_Xda_Xm2_mid vss sky130_fd_pr__nfet_01v8_lvt w=1.8 l=0.15
X248 t_Xlane0_Xda_Xm2_mid rst_n vss vss sky130_fd_pr__nfet_01v8_lvt w=1.8 l=0.15
X249 t_Xlane0_Xda_m2 t_Xlane0_Xda_m1 vdd vdd sky130_fd_pr__pfet_01v8 w=2.4 l=0.15
X250 t_Xlane0_Xda_m2 rst_n vdd vdd sky130_fd_pr__pfet_01v8 w=2.4 l=0.15
X251 t_Xlane0_Xda_m3 t_Xlane0_Xda_m2 vss vss sky130_fd_pr__nfet_01v8_lvt w=0.8 l=0.15
X252 t_Xlane0_Xda_m3 t_Xlane0_Xda_m2 vdd vdd sky130_fd_pr__pfet_01v8 w=1.6 l=0.15
X253 t_Xlane0_Xda_m3 t_Xlane0_Xda_clki t_Xlane0_Xda_m1 vss sky130_fd_pr__nfet_01v8_lvt w=0.8 l=0.15
X254 t_Xlane0_Xda_m3 t_Xlane0_Xda_clkb t_Xlane0_Xda_m1 vdd sky130_fd_pr__pfet_01v8 w=1.6 l=0.15
X255 t_Xlane0_Xda_m2 t_Xlane0_Xda_clki t_Xlane0_Xda_s1 vss sky130_fd_pr__nfet_01v8_lvt w=1.2 l=0.15
X256 t_Xlane0_Xda_m2 t_Xlane0_Xda_clkb t_Xlane0_Xda_s1 vdd sky130_fd_pr__pfet_01v8 w=2.4 l=0.15
X257 t_Xlane0_Xda_qi t_Xlane0_Xda_s1 vss vss sky130_fd_pr__nfet_01v8_lvt w=1.44 l=0.15
X258 t_Xlane0_Xda_qi t_Xlane0_Xda_s1 vdd vdd sky130_fd_pr__pfet_01v8 w=2.88 l=0.15
X259 t_Xlane0_Xda_s2 t_Xlane0_Xda_qi t_Xlane0_Xda_Xsfb_mid vss sky130_fd_pr__nfet_01v8_lvt w=1.2 l=0.15
X260 t_Xlane0_Xda_Xsfb_mid rst_n vss vss sky130_fd_pr__nfet_01v8_lvt w=1.2 l=0.15
X261 t_Xlane0_Xda_s2 t_Xlane0_Xda_qi vdd vdd sky130_fd_pr__pfet_01v8 w=1.6 l=0.15
X262 t_Xlane0_Xda_s2 rst_n vdd vdd sky130_fd_pr__pfet_01v8 w=1.6 l=0.15
X263 t_Xlane0_Xda_s2 t_Xlane0_Xda_clkb t_Xlane0_Xda_s1 vss sky130_fd_pr__nfet_01v8_lvt w=0.8 l=0.15
X264 t_Xlane0_Xda_s2 t_Xlane0_Xda_clki t_Xlane0_Xda_s1 vdd sky130_fd_pr__pfet_01v8 w=1.6 l=0.15
X265 t_Xlane0_da t_Xlane0_Xda_s1 vss vss sky130_fd_pr__nfet_01v8_lvt w=1.8 l=0.15
X266 t_Xlane0_da t_Xlane0_Xda_s1 vdd vdd sky130_fd_pr__pfet_01v8 w=3.6 l=0.15
X267 t_Xlane0_dab t_Xlane0_Xda_qi vss vss sky130_fd_pr__nfet_01v8_lvt w=1.8 l=0.15
X268 t_Xlane0_dab t_Xlane0_Xda_qi vdd vdd sky130_fd_pr__pfet_01v8 w=3.6 l=0.15
X269 t_Xlane0_Xdb_clkb t_clk500b vss vss sky130_fd_pr__nfet_01v8_lvt w=1.2 l=0.15
X270 t_Xlane0_Xdb_clkb t_clk500b vdd vdd sky130_fd_pr__pfet_01v8 w=2.4 l=0.15
X271 t_Xlane0_Xdb_clki t_Xlane0_Xdb_clkb vss vss sky130_fd_pr__nfet_01v8_lvt w=1.2 l=0.15
X272 t_Xlane0_Xdb_clki t_Xlane0_Xdb_clkb vdd vdd sky130_fd_pr__pfet_01v8 w=2.4 l=0.15
X273 t_Xlane0_mb t_Xlane0_Xdb_clkb t_Xlane0_Xdb_m1 vss sky130_fd_pr__nfet_01v8_lvt w=1.2 l=0.15
X274 t_Xlane0_mb t_Xlane0_Xdb_clki t_Xlane0_Xdb_m1 vdd sky130_fd_pr__pfet_01v8 w=2.4 l=0.15
X275 t_Xlane0_Xdb_m2 t_Xlane0_Xdb_m1 t_Xlane0_Xdb_Xm2_mid vss sky130_fd_pr__nfet_01v8_lvt w=1.8 l=0.15
X276 t_Xlane0_Xdb_Xm2_mid rst_n vss vss sky130_fd_pr__nfet_01v8_lvt w=1.8 l=0.15
X277 t_Xlane0_Xdb_m2 t_Xlane0_Xdb_m1 vdd vdd sky130_fd_pr__pfet_01v8 w=2.4 l=0.15
X278 t_Xlane0_Xdb_m2 rst_n vdd vdd sky130_fd_pr__pfet_01v8 w=2.4 l=0.15
X279 t_Xlane0_Xdb_m3 t_Xlane0_Xdb_m2 vss vss sky130_fd_pr__nfet_01v8_lvt w=0.8 l=0.15
X280 t_Xlane0_Xdb_m3 t_Xlane0_Xdb_m2 vdd vdd sky130_fd_pr__pfet_01v8 w=1.6 l=0.15
X281 t_Xlane0_Xdb_m3 t_Xlane0_Xdb_clki t_Xlane0_Xdb_m1 vss sky130_fd_pr__nfet_01v8_lvt w=0.8 l=0.15
X282 t_Xlane0_Xdb_m3 t_Xlane0_Xdb_clkb t_Xlane0_Xdb_m1 vdd sky130_fd_pr__pfet_01v8 w=1.6 l=0.15
X283 t_Xlane0_Xdb_m2 t_Xlane0_Xdb_clki t_Xlane0_Xdb_s1 vss sky130_fd_pr__nfet_01v8_lvt w=1.2 l=0.15
X284 t_Xlane0_Xdb_m2 t_Xlane0_Xdb_clkb t_Xlane0_Xdb_s1 vdd sky130_fd_pr__pfet_01v8 w=2.4 l=0.15
X285 t_Xlane0_Xdb_qi t_Xlane0_Xdb_s1 vss vss sky130_fd_pr__nfet_01v8_lvt w=1.44 l=0.15
X286 t_Xlane0_Xdb_qi t_Xlane0_Xdb_s1 vdd vdd sky130_fd_pr__pfet_01v8 w=2.88 l=0.15
X287 t_Xlane0_Xdb_s2 t_Xlane0_Xdb_qi t_Xlane0_Xdb_Xsfb_mid vss sky130_fd_pr__nfet_01v8_lvt w=1.2 l=0.15
X288 t_Xlane0_Xdb_Xsfb_mid rst_n vss vss sky130_fd_pr__nfet_01v8_lvt w=1.2 l=0.15
X289 t_Xlane0_Xdb_s2 t_Xlane0_Xdb_qi vdd vdd sky130_fd_pr__pfet_01v8 w=1.6 l=0.15
X290 t_Xlane0_Xdb_s2 rst_n vdd vdd sky130_fd_pr__pfet_01v8 w=1.6 l=0.15
X291 t_Xlane0_Xdb_s2 t_Xlane0_Xdb_clkb t_Xlane0_Xdb_s1 vss sky130_fd_pr__nfet_01v8_lvt w=0.8 l=0.15
X292 t_Xlane0_Xdb_s2 t_Xlane0_Xdb_clki t_Xlane0_Xdb_s1 vdd sky130_fd_pr__pfet_01v8 w=1.6 l=0.15
X293 t_Xlane0_db t_Xlane0_Xdb_s1 vss vss sky130_fd_pr__nfet_01v8_lvt w=1.8 l=0.15
X294 t_Xlane0_db t_Xlane0_Xdb_s1 vdd vdd sky130_fd_pr__pfet_01v8 w=3.6 l=0.15
X295 t_Xlane0_dbb t_Xlane0_Xdb_qi vss vss sky130_fd_pr__nfet_01v8_lvt w=1.8 l=0.15
X296 t_Xlane0_dbb t_Xlane0_Xdb_qi vdd vdd sky130_fd_pr__pfet_01v8 w=3.6 l=0.15
X297 t_Xlane0_da t_clk500b t_Xlane0_Xmc_mid vss sky130_fd_pr__nfet_01v8_lvt w=1.5 l=0.15
X298 t_Xlane0_da t_clk500 t_Xlane0_Xmc_mid vdd sky130_fd_pr__pfet_01v8 w=3 l=0.15
X299 t_Xlane0_db t_clk500 t_Xlane0_Xmc_mid vss sky130_fd_pr__nfet_01v8_lvt w=1.5 l=0.15
X300 t_Xlane0_db t_clk500b t_Xlane0_Xmc_mid vdd sky130_fd_pr__pfet_01v8 w=3 l=0.15
X301 t_Xlane0_Xmc_yb t_Xlane0_Xmc_mid vss vss sky130_fd_pr__nfet_01v8_lvt w=1.5 l=0.15
X302 t_Xlane0_Xmc_yb t_Xlane0_Xmc_mid vdd vdd sky130_fd_pr__pfet_01v8 w=3 l=0.15
X303 t_Xlane0_mc t_Xlane0_Xmc_yb vss vss sky130_fd_pr__nfet_01v8_lvt w=1.5 l=0.15
X304 t_Xlane0_mc t_Xlane0_Xmc_yb vdd vdd sky130_fd_pr__pfet_01v8 w=3 l=0.15
X305 t_Xlane0_Xd1g_clkb t_c0 vss vss sky130_fd_pr__nfet_01v8_lvt w=1.2 l=0.15
X306 t_Xlane0_Xd1g_clkb t_c0 vdd vdd sky130_fd_pr__pfet_01v8 w=2.4 l=0.15
X307 t_Xlane0_Xd1g_clki t_Xlane0_Xd1g_clkb vss vss sky130_fd_pr__nfet_01v8_lvt w=1.2 l=0.15
X308 t_Xlane0_Xd1g_clki t_Xlane0_Xd1g_clkb vdd vdd sky130_fd_pr__pfet_01v8 w=2.4 l=0.15
X309 t_Xlane0_mc t_Xlane0_Xd1g_clkb t_Xlane0_Xd1g_m1 vss sky130_fd_pr__nfet_01v8_lvt w=1.5 l=0.15
X310 t_Xlane0_mc t_Xlane0_Xd1g_clki t_Xlane0_Xd1g_m1 vdd sky130_fd_pr__pfet_01v8 w=3 l=0.15
X311 t_Xlane0_Xd1g_m2 t_Xlane0_Xd1g_m1 t_Xlane0_Xd1g_Xm2_mid vss sky130_fd_pr__nfet_01v8_lvt w=2.25 l=0.15
X312 t_Xlane0_Xd1g_Xm2_mid rst_n vss vss sky130_fd_pr__nfet_01v8_lvt w=2.25 l=0.15
X313 t_Xlane0_Xd1g_m2 t_Xlane0_Xd1g_m1 vdd vdd sky130_fd_pr__pfet_01v8 w=3 l=0.15
X314 t_Xlane0_Xd1g_m2 rst_n vdd vdd sky130_fd_pr__pfet_01v8 w=3 l=0.15
X315 t_Xlane0_Xd1g_m3 t_Xlane0_Xd1g_m2 vss vss sky130_fd_pr__nfet_01v8_lvt w=0.8 l=0.15
X316 t_Xlane0_Xd1g_m3 t_Xlane0_Xd1g_m2 vdd vdd sky130_fd_pr__pfet_01v8 w=1.6 l=0.15
X317 t_Xlane0_Xd1g_m3 t_Xlane0_Xd1g_clki t_Xlane0_Xd1g_m1 vss sky130_fd_pr__nfet_01v8_lvt w=0.8 l=0.15
X318 t_Xlane0_Xd1g_m3 t_Xlane0_Xd1g_clkb t_Xlane0_Xd1g_m1 vdd sky130_fd_pr__pfet_01v8 w=1.6 l=0.15
X319 t_Xlane0_Xd1g_m2 t_Xlane0_Xd1g_clki t_Xlane0_Xd1g_s1 vss sky130_fd_pr__nfet_01v8_lvt w=1.5 l=0.15
X320 t_Xlane0_Xd1g_m2 t_Xlane0_Xd1g_clkb t_Xlane0_Xd1g_s1 vdd sky130_fd_pr__pfet_01v8 w=3 l=0.15
X321 t_Xlane0_Xd1g_qi t_Xlane0_Xd1g_s1 vss vss sky130_fd_pr__nfet_01v8_lvt w=1.8 l=0.15
X322 t_Xlane0_Xd1g_qi t_Xlane0_Xd1g_s1 vdd vdd sky130_fd_pr__pfet_01v8 w=3.6 l=0.15
X323 t_Xlane0_Xd1g_s2 t_Xlane0_Xd1g_qi t_Xlane0_Xd1g_Xsfb_mid vss sky130_fd_pr__nfet_01v8_lvt w=1.2 l=0.15
X324 t_Xlane0_Xd1g_Xsfb_mid rst_n vss vss sky130_fd_pr__nfet_01v8_lvt w=1.2 l=0.15
X325 t_Xlane0_Xd1g_s2 t_Xlane0_Xd1g_qi vdd vdd sky130_fd_pr__pfet_01v8 w=1.6 l=0.15
X326 t_Xlane0_Xd1g_s2 rst_n vdd vdd sky130_fd_pr__pfet_01v8 w=1.6 l=0.15
X327 t_Xlane0_Xd1g_s2 t_Xlane0_Xd1g_clkb t_Xlane0_Xd1g_s1 vss sky130_fd_pr__nfet_01v8_lvt w=0.8 l=0.15
X328 t_Xlane0_Xd1g_s2 t_Xlane0_Xd1g_clki t_Xlane0_Xd1g_s1 vdd sky130_fd_pr__pfet_01v8 w=1.6 l=0.15
X329 t_l0 t_Xlane0_Xd1g_s1 vss vss sky130_fd_pr__nfet_01v8_lvt w=2.25 l=0.15
X330 t_l0 t_Xlane0_Xd1g_s1 vdd vdd sky130_fd_pr__pfet_01v8 w=4.5 l=0.15
X331 t_Xlane0_l_outb t_Xlane0_Xd1g_qi vss vss sky130_fd_pr__nfet_01v8_lvt w=2.25 l=0.15
X332 t_Xlane0_l_outb t_Xlane0_Xd1g_qi vdd vdd sky130_fd_pr__pfet_01v8 w=4.5 l=0.15
X333 t_Xlane1_Xr0_clkb t_clk250b vss vss sky130_fd_pr__nfet_01v8_lvt w=1.2 l=0.15
X334 t_Xlane1_Xr0_clkb t_clk250b vdd vdd sky130_fd_pr__pfet_01v8 w=2.4 l=0.15
X335 t_Xlane1_Xr0_clki t_Xlane1_Xr0_clkb vss vss sky130_fd_pr__nfet_01v8_lvt w=1.2 l=0.15
X336 t_Xlane1_Xr0_clki t_Xlane1_Xr0_clkb vdd vdd sky130_fd_pr__pfet_01v8 w=2.4 l=0.15
X337 din1 t_Xlane1_Xr0_clkb t_Xlane1_Xr0_m1 vss sky130_fd_pr__nfet_01v8_lvt w=0.8 l=0.15
X338 din1 t_Xlane1_Xr0_clki t_Xlane1_Xr0_m1 vdd sky130_fd_pr__pfet_01v8 w=1.6 l=0.15
X339 t_Xlane1_Xr0_m2 t_Xlane1_Xr0_m1 t_Xlane1_Xr0_Xm2_mid vss sky130_fd_pr__nfet_01v8_lvt w=1.2 l=0.15
X340 t_Xlane1_Xr0_Xm2_mid rst_n vss vss sky130_fd_pr__nfet_01v8_lvt w=1.2 l=0.15
X341 t_Xlane1_Xr0_m2 t_Xlane1_Xr0_m1 vdd vdd sky130_fd_pr__pfet_01v8 w=1.6 l=0.15
X342 t_Xlane1_Xr0_m2 rst_n vdd vdd sky130_fd_pr__pfet_01v8 w=1.6 l=0.15
X343 t_Xlane1_Xr0_m3 t_Xlane1_Xr0_m2 vss vss sky130_fd_pr__nfet_01v8_lvt w=0.8 l=0.15
X344 t_Xlane1_Xr0_m3 t_Xlane1_Xr0_m2 vdd vdd sky130_fd_pr__pfet_01v8 w=1.6 l=0.15
X345 t_Xlane1_Xr0_m3 t_Xlane1_Xr0_clki t_Xlane1_Xr0_m1 vss sky130_fd_pr__nfet_01v8_lvt w=0.8 l=0.15
X346 t_Xlane1_Xr0_m3 t_Xlane1_Xr0_clkb t_Xlane1_Xr0_m1 vdd sky130_fd_pr__pfet_01v8 w=1.6 l=0.15
X347 t_Xlane1_Xr0_m2 t_Xlane1_Xr0_clki t_Xlane1_Xr0_s1 vss sky130_fd_pr__nfet_01v8_lvt w=0.8 l=0.15
X348 t_Xlane1_Xr0_m2 t_Xlane1_Xr0_clkb t_Xlane1_Xr0_s1 vdd sky130_fd_pr__pfet_01v8 w=1.6 l=0.15
X349 t_Xlane1_Xr0_qi t_Xlane1_Xr0_s1 vss vss sky130_fd_pr__nfet_01v8_lvt w=0.96 l=0.15
X350 t_Xlane1_Xr0_qi t_Xlane1_Xr0_s1 vdd vdd sky130_fd_pr__pfet_01v8 w=1.92 l=0.15
X351 t_Xlane1_Xr0_s2 t_Xlane1_Xr0_qi t_Xlane1_Xr0_Xsfb_mid vss sky130_fd_pr__nfet_01v8_lvt w=1.2 l=0.15
X352 t_Xlane1_Xr0_Xsfb_mid rst_n vss vss sky130_fd_pr__nfet_01v8_lvt w=1.2 l=0.15
X353 t_Xlane1_Xr0_s2 t_Xlane1_Xr0_qi vdd vdd sky130_fd_pr__pfet_01v8 w=1.6 l=0.15
X354 t_Xlane1_Xr0_s2 rst_n vdd vdd sky130_fd_pr__pfet_01v8 w=1.6 l=0.15
X355 t_Xlane1_Xr0_s2 t_Xlane1_Xr0_clkb t_Xlane1_Xr0_s1 vss sky130_fd_pr__nfet_01v8_lvt w=0.8 l=0.15
X356 t_Xlane1_Xr0_s2 t_Xlane1_Xr0_clki t_Xlane1_Xr0_s1 vdd sky130_fd_pr__pfet_01v8 w=1.6 l=0.15
X357 t_Xlane1_r0 t_Xlane1_Xr0_s1 vss vss sky130_fd_pr__nfet_01v8_lvt w=1.2 l=0.15
X358 t_Xlane1_r0 t_Xlane1_Xr0_s1 vdd vdd sky130_fd_pr__pfet_01v8 w=2.4 l=0.15
X359 t_Xlane1_r0b t_Xlane1_Xr0_qi vss vss sky130_fd_pr__nfet_01v8_lvt w=1.2 l=0.15
X360 t_Xlane1_r0b t_Xlane1_Xr0_qi vdd vdd sky130_fd_pr__pfet_01v8 w=2.4 l=0.15
X361 t_Xlane1_Xr1_clkb t_clk250b vss vss sky130_fd_pr__nfet_01v8_lvt w=1.2 l=0.15
X362 t_Xlane1_Xr1_clkb t_clk250b vdd vdd sky130_fd_pr__pfet_01v8 w=2.4 l=0.15
X363 t_Xlane1_Xr1_clki t_Xlane1_Xr1_clkb vss vss sky130_fd_pr__nfet_01v8_lvt w=1.2 l=0.15
X364 t_Xlane1_Xr1_clki t_Xlane1_Xr1_clkb vdd vdd sky130_fd_pr__pfet_01v8 w=2.4 l=0.15
X365 din5 t_Xlane1_Xr1_clkb t_Xlane1_Xr1_m1 vss sky130_fd_pr__nfet_01v8_lvt w=0.8 l=0.15
X366 din5 t_Xlane1_Xr1_clki t_Xlane1_Xr1_m1 vdd sky130_fd_pr__pfet_01v8 w=1.6 l=0.15
X367 t_Xlane1_Xr1_m2 t_Xlane1_Xr1_m1 t_Xlane1_Xr1_Xm2_mid vss sky130_fd_pr__nfet_01v8_lvt w=1.2 l=0.15
X368 t_Xlane1_Xr1_Xm2_mid rst_n vss vss sky130_fd_pr__nfet_01v8_lvt w=1.2 l=0.15
X369 t_Xlane1_Xr1_m2 t_Xlane1_Xr1_m1 vdd vdd sky130_fd_pr__pfet_01v8 w=1.6 l=0.15
X370 t_Xlane1_Xr1_m2 rst_n vdd vdd sky130_fd_pr__pfet_01v8 w=1.6 l=0.15
X371 t_Xlane1_Xr1_m3 t_Xlane1_Xr1_m2 vss vss sky130_fd_pr__nfet_01v8_lvt w=0.8 l=0.15
X372 t_Xlane1_Xr1_m3 t_Xlane1_Xr1_m2 vdd vdd sky130_fd_pr__pfet_01v8 w=1.6 l=0.15
X373 t_Xlane1_Xr1_m3 t_Xlane1_Xr1_clki t_Xlane1_Xr1_m1 vss sky130_fd_pr__nfet_01v8_lvt w=0.8 l=0.15
X374 t_Xlane1_Xr1_m3 t_Xlane1_Xr1_clkb t_Xlane1_Xr1_m1 vdd sky130_fd_pr__pfet_01v8 w=1.6 l=0.15
X375 t_Xlane1_Xr1_m2 t_Xlane1_Xr1_clki t_Xlane1_Xr1_s1 vss sky130_fd_pr__nfet_01v8_lvt w=0.8 l=0.15
X376 t_Xlane1_Xr1_m2 t_Xlane1_Xr1_clkb t_Xlane1_Xr1_s1 vdd sky130_fd_pr__pfet_01v8 w=1.6 l=0.15
X377 t_Xlane1_Xr1_qi t_Xlane1_Xr1_s1 vss vss sky130_fd_pr__nfet_01v8_lvt w=0.96 l=0.15
X378 t_Xlane1_Xr1_qi t_Xlane1_Xr1_s1 vdd vdd sky130_fd_pr__pfet_01v8 w=1.92 l=0.15
X379 t_Xlane1_Xr1_s2 t_Xlane1_Xr1_qi t_Xlane1_Xr1_Xsfb_mid vss sky130_fd_pr__nfet_01v8_lvt w=1.2 l=0.15
X380 t_Xlane1_Xr1_Xsfb_mid rst_n vss vss sky130_fd_pr__nfet_01v8_lvt w=1.2 l=0.15
X381 t_Xlane1_Xr1_s2 t_Xlane1_Xr1_qi vdd vdd sky130_fd_pr__pfet_01v8 w=1.6 l=0.15
X382 t_Xlane1_Xr1_s2 rst_n vdd vdd sky130_fd_pr__pfet_01v8 w=1.6 l=0.15
X383 t_Xlane1_Xr1_s2 t_Xlane1_Xr1_clkb t_Xlane1_Xr1_s1 vss sky130_fd_pr__nfet_01v8_lvt w=0.8 l=0.15
X384 t_Xlane1_Xr1_s2 t_Xlane1_Xr1_clki t_Xlane1_Xr1_s1 vdd sky130_fd_pr__pfet_01v8 w=1.6 l=0.15
X385 t_Xlane1_r1 t_Xlane1_Xr1_s1 vss vss sky130_fd_pr__nfet_01v8_lvt w=1.2 l=0.15
X386 t_Xlane1_r1 t_Xlane1_Xr1_s1 vdd vdd sky130_fd_pr__pfet_01v8 w=2.4 l=0.15
X387 t_Xlane1_r1b t_Xlane1_Xr1_qi vss vss sky130_fd_pr__nfet_01v8_lvt w=1.2 l=0.15
X388 t_Xlane1_r1b t_Xlane1_Xr1_qi vdd vdd sky130_fd_pr__pfet_01v8 w=2.4 l=0.15
X389 t_Xlane1_Xr2_clkb t_clk250b vss vss sky130_fd_pr__nfet_01v8_lvt w=1.2 l=0.15
X390 t_Xlane1_Xr2_clkb t_clk250b vdd vdd sky130_fd_pr__pfet_01v8 w=2.4 l=0.15
X391 t_Xlane1_Xr2_clki t_Xlane1_Xr2_clkb vss vss sky130_fd_pr__nfet_01v8_lvt w=1.2 l=0.15
X392 t_Xlane1_Xr2_clki t_Xlane1_Xr2_clkb vdd vdd sky130_fd_pr__pfet_01v8 w=2.4 l=0.15
X393 din9 t_Xlane1_Xr2_clkb t_Xlane1_Xr2_m1 vss sky130_fd_pr__nfet_01v8_lvt w=0.8 l=0.15
X394 din9 t_Xlane1_Xr2_clki t_Xlane1_Xr2_m1 vdd sky130_fd_pr__pfet_01v8 w=1.6 l=0.15
X395 t_Xlane1_Xr2_m2 t_Xlane1_Xr2_m1 t_Xlane1_Xr2_Xm2_mid vss sky130_fd_pr__nfet_01v8_lvt w=1.2 l=0.15
X396 t_Xlane1_Xr2_Xm2_mid rst_n vss vss sky130_fd_pr__nfet_01v8_lvt w=1.2 l=0.15
X397 t_Xlane1_Xr2_m2 t_Xlane1_Xr2_m1 vdd vdd sky130_fd_pr__pfet_01v8 w=1.6 l=0.15
X398 t_Xlane1_Xr2_m2 rst_n vdd vdd sky130_fd_pr__pfet_01v8 w=1.6 l=0.15
X399 t_Xlane1_Xr2_m3 t_Xlane1_Xr2_m2 vss vss sky130_fd_pr__nfet_01v8_lvt w=0.8 l=0.15
X400 t_Xlane1_Xr2_m3 t_Xlane1_Xr2_m2 vdd vdd sky130_fd_pr__pfet_01v8 w=1.6 l=0.15
X401 t_Xlane1_Xr2_m3 t_Xlane1_Xr2_clki t_Xlane1_Xr2_m1 vss sky130_fd_pr__nfet_01v8_lvt w=0.8 l=0.15
X402 t_Xlane1_Xr2_m3 t_Xlane1_Xr2_clkb t_Xlane1_Xr2_m1 vdd sky130_fd_pr__pfet_01v8 w=1.6 l=0.15
X403 t_Xlane1_Xr2_m2 t_Xlane1_Xr2_clki t_Xlane1_Xr2_s1 vss sky130_fd_pr__nfet_01v8_lvt w=0.8 l=0.15
X404 t_Xlane1_Xr2_m2 t_Xlane1_Xr2_clkb t_Xlane1_Xr2_s1 vdd sky130_fd_pr__pfet_01v8 w=1.6 l=0.15
X405 t_Xlane1_Xr2_qi t_Xlane1_Xr2_s1 vss vss sky130_fd_pr__nfet_01v8_lvt w=0.96 l=0.15
X406 t_Xlane1_Xr2_qi t_Xlane1_Xr2_s1 vdd vdd sky130_fd_pr__pfet_01v8 w=1.92 l=0.15
X407 t_Xlane1_Xr2_s2 t_Xlane1_Xr2_qi t_Xlane1_Xr2_Xsfb_mid vss sky130_fd_pr__nfet_01v8_lvt w=1.2 l=0.15
X408 t_Xlane1_Xr2_Xsfb_mid rst_n vss vss sky130_fd_pr__nfet_01v8_lvt w=1.2 l=0.15
X409 t_Xlane1_Xr2_s2 t_Xlane1_Xr2_qi vdd vdd sky130_fd_pr__pfet_01v8 w=1.6 l=0.15
X410 t_Xlane1_Xr2_s2 rst_n vdd vdd sky130_fd_pr__pfet_01v8 w=1.6 l=0.15
X411 t_Xlane1_Xr2_s2 t_Xlane1_Xr2_clkb t_Xlane1_Xr2_s1 vss sky130_fd_pr__nfet_01v8_lvt w=0.8 l=0.15
X412 t_Xlane1_Xr2_s2 t_Xlane1_Xr2_clki t_Xlane1_Xr2_s1 vdd sky130_fd_pr__pfet_01v8 w=1.6 l=0.15
X413 t_Xlane1_r2 t_Xlane1_Xr2_s1 vss vss sky130_fd_pr__nfet_01v8_lvt w=1.2 l=0.15
X414 t_Xlane1_r2 t_Xlane1_Xr2_s1 vdd vdd sky130_fd_pr__pfet_01v8 w=2.4 l=0.15
X415 t_Xlane1_r2b t_Xlane1_Xr2_qi vss vss sky130_fd_pr__nfet_01v8_lvt w=1.2 l=0.15
X416 t_Xlane1_r2b t_Xlane1_Xr2_qi vdd vdd sky130_fd_pr__pfet_01v8 w=2.4 l=0.15
X417 t_Xlane1_Xr3_m_clkb t_clk250b vss vss sky130_fd_pr__nfet_01v8_lvt w=1.2 l=0.15
X418 t_Xlane1_Xr3_m_clkb t_clk250b vdd vdd sky130_fd_pr__pfet_01v8 w=2.4 l=0.15
X419 t_Xlane1_Xr3_m_clki t_Xlane1_Xr3_m_clkb vss vss sky130_fd_pr__nfet_01v8_lvt w=1.2 l=0.15
X420 t_Xlane1_Xr3_m_clki t_Xlane1_Xr3_m_clkb vdd vdd sky130_fd_pr__pfet_01v8 w=2.4 l=0.15
X421 din13 t_Xlane1_Xr3_m_clkb t_Xlane1_Xr3_m_m1 vss sky130_fd_pr__nfet_01v8_lvt w=0.8 l=0.15
X422 din13 t_Xlane1_Xr3_m_clki t_Xlane1_Xr3_m_m1 vdd sky130_fd_pr__pfet_01v8 w=1.6 l=0.15
X423 t_Xlane1_Xr3_m_m2 t_Xlane1_Xr3_m_m1 t_Xlane1_Xr3_m_Xm2_mid vss sky130_fd_pr__nfet_01v8_lvt w=1.2 l=0.15
X424 t_Xlane1_Xr3_m_Xm2_mid rst_n vss vss sky130_fd_pr__nfet_01v8_lvt w=1.2 l=0.15
X425 t_Xlane1_Xr3_m_m2 t_Xlane1_Xr3_m_m1 vdd vdd sky130_fd_pr__pfet_01v8 w=1.6 l=0.15
X426 t_Xlane1_Xr3_m_m2 rst_n vdd vdd sky130_fd_pr__pfet_01v8 w=1.6 l=0.15
X427 t_Xlane1_Xr3_m_m3 t_Xlane1_Xr3_m_m2 vss vss sky130_fd_pr__nfet_01v8_lvt w=0.8 l=0.15
X428 t_Xlane1_Xr3_m_m3 t_Xlane1_Xr3_m_m2 vdd vdd sky130_fd_pr__pfet_01v8 w=1.6 l=0.15
X429 t_Xlane1_Xr3_m_m3 t_Xlane1_Xr3_m_clki t_Xlane1_Xr3_m_m1 vss sky130_fd_pr__nfet_01v8_lvt w=0.8 l=0.15
X430 t_Xlane1_Xr3_m_m3 t_Xlane1_Xr3_m_clkb t_Xlane1_Xr3_m_m1 vdd sky130_fd_pr__pfet_01v8 w=1.6 l=0.15
X431 t_Xlane1_Xr3_m_m2 t_Xlane1_Xr3_m_clki t_Xlane1_Xr3_m_s1 vss sky130_fd_pr__nfet_01v8_lvt w=0.8 l=0.15
X432 t_Xlane1_Xr3_m_m2 t_Xlane1_Xr3_m_clkb t_Xlane1_Xr3_m_s1 vdd sky130_fd_pr__pfet_01v8 w=1.6 l=0.15
X433 t_Xlane1_Xr3_m_qi t_Xlane1_Xr3_m_s1 vss vss sky130_fd_pr__nfet_01v8_lvt w=0.96 l=0.15
X434 t_Xlane1_Xr3_m_qi t_Xlane1_Xr3_m_s1 vdd vdd sky130_fd_pr__pfet_01v8 w=1.92 l=0.15
X435 t_Xlane1_Xr3_m_s2 t_Xlane1_Xr3_m_qi t_Xlane1_Xr3_m_Xsfb_mid vss sky130_fd_pr__nfet_01v8_lvt w=1.2 l=0.15
X436 t_Xlane1_Xr3_m_Xsfb_mid rst_n vss vss sky130_fd_pr__nfet_01v8_lvt w=1.2 l=0.15
X437 t_Xlane1_Xr3_m_s2 t_Xlane1_Xr3_m_qi vdd vdd sky130_fd_pr__pfet_01v8 w=1.6 l=0.15
X438 t_Xlane1_Xr3_m_s2 rst_n vdd vdd sky130_fd_pr__pfet_01v8 w=1.6 l=0.15
X439 t_Xlane1_Xr3_m_s2 t_Xlane1_Xr3_m_clkb t_Xlane1_Xr3_m_s1 vss sky130_fd_pr__nfet_01v8_lvt w=0.8 l=0.15
X440 t_Xlane1_Xr3_m_s2 t_Xlane1_Xr3_m_clki t_Xlane1_Xr3_m_s1 vdd sky130_fd_pr__pfet_01v8 w=1.6 l=0.15
X441 t_Xlane1_r3_m t_Xlane1_Xr3_m_s1 vss vss sky130_fd_pr__nfet_01v8_lvt w=1.2 l=0.15
X442 t_Xlane1_r3_m t_Xlane1_Xr3_m_s1 vdd vdd sky130_fd_pr__pfet_01v8 w=2.4 l=0.15
X443 t_Xlane1_r3_mb t_Xlane1_Xr3_m_qi vss vss sky130_fd_pr__nfet_01v8_lvt w=1.2 l=0.15
X444 t_Xlane1_r3_mb t_Xlane1_Xr3_m_qi vdd vdd sky130_fd_pr__pfet_01v8 w=2.4 l=0.15
X445 t_Xlane1_Xr3_clkb t_clk250 vss vss sky130_fd_pr__nfet_01v8_lvt w=1.2 l=0.15
X446 t_Xlane1_Xr3_clkb t_clk250 vdd vdd sky130_fd_pr__pfet_01v8 w=2.4 l=0.15
X447 t_Xlane1_Xr3_clki t_Xlane1_Xr3_clkb vss vss sky130_fd_pr__nfet_01v8_lvt w=1.2 l=0.15
X448 t_Xlane1_Xr3_clki t_Xlane1_Xr3_clkb vdd vdd sky130_fd_pr__pfet_01v8 w=2.4 l=0.15
X449 t_Xlane1_r3_m t_Xlane1_Xr3_clkb t_Xlane1_Xr3_m1 vss sky130_fd_pr__nfet_01v8_lvt w=0.8 l=0.15
X450 t_Xlane1_r3_m t_Xlane1_Xr3_clki t_Xlane1_Xr3_m1 vdd sky130_fd_pr__pfet_01v8 w=1.6 l=0.15
X451 t_Xlane1_Xr3_m2 t_Xlane1_Xr3_m1 t_Xlane1_Xr3_Xm2_mid vss sky130_fd_pr__nfet_01v8_lvt w=1.2 l=0.15
X452 t_Xlane1_Xr3_Xm2_mid rst_n vss vss sky130_fd_pr__nfet_01v8_lvt w=1.2 l=0.15
X453 t_Xlane1_Xr3_m2 t_Xlane1_Xr3_m1 vdd vdd sky130_fd_pr__pfet_01v8 w=1.6 l=0.15
X454 t_Xlane1_Xr3_m2 rst_n vdd vdd sky130_fd_pr__pfet_01v8 w=1.6 l=0.15
X455 t_Xlane1_Xr3_m3 t_Xlane1_Xr3_m2 vss vss sky130_fd_pr__nfet_01v8_lvt w=0.8 l=0.15
X456 t_Xlane1_Xr3_m3 t_Xlane1_Xr3_m2 vdd vdd sky130_fd_pr__pfet_01v8 w=1.6 l=0.15
X457 t_Xlane1_Xr3_m3 t_Xlane1_Xr3_clki t_Xlane1_Xr3_m1 vss sky130_fd_pr__nfet_01v8_lvt w=0.8 l=0.15
X458 t_Xlane1_Xr3_m3 t_Xlane1_Xr3_clkb t_Xlane1_Xr3_m1 vdd sky130_fd_pr__pfet_01v8 w=1.6 l=0.15
X459 t_Xlane1_Xr3_m2 t_Xlane1_Xr3_clki t_Xlane1_Xr3_s1 vss sky130_fd_pr__nfet_01v8_lvt w=0.8 l=0.15
X460 t_Xlane1_Xr3_m2 t_Xlane1_Xr3_clkb t_Xlane1_Xr3_s1 vdd sky130_fd_pr__pfet_01v8 w=1.6 l=0.15
X461 t_Xlane1_Xr3_qi t_Xlane1_Xr3_s1 vss vss sky130_fd_pr__nfet_01v8_lvt w=0.96 l=0.15
X462 t_Xlane1_Xr3_qi t_Xlane1_Xr3_s1 vdd vdd sky130_fd_pr__pfet_01v8 w=1.92 l=0.15
X463 t_Xlane1_Xr3_s2 t_Xlane1_Xr3_qi t_Xlane1_Xr3_Xsfb_mid vss sky130_fd_pr__nfet_01v8_lvt w=1.2 l=0.15
X464 t_Xlane1_Xr3_Xsfb_mid rst_n vss vss sky130_fd_pr__nfet_01v8_lvt w=1.2 l=0.15
X465 t_Xlane1_Xr3_s2 t_Xlane1_Xr3_qi vdd vdd sky130_fd_pr__pfet_01v8 w=1.6 l=0.15
X466 t_Xlane1_Xr3_s2 rst_n vdd vdd sky130_fd_pr__pfet_01v8 w=1.6 l=0.15
X467 t_Xlane1_Xr3_s2 t_Xlane1_Xr3_clkb t_Xlane1_Xr3_s1 vss sky130_fd_pr__nfet_01v8_lvt w=0.8 l=0.15
X468 t_Xlane1_Xr3_s2 t_Xlane1_Xr3_clki t_Xlane1_Xr3_s1 vdd sky130_fd_pr__pfet_01v8 w=1.6 l=0.15
X469 t_Xlane1_r3 t_Xlane1_Xr3_s1 vss vss sky130_fd_pr__nfet_01v8_lvt w=1.2 l=0.15
X470 t_Xlane1_r3 t_Xlane1_Xr3_s1 vdd vdd sky130_fd_pr__pfet_01v8 w=2.4 l=0.15
X471 t_Xlane1_r3b t_Xlane1_Xr3_qi vss vss sky130_fd_pr__nfet_01v8_lvt w=1.2 l=0.15
X472 t_Xlane1_r3b t_Xlane1_Xr3_qi vdd vdd sky130_fd_pr__pfet_01v8 w=2.4 l=0.15
X473 t_Xlane1_r2 t_clk250 t_Xlane1_Xma_mid vss sky130_fd_pr__nfet_01v8_lvt w=0.9 l=0.15
X474 t_Xlane1_r2 t_clk250b t_Xlane1_Xma_mid vdd sky130_fd_pr__pfet_01v8 w=1.8 l=0.15
X475 t_Xlane1_r0 t_clk250b t_Xlane1_Xma_mid vss sky130_fd_pr__nfet_01v8_lvt w=0.9 l=0.15
X476 t_Xlane1_r0 t_clk250 t_Xlane1_Xma_mid vdd sky130_fd_pr__pfet_01v8 w=1.8 l=0.15
X477 t_Xlane1_Xma_yb t_Xlane1_Xma_mid vss vss sky130_fd_pr__nfet_01v8_lvt w=0.9 l=0.15
X478 t_Xlane1_Xma_yb t_Xlane1_Xma_mid vdd vdd sky130_fd_pr__pfet_01v8 w=1.8 l=0.15
X479 t_Xlane1_ma t_Xlane1_Xma_yb vss vss sky130_fd_pr__nfet_01v8_lvt w=0.9 l=0.15
X480 t_Xlane1_ma t_Xlane1_Xma_yb vdd vdd sky130_fd_pr__pfet_01v8 w=1.8 l=0.15
X481 t_Xlane1_r1 t_clk250 t_Xlane1_Xmb_mid vss sky130_fd_pr__nfet_01v8_lvt w=0.9 l=0.15
X482 t_Xlane1_r1 t_clk250b t_Xlane1_Xmb_mid vdd sky130_fd_pr__pfet_01v8 w=1.8 l=0.15
X483 t_Xlane1_r3 t_clk250b t_Xlane1_Xmb_mid vss sky130_fd_pr__nfet_01v8_lvt w=0.9 l=0.15
X484 t_Xlane1_r3 t_clk250 t_Xlane1_Xmb_mid vdd sky130_fd_pr__pfet_01v8 w=1.8 l=0.15
X485 t_Xlane1_Xmb_yb t_Xlane1_Xmb_mid vss vss sky130_fd_pr__nfet_01v8_lvt w=0.9 l=0.15
X486 t_Xlane1_Xmb_yb t_Xlane1_Xmb_mid vdd vdd sky130_fd_pr__pfet_01v8 w=1.8 l=0.15
X487 t_Xlane1_mb t_Xlane1_Xmb_yb vss vss sky130_fd_pr__nfet_01v8_lvt w=0.9 l=0.15
X488 t_Xlane1_mb t_Xlane1_Xmb_yb vdd vdd sky130_fd_pr__pfet_01v8 w=1.8 l=0.15
X489 t_Xlane1_Xda_clkb t_clk500 vss vss sky130_fd_pr__nfet_01v8_lvt w=1.2 l=0.15
X490 t_Xlane1_Xda_clkb t_clk500 vdd vdd sky130_fd_pr__pfet_01v8 w=2.4 l=0.15
X491 t_Xlane1_Xda_clki t_Xlane1_Xda_clkb vss vss sky130_fd_pr__nfet_01v8_lvt w=1.2 l=0.15
X492 t_Xlane1_Xda_clki t_Xlane1_Xda_clkb vdd vdd sky130_fd_pr__pfet_01v8 w=2.4 l=0.15
X493 t_Xlane1_ma t_Xlane1_Xda_clkb t_Xlane1_Xda_m1 vss sky130_fd_pr__nfet_01v8_lvt w=1.2 l=0.15
X494 t_Xlane1_ma t_Xlane1_Xda_clki t_Xlane1_Xda_m1 vdd sky130_fd_pr__pfet_01v8 w=2.4 l=0.15
X495 t_Xlane1_Xda_m2 t_Xlane1_Xda_m1 t_Xlane1_Xda_Xm2_mid vss sky130_fd_pr__nfet_01v8_lvt w=1.8 l=0.15
X496 t_Xlane1_Xda_Xm2_mid rst_n vss vss sky130_fd_pr__nfet_01v8_lvt w=1.8 l=0.15
X497 t_Xlane1_Xda_m2 t_Xlane1_Xda_m1 vdd vdd sky130_fd_pr__pfet_01v8 w=2.4 l=0.15
X498 t_Xlane1_Xda_m2 rst_n vdd vdd sky130_fd_pr__pfet_01v8 w=2.4 l=0.15
X499 t_Xlane1_Xda_m3 t_Xlane1_Xda_m2 vss vss sky130_fd_pr__nfet_01v8_lvt w=0.8 l=0.15
X500 t_Xlane1_Xda_m3 t_Xlane1_Xda_m2 vdd vdd sky130_fd_pr__pfet_01v8 w=1.6 l=0.15
X501 t_Xlane1_Xda_m3 t_Xlane1_Xda_clki t_Xlane1_Xda_m1 vss sky130_fd_pr__nfet_01v8_lvt w=0.8 l=0.15
X502 t_Xlane1_Xda_m3 t_Xlane1_Xda_clkb t_Xlane1_Xda_m1 vdd sky130_fd_pr__pfet_01v8 w=1.6 l=0.15
X503 t_Xlane1_Xda_m2 t_Xlane1_Xda_clki t_Xlane1_Xda_s1 vss sky130_fd_pr__nfet_01v8_lvt w=1.2 l=0.15
X504 t_Xlane1_Xda_m2 t_Xlane1_Xda_clkb t_Xlane1_Xda_s1 vdd sky130_fd_pr__pfet_01v8 w=2.4 l=0.15
X505 t_Xlane1_Xda_qi t_Xlane1_Xda_s1 vss vss sky130_fd_pr__nfet_01v8_lvt w=1.44 l=0.15
X506 t_Xlane1_Xda_qi t_Xlane1_Xda_s1 vdd vdd sky130_fd_pr__pfet_01v8 w=2.88 l=0.15
X507 t_Xlane1_Xda_s2 t_Xlane1_Xda_qi t_Xlane1_Xda_Xsfb_mid vss sky130_fd_pr__nfet_01v8_lvt w=1.2 l=0.15
X508 t_Xlane1_Xda_Xsfb_mid rst_n vss vss sky130_fd_pr__nfet_01v8_lvt w=1.2 l=0.15
X509 t_Xlane1_Xda_s2 t_Xlane1_Xda_qi vdd vdd sky130_fd_pr__pfet_01v8 w=1.6 l=0.15
X510 t_Xlane1_Xda_s2 rst_n vdd vdd sky130_fd_pr__pfet_01v8 w=1.6 l=0.15
X511 t_Xlane1_Xda_s2 t_Xlane1_Xda_clkb t_Xlane1_Xda_s1 vss sky130_fd_pr__nfet_01v8_lvt w=0.8 l=0.15
X512 t_Xlane1_Xda_s2 t_Xlane1_Xda_clki t_Xlane1_Xda_s1 vdd sky130_fd_pr__pfet_01v8 w=1.6 l=0.15
X513 t_Xlane1_da t_Xlane1_Xda_s1 vss vss sky130_fd_pr__nfet_01v8_lvt w=1.8 l=0.15
X514 t_Xlane1_da t_Xlane1_Xda_s1 vdd vdd sky130_fd_pr__pfet_01v8 w=3.6 l=0.15
X515 t_Xlane1_dab t_Xlane1_Xda_qi vss vss sky130_fd_pr__nfet_01v8_lvt w=1.8 l=0.15
X516 t_Xlane1_dab t_Xlane1_Xda_qi vdd vdd sky130_fd_pr__pfet_01v8 w=3.6 l=0.15
X517 t_Xlane1_Xdb_clkb t_clk500b vss vss sky130_fd_pr__nfet_01v8_lvt w=1.2 l=0.15
X518 t_Xlane1_Xdb_clkb t_clk500b vdd vdd sky130_fd_pr__pfet_01v8 w=2.4 l=0.15
X519 t_Xlane1_Xdb_clki t_Xlane1_Xdb_clkb vss vss sky130_fd_pr__nfet_01v8_lvt w=1.2 l=0.15
X520 t_Xlane1_Xdb_clki t_Xlane1_Xdb_clkb vdd vdd sky130_fd_pr__pfet_01v8 w=2.4 l=0.15
X521 t_Xlane1_mb t_Xlane1_Xdb_clkb t_Xlane1_Xdb_m1 vss sky130_fd_pr__nfet_01v8_lvt w=1.2 l=0.15
X522 t_Xlane1_mb t_Xlane1_Xdb_clki t_Xlane1_Xdb_m1 vdd sky130_fd_pr__pfet_01v8 w=2.4 l=0.15
X523 t_Xlane1_Xdb_m2 t_Xlane1_Xdb_m1 t_Xlane1_Xdb_Xm2_mid vss sky130_fd_pr__nfet_01v8_lvt w=1.8 l=0.15
X524 t_Xlane1_Xdb_Xm2_mid rst_n vss vss sky130_fd_pr__nfet_01v8_lvt w=1.8 l=0.15
X525 t_Xlane1_Xdb_m2 t_Xlane1_Xdb_m1 vdd vdd sky130_fd_pr__pfet_01v8 w=2.4 l=0.15
X526 t_Xlane1_Xdb_m2 rst_n vdd vdd sky130_fd_pr__pfet_01v8 w=2.4 l=0.15
X527 t_Xlane1_Xdb_m3 t_Xlane1_Xdb_m2 vss vss sky130_fd_pr__nfet_01v8_lvt w=0.8 l=0.15
X528 t_Xlane1_Xdb_m3 t_Xlane1_Xdb_m2 vdd vdd sky130_fd_pr__pfet_01v8 w=1.6 l=0.15
X529 t_Xlane1_Xdb_m3 t_Xlane1_Xdb_clki t_Xlane1_Xdb_m1 vss sky130_fd_pr__nfet_01v8_lvt w=0.8 l=0.15
X530 t_Xlane1_Xdb_m3 t_Xlane1_Xdb_clkb t_Xlane1_Xdb_m1 vdd sky130_fd_pr__pfet_01v8 w=1.6 l=0.15
X531 t_Xlane1_Xdb_m2 t_Xlane1_Xdb_clki t_Xlane1_Xdb_s1 vss sky130_fd_pr__nfet_01v8_lvt w=1.2 l=0.15
X532 t_Xlane1_Xdb_m2 t_Xlane1_Xdb_clkb t_Xlane1_Xdb_s1 vdd sky130_fd_pr__pfet_01v8 w=2.4 l=0.15
X533 t_Xlane1_Xdb_qi t_Xlane1_Xdb_s1 vss vss sky130_fd_pr__nfet_01v8_lvt w=1.44 l=0.15
X534 t_Xlane1_Xdb_qi t_Xlane1_Xdb_s1 vdd vdd sky130_fd_pr__pfet_01v8 w=2.88 l=0.15
X535 t_Xlane1_Xdb_s2 t_Xlane1_Xdb_qi t_Xlane1_Xdb_Xsfb_mid vss sky130_fd_pr__nfet_01v8_lvt w=1.2 l=0.15
X536 t_Xlane1_Xdb_Xsfb_mid rst_n vss vss sky130_fd_pr__nfet_01v8_lvt w=1.2 l=0.15
X537 t_Xlane1_Xdb_s2 t_Xlane1_Xdb_qi vdd vdd sky130_fd_pr__pfet_01v8 w=1.6 l=0.15
X538 t_Xlane1_Xdb_s2 rst_n vdd vdd sky130_fd_pr__pfet_01v8 w=1.6 l=0.15
X539 t_Xlane1_Xdb_s2 t_Xlane1_Xdb_clkb t_Xlane1_Xdb_s1 vss sky130_fd_pr__nfet_01v8_lvt w=0.8 l=0.15
X540 t_Xlane1_Xdb_s2 t_Xlane1_Xdb_clki t_Xlane1_Xdb_s1 vdd sky130_fd_pr__pfet_01v8 w=1.6 l=0.15
X541 t_Xlane1_db t_Xlane1_Xdb_s1 vss vss sky130_fd_pr__nfet_01v8_lvt w=1.8 l=0.15
X542 t_Xlane1_db t_Xlane1_Xdb_s1 vdd vdd sky130_fd_pr__pfet_01v8 w=3.6 l=0.15
X543 t_Xlane1_dbb t_Xlane1_Xdb_qi vss vss sky130_fd_pr__nfet_01v8_lvt w=1.8 l=0.15
X544 t_Xlane1_dbb t_Xlane1_Xdb_qi vdd vdd sky130_fd_pr__pfet_01v8 w=3.6 l=0.15
X545 t_Xlane1_da t_clk500b t_Xlane1_Xmc_mid vss sky130_fd_pr__nfet_01v8_lvt w=1.5 l=0.15
X546 t_Xlane1_da t_clk500 t_Xlane1_Xmc_mid vdd sky130_fd_pr__pfet_01v8 w=3 l=0.15
X547 t_Xlane1_db t_clk500 t_Xlane1_Xmc_mid vss sky130_fd_pr__nfet_01v8_lvt w=1.5 l=0.15
X548 t_Xlane1_db t_clk500b t_Xlane1_Xmc_mid vdd sky130_fd_pr__pfet_01v8 w=3 l=0.15
X549 t_Xlane1_Xmc_yb t_Xlane1_Xmc_mid vss vss sky130_fd_pr__nfet_01v8_lvt w=1.5 l=0.15
X550 t_Xlane1_Xmc_yb t_Xlane1_Xmc_mid vdd vdd sky130_fd_pr__pfet_01v8 w=3 l=0.15
X551 t_Xlane1_mc t_Xlane1_Xmc_yb vss vss sky130_fd_pr__nfet_01v8_lvt w=1.5 l=0.15
X552 t_Xlane1_mc t_Xlane1_Xmc_yb vdd vdd sky130_fd_pr__pfet_01v8 w=3 l=0.15
X553 t_Xlane1_Xd1g_clkb t_c0 vss vss sky130_fd_pr__nfet_01v8_lvt w=1.2 l=0.15
X554 t_Xlane1_Xd1g_clkb t_c0 vdd vdd sky130_fd_pr__pfet_01v8 w=2.4 l=0.15
X555 t_Xlane1_Xd1g_clki t_Xlane1_Xd1g_clkb vss vss sky130_fd_pr__nfet_01v8_lvt w=1.2 l=0.15
X556 t_Xlane1_Xd1g_clki t_Xlane1_Xd1g_clkb vdd vdd sky130_fd_pr__pfet_01v8 w=2.4 l=0.15
X557 t_Xlane1_mc t_Xlane1_Xd1g_clkb t_Xlane1_Xd1g_m1 vss sky130_fd_pr__nfet_01v8_lvt w=1.5 l=0.15
X558 t_Xlane1_mc t_Xlane1_Xd1g_clki t_Xlane1_Xd1g_m1 vdd sky130_fd_pr__pfet_01v8 w=3 l=0.15
X559 t_Xlane1_Xd1g_m2 t_Xlane1_Xd1g_m1 t_Xlane1_Xd1g_Xm2_mid vss sky130_fd_pr__nfet_01v8_lvt w=2.25 l=0.15
X560 t_Xlane1_Xd1g_Xm2_mid rst_n vss vss sky130_fd_pr__nfet_01v8_lvt w=2.25 l=0.15
X561 t_Xlane1_Xd1g_m2 t_Xlane1_Xd1g_m1 vdd vdd sky130_fd_pr__pfet_01v8 w=3 l=0.15
X562 t_Xlane1_Xd1g_m2 rst_n vdd vdd sky130_fd_pr__pfet_01v8 w=3 l=0.15
X563 t_Xlane1_Xd1g_m3 t_Xlane1_Xd1g_m2 vss vss sky130_fd_pr__nfet_01v8_lvt w=0.8 l=0.15
X564 t_Xlane1_Xd1g_m3 t_Xlane1_Xd1g_m2 vdd vdd sky130_fd_pr__pfet_01v8 w=1.6 l=0.15
X565 t_Xlane1_Xd1g_m3 t_Xlane1_Xd1g_clki t_Xlane1_Xd1g_m1 vss sky130_fd_pr__nfet_01v8_lvt w=0.8 l=0.15
X566 t_Xlane1_Xd1g_m3 t_Xlane1_Xd1g_clkb t_Xlane1_Xd1g_m1 vdd sky130_fd_pr__pfet_01v8 w=1.6 l=0.15
X567 t_Xlane1_Xd1g_m2 t_Xlane1_Xd1g_clki t_Xlane1_Xd1g_s1 vss sky130_fd_pr__nfet_01v8_lvt w=1.5 l=0.15
X568 t_Xlane1_Xd1g_m2 t_Xlane1_Xd1g_clkb t_Xlane1_Xd1g_s1 vdd sky130_fd_pr__pfet_01v8 w=3 l=0.15
X569 t_Xlane1_Xd1g_qi t_Xlane1_Xd1g_s1 vss vss sky130_fd_pr__nfet_01v8_lvt w=1.8 l=0.15
X570 t_Xlane1_Xd1g_qi t_Xlane1_Xd1g_s1 vdd vdd sky130_fd_pr__pfet_01v8 w=3.6 l=0.15
X571 t_Xlane1_Xd1g_s2 t_Xlane1_Xd1g_qi t_Xlane1_Xd1g_Xsfb_mid vss sky130_fd_pr__nfet_01v8_lvt w=1.2 l=0.15
X572 t_Xlane1_Xd1g_Xsfb_mid rst_n vss vss sky130_fd_pr__nfet_01v8_lvt w=1.2 l=0.15
X573 t_Xlane1_Xd1g_s2 t_Xlane1_Xd1g_qi vdd vdd sky130_fd_pr__pfet_01v8 w=1.6 l=0.15
X574 t_Xlane1_Xd1g_s2 rst_n vdd vdd sky130_fd_pr__pfet_01v8 w=1.6 l=0.15
X575 t_Xlane1_Xd1g_s2 t_Xlane1_Xd1g_clkb t_Xlane1_Xd1g_s1 vss sky130_fd_pr__nfet_01v8_lvt w=0.8 l=0.15
X576 t_Xlane1_Xd1g_s2 t_Xlane1_Xd1g_clki t_Xlane1_Xd1g_s1 vdd sky130_fd_pr__pfet_01v8 w=1.6 l=0.15
X577 t_l1 t_Xlane1_Xd1g_s1 vss vss sky130_fd_pr__nfet_01v8_lvt w=2.25 l=0.15
X578 t_l1 t_Xlane1_Xd1g_s1 vdd vdd sky130_fd_pr__pfet_01v8 w=4.5 l=0.15
X579 t_Xlane1_l_outb t_Xlane1_Xd1g_qi vss vss sky130_fd_pr__nfet_01v8_lvt w=2.25 l=0.15
X580 t_Xlane1_l_outb t_Xlane1_Xd1g_qi vdd vdd sky130_fd_pr__pfet_01v8 w=4.5 l=0.15
X581 t_Xlane2_Xr0_clkb t_clk250b vss vss sky130_fd_pr__nfet_01v8_lvt w=1.2 l=0.15
X582 t_Xlane2_Xr0_clkb t_clk250b vdd vdd sky130_fd_pr__pfet_01v8 w=2.4 l=0.15
X583 t_Xlane2_Xr0_clki t_Xlane2_Xr0_clkb vss vss sky130_fd_pr__nfet_01v8_lvt w=1.2 l=0.15
X584 t_Xlane2_Xr0_clki t_Xlane2_Xr0_clkb vdd vdd sky130_fd_pr__pfet_01v8 w=2.4 l=0.15
X585 din2 t_Xlane2_Xr0_clkb t_Xlane2_Xr0_m1 vss sky130_fd_pr__nfet_01v8_lvt w=0.8 l=0.15
X586 din2 t_Xlane2_Xr0_clki t_Xlane2_Xr0_m1 vdd sky130_fd_pr__pfet_01v8 w=1.6 l=0.15
X587 t_Xlane2_Xr0_m2 t_Xlane2_Xr0_m1 t_Xlane2_Xr0_Xm2_mid vss sky130_fd_pr__nfet_01v8_lvt w=1.2 l=0.15
X588 t_Xlane2_Xr0_Xm2_mid rst_n vss vss sky130_fd_pr__nfet_01v8_lvt w=1.2 l=0.15
X589 t_Xlane2_Xr0_m2 t_Xlane2_Xr0_m1 vdd vdd sky130_fd_pr__pfet_01v8 w=1.6 l=0.15
X590 t_Xlane2_Xr0_m2 rst_n vdd vdd sky130_fd_pr__pfet_01v8 w=1.6 l=0.15
X591 t_Xlane2_Xr0_m3 t_Xlane2_Xr0_m2 vss vss sky130_fd_pr__nfet_01v8_lvt w=0.8 l=0.15
X592 t_Xlane2_Xr0_m3 t_Xlane2_Xr0_m2 vdd vdd sky130_fd_pr__pfet_01v8 w=1.6 l=0.15
X593 t_Xlane2_Xr0_m3 t_Xlane2_Xr0_clki t_Xlane2_Xr0_m1 vss sky130_fd_pr__nfet_01v8_lvt w=0.8 l=0.15
X594 t_Xlane2_Xr0_m3 t_Xlane2_Xr0_clkb t_Xlane2_Xr0_m1 vdd sky130_fd_pr__pfet_01v8 w=1.6 l=0.15
X595 t_Xlane2_Xr0_m2 t_Xlane2_Xr0_clki t_Xlane2_Xr0_s1 vss sky130_fd_pr__nfet_01v8_lvt w=0.8 l=0.15
X596 t_Xlane2_Xr0_m2 t_Xlane2_Xr0_clkb t_Xlane2_Xr0_s1 vdd sky130_fd_pr__pfet_01v8 w=1.6 l=0.15
X597 t_Xlane2_Xr0_qi t_Xlane2_Xr0_s1 vss vss sky130_fd_pr__nfet_01v8_lvt w=0.96 l=0.15
X598 t_Xlane2_Xr0_qi t_Xlane2_Xr0_s1 vdd vdd sky130_fd_pr__pfet_01v8 w=1.92 l=0.15
X599 t_Xlane2_Xr0_s2 t_Xlane2_Xr0_qi t_Xlane2_Xr0_Xsfb_mid vss sky130_fd_pr__nfet_01v8_lvt w=1.2 l=0.15
X600 t_Xlane2_Xr0_Xsfb_mid rst_n vss vss sky130_fd_pr__nfet_01v8_lvt w=1.2 l=0.15
X601 t_Xlane2_Xr0_s2 t_Xlane2_Xr0_qi vdd vdd sky130_fd_pr__pfet_01v8 w=1.6 l=0.15
X602 t_Xlane2_Xr0_s2 rst_n vdd vdd sky130_fd_pr__pfet_01v8 w=1.6 l=0.15
X603 t_Xlane2_Xr0_s2 t_Xlane2_Xr0_clkb t_Xlane2_Xr0_s1 vss sky130_fd_pr__nfet_01v8_lvt w=0.8 l=0.15
X604 t_Xlane2_Xr0_s2 t_Xlane2_Xr0_clki t_Xlane2_Xr0_s1 vdd sky130_fd_pr__pfet_01v8 w=1.6 l=0.15
X605 t_Xlane2_r0 t_Xlane2_Xr0_s1 vss vss sky130_fd_pr__nfet_01v8_lvt w=1.2 l=0.15
X606 t_Xlane2_r0 t_Xlane2_Xr0_s1 vdd vdd sky130_fd_pr__pfet_01v8 w=2.4 l=0.15
X607 t_Xlane2_r0b t_Xlane2_Xr0_qi vss vss sky130_fd_pr__nfet_01v8_lvt w=1.2 l=0.15
X608 t_Xlane2_r0b t_Xlane2_Xr0_qi vdd vdd sky130_fd_pr__pfet_01v8 w=2.4 l=0.15
X609 t_Xlane2_Xr1_clkb t_clk250b vss vss sky130_fd_pr__nfet_01v8_lvt w=1.2 l=0.15
X610 t_Xlane2_Xr1_clkb t_clk250b vdd vdd sky130_fd_pr__pfet_01v8 w=2.4 l=0.15
X611 t_Xlane2_Xr1_clki t_Xlane2_Xr1_clkb vss vss sky130_fd_pr__nfet_01v8_lvt w=1.2 l=0.15
X612 t_Xlane2_Xr1_clki t_Xlane2_Xr1_clkb vdd vdd sky130_fd_pr__pfet_01v8 w=2.4 l=0.15
X613 din6 t_Xlane2_Xr1_clkb t_Xlane2_Xr1_m1 vss sky130_fd_pr__nfet_01v8_lvt w=0.8 l=0.15
X614 din6 t_Xlane2_Xr1_clki t_Xlane2_Xr1_m1 vdd sky130_fd_pr__pfet_01v8 w=1.6 l=0.15
X615 t_Xlane2_Xr1_m2 t_Xlane2_Xr1_m1 t_Xlane2_Xr1_Xm2_mid vss sky130_fd_pr__nfet_01v8_lvt w=1.2 l=0.15
X616 t_Xlane2_Xr1_Xm2_mid rst_n vss vss sky130_fd_pr__nfet_01v8_lvt w=1.2 l=0.15
X617 t_Xlane2_Xr1_m2 t_Xlane2_Xr1_m1 vdd vdd sky130_fd_pr__pfet_01v8 w=1.6 l=0.15
X618 t_Xlane2_Xr1_m2 rst_n vdd vdd sky130_fd_pr__pfet_01v8 w=1.6 l=0.15
X619 t_Xlane2_Xr1_m3 t_Xlane2_Xr1_m2 vss vss sky130_fd_pr__nfet_01v8_lvt w=0.8 l=0.15
X620 t_Xlane2_Xr1_m3 t_Xlane2_Xr1_m2 vdd vdd sky130_fd_pr__pfet_01v8 w=1.6 l=0.15
X621 t_Xlane2_Xr1_m3 t_Xlane2_Xr1_clki t_Xlane2_Xr1_m1 vss sky130_fd_pr__nfet_01v8_lvt w=0.8 l=0.15
X622 t_Xlane2_Xr1_m3 t_Xlane2_Xr1_clkb t_Xlane2_Xr1_m1 vdd sky130_fd_pr__pfet_01v8 w=1.6 l=0.15
X623 t_Xlane2_Xr1_m2 t_Xlane2_Xr1_clki t_Xlane2_Xr1_s1 vss sky130_fd_pr__nfet_01v8_lvt w=0.8 l=0.15
X624 t_Xlane2_Xr1_m2 t_Xlane2_Xr1_clkb t_Xlane2_Xr1_s1 vdd sky130_fd_pr__pfet_01v8 w=1.6 l=0.15
X625 t_Xlane2_Xr1_qi t_Xlane2_Xr1_s1 vss vss sky130_fd_pr__nfet_01v8_lvt w=0.96 l=0.15
X626 t_Xlane2_Xr1_qi t_Xlane2_Xr1_s1 vdd vdd sky130_fd_pr__pfet_01v8 w=1.92 l=0.15
X627 t_Xlane2_Xr1_s2 t_Xlane2_Xr1_qi t_Xlane2_Xr1_Xsfb_mid vss sky130_fd_pr__nfet_01v8_lvt w=1.2 l=0.15
X628 t_Xlane2_Xr1_Xsfb_mid rst_n vss vss sky130_fd_pr__nfet_01v8_lvt w=1.2 l=0.15
X629 t_Xlane2_Xr1_s2 t_Xlane2_Xr1_qi vdd vdd sky130_fd_pr__pfet_01v8 w=1.6 l=0.15
X630 t_Xlane2_Xr1_s2 rst_n vdd vdd sky130_fd_pr__pfet_01v8 w=1.6 l=0.15
X631 t_Xlane2_Xr1_s2 t_Xlane2_Xr1_clkb t_Xlane2_Xr1_s1 vss sky130_fd_pr__nfet_01v8_lvt w=0.8 l=0.15
X632 t_Xlane2_Xr1_s2 t_Xlane2_Xr1_clki t_Xlane2_Xr1_s1 vdd sky130_fd_pr__pfet_01v8 w=1.6 l=0.15
X633 t_Xlane2_r1 t_Xlane2_Xr1_s1 vss vss sky130_fd_pr__nfet_01v8_lvt w=1.2 l=0.15
X634 t_Xlane2_r1 t_Xlane2_Xr1_s1 vdd vdd sky130_fd_pr__pfet_01v8 w=2.4 l=0.15
X635 t_Xlane2_r1b t_Xlane2_Xr1_qi vss vss sky130_fd_pr__nfet_01v8_lvt w=1.2 l=0.15
X636 t_Xlane2_r1b t_Xlane2_Xr1_qi vdd vdd sky130_fd_pr__pfet_01v8 w=2.4 l=0.15
X637 t_Xlane2_Xr2_clkb t_clk250b vss vss sky130_fd_pr__nfet_01v8_lvt w=1.2 l=0.15
X638 t_Xlane2_Xr2_clkb t_clk250b vdd vdd sky130_fd_pr__pfet_01v8 w=2.4 l=0.15
X639 t_Xlane2_Xr2_clki t_Xlane2_Xr2_clkb vss vss sky130_fd_pr__nfet_01v8_lvt w=1.2 l=0.15
X640 t_Xlane2_Xr2_clki t_Xlane2_Xr2_clkb vdd vdd sky130_fd_pr__pfet_01v8 w=2.4 l=0.15
X641 din10 t_Xlane2_Xr2_clkb t_Xlane2_Xr2_m1 vss sky130_fd_pr__nfet_01v8_lvt w=0.8 l=0.15
X642 din10 t_Xlane2_Xr2_clki t_Xlane2_Xr2_m1 vdd sky130_fd_pr__pfet_01v8 w=1.6 l=0.15
X643 t_Xlane2_Xr2_m2 t_Xlane2_Xr2_m1 t_Xlane2_Xr2_Xm2_mid vss sky130_fd_pr__nfet_01v8_lvt w=1.2 l=0.15
X644 t_Xlane2_Xr2_Xm2_mid rst_n vss vss sky130_fd_pr__nfet_01v8_lvt w=1.2 l=0.15
X645 t_Xlane2_Xr2_m2 t_Xlane2_Xr2_m1 vdd vdd sky130_fd_pr__pfet_01v8 w=1.6 l=0.15
X646 t_Xlane2_Xr2_m2 rst_n vdd vdd sky130_fd_pr__pfet_01v8 w=1.6 l=0.15
X647 t_Xlane2_Xr2_m3 t_Xlane2_Xr2_m2 vss vss sky130_fd_pr__nfet_01v8_lvt w=0.8 l=0.15
X648 t_Xlane2_Xr2_m3 t_Xlane2_Xr2_m2 vdd vdd sky130_fd_pr__pfet_01v8 w=1.6 l=0.15
X649 t_Xlane2_Xr2_m3 t_Xlane2_Xr2_clki t_Xlane2_Xr2_m1 vss sky130_fd_pr__nfet_01v8_lvt w=0.8 l=0.15
X650 t_Xlane2_Xr2_m3 t_Xlane2_Xr2_clkb t_Xlane2_Xr2_m1 vdd sky130_fd_pr__pfet_01v8 w=1.6 l=0.15
X651 t_Xlane2_Xr2_m2 t_Xlane2_Xr2_clki t_Xlane2_Xr2_s1 vss sky130_fd_pr__nfet_01v8_lvt w=0.8 l=0.15
X652 t_Xlane2_Xr2_m2 t_Xlane2_Xr2_clkb t_Xlane2_Xr2_s1 vdd sky130_fd_pr__pfet_01v8 w=1.6 l=0.15
X653 t_Xlane2_Xr2_qi t_Xlane2_Xr2_s1 vss vss sky130_fd_pr__nfet_01v8_lvt w=0.96 l=0.15
X654 t_Xlane2_Xr2_qi t_Xlane2_Xr2_s1 vdd vdd sky130_fd_pr__pfet_01v8 w=1.92 l=0.15
X655 t_Xlane2_Xr2_s2 t_Xlane2_Xr2_qi t_Xlane2_Xr2_Xsfb_mid vss sky130_fd_pr__nfet_01v8_lvt w=1.2 l=0.15
X656 t_Xlane2_Xr2_Xsfb_mid rst_n vss vss sky130_fd_pr__nfet_01v8_lvt w=1.2 l=0.15
X657 t_Xlane2_Xr2_s2 t_Xlane2_Xr2_qi vdd vdd sky130_fd_pr__pfet_01v8 w=1.6 l=0.15
X658 t_Xlane2_Xr2_s2 rst_n vdd vdd sky130_fd_pr__pfet_01v8 w=1.6 l=0.15
X659 t_Xlane2_Xr2_s2 t_Xlane2_Xr2_clkb t_Xlane2_Xr2_s1 vss sky130_fd_pr__nfet_01v8_lvt w=0.8 l=0.15
X660 t_Xlane2_Xr2_s2 t_Xlane2_Xr2_clki t_Xlane2_Xr2_s1 vdd sky130_fd_pr__pfet_01v8 w=1.6 l=0.15
X661 t_Xlane2_r2 t_Xlane2_Xr2_s1 vss vss sky130_fd_pr__nfet_01v8_lvt w=1.2 l=0.15
X662 t_Xlane2_r2 t_Xlane2_Xr2_s1 vdd vdd sky130_fd_pr__pfet_01v8 w=2.4 l=0.15
X663 t_Xlane2_r2b t_Xlane2_Xr2_qi vss vss sky130_fd_pr__nfet_01v8_lvt w=1.2 l=0.15
X664 t_Xlane2_r2b t_Xlane2_Xr2_qi vdd vdd sky130_fd_pr__pfet_01v8 w=2.4 l=0.15
X665 t_Xlane2_Xr3_m_clkb t_clk250b vss vss sky130_fd_pr__nfet_01v8_lvt w=1.2 l=0.15
X666 t_Xlane2_Xr3_m_clkb t_clk250b vdd vdd sky130_fd_pr__pfet_01v8 w=2.4 l=0.15
X667 t_Xlane2_Xr3_m_clki t_Xlane2_Xr3_m_clkb vss vss sky130_fd_pr__nfet_01v8_lvt w=1.2 l=0.15
X668 t_Xlane2_Xr3_m_clki t_Xlane2_Xr3_m_clkb vdd vdd sky130_fd_pr__pfet_01v8 w=2.4 l=0.15
X669 din14 t_Xlane2_Xr3_m_clkb t_Xlane2_Xr3_m_m1 vss sky130_fd_pr__nfet_01v8_lvt w=0.8 l=0.15
X670 din14 t_Xlane2_Xr3_m_clki t_Xlane2_Xr3_m_m1 vdd sky130_fd_pr__pfet_01v8 w=1.6 l=0.15
X671 t_Xlane2_Xr3_m_m2 t_Xlane2_Xr3_m_m1 t_Xlane2_Xr3_m_Xm2_mid vss sky130_fd_pr__nfet_01v8_lvt w=1.2 l=0.15
X672 t_Xlane2_Xr3_m_Xm2_mid rst_n vss vss sky130_fd_pr__nfet_01v8_lvt w=1.2 l=0.15
X673 t_Xlane2_Xr3_m_m2 t_Xlane2_Xr3_m_m1 vdd vdd sky130_fd_pr__pfet_01v8 w=1.6 l=0.15
X674 t_Xlane2_Xr3_m_m2 rst_n vdd vdd sky130_fd_pr__pfet_01v8 w=1.6 l=0.15
X675 t_Xlane2_Xr3_m_m3 t_Xlane2_Xr3_m_m2 vss vss sky130_fd_pr__nfet_01v8_lvt w=0.8 l=0.15
X676 t_Xlane2_Xr3_m_m3 t_Xlane2_Xr3_m_m2 vdd vdd sky130_fd_pr__pfet_01v8 w=1.6 l=0.15
X677 t_Xlane2_Xr3_m_m3 t_Xlane2_Xr3_m_clki t_Xlane2_Xr3_m_m1 vss sky130_fd_pr__nfet_01v8_lvt w=0.8 l=0.15
X678 t_Xlane2_Xr3_m_m3 t_Xlane2_Xr3_m_clkb t_Xlane2_Xr3_m_m1 vdd sky130_fd_pr__pfet_01v8 w=1.6 l=0.15
X679 t_Xlane2_Xr3_m_m2 t_Xlane2_Xr3_m_clki t_Xlane2_Xr3_m_s1 vss sky130_fd_pr__nfet_01v8_lvt w=0.8 l=0.15
X680 t_Xlane2_Xr3_m_m2 t_Xlane2_Xr3_m_clkb t_Xlane2_Xr3_m_s1 vdd sky130_fd_pr__pfet_01v8 w=1.6 l=0.15
X681 t_Xlane2_Xr3_m_qi t_Xlane2_Xr3_m_s1 vss vss sky130_fd_pr__nfet_01v8_lvt w=0.96 l=0.15
X682 t_Xlane2_Xr3_m_qi t_Xlane2_Xr3_m_s1 vdd vdd sky130_fd_pr__pfet_01v8 w=1.92 l=0.15
X683 t_Xlane2_Xr3_m_s2 t_Xlane2_Xr3_m_qi t_Xlane2_Xr3_m_Xsfb_mid vss sky130_fd_pr__nfet_01v8_lvt w=1.2 l=0.15
X684 t_Xlane2_Xr3_m_Xsfb_mid rst_n vss vss sky130_fd_pr__nfet_01v8_lvt w=1.2 l=0.15
X685 t_Xlane2_Xr3_m_s2 t_Xlane2_Xr3_m_qi vdd vdd sky130_fd_pr__pfet_01v8 w=1.6 l=0.15
X686 t_Xlane2_Xr3_m_s2 rst_n vdd vdd sky130_fd_pr__pfet_01v8 w=1.6 l=0.15
X687 t_Xlane2_Xr3_m_s2 t_Xlane2_Xr3_m_clkb t_Xlane2_Xr3_m_s1 vss sky130_fd_pr__nfet_01v8_lvt w=0.8 l=0.15
X688 t_Xlane2_Xr3_m_s2 t_Xlane2_Xr3_m_clki t_Xlane2_Xr3_m_s1 vdd sky130_fd_pr__pfet_01v8 w=1.6 l=0.15
X689 t_Xlane2_r3_m t_Xlane2_Xr3_m_s1 vss vss sky130_fd_pr__nfet_01v8_lvt w=1.2 l=0.15
X690 t_Xlane2_r3_m t_Xlane2_Xr3_m_s1 vdd vdd sky130_fd_pr__pfet_01v8 w=2.4 l=0.15
X691 t_Xlane2_r3_mb t_Xlane2_Xr3_m_qi vss vss sky130_fd_pr__nfet_01v8_lvt w=1.2 l=0.15
X692 t_Xlane2_r3_mb t_Xlane2_Xr3_m_qi vdd vdd sky130_fd_pr__pfet_01v8 w=2.4 l=0.15
X693 t_Xlane2_Xr3_clkb t_clk250 vss vss sky130_fd_pr__nfet_01v8_lvt w=1.2 l=0.15
X694 t_Xlane2_Xr3_clkb t_clk250 vdd vdd sky130_fd_pr__pfet_01v8 w=2.4 l=0.15
X695 t_Xlane2_Xr3_clki t_Xlane2_Xr3_clkb vss vss sky130_fd_pr__nfet_01v8_lvt w=1.2 l=0.15
X696 t_Xlane2_Xr3_clki t_Xlane2_Xr3_clkb vdd vdd sky130_fd_pr__pfet_01v8 w=2.4 l=0.15
X697 t_Xlane2_r3_m t_Xlane2_Xr3_clkb t_Xlane2_Xr3_m1 vss sky130_fd_pr__nfet_01v8_lvt w=0.8 l=0.15
X698 t_Xlane2_r3_m t_Xlane2_Xr3_clki t_Xlane2_Xr3_m1 vdd sky130_fd_pr__pfet_01v8 w=1.6 l=0.15
X699 t_Xlane2_Xr3_m2 t_Xlane2_Xr3_m1 t_Xlane2_Xr3_Xm2_mid vss sky130_fd_pr__nfet_01v8_lvt w=1.2 l=0.15
X700 t_Xlane2_Xr3_Xm2_mid rst_n vss vss sky130_fd_pr__nfet_01v8_lvt w=1.2 l=0.15
X701 t_Xlane2_Xr3_m2 t_Xlane2_Xr3_m1 vdd vdd sky130_fd_pr__pfet_01v8 w=1.6 l=0.15
X702 t_Xlane2_Xr3_m2 rst_n vdd vdd sky130_fd_pr__pfet_01v8 w=1.6 l=0.15
X703 t_Xlane2_Xr3_m3 t_Xlane2_Xr3_m2 vss vss sky130_fd_pr__nfet_01v8_lvt w=0.8 l=0.15
X704 t_Xlane2_Xr3_m3 t_Xlane2_Xr3_m2 vdd vdd sky130_fd_pr__pfet_01v8 w=1.6 l=0.15
X705 t_Xlane2_Xr3_m3 t_Xlane2_Xr3_clki t_Xlane2_Xr3_m1 vss sky130_fd_pr__nfet_01v8_lvt w=0.8 l=0.15
X706 t_Xlane2_Xr3_m3 t_Xlane2_Xr3_clkb t_Xlane2_Xr3_m1 vdd sky130_fd_pr__pfet_01v8 w=1.6 l=0.15
X707 t_Xlane2_Xr3_m2 t_Xlane2_Xr3_clki t_Xlane2_Xr3_s1 vss sky130_fd_pr__nfet_01v8_lvt w=0.8 l=0.15
X708 t_Xlane2_Xr3_m2 t_Xlane2_Xr3_clkb t_Xlane2_Xr3_s1 vdd sky130_fd_pr__pfet_01v8 w=1.6 l=0.15
X709 t_Xlane2_Xr3_qi t_Xlane2_Xr3_s1 vss vss sky130_fd_pr__nfet_01v8_lvt w=0.96 l=0.15
X710 t_Xlane2_Xr3_qi t_Xlane2_Xr3_s1 vdd vdd sky130_fd_pr__pfet_01v8 w=1.92 l=0.15
X711 t_Xlane2_Xr3_s2 t_Xlane2_Xr3_qi t_Xlane2_Xr3_Xsfb_mid vss sky130_fd_pr__nfet_01v8_lvt w=1.2 l=0.15
X712 t_Xlane2_Xr3_Xsfb_mid rst_n vss vss sky130_fd_pr__nfet_01v8_lvt w=1.2 l=0.15
X713 t_Xlane2_Xr3_s2 t_Xlane2_Xr3_qi vdd vdd sky130_fd_pr__pfet_01v8 w=1.6 l=0.15
X714 t_Xlane2_Xr3_s2 rst_n vdd vdd sky130_fd_pr__pfet_01v8 w=1.6 l=0.15
X715 t_Xlane2_Xr3_s2 t_Xlane2_Xr3_clkb t_Xlane2_Xr3_s1 vss sky130_fd_pr__nfet_01v8_lvt w=0.8 l=0.15
X716 t_Xlane2_Xr3_s2 t_Xlane2_Xr3_clki t_Xlane2_Xr3_s1 vdd sky130_fd_pr__pfet_01v8 w=1.6 l=0.15
X717 t_Xlane2_r3 t_Xlane2_Xr3_s1 vss vss sky130_fd_pr__nfet_01v8_lvt w=1.2 l=0.15
X718 t_Xlane2_r3 t_Xlane2_Xr3_s1 vdd vdd sky130_fd_pr__pfet_01v8 w=2.4 l=0.15
X719 t_Xlane2_r3b t_Xlane2_Xr3_qi vss vss sky130_fd_pr__nfet_01v8_lvt w=1.2 l=0.15
X720 t_Xlane2_r3b t_Xlane2_Xr3_qi vdd vdd sky130_fd_pr__pfet_01v8 w=2.4 l=0.15
X721 t_Xlane2_r2 t_clk250 t_Xlane2_Xma_mid vss sky130_fd_pr__nfet_01v8_lvt w=0.9 l=0.15
X722 t_Xlane2_r2 t_clk250b t_Xlane2_Xma_mid vdd sky130_fd_pr__pfet_01v8 w=1.8 l=0.15
X723 t_Xlane2_r0 t_clk250b t_Xlane2_Xma_mid vss sky130_fd_pr__nfet_01v8_lvt w=0.9 l=0.15
X724 t_Xlane2_r0 t_clk250 t_Xlane2_Xma_mid vdd sky130_fd_pr__pfet_01v8 w=1.8 l=0.15
X725 t_Xlane2_Xma_yb t_Xlane2_Xma_mid vss vss sky130_fd_pr__nfet_01v8_lvt w=0.9 l=0.15
X726 t_Xlane2_Xma_yb t_Xlane2_Xma_mid vdd vdd sky130_fd_pr__pfet_01v8 w=1.8 l=0.15
X727 t_Xlane2_ma t_Xlane2_Xma_yb vss vss sky130_fd_pr__nfet_01v8_lvt w=0.9 l=0.15
X728 t_Xlane2_ma t_Xlane2_Xma_yb vdd vdd sky130_fd_pr__pfet_01v8 w=1.8 l=0.15
X729 t_Xlane2_r1 t_clk250 t_Xlane2_Xmb_mid vss sky130_fd_pr__nfet_01v8_lvt w=0.9 l=0.15
X730 t_Xlane2_r1 t_clk250b t_Xlane2_Xmb_mid vdd sky130_fd_pr__pfet_01v8 w=1.8 l=0.15
X731 t_Xlane2_r3 t_clk250b t_Xlane2_Xmb_mid vss sky130_fd_pr__nfet_01v8_lvt w=0.9 l=0.15
X732 t_Xlane2_r3 t_clk250 t_Xlane2_Xmb_mid vdd sky130_fd_pr__pfet_01v8 w=1.8 l=0.15
X733 t_Xlane2_Xmb_yb t_Xlane2_Xmb_mid vss vss sky130_fd_pr__nfet_01v8_lvt w=0.9 l=0.15
X734 t_Xlane2_Xmb_yb t_Xlane2_Xmb_mid vdd vdd sky130_fd_pr__pfet_01v8 w=1.8 l=0.15
X735 t_Xlane2_mb t_Xlane2_Xmb_yb vss vss sky130_fd_pr__nfet_01v8_lvt w=0.9 l=0.15
X736 t_Xlane2_mb t_Xlane2_Xmb_yb vdd vdd sky130_fd_pr__pfet_01v8 w=1.8 l=0.15
X737 t_Xlane2_Xda_clkb t_clk500 vss vss sky130_fd_pr__nfet_01v8_lvt w=1.2 l=0.15
X738 t_Xlane2_Xda_clkb t_clk500 vdd vdd sky130_fd_pr__pfet_01v8 w=2.4 l=0.15
X739 t_Xlane2_Xda_clki t_Xlane2_Xda_clkb vss vss sky130_fd_pr__nfet_01v8_lvt w=1.2 l=0.15
X740 t_Xlane2_Xda_clki t_Xlane2_Xda_clkb vdd vdd sky130_fd_pr__pfet_01v8 w=2.4 l=0.15
X741 t_Xlane2_ma t_Xlane2_Xda_clkb t_Xlane2_Xda_m1 vss sky130_fd_pr__nfet_01v8_lvt w=1.2 l=0.15
X742 t_Xlane2_ma t_Xlane2_Xda_clki t_Xlane2_Xda_m1 vdd sky130_fd_pr__pfet_01v8 w=2.4 l=0.15
X743 t_Xlane2_Xda_m2 t_Xlane2_Xda_m1 t_Xlane2_Xda_Xm2_mid vss sky130_fd_pr__nfet_01v8_lvt w=1.8 l=0.15
X744 t_Xlane2_Xda_Xm2_mid rst_n vss vss sky130_fd_pr__nfet_01v8_lvt w=1.8 l=0.15
X745 t_Xlane2_Xda_m2 t_Xlane2_Xda_m1 vdd vdd sky130_fd_pr__pfet_01v8 w=2.4 l=0.15
X746 t_Xlane2_Xda_m2 rst_n vdd vdd sky130_fd_pr__pfet_01v8 w=2.4 l=0.15
X747 t_Xlane2_Xda_m3 t_Xlane2_Xda_m2 vss vss sky130_fd_pr__nfet_01v8_lvt w=0.8 l=0.15
X748 t_Xlane2_Xda_m3 t_Xlane2_Xda_m2 vdd vdd sky130_fd_pr__pfet_01v8 w=1.6 l=0.15
X749 t_Xlane2_Xda_m3 t_Xlane2_Xda_clki t_Xlane2_Xda_m1 vss sky130_fd_pr__nfet_01v8_lvt w=0.8 l=0.15
X750 t_Xlane2_Xda_m3 t_Xlane2_Xda_clkb t_Xlane2_Xda_m1 vdd sky130_fd_pr__pfet_01v8 w=1.6 l=0.15
X751 t_Xlane2_Xda_m2 t_Xlane2_Xda_clki t_Xlane2_Xda_s1 vss sky130_fd_pr__nfet_01v8_lvt w=1.2 l=0.15
X752 t_Xlane2_Xda_m2 t_Xlane2_Xda_clkb t_Xlane2_Xda_s1 vdd sky130_fd_pr__pfet_01v8 w=2.4 l=0.15
X753 t_Xlane2_Xda_qi t_Xlane2_Xda_s1 vss vss sky130_fd_pr__nfet_01v8_lvt w=1.44 l=0.15
X754 t_Xlane2_Xda_qi t_Xlane2_Xda_s1 vdd vdd sky130_fd_pr__pfet_01v8 w=2.88 l=0.15
X755 t_Xlane2_Xda_s2 t_Xlane2_Xda_qi t_Xlane2_Xda_Xsfb_mid vss sky130_fd_pr__nfet_01v8_lvt w=1.2 l=0.15
X756 t_Xlane2_Xda_Xsfb_mid rst_n vss vss sky130_fd_pr__nfet_01v8_lvt w=1.2 l=0.15
X757 t_Xlane2_Xda_s2 t_Xlane2_Xda_qi vdd vdd sky130_fd_pr__pfet_01v8 w=1.6 l=0.15
X758 t_Xlane2_Xda_s2 rst_n vdd vdd sky130_fd_pr__pfet_01v8 w=1.6 l=0.15
X759 t_Xlane2_Xda_s2 t_Xlane2_Xda_clkb t_Xlane2_Xda_s1 vss sky130_fd_pr__nfet_01v8_lvt w=0.8 l=0.15
X760 t_Xlane2_Xda_s2 t_Xlane2_Xda_clki t_Xlane2_Xda_s1 vdd sky130_fd_pr__pfet_01v8 w=1.6 l=0.15
X761 t_Xlane2_da t_Xlane2_Xda_s1 vss vss sky130_fd_pr__nfet_01v8_lvt w=1.8 l=0.15
X762 t_Xlane2_da t_Xlane2_Xda_s1 vdd vdd sky130_fd_pr__pfet_01v8 w=3.6 l=0.15
X763 t_Xlane2_dab t_Xlane2_Xda_qi vss vss sky130_fd_pr__nfet_01v8_lvt w=1.8 l=0.15
X764 t_Xlane2_dab t_Xlane2_Xda_qi vdd vdd sky130_fd_pr__pfet_01v8 w=3.6 l=0.15
X765 t_Xlane2_Xdb_clkb t_clk500b vss vss sky130_fd_pr__nfet_01v8_lvt w=1.2 l=0.15
X766 t_Xlane2_Xdb_clkb t_clk500b vdd vdd sky130_fd_pr__pfet_01v8 w=2.4 l=0.15
X767 t_Xlane2_Xdb_clki t_Xlane2_Xdb_clkb vss vss sky130_fd_pr__nfet_01v8_lvt w=1.2 l=0.15
X768 t_Xlane2_Xdb_clki t_Xlane2_Xdb_clkb vdd vdd sky130_fd_pr__pfet_01v8 w=2.4 l=0.15
X769 t_Xlane2_mb t_Xlane2_Xdb_clkb t_Xlane2_Xdb_m1 vss sky130_fd_pr__nfet_01v8_lvt w=1.2 l=0.15
X770 t_Xlane2_mb t_Xlane2_Xdb_clki t_Xlane2_Xdb_m1 vdd sky130_fd_pr__pfet_01v8 w=2.4 l=0.15
X771 t_Xlane2_Xdb_m2 t_Xlane2_Xdb_m1 t_Xlane2_Xdb_Xm2_mid vss sky130_fd_pr__nfet_01v8_lvt w=1.8 l=0.15
X772 t_Xlane2_Xdb_Xm2_mid rst_n vss vss sky130_fd_pr__nfet_01v8_lvt w=1.8 l=0.15
X773 t_Xlane2_Xdb_m2 t_Xlane2_Xdb_m1 vdd vdd sky130_fd_pr__pfet_01v8 w=2.4 l=0.15
X774 t_Xlane2_Xdb_m2 rst_n vdd vdd sky130_fd_pr__pfet_01v8 w=2.4 l=0.15
X775 t_Xlane2_Xdb_m3 t_Xlane2_Xdb_m2 vss vss sky130_fd_pr__nfet_01v8_lvt w=0.8 l=0.15
X776 t_Xlane2_Xdb_m3 t_Xlane2_Xdb_m2 vdd vdd sky130_fd_pr__pfet_01v8 w=1.6 l=0.15
X777 t_Xlane2_Xdb_m3 t_Xlane2_Xdb_clki t_Xlane2_Xdb_m1 vss sky130_fd_pr__nfet_01v8_lvt w=0.8 l=0.15
X778 t_Xlane2_Xdb_m3 t_Xlane2_Xdb_clkb t_Xlane2_Xdb_m1 vdd sky130_fd_pr__pfet_01v8 w=1.6 l=0.15
X779 t_Xlane2_Xdb_m2 t_Xlane2_Xdb_clki t_Xlane2_Xdb_s1 vss sky130_fd_pr__nfet_01v8_lvt w=1.2 l=0.15
X780 t_Xlane2_Xdb_m2 t_Xlane2_Xdb_clkb t_Xlane2_Xdb_s1 vdd sky130_fd_pr__pfet_01v8 w=2.4 l=0.15
X781 t_Xlane2_Xdb_qi t_Xlane2_Xdb_s1 vss vss sky130_fd_pr__nfet_01v8_lvt w=1.44 l=0.15
X782 t_Xlane2_Xdb_qi t_Xlane2_Xdb_s1 vdd vdd sky130_fd_pr__pfet_01v8 w=2.88 l=0.15
X783 t_Xlane2_Xdb_s2 t_Xlane2_Xdb_qi t_Xlane2_Xdb_Xsfb_mid vss sky130_fd_pr__nfet_01v8_lvt w=1.2 l=0.15
X784 t_Xlane2_Xdb_Xsfb_mid rst_n vss vss sky130_fd_pr__nfet_01v8_lvt w=1.2 l=0.15
X785 t_Xlane2_Xdb_s2 t_Xlane2_Xdb_qi vdd vdd sky130_fd_pr__pfet_01v8 w=1.6 l=0.15
X786 t_Xlane2_Xdb_s2 rst_n vdd vdd sky130_fd_pr__pfet_01v8 w=1.6 l=0.15
X787 t_Xlane2_Xdb_s2 t_Xlane2_Xdb_clkb t_Xlane2_Xdb_s1 vss sky130_fd_pr__nfet_01v8_lvt w=0.8 l=0.15
X788 t_Xlane2_Xdb_s2 t_Xlane2_Xdb_clki t_Xlane2_Xdb_s1 vdd sky130_fd_pr__pfet_01v8 w=1.6 l=0.15
X789 t_Xlane2_db t_Xlane2_Xdb_s1 vss vss sky130_fd_pr__nfet_01v8_lvt w=1.8 l=0.15
X790 t_Xlane2_db t_Xlane2_Xdb_s1 vdd vdd sky130_fd_pr__pfet_01v8 w=3.6 l=0.15
X791 t_Xlane2_dbb t_Xlane2_Xdb_qi vss vss sky130_fd_pr__nfet_01v8_lvt w=1.8 l=0.15
X792 t_Xlane2_dbb t_Xlane2_Xdb_qi vdd vdd sky130_fd_pr__pfet_01v8 w=3.6 l=0.15
X793 t_Xlane2_da t_clk500b t_Xlane2_Xmc_mid vss sky130_fd_pr__nfet_01v8_lvt w=1.5 l=0.15
X794 t_Xlane2_da t_clk500 t_Xlane2_Xmc_mid vdd sky130_fd_pr__pfet_01v8 w=3 l=0.15
X795 t_Xlane2_db t_clk500 t_Xlane2_Xmc_mid vss sky130_fd_pr__nfet_01v8_lvt w=1.5 l=0.15
X796 t_Xlane2_db t_clk500b t_Xlane2_Xmc_mid vdd sky130_fd_pr__pfet_01v8 w=3 l=0.15
X797 t_Xlane2_Xmc_yb t_Xlane2_Xmc_mid vss vss sky130_fd_pr__nfet_01v8_lvt w=1.5 l=0.15
X798 t_Xlane2_Xmc_yb t_Xlane2_Xmc_mid vdd vdd sky130_fd_pr__pfet_01v8 w=3 l=0.15
X799 t_Xlane2_mc t_Xlane2_Xmc_yb vss vss sky130_fd_pr__nfet_01v8_lvt w=1.5 l=0.15
X800 t_Xlane2_mc t_Xlane2_Xmc_yb vdd vdd sky130_fd_pr__pfet_01v8 w=3 l=0.15
X801 t_Xlane2_Xd1g_clkb t_c0 vss vss sky130_fd_pr__nfet_01v8_lvt w=1.2 l=0.15
X802 t_Xlane2_Xd1g_clkb t_c0 vdd vdd sky130_fd_pr__pfet_01v8 w=2.4 l=0.15
X803 t_Xlane2_Xd1g_clki t_Xlane2_Xd1g_clkb vss vss sky130_fd_pr__nfet_01v8_lvt w=1.2 l=0.15
X804 t_Xlane2_Xd1g_clki t_Xlane2_Xd1g_clkb vdd vdd sky130_fd_pr__pfet_01v8 w=2.4 l=0.15
X805 t_Xlane2_mc t_Xlane2_Xd1g_clkb t_Xlane2_Xd1g_m1 vss sky130_fd_pr__nfet_01v8_lvt w=1.5 l=0.15
X806 t_Xlane2_mc t_Xlane2_Xd1g_clki t_Xlane2_Xd1g_m1 vdd sky130_fd_pr__pfet_01v8 w=3 l=0.15
X807 t_Xlane2_Xd1g_m2 t_Xlane2_Xd1g_m1 t_Xlane2_Xd1g_Xm2_mid vss sky130_fd_pr__nfet_01v8_lvt w=2.25 l=0.15
X808 t_Xlane2_Xd1g_Xm2_mid rst_n vss vss sky130_fd_pr__nfet_01v8_lvt w=2.25 l=0.15
X809 t_Xlane2_Xd1g_m2 t_Xlane2_Xd1g_m1 vdd vdd sky130_fd_pr__pfet_01v8 w=3 l=0.15
X810 t_Xlane2_Xd1g_m2 rst_n vdd vdd sky130_fd_pr__pfet_01v8 w=3 l=0.15
X811 t_Xlane2_Xd1g_m3 t_Xlane2_Xd1g_m2 vss vss sky130_fd_pr__nfet_01v8_lvt w=0.8 l=0.15
X812 t_Xlane2_Xd1g_m3 t_Xlane2_Xd1g_m2 vdd vdd sky130_fd_pr__pfet_01v8 w=1.6 l=0.15
X813 t_Xlane2_Xd1g_m3 t_Xlane2_Xd1g_clki t_Xlane2_Xd1g_m1 vss sky130_fd_pr__nfet_01v8_lvt w=0.8 l=0.15
X814 t_Xlane2_Xd1g_m3 t_Xlane2_Xd1g_clkb t_Xlane2_Xd1g_m1 vdd sky130_fd_pr__pfet_01v8 w=1.6 l=0.15
X815 t_Xlane2_Xd1g_m2 t_Xlane2_Xd1g_clki t_Xlane2_Xd1g_s1 vss sky130_fd_pr__nfet_01v8_lvt w=1.5 l=0.15
X816 t_Xlane2_Xd1g_m2 t_Xlane2_Xd1g_clkb t_Xlane2_Xd1g_s1 vdd sky130_fd_pr__pfet_01v8 w=3 l=0.15
X817 t_Xlane2_Xd1g_qi t_Xlane2_Xd1g_s1 vss vss sky130_fd_pr__nfet_01v8_lvt w=1.8 l=0.15
X818 t_Xlane2_Xd1g_qi t_Xlane2_Xd1g_s1 vdd vdd sky130_fd_pr__pfet_01v8 w=3.6 l=0.15
X819 t_Xlane2_Xd1g_s2 t_Xlane2_Xd1g_qi t_Xlane2_Xd1g_Xsfb_mid vss sky130_fd_pr__nfet_01v8_lvt w=1.2 l=0.15
X820 t_Xlane2_Xd1g_Xsfb_mid rst_n vss vss sky130_fd_pr__nfet_01v8_lvt w=1.2 l=0.15
X821 t_Xlane2_Xd1g_s2 t_Xlane2_Xd1g_qi vdd vdd sky130_fd_pr__pfet_01v8 w=1.6 l=0.15
X822 t_Xlane2_Xd1g_s2 rst_n vdd vdd sky130_fd_pr__pfet_01v8 w=1.6 l=0.15
X823 t_Xlane2_Xd1g_s2 t_Xlane2_Xd1g_clkb t_Xlane2_Xd1g_s1 vss sky130_fd_pr__nfet_01v8_lvt w=0.8 l=0.15
X824 t_Xlane2_Xd1g_s2 t_Xlane2_Xd1g_clki t_Xlane2_Xd1g_s1 vdd sky130_fd_pr__pfet_01v8 w=1.6 l=0.15
X825 t_l2 t_Xlane2_Xd1g_s1 vss vss sky130_fd_pr__nfet_01v8_lvt w=2.25 l=0.15
X826 t_l2 t_Xlane2_Xd1g_s1 vdd vdd sky130_fd_pr__pfet_01v8 w=4.5 l=0.15
X827 t_Xlane2_l_outb t_Xlane2_Xd1g_qi vss vss sky130_fd_pr__nfet_01v8_lvt w=2.25 l=0.15
X828 t_Xlane2_l_outb t_Xlane2_Xd1g_qi vdd vdd sky130_fd_pr__pfet_01v8 w=4.5 l=0.15
X829 t_Xlane3_Xr0_clkb t_clk250b vss vss sky130_fd_pr__nfet_01v8_lvt w=1.2 l=0.15
X830 t_Xlane3_Xr0_clkb t_clk250b vdd vdd sky130_fd_pr__pfet_01v8 w=2.4 l=0.15
X831 t_Xlane3_Xr0_clki t_Xlane3_Xr0_clkb vss vss sky130_fd_pr__nfet_01v8_lvt w=1.2 l=0.15
X832 t_Xlane3_Xr0_clki t_Xlane3_Xr0_clkb vdd vdd sky130_fd_pr__pfet_01v8 w=2.4 l=0.15
X833 din3 t_Xlane3_Xr0_clkb t_Xlane3_Xr0_m1 vss sky130_fd_pr__nfet_01v8_lvt w=0.8 l=0.15
X834 din3 t_Xlane3_Xr0_clki t_Xlane3_Xr0_m1 vdd sky130_fd_pr__pfet_01v8 w=1.6 l=0.15
X835 t_Xlane3_Xr0_m2 t_Xlane3_Xr0_m1 t_Xlane3_Xr0_Xm2_mid vss sky130_fd_pr__nfet_01v8_lvt w=1.2 l=0.15
X836 t_Xlane3_Xr0_Xm2_mid rst_n vss vss sky130_fd_pr__nfet_01v8_lvt w=1.2 l=0.15
X837 t_Xlane3_Xr0_m2 t_Xlane3_Xr0_m1 vdd vdd sky130_fd_pr__pfet_01v8 w=1.6 l=0.15
X838 t_Xlane3_Xr0_m2 rst_n vdd vdd sky130_fd_pr__pfet_01v8 w=1.6 l=0.15
X839 t_Xlane3_Xr0_m3 t_Xlane3_Xr0_m2 vss vss sky130_fd_pr__nfet_01v8_lvt w=0.8 l=0.15
X840 t_Xlane3_Xr0_m3 t_Xlane3_Xr0_m2 vdd vdd sky130_fd_pr__pfet_01v8 w=1.6 l=0.15
X841 t_Xlane3_Xr0_m3 t_Xlane3_Xr0_clki t_Xlane3_Xr0_m1 vss sky130_fd_pr__nfet_01v8_lvt w=0.8 l=0.15
X842 t_Xlane3_Xr0_m3 t_Xlane3_Xr0_clkb t_Xlane3_Xr0_m1 vdd sky130_fd_pr__pfet_01v8 w=1.6 l=0.15
X843 t_Xlane3_Xr0_m2 t_Xlane3_Xr0_clki t_Xlane3_Xr0_s1 vss sky130_fd_pr__nfet_01v8_lvt w=0.8 l=0.15
X844 t_Xlane3_Xr0_m2 t_Xlane3_Xr0_clkb t_Xlane3_Xr0_s1 vdd sky130_fd_pr__pfet_01v8 w=1.6 l=0.15
X845 t_Xlane3_Xr0_qi t_Xlane3_Xr0_s1 vss vss sky130_fd_pr__nfet_01v8_lvt w=0.96 l=0.15
X846 t_Xlane3_Xr0_qi t_Xlane3_Xr0_s1 vdd vdd sky130_fd_pr__pfet_01v8 w=1.92 l=0.15
X847 t_Xlane3_Xr0_s2 t_Xlane3_Xr0_qi t_Xlane3_Xr0_Xsfb_mid vss sky130_fd_pr__nfet_01v8_lvt w=1.2 l=0.15
X848 t_Xlane3_Xr0_Xsfb_mid rst_n vss vss sky130_fd_pr__nfet_01v8_lvt w=1.2 l=0.15
X849 t_Xlane3_Xr0_s2 t_Xlane3_Xr0_qi vdd vdd sky130_fd_pr__pfet_01v8 w=1.6 l=0.15
X850 t_Xlane3_Xr0_s2 rst_n vdd vdd sky130_fd_pr__pfet_01v8 w=1.6 l=0.15
X851 t_Xlane3_Xr0_s2 t_Xlane3_Xr0_clkb t_Xlane3_Xr0_s1 vss sky130_fd_pr__nfet_01v8_lvt w=0.8 l=0.15
X852 t_Xlane3_Xr0_s2 t_Xlane3_Xr0_clki t_Xlane3_Xr0_s1 vdd sky130_fd_pr__pfet_01v8 w=1.6 l=0.15
X853 t_Xlane3_r0 t_Xlane3_Xr0_s1 vss vss sky130_fd_pr__nfet_01v8_lvt w=1.2 l=0.15
X854 t_Xlane3_r0 t_Xlane3_Xr0_s1 vdd vdd sky130_fd_pr__pfet_01v8 w=2.4 l=0.15
X855 t_Xlane3_r0b t_Xlane3_Xr0_qi vss vss sky130_fd_pr__nfet_01v8_lvt w=1.2 l=0.15
X856 t_Xlane3_r0b t_Xlane3_Xr0_qi vdd vdd sky130_fd_pr__pfet_01v8 w=2.4 l=0.15
X857 t_Xlane3_Xr1_clkb t_clk250b vss vss sky130_fd_pr__nfet_01v8_lvt w=1.2 l=0.15
X858 t_Xlane3_Xr1_clkb t_clk250b vdd vdd sky130_fd_pr__pfet_01v8 w=2.4 l=0.15
X859 t_Xlane3_Xr1_clki t_Xlane3_Xr1_clkb vss vss sky130_fd_pr__nfet_01v8_lvt w=1.2 l=0.15
X860 t_Xlane3_Xr1_clki t_Xlane3_Xr1_clkb vdd vdd sky130_fd_pr__pfet_01v8 w=2.4 l=0.15
X861 din7 t_Xlane3_Xr1_clkb t_Xlane3_Xr1_m1 vss sky130_fd_pr__nfet_01v8_lvt w=0.8 l=0.15
X862 din7 t_Xlane3_Xr1_clki t_Xlane3_Xr1_m1 vdd sky130_fd_pr__pfet_01v8 w=1.6 l=0.15
X863 t_Xlane3_Xr1_m2 t_Xlane3_Xr1_m1 t_Xlane3_Xr1_Xm2_mid vss sky130_fd_pr__nfet_01v8_lvt w=1.2 l=0.15
X864 t_Xlane3_Xr1_Xm2_mid rst_n vss vss sky130_fd_pr__nfet_01v8_lvt w=1.2 l=0.15
X865 t_Xlane3_Xr1_m2 t_Xlane3_Xr1_m1 vdd vdd sky130_fd_pr__pfet_01v8 w=1.6 l=0.15
X866 t_Xlane3_Xr1_m2 rst_n vdd vdd sky130_fd_pr__pfet_01v8 w=1.6 l=0.15
X867 t_Xlane3_Xr1_m3 t_Xlane3_Xr1_m2 vss vss sky130_fd_pr__nfet_01v8_lvt w=0.8 l=0.15
X868 t_Xlane3_Xr1_m3 t_Xlane3_Xr1_m2 vdd vdd sky130_fd_pr__pfet_01v8 w=1.6 l=0.15
X869 t_Xlane3_Xr1_m3 t_Xlane3_Xr1_clki t_Xlane3_Xr1_m1 vss sky130_fd_pr__nfet_01v8_lvt w=0.8 l=0.15
X870 t_Xlane3_Xr1_m3 t_Xlane3_Xr1_clkb t_Xlane3_Xr1_m1 vdd sky130_fd_pr__pfet_01v8 w=1.6 l=0.15
X871 t_Xlane3_Xr1_m2 t_Xlane3_Xr1_clki t_Xlane3_Xr1_s1 vss sky130_fd_pr__nfet_01v8_lvt w=0.8 l=0.15
X872 t_Xlane3_Xr1_m2 t_Xlane3_Xr1_clkb t_Xlane3_Xr1_s1 vdd sky130_fd_pr__pfet_01v8 w=1.6 l=0.15
X873 t_Xlane3_Xr1_qi t_Xlane3_Xr1_s1 vss vss sky130_fd_pr__nfet_01v8_lvt w=0.96 l=0.15
X874 t_Xlane3_Xr1_qi t_Xlane3_Xr1_s1 vdd vdd sky130_fd_pr__pfet_01v8 w=1.92 l=0.15
X875 t_Xlane3_Xr1_s2 t_Xlane3_Xr1_qi t_Xlane3_Xr1_Xsfb_mid vss sky130_fd_pr__nfet_01v8_lvt w=1.2 l=0.15
X876 t_Xlane3_Xr1_Xsfb_mid rst_n vss vss sky130_fd_pr__nfet_01v8_lvt w=1.2 l=0.15
X877 t_Xlane3_Xr1_s2 t_Xlane3_Xr1_qi vdd vdd sky130_fd_pr__pfet_01v8 w=1.6 l=0.15
X878 t_Xlane3_Xr1_s2 rst_n vdd vdd sky130_fd_pr__pfet_01v8 w=1.6 l=0.15
X879 t_Xlane3_Xr1_s2 t_Xlane3_Xr1_clkb t_Xlane3_Xr1_s1 vss sky130_fd_pr__nfet_01v8_lvt w=0.8 l=0.15
X880 t_Xlane3_Xr1_s2 t_Xlane3_Xr1_clki t_Xlane3_Xr1_s1 vdd sky130_fd_pr__pfet_01v8 w=1.6 l=0.15
X881 t_Xlane3_r1 t_Xlane3_Xr1_s1 vss vss sky130_fd_pr__nfet_01v8_lvt w=1.2 l=0.15
X882 t_Xlane3_r1 t_Xlane3_Xr1_s1 vdd vdd sky130_fd_pr__pfet_01v8 w=2.4 l=0.15
X883 t_Xlane3_r1b t_Xlane3_Xr1_qi vss vss sky130_fd_pr__nfet_01v8_lvt w=1.2 l=0.15
X884 t_Xlane3_r1b t_Xlane3_Xr1_qi vdd vdd sky130_fd_pr__pfet_01v8 w=2.4 l=0.15
X885 t_Xlane3_Xr2_clkb t_clk250b vss vss sky130_fd_pr__nfet_01v8_lvt w=1.2 l=0.15
X886 t_Xlane3_Xr2_clkb t_clk250b vdd vdd sky130_fd_pr__pfet_01v8 w=2.4 l=0.15
X887 t_Xlane3_Xr2_clki t_Xlane3_Xr2_clkb vss vss sky130_fd_pr__nfet_01v8_lvt w=1.2 l=0.15
X888 t_Xlane3_Xr2_clki t_Xlane3_Xr2_clkb vdd vdd sky130_fd_pr__pfet_01v8 w=2.4 l=0.15
X889 din11 t_Xlane3_Xr2_clkb t_Xlane3_Xr2_m1 vss sky130_fd_pr__nfet_01v8_lvt w=0.8 l=0.15
X890 din11 t_Xlane3_Xr2_clki t_Xlane3_Xr2_m1 vdd sky130_fd_pr__pfet_01v8 w=1.6 l=0.15
X891 t_Xlane3_Xr2_m2 t_Xlane3_Xr2_m1 t_Xlane3_Xr2_Xm2_mid vss sky130_fd_pr__nfet_01v8_lvt w=1.2 l=0.15
X892 t_Xlane3_Xr2_Xm2_mid rst_n vss vss sky130_fd_pr__nfet_01v8_lvt w=1.2 l=0.15
X893 t_Xlane3_Xr2_m2 t_Xlane3_Xr2_m1 vdd vdd sky130_fd_pr__pfet_01v8 w=1.6 l=0.15
X894 t_Xlane3_Xr2_m2 rst_n vdd vdd sky130_fd_pr__pfet_01v8 w=1.6 l=0.15
X895 t_Xlane3_Xr2_m3 t_Xlane3_Xr2_m2 vss vss sky130_fd_pr__nfet_01v8_lvt w=0.8 l=0.15
X896 t_Xlane3_Xr2_m3 t_Xlane3_Xr2_m2 vdd vdd sky130_fd_pr__pfet_01v8 w=1.6 l=0.15
X897 t_Xlane3_Xr2_m3 t_Xlane3_Xr2_clki t_Xlane3_Xr2_m1 vss sky130_fd_pr__nfet_01v8_lvt w=0.8 l=0.15
X898 t_Xlane3_Xr2_m3 t_Xlane3_Xr2_clkb t_Xlane3_Xr2_m1 vdd sky130_fd_pr__pfet_01v8 w=1.6 l=0.15
X899 t_Xlane3_Xr2_m2 t_Xlane3_Xr2_clki t_Xlane3_Xr2_s1 vss sky130_fd_pr__nfet_01v8_lvt w=0.8 l=0.15
X900 t_Xlane3_Xr2_m2 t_Xlane3_Xr2_clkb t_Xlane3_Xr2_s1 vdd sky130_fd_pr__pfet_01v8 w=1.6 l=0.15
X901 t_Xlane3_Xr2_qi t_Xlane3_Xr2_s1 vss vss sky130_fd_pr__nfet_01v8_lvt w=0.96 l=0.15
X902 t_Xlane3_Xr2_qi t_Xlane3_Xr2_s1 vdd vdd sky130_fd_pr__pfet_01v8 w=1.92 l=0.15
X903 t_Xlane3_Xr2_s2 t_Xlane3_Xr2_qi t_Xlane3_Xr2_Xsfb_mid vss sky130_fd_pr__nfet_01v8_lvt w=1.2 l=0.15
X904 t_Xlane3_Xr2_Xsfb_mid rst_n vss vss sky130_fd_pr__nfet_01v8_lvt w=1.2 l=0.15
X905 t_Xlane3_Xr2_s2 t_Xlane3_Xr2_qi vdd vdd sky130_fd_pr__pfet_01v8 w=1.6 l=0.15
X906 t_Xlane3_Xr2_s2 rst_n vdd vdd sky130_fd_pr__pfet_01v8 w=1.6 l=0.15
X907 t_Xlane3_Xr2_s2 t_Xlane3_Xr2_clkb t_Xlane3_Xr2_s1 vss sky130_fd_pr__nfet_01v8_lvt w=0.8 l=0.15
X908 t_Xlane3_Xr2_s2 t_Xlane3_Xr2_clki t_Xlane3_Xr2_s1 vdd sky130_fd_pr__pfet_01v8 w=1.6 l=0.15
X909 t_Xlane3_r2 t_Xlane3_Xr2_s1 vss vss sky130_fd_pr__nfet_01v8_lvt w=1.2 l=0.15
X910 t_Xlane3_r2 t_Xlane3_Xr2_s1 vdd vdd sky130_fd_pr__pfet_01v8 w=2.4 l=0.15
X911 t_Xlane3_r2b t_Xlane3_Xr2_qi vss vss sky130_fd_pr__nfet_01v8_lvt w=1.2 l=0.15
X912 t_Xlane3_r2b t_Xlane3_Xr2_qi vdd vdd sky130_fd_pr__pfet_01v8 w=2.4 l=0.15
X913 t_Xlane3_Xr3_m_clkb t_clk250b vss vss sky130_fd_pr__nfet_01v8_lvt w=1.2 l=0.15
X914 t_Xlane3_Xr3_m_clkb t_clk250b vdd vdd sky130_fd_pr__pfet_01v8 w=2.4 l=0.15
X915 t_Xlane3_Xr3_m_clki t_Xlane3_Xr3_m_clkb vss vss sky130_fd_pr__nfet_01v8_lvt w=1.2 l=0.15
X916 t_Xlane3_Xr3_m_clki t_Xlane3_Xr3_m_clkb vdd vdd sky130_fd_pr__pfet_01v8 w=2.4 l=0.15
X917 din15 t_Xlane3_Xr3_m_clkb t_Xlane3_Xr3_m_m1 vss sky130_fd_pr__nfet_01v8_lvt w=0.8 l=0.15
X918 din15 t_Xlane3_Xr3_m_clki t_Xlane3_Xr3_m_m1 vdd sky130_fd_pr__pfet_01v8 w=1.6 l=0.15
X919 t_Xlane3_Xr3_m_m2 t_Xlane3_Xr3_m_m1 t_Xlane3_Xr3_m_Xm2_mid vss sky130_fd_pr__nfet_01v8_lvt w=1.2 l=0.15
X920 t_Xlane3_Xr3_m_Xm2_mid rst_n vss vss sky130_fd_pr__nfet_01v8_lvt w=1.2 l=0.15
X921 t_Xlane3_Xr3_m_m2 t_Xlane3_Xr3_m_m1 vdd vdd sky130_fd_pr__pfet_01v8 w=1.6 l=0.15
X922 t_Xlane3_Xr3_m_m2 rst_n vdd vdd sky130_fd_pr__pfet_01v8 w=1.6 l=0.15
X923 t_Xlane3_Xr3_m_m3 t_Xlane3_Xr3_m_m2 vss vss sky130_fd_pr__nfet_01v8_lvt w=0.8 l=0.15
X924 t_Xlane3_Xr3_m_m3 t_Xlane3_Xr3_m_m2 vdd vdd sky130_fd_pr__pfet_01v8 w=1.6 l=0.15
X925 t_Xlane3_Xr3_m_m3 t_Xlane3_Xr3_m_clki t_Xlane3_Xr3_m_m1 vss sky130_fd_pr__nfet_01v8_lvt w=0.8 l=0.15
X926 t_Xlane3_Xr3_m_m3 t_Xlane3_Xr3_m_clkb t_Xlane3_Xr3_m_m1 vdd sky130_fd_pr__pfet_01v8 w=1.6 l=0.15
X927 t_Xlane3_Xr3_m_m2 t_Xlane3_Xr3_m_clki t_Xlane3_Xr3_m_s1 vss sky130_fd_pr__nfet_01v8_lvt w=0.8 l=0.15
X928 t_Xlane3_Xr3_m_m2 t_Xlane3_Xr3_m_clkb t_Xlane3_Xr3_m_s1 vdd sky130_fd_pr__pfet_01v8 w=1.6 l=0.15
X929 t_Xlane3_Xr3_m_qi t_Xlane3_Xr3_m_s1 vss vss sky130_fd_pr__nfet_01v8_lvt w=0.96 l=0.15
X930 t_Xlane3_Xr3_m_qi t_Xlane3_Xr3_m_s1 vdd vdd sky130_fd_pr__pfet_01v8 w=1.92 l=0.15
X931 t_Xlane3_Xr3_m_s2 t_Xlane3_Xr3_m_qi t_Xlane3_Xr3_m_Xsfb_mid vss sky130_fd_pr__nfet_01v8_lvt w=1.2 l=0.15
X932 t_Xlane3_Xr3_m_Xsfb_mid rst_n vss vss sky130_fd_pr__nfet_01v8_lvt w=1.2 l=0.15
X933 t_Xlane3_Xr3_m_s2 t_Xlane3_Xr3_m_qi vdd vdd sky130_fd_pr__pfet_01v8 w=1.6 l=0.15
X934 t_Xlane3_Xr3_m_s2 rst_n vdd vdd sky130_fd_pr__pfet_01v8 w=1.6 l=0.15
X935 t_Xlane3_Xr3_m_s2 t_Xlane3_Xr3_m_clkb t_Xlane3_Xr3_m_s1 vss sky130_fd_pr__nfet_01v8_lvt w=0.8 l=0.15
X936 t_Xlane3_Xr3_m_s2 t_Xlane3_Xr3_m_clki t_Xlane3_Xr3_m_s1 vdd sky130_fd_pr__pfet_01v8 w=1.6 l=0.15
X937 t_Xlane3_r3_m t_Xlane3_Xr3_m_s1 vss vss sky130_fd_pr__nfet_01v8_lvt w=1.2 l=0.15
X938 t_Xlane3_r3_m t_Xlane3_Xr3_m_s1 vdd vdd sky130_fd_pr__pfet_01v8 w=2.4 l=0.15
X939 t_Xlane3_r3_mb t_Xlane3_Xr3_m_qi vss vss sky130_fd_pr__nfet_01v8_lvt w=1.2 l=0.15
X940 t_Xlane3_r3_mb t_Xlane3_Xr3_m_qi vdd vdd sky130_fd_pr__pfet_01v8 w=2.4 l=0.15
X941 t_Xlane3_Xr3_clkb t_clk250 vss vss sky130_fd_pr__nfet_01v8_lvt w=1.2 l=0.15
X942 t_Xlane3_Xr3_clkb t_clk250 vdd vdd sky130_fd_pr__pfet_01v8 w=2.4 l=0.15
X943 t_Xlane3_Xr3_clki t_Xlane3_Xr3_clkb vss vss sky130_fd_pr__nfet_01v8_lvt w=1.2 l=0.15
X944 t_Xlane3_Xr3_clki t_Xlane3_Xr3_clkb vdd vdd sky130_fd_pr__pfet_01v8 w=2.4 l=0.15
X945 t_Xlane3_r3_m t_Xlane3_Xr3_clkb t_Xlane3_Xr3_m1 vss sky130_fd_pr__nfet_01v8_lvt w=0.8 l=0.15
X946 t_Xlane3_r3_m t_Xlane3_Xr3_clki t_Xlane3_Xr3_m1 vdd sky130_fd_pr__pfet_01v8 w=1.6 l=0.15
X947 t_Xlane3_Xr3_m2 t_Xlane3_Xr3_m1 t_Xlane3_Xr3_Xm2_mid vss sky130_fd_pr__nfet_01v8_lvt w=1.2 l=0.15
X948 t_Xlane3_Xr3_Xm2_mid rst_n vss vss sky130_fd_pr__nfet_01v8_lvt w=1.2 l=0.15
X949 t_Xlane3_Xr3_m2 t_Xlane3_Xr3_m1 vdd vdd sky130_fd_pr__pfet_01v8 w=1.6 l=0.15
X950 t_Xlane3_Xr3_m2 rst_n vdd vdd sky130_fd_pr__pfet_01v8 w=1.6 l=0.15
X951 t_Xlane3_Xr3_m3 t_Xlane3_Xr3_m2 vss vss sky130_fd_pr__nfet_01v8_lvt w=0.8 l=0.15
X952 t_Xlane3_Xr3_m3 t_Xlane3_Xr3_m2 vdd vdd sky130_fd_pr__pfet_01v8 w=1.6 l=0.15
X953 t_Xlane3_Xr3_m3 t_Xlane3_Xr3_clki t_Xlane3_Xr3_m1 vss sky130_fd_pr__nfet_01v8_lvt w=0.8 l=0.15
X954 t_Xlane3_Xr3_m3 t_Xlane3_Xr3_clkb t_Xlane3_Xr3_m1 vdd sky130_fd_pr__pfet_01v8 w=1.6 l=0.15
X955 t_Xlane3_Xr3_m2 t_Xlane3_Xr3_clki t_Xlane3_Xr3_s1 vss sky130_fd_pr__nfet_01v8_lvt w=0.8 l=0.15
X956 t_Xlane3_Xr3_m2 t_Xlane3_Xr3_clkb t_Xlane3_Xr3_s1 vdd sky130_fd_pr__pfet_01v8 w=1.6 l=0.15
X957 t_Xlane3_Xr3_qi t_Xlane3_Xr3_s1 vss vss sky130_fd_pr__nfet_01v8_lvt w=0.96 l=0.15
X958 t_Xlane3_Xr3_qi t_Xlane3_Xr3_s1 vdd vdd sky130_fd_pr__pfet_01v8 w=1.92 l=0.15
X959 t_Xlane3_Xr3_s2 t_Xlane3_Xr3_qi t_Xlane3_Xr3_Xsfb_mid vss sky130_fd_pr__nfet_01v8_lvt w=1.2 l=0.15
X960 t_Xlane3_Xr3_Xsfb_mid rst_n vss vss sky130_fd_pr__nfet_01v8_lvt w=1.2 l=0.15
X961 t_Xlane3_Xr3_s2 t_Xlane3_Xr3_qi vdd vdd sky130_fd_pr__pfet_01v8 w=1.6 l=0.15
X962 t_Xlane3_Xr3_s2 rst_n vdd vdd sky130_fd_pr__pfet_01v8 w=1.6 l=0.15
X963 t_Xlane3_Xr3_s2 t_Xlane3_Xr3_clkb t_Xlane3_Xr3_s1 vss sky130_fd_pr__nfet_01v8_lvt w=0.8 l=0.15
X964 t_Xlane3_Xr3_s2 t_Xlane3_Xr3_clki t_Xlane3_Xr3_s1 vdd sky130_fd_pr__pfet_01v8 w=1.6 l=0.15
X965 t_Xlane3_r3 t_Xlane3_Xr3_s1 vss vss sky130_fd_pr__nfet_01v8_lvt w=1.2 l=0.15
X966 t_Xlane3_r3 t_Xlane3_Xr3_s1 vdd vdd sky130_fd_pr__pfet_01v8 w=2.4 l=0.15
X967 t_Xlane3_r3b t_Xlane3_Xr3_qi vss vss sky130_fd_pr__nfet_01v8_lvt w=1.2 l=0.15
X968 t_Xlane3_r3b t_Xlane3_Xr3_qi vdd vdd sky130_fd_pr__pfet_01v8 w=2.4 l=0.15
X969 t_Xlane3_r2 t_clk250 t_Xlane3_Xma_mid vss sky130_fd_pr__nfet_01v8_lvt w=0.9 l=0.15
X970 t_Xlane3_r2 t_clk250b t_Xlane3_Xma_mid vdd sky130_fd_pr__pfet_01v8 w=1.8 l=0.15
X971 t_Xlane3_r0 t_clk250b t_Xlane3_Xma_mid vss sky130_fd_pr__nfet_01v8_lvt w=0.9 l=0.15
X972 t_Xlane3_r0 t_clk250 t_Xlane3_Xma_mid vdd sky130_fd_pr__pfet_01v8 w=1.8 l=0.15
X973 t_Xlane3_Xma_yb t_Xlane3_Xma_mid vss vss sky130_fd_pr__nfet_01v8_lvt w=0.9 l=0.15
X974 t_Xlane3_Xma_yb t_Xlane3_Xma_mid vdd vdd sky130_fd_pr__pfet_01v8 w=1.8 l=0.15
X975 t_Xlane3_ma t_Xlane3_Xma_yb vss vss sky130_fd_pr__nfet_01v8_lvt w=0.9 l=0.15
X976 t_Xlane3_ma t_Xlane3_Xma_yb vdd vdd sky130_fd_pr__pfet_01v8 w=1.8 l=0.15
X977 t_Xlane3_r1 t_clk250 t_Xlane3_Xmb_mid vss sky130_fd_pr__nfet_01v8_lvt w=0.9 l=0.15
X978 t_Xlane3_r1 t_clk250b t_Xlane3_Xmb_mid vdd sky130_fd_pr__pfet_01v8 w=1.8 l=0.15
X979 t_Xlane3_r3 t_clk250b t_Xlane3_Xmb_mid vss sky130_fd_pr__nfet_01v8_lvt w=0.9 l=0.15
X980 t_Xlane3_r3 t_clk250 t_Xlane3_Xmb_mid vdd sky130_fd_pr__pfet_01v8 w=1.8 l=0.15
X981 t_Xlane3_Xmb_yb t_Xlane3_Xmb_mid vss vss sky130_fd_pr__nfet_01v8_lvt w=0.9 l=0.15
X982 t_Xlane3_Xmb_yb t_Xlane3_Xmb_mid vdd vdd sky130_fd_pr__pfet_01v8 w=1.8 l=0.15
X983 t_Xlane3_mb t_Xlane3_Xmb_yb vss vss sky130_fd_pr__nfet_01v8_lvt w=0.9 l=0.15
X984 t_Xlane3_mb t_Xlane3_Xmb_yb vdd vdd sky130_fd_pr__pfet_01v8 w=1.8 l=0.15
X985 t_Xlane3_Xda_clkb t_clk500 vss vss sky130_fd_pr__nfet_01v8_lvt w=1.2 l=0.15
X986 t_Xlane3_Xda_clkb t_clk500 vdd vdd sky130_fd_pr__pfet_01v8 w=2.4 l=0.15
X987 t_Xlane3_Xda_clki t_Xlane3_Xda_clkb vss vss sky130_fd_pr__nfet_01v8_lvt w=1.2 l=0.15
X988 t_Xlane3_Xda_clki t_Xlane3_Xda_clkb vdd vdd sky130_fd_pr__pfet_01v8 w=2.4 l=0.15
X989 t_Xlane3_ma t_Xlane3_Xda_clkb t_Xlane3_Xda_m1 vss sky130_fd_pr__nfet_01v8_lvt w=1.2 l=0.15
X990 t_Xlane3_ma t_Xlane3_Xda_clki t_Xlane3_Xda_m1 vdd sky130_fd_pr__pfet_01v8 w=2.4 l=0.15
X991 t_Xlane3_Xda_m2 t_Xlane3_Xda_m1 t_Xlane3_Xda_Xm2_mid vss sky130_fd_pr__nfet_01v8_lvt w=1.8 l=0.15
X992 t_Xlane3_Xda_Xm2_mid rst_n vss vss sky130_fd_pr__nfet_01v8_lvt w=1.8 l=0.15
X993 t_Xlane3_Xda_m2 t_Xlane3_Xda_m1 vdd vdd sky130_fd_pr__pfet_01v8 w=2.4 l=0.15
X994 t_Xlane3_Xda_m2 rst_n vdd vdd sky130_fd_pr__pfet_01v8 w=2.4 l=0.15
X995 t_Xlane3_Xda_m3 t_Xlane3_Xda_m2 vss vss sky130_fd_pr__nfet_01v8_lvt w=0.8 l=0.15
X996 t_Xlane3_Xda_m3 t_Xlane3_Xda_m2 vdd vdd sky130_fd_pr__pfet_01v8 w=1.6 l=0.15
X997 t_Xlane3_Xda_m3 t_Xlane3_Xda_clki t_Xlane3_Xda_m1 vss sky130_fd_pr__nfet_01v8_lvt w=0.8 l=0.15
X998 t_Xlane3_Xda_m3 t_Xlane3_Xda_clkb t_Xlane3_Xda_m1 vdd sky130_fd_pr__pfet_01v8 w=1.6 l=0.15
X999 t_Xlane3_Xda_m2 t_Xlane3_Xda_clki t_Xlane3_Xda_s1 vss sky130_fd_pr__nfet_01v8_lvt w=1.2 l=0.15
X1000 t_Xlane3_Xda_m2 t_Xlane3_Xda_clkb t_Xlane3_Xda_s1 vdd sky130_fd_pr__pfet_01v8 w=2.4 l=0.15
X1001 t_Xlane3_Xda_qi t_Xlane3_Xda_s1 vss vss sky130_fd_pr__nfet_01v8_lvt w=1.44 l=0.15
X1002 t_Xlane3_Xda_qi t_Xlane3_Xda_s1 vdd vdd sky130_fd_pr__pfet_01v8 w=2.88 l=0.15
X1003 t_Xlane3_Xda_s2 t_Xlane3_Xda_qi t_Xlane3_Xda_Xsfb_mid vss sky130_fd_pr__nfet_01v8_lvt w=1.2 l=0.15
X1004 t_Xlane3_Xda_Xsfb_mid rst_n vss vss sky130_fd_pr__nfet_01v8_lvt w=1.2 l=0.15
X1005 t_Xlane3_Xda_s2 t_Xlane3_Xda_qi vdd vdd sky130_fd_pr__pfet_01v8 w=1.6 l=0.15
X1006 t_Xlane3_Xda_s2 rst_n vdd vdd sky130_fd_pr__pfet_01v8 w=1.6 l=0.15
X1007 t_Xlane3_Xda_s2 t_Xlane3_Xda_clkb t_Xlane3_Xda_s1 vss sky130_fd_pr__nfet_01v8_lvt w=0.8 l=0.15
X1008 t_Xlane3_Xda_s2 t_Xlane3_Xda_clki t_Xlane3_Xda_s1 vdd sky130_fd_pr__pfet_01v8 w=1.6 l=0.15
X1009 t_Xlane3_da t_Xlane3_Xda_s1 vss vss sky130_fd_pr__nfet_01v8_lvt w=1.8 l=0.15
X1010 t_Xlane3_da t_Xlane3_Xda_s1 vdd vdd sky130_fd_pr__pfet_01v8 w=3.6 l=0.15
X1011 t_Xlane3_dab t_Xlane3_Xda_qi vss vss sky130_fd_pr__nfet_01v8_lvt w=1.8 l=0.15
X1012 t_Xlane3_dab t_Xlane3_Xda_qi vdd vdd sky130_fd_pr__pfet_01v8 w=3.6 l=0.15
X1013 t_Xlane3_Xdb_clkb t_clk500b vss vss sky130_fd_pr__nfet_01v8_lvt w=1.2 l=0.15
X1014 t_Xlane3_Xdb_clkb t_clk500b vdd vdd sky130_fd_pr__pfet_01v8 w=2.4 l=0.15
X1015 t_Xlane3_Xdb_clki t_Xlane3_Xdb_clkb vss vss sky130_fd_pr__nfet_01v8_lvt w=1.2 l=0.15
X1016 t_Xlane3_Xdb_clki t_Xlane3_Xdb_clkb vdd vdd sky130_fd_pr__pfet_01v8 w=2.4 l=0.15
X1017 t_Xlane3_mb t_Xlane3_Xdb_clkb t_Xlane3_Xdb_m1 vss sky130_fd_pr__nfet_01v8_lvt w=1.2 l=0.15
X1018 t_Xlane3_mb t_Xlane3_Xdb_clki t_Xlane3_Xdb_m1 vdd sky130_fd_pr__pfet_01v8 w=2.4 l=0.15
X1019 t_Xlane3_Xdb_m2 t_Xlane3_Xdb_m1 t_Xlane3_Xdb_Xm2_mid vss sky130_fd_pr__nfet_01v8_lvt w=1.8 l=0.15
X1020 t_Xlane3_Xdb_Xm2_mid rst_n vss vss sky130_fd_pr__nfet_01v8_lvt w=1.8 l=0.15
X1021 t_Xlane3_Xdb_m2 t_Xlane3_Xdb_m1 vdd vdd sky130_fd_pr__pfet_01v8 w=2.4 l=0.15
X1022 t_Xlane3_Xdb_m2 rst_n vdd vdd sky130_fd_pr__pfet_01v8 w=2.4 l=0.15
X1023 t_Xlane3_Xdb_m3 t_Xlane3_Xdb_m2 vss vss sky130_fd_pr__nfet_01v8_lvt w=0.8 l=0.15
X1024 t_Xlane3_Xdb_m3 t_Xlane3_Xdb_m2 vdd vdd sky130_fd_pr__pfet_01v8 w=1.6 l=0.15
X1025 t_Xlane3_Xdb_m3 t_Xlane3_Xdb_clki t_Xlane3_Xdb_m1 vss sky130_fd_pr__nfet_01v8_lvt w=0.8 l=0.15
X1026 t_Xlane3_Xdb_m3 t_Xlane3_Xdb_clkb t_Xlane3_Xdb_m1 vdd sky130_fd_pr__pfet_01v8 w=1.6 l=0.15
X1027 t_Xlane3_Xdb_m2 t_Xlane3_Xdb_clki t_Xlane3_Xdb_s1 vss sky130_fd_pr__nfet_01v8_lvt w=1.2 l=0.15
X1028 t_Xlane3_Xdb_m2 t_Xlane3_Xdb_clkb t_Xlane3_Xdb_s1 vdd sky130_fd_pr__pfet_01v8 w=2.4 l=0.15
X1029 t_Xlane3_Xdb_qi t_Xlane3_Xdb_s1 vss vss sky130_fd_pr__nfet_01v8_lvt w=1.44 l=0.15
X1030 t_Xlane3_Xdb_qi t_Xlane3_Xdb_s1 vdd vdd sky130_fd_pr__pfet_01v8 w=2.88 l=0.15
X1031 t_Xlane3_Xdb_s2 t_Xlane3_Xdb_qi t_Xlane3_Xdb_Xsfb_mid vss sky130_fd_pr__nfet_01v8_lvt w=1.2 l=0.15
X1032 t_Xlane3_Xdb_Xsfb_mid rst_n vss vss sky130_fd_pr__nfet_01v8_lvt w=1.2 l=0.15
X1033 t_Xlane3_Xdb_s2 t_Xlane3_Xdb_qi vdd vdd sky130_fd_pr__pfet_01v8 w=1.6 l=0.15
X1034 t_Xlane3_Xdb_s2 rst_n vdd vdd sky130_fd_pr__pfet_01v8 w=1.6 l=0.15
X1035 t_Xlane3_Xdb_s2 t_Xlane3_Xdb_clkb t_Xlane3_Xdb_s1 vss sky130_fd_pr__nfet_01v8_lvt w=0.8 l=0.15
X1036 t_Xlane3_Xdb_s2 t_Xlane3_Xdb_clki t_Xlane3_Xdb_s1 vdd sky130_fd_pr__pfet_01v8 w=1.6 l=0.15
X1037 t_Xlane3_db t_Xlane3_Xdb_s1 vss vss sky130_fd_pr__nfet_01v8_lvt w=1.8 l=0.15
X1038 t_Xlane3_db t_Xlane3_Xdb_s1 vdd vdd sky130_fd_pr__pfet_01v8 w=3.6 l=0.15
X1039 t_Xlane3_dbb t_Xlane3_Xdb_qi vss vss sky130_fd_pr__nfet_01v8_lvt w=1.8 l=0.15
X1040 t_Xlane3_dbb t_Xlane3_Xdb_qi vdd vdd sky130_fd_pr__pfet_01v8 w=3.6 l=0.15
X1041 t_Xlane3_da t_clk500b t_Xlane3_Xmc_mid vss sky130_fd_pr__nfet_01v8_lvt w=1.5 l=0.15
X1042 t_Xlane3_da t_clk500 t_Xlane3_Xmc_mid vdd sky130_fd_pr__pfet_01v8 w=3 l=0.15
X1043 t_Xlane3_db t_clk500 t_Xlane3_Xmc_mid vss sky130_fd_pr__nfet_01v8_lvt w=1.5 l=0.15
X1044 t_Xlane3_db t_clk500b t_Xlane3_Xmc_mid vdd sky130_fd_pr__pfet_01v8 w=3 l=0.15
X1045 t_Xlane3_Xmc_yb t_Xlane3_Xmc_mid vss vss sky130_fd_pr__nfet_01v8_lvt w=1.5 l=0.15
X1046 t_Xlane3_Xmc_yb t_Xlane3_Xmc_mid vdd vdd sky130_fd_pr__pfet_01v8 w=3 l=0.15
X1047 t_Xlane3_mc t_Xlane3_Xmc_yb vss vss sky130_fd_pr__nfet_01v8_lvt w=1.5 l=0.15
X1048 t_Xlane3_mc t_Xlane3_Xmc_yb vdd vdd sky130_fd_pr__pfet_01v8 w=3 l=0.15
X1049 t_Xlane3_Xd1g_clkb t_c0 vss vss sky130_fd_pr__nfet_01v8_lvt w=1.2 l=0.15
X1050 t_Xlane3_Xd1g_clkb t_c0 vdd vdd sky130_fd_pr__pfet_01v8 w=2.4 l=0.15
X1051 t_Xlane3_Xd1g_clki t_Xlane3_Xd1g_clkb vss vss sky130_fd_pr__nfet_01v8_lvt w=1.2 l=0.15
X1052 t_Xlane3_Xd1g_clki t_Xlane3_Xd1g_clkb vdd vdd sky130_fd_pr__pfet_01v8 w=2.4 l=0.15
X1053 t_Xlane3_mc t_Xlane3_Xd1g_clkb t_Xlane3_Xd1g_m1 vss sky130_fd_pr__nfet_01v8_lvt w=1.5 l=0.15
X1054 t_Xlane3_mc t_Xlane3_Xd1g_clki t_Xlane3_Xd1g_m1 vdd sky130_fd_pr__pfet_01v8 w=3 l=0.15
X1055 t_Xlane3_Xd1g_m2 t_Xlane3_Xd1g_m1 t_Xlane3_Xd1g_Xm2_mid vss sky130_fd_pr__nfet_01v8_lvt w=2.25 l=0.15
X1056 t_Xlane3_Xd1g_Xm2_mid rst_n vss vss sky130_fd_pr__nfet_01v8_lvt w=2.25 l=0.15
X1057 t_Xlane3_Xd1g_m2 t_Xlane3_Xd1g_m1 vdd vdd sky130_fd_pr__pfet_01v8 w=3 l=0.15
X1058 t_Xlane3_Xd1g_m2 rst_n vdd vdd sky130_fd_pr__pfet_01v8 w=3 l=0.15
X1059 t_Xlane3_Xd1g_m3 t_Xlane3_Xd1g_m2 vss vss sky130_fd_pr__nfet_01v8_lvt w=0.8 l=0.15
X1060 t_Xlane3_Xd1g_m3 t_Xlane3_Xd1g_m2 vdd vdd sky130_fd_pr__pfet_01v8 w=1.6 l=0.15
X1061 t_Xlane3_Xd1g_m3 t_Xlane3_Xd1g_clki t_Xlane3_Xd1g_m1 vss sky130_fd_pr__nfet_01v8_lvt w=0.8 l=0.15
X1062 t_Xlane3_Xd1g_m3 t_Xlane3_Xd1g_clkb t_Xlane3_Xd1g_m1 vdd sky130_fd_pr__pfet_01v8 w=1.6 l=0.15
X1063 t_Xlane3_Xd1g_m2 t_Xlane3_Xd1g_clki t_Xlane3_Xd1g_s1 vss sky130_fd_pr__nfet_01v8_lvt w=1.5 l=0.15
X1064 t_Xlane3_Xd1g_m2 t_Xlane3_Xd1g_clkb t_Xlane3_Xd1g_s1 vdd sky130_fd_pr__pfet_01v8 w=3 l=0.15
X1065 t_Xlane3_Xd1g_qi t_Xlane3_Xd1g_s1 vss vss sky130_fd_pr__nfet_01v8_lvt w=1.8 l=0.15
X1066 t_Xlane3_Xd1g_qi t_Xlane3_Xd1g_s1 vdd vdd sky130_fd_pr__pfet_01v8 w=3.6 l=0.15
X1067 t_Xlane3_Xd1g_s2 t_Xlane3_Xd1g_qi t_Xlane3_Xd1g_Xsfb_mid vss sky130_fd_pr__nfet_01v8_lvt w=1.2 l=0.15
X1068 t_Xlane3_Xd1g_Xsfb_mid rst_n vss vss sky130_fd_pr__nfet_01v8_lvt w=1.2 l=0.15
X1069 t_Xlane3_Xd1g_s2 t_Xlane3_Xd1g_qi vdd vdd sky130_fd_pr__pfet_01v8 w=1.6 l=0.15
X1070 t_Xlane3_Xd1g_s2 rst_n vdd vdd sky130_fd_pr__pfet_01v8 w=1.6 l=0.15
X1071 t_Xlane3_Xd1g_s2 t_Xlane3_Xd1g_clkb t_Xlane3_Xd1g_s1 vss sky130_fd_pr__nfet_01v8_lvt w=0.8 l=0.15
X1072 t_Xlane3_Xd1g_s2 t_Xlane3_Xd1g_clki t_Xlane3_Xd1g_s1 vdd sky130_fd_pr__pfet_01v8 w=1.6 l=0.15
X1073 t_l3 t_Xlane3_Xd1g_s1 vss vss sky130_fd_pr__nfet_01v8_lvt w=2.25 l=0.15
X1074 t_l3 t_Xlane3_Xd1g_s1 vdd vdd sky130_fd_pr__pfet_01v8 w=4.5 l=0.15
X1075 t_Xlane3_l_outb t_Xlane3_Xd1g_qi vss vss sky130_fd_pr__nfet_01v8_lvt w=2.25 l=0.15
X1076 t_Xlane3_l_outb t_Xlane3_Xd1g_qi vdd vdd sky130_fd_pr__pfet_01v8 w=4.5 l=0.15
X1077 t_Xst0_clkb t_c180 vss vss sky130_fd_pr__nfet_01v8_lvt w=1.4 l=0.15
X1078 t_Xst0_clkb t_c180 vdd vdd sky130_fd_pr__pfet_01v8 w=3.4 l=0.15
X1079 t_Xst0_clki t_Xst0_clkb vss vss sky130_fd_pr__nfet_01v8_lvt w=1.4 l=0.15
X1080 t_Xst0_clki t_Xst0_clkb vdd vdd sky130_fd_pr__pfet_01v8 w=3.4 l=0.15
X1081 t_l0 t_Xst0_clkb t_Xst0_m1 vss sky130_fd_pr__nfet_01v8_lvt w=1.5 l=0.15
X1082 t_l0 t_Xst0_clki t_Xst0_m1 vdd sky130_fd_pr__pfet_01v8 w=2.8 l=0.15
X1083 t_Xst0_m2 t_Xst0_m1 t_Xst0_Xm2_mid vss sky130_fd_pr__nfet_01v8_lvt w=2.25 l=0.15
X1084 t_Xst0_Xm2_mid rst_n vss vss sky130_fd_pr__nfet_01v8_lvt w=2.25 l=0.15
X1085 t_Xst0_m2 t_Xst0_m1 vdd vdd sky130_fd_pr__pfet_01v8 w=2.8 l=0.15
X1086 t_Xst0_m2 rst_n vdd vdd sky130_fd_pr__pfet_01v8 w=2.8 l=0.15
X1087 t_Xst0_m3 t_Xst0_m2 vss vss sky130_fd_pr__nfet_01v8_lvt w=0.8 l=0.15
X1088 t_Xst0_m3 t_Xst0_m2 vdd vdd sky130_fd_pr__pfet_01v8 w=1.6 l=0.15
X1089 t_Xst0_m3 t_Xst0_clki t_Xst0_m1 vss sky130_fd_pr__nfet_01v8_lvt w=0.8 l=0.15
X1090 t_Xst0_m3 t_Xst0_clkb t_Xst0_m1 vdd sky130_fd_pr__pfet_01v8 w=1.6 l=0.15
X1091 t_Xst0_m2 t_Xst0_clki t_Xst0_s1 vss sky130_fd_pr__nfet_01v8_lvt w=1.5 l=0.15
X1092 t_Xst0_m2 t_Xst0_clkb t_Xst0_s1 vdd sky130_fd_pr__pfet_01v8 w=2.8 l=0.15
X1093 t_Xst0_qi t_Xst0_s1 vss vss sky130_fd_pr__nfet_01v8_lvt w=2.1 l=0.15
X1094 t_Xst0_qi t_Xst0_s1 vdd vdd sky130_fd_pr__pfet_01v8 w=5 l=0.15
X1095 t_Xst0_s2 t_Xst0_qi t_Xst0_Xsfb_mid vss sky130_fd_pr__nfet_01v8_lvt w=1.2 l=0.15
X1096 t_Xst0_Xsfb_mid rst_n vss vss sky130_fd_pr__nfet_01v8_lvt w=1.2 l=0.15
X1097 t_Xst0_s2 t_Xst0_qi vdd vdd sky130_fd_pr__pfet_01v8 w=1.6 l=0.15
X1098 t_Xst0_s2 rst_n vdd vdd sky130_fd_pr__pfet_01v8 w=1.6 l=0.15
X1099 t_Xst0_s2 t_Xst0_clkb t_Xst0_s1 vss sky130_fd_pr__nfet_01v8_lvt w=0.8 l=0.15
X1100 t_Xst0_s2 t_Xst0_clki t_Xst0_s1 vdd sky130_fd_pr__pfet_01v8 w=1.6 l=0.15
X1101 d0 t_Xst0_s1 vss vss sky130_fd_pr__nfet_01v8_lvt w=2.7 l=0.15
X1102 d0 t_Xst0_s1 vdd vdd sky130_fd_pr__pfet_01v8 w=7.5 l=0.15
X1103 db0 t_Xst0_qi vss vss sky130_fd_pr__nfet_01v8_lvt w=2.7 l=0.15
X1104 db0 t_Xst0_qi vdd vdd sky130_fd_pr__pfet_01v8 w=7.5 l=0.15
X1105 t_Xst1_clkb t_c270 vss vss sky130_fd_pr__nfet_01v8_lvt w=1.4 l=0.15
X1106 t_Xst1_clkb t_c270 vdd vdd sky130_fd_pr__pfet_01v8 w=3.4 l=0.15
X1107 t_Xst1_clki t_Xst1_clkb vss vss sky130_fd_pr__nfet_01v8_lvt w=1.4 l=0.15
X1108 t_Xst1_clki t_Xst1_clkb vdd vdd sky130_fd_pr__pfet_01v8 w=3.4 l=0.15
X1109 t_l1 t_Xst1_clkb t_Xst1_m1 vss sky130_fd_pr__nfet_01v8_lvt w=1.5 l=0.15
X1110 t_l1 t_Xst1_clki t_Xst1_m1 vdd sky130_fd_pr__pfet_01v8 w=2.8 l=0.15
X1111 t_Xst1_m2 t_Xst1_m1 t_Xst1_Xm2_mid vss sky130_fd_pr__nfet_01v8_lvt w=2.25 l=0.15
X1112 t_Xst1_Xm2_mid rst_n vss vss sky130_fd_pr__nfet_01v8_lvt w=2.25 l=0.15
X1113 t_Xst1_m2 t_Xst1_m1 vdd vdd sky130_fd_pr__pfet_01v8 w=2.8 l=0.15
X1114 t_Xst1_m2 rst_n vdd vdd sky130_fd_pr__pfet_01v8 w=2.8 l=0.15
X1115 t_Xst1_m3 t_Xst1_m2 vss vss sky130_fd_pr__nfet_01v8_lvt w=0.8 l=0.15
X1116 t_Xst1_m3 t_Xst1_m2 vdd vdd sky130_fd_pr__pfet_01v8 w=1.6 l=0.15
X1117 t_Xst1_m3 t_Xst1_clki t_Xst1_m1 vss sky130_fd_pr__nfet_01v8_lvt w=0.8 l=0.15
X1118 t_Xst1_m3 t_Xst1_clkb t_Xst1_m1 vdd sky130_fd_pr__pfet_01v8 w=1.6 l=0.15
X1119 t_Xst1_m2 t_Xst1_clki t_Xst1_s1 vss sky130_fd_pr__nfet_01v8_lvt w=1.5 l=0.15
X1120 t_Xst1_m2 t_Xst1_clkb t_Xst1_s1 vdd sky130_fd_pr__pfet_01v8 w=2.8 l=0.15
X1121 t_Xst1_qi t_Xst1_s1 vss vss sky130_fd_pr__nfet_01v8_lvt w=2.1 l=0.15
X1122 t_Xst1_qi t_Xst1_s1 vdd vdd sky130_fd_pr__pfet_01v8 w=5 l=0.15
X1123 t_Xst1_s2 t_Xst1_qi t_Xst1_Xsfb_mid vss sky130_fd_pr__nfet_01v8_lvt w=1.2 l=0.15
X1124 t_Xst1_Xsfb_mid rst_n vss vss sky130_fd_pr__nfet_01v8_lvt w=1.2 l=0.15
X1125 t_Xst1_s2 t_Xst1_qi vdd vdd sky130_fd_pr__pfet_01v8 w=1.6 l=0.15
X1126 t_Xst1_s2 rst_n vdd vdd sky130_fd_pr__pfet_01v8 w=1.6 l=0.15
X1127 t_Xst1_s2 t_Xst1_clkb t_Xst1_s1 vss sky130_fd_pr__nfet_01v8_lvt w=0.8 l=0.15
X1128 t_Xst1_s2 t_Xst1_clki t_Xst1_s1 vdd sky130_fd_pr__pfet_01v8 w=1.6 l=0.15
X1129 d1 t_Xst1_s1 vss vss sky130_fd_pr__nfet_01v8_lvt w=2.7 l=0.15
X1130 d1 t_Xst1_s1 vdd vdd sky130_fd_pr__pfet_01v8 w=7.5 l=0.15
X1131 db1 t_Xst1_qi vss vss sky130_fd_pr__nfet_01v8_lvt w=2.7 l=0.15
X1132 db1 t_Xst1_qi vdd vdd sky130_fd_pr__pfet_01v8 w=7.5 l=0.15
X1133 t_Xst2a_clkb t_c180 vss vss sky130_fd_pr__nfet_01v8_lvt w=1.2 l=0.15
X1134 t_Xst2a_clkb t_c180 vdd vdd sky130_fd_pr__pfet_01v8 w=2.4 l=0.15
X1135 t_Xst2a_clki t_Xst2a_clkb vss vss sky130_fd_pr__nfet_01v8_lvt w=1.2 l=0.15
X1136 t_Xst2a_clki t_Xst2a_clkb vdd vdd sky130_fd_pr__pfet_01v8 w=2.4 l=0.15
X1137 t_l2 t_Xst2a_clkb t_Xst2a_m1 vss sky130_fd_pr__nfet_01v8_lvt w=1.5 l=0.15
X1138 t_l2 t_Xst2a_clki t_Xst2a_m1 vdd sky130_fd_pr__pfet_01v8 w=3 l=0.15
X1139 t_Xst2a_m2 t_Xst2a_m1 t_Xst2a_Xm2_mid vss sky130_fd_pr__nfet_01v8_lvt w=2.25 l=0.15
X1140 t_Xst2a_Xm2_mid rst_n vss vss sky130_fd_pr__nfet_01v8_lvt w=2.25 l=0.15
X1141 t_Xst2a_m2 t_Xst2a_m1 vdd vdd sky130_fd_pr__pfet_01v8 w=3 l=0.15
X1142 t_Xst2a_m2 rst_n vdd vdd sky130_fd_pr__pfet_01v8 w=3 l=0.15
X1143 t_Xst2a_m3 t_Xst2a_m2 vss vss sky130_fd_pr__nfet_01v8_lvt w=0.8 l=0.15
X1144 t_Xst2a_m3 t_Xst2a_m2 vdd vdd sky130_fd_pr__pfet_01v8 w=1.6 l=0.15
X1145 t_Xst2a_m3 t_Xst2a_clki t_Xst2a_m1 vss sky130_fd_pr__nfet_01v8_lvt w=0.8 l=0.15
X1146 t_Xst2a_m3 t_Xst2a_clkb t_Xst2a_m1 vdd sky130_fd_pr__pfet_01v8 w=1.6 l=0.15
X1147 t_Xst2a_m2 t_Xst2a_clki t_Xst2a_s1 vss sky130_fd_pr__nfet_01v8_lvt w=1.5 l=0.15
X1148 t_Xst2a_m2 t_Xst2a_clkb t_Xst2a_s1 vdd sky130_fd_pr__pfet_01v8 w=3 l=0.15
X1149 t_Xst2a_qi t_Xst2a_s1 vss vss sky130_fd_pr__nfet_01v8_lvt w=1.8 l=0.15
X1150 t_Xst2a_qi t_Xst2a_s1 vdd vdd sky130_fd_pr__pfet_01v8 w=3.6 l=0.15
X1151 t_Xst2a_s2 t_Xst2a_qi t_Xst2a_Xsfb_mid vss sky130_fd_pr__nfet_01v8_lvt w=1.2 l=0.15
X1152 t_Xst2a_Xsfb_mid rst_n vss vss sky130_fd_pr__nfet_01v8_lvt w=1.2 l=0.15
X1153 t_Xst2a_s2 t_Xst2a_qi vdd vdd sky130_fd_pr__pfet_01v8 w=1.6 l=0.15
X1154 t_Xst2a_s2 rst_n vdd vdd sky130_fd_pr__pfet_01v8 w=1.6 l=0.15
X1155 t_Xst2a_s2 t_Xst2a_clkb t_Xst2a_s1 vss sky130_fd_pr__nfet_01v8_lvt w=0.8 l=0.15
X1156 t_Xst2a_s2 t_Xst2a_clki t_Xst2a_s1 vdd sky130_fd_pr__pfet_01v8 w=1.6 l=0.15
X1157 t_l2h t_Xst2a_s1 vss vss sky130_fd_pr__nfet_01v8_lvt w=2.25 l=0.15
X1158 t_l2h t_Xst2a_s1 vdd vdd sky130_fd_pr__pfet_01v8 w=4.5 l=0.15
X1159 t_l2hb t_Xst2a_qi vss vss sky130_fd_pr__nfet_01v8_lvt w=2.25 l=0.15
X1160 t_l2hb t_Xst2a_qi vdd vdd sky130_fd_pr__pfet_01v8 w=4.5 l=0.15
X1161 t_Xst2b_clkb t_c0 vss vss sky130_fd_pr__nfet_01v8_lvt w=1.4 l=0.15
X1162 t_Xst2b_clkb t_c0 vdd vdd sky130_fd_pr__pfet_01v8 w=3.4 l=0.15
X1163 t_Xst2b_clki t_Xst2b_clkb vss vss sky130_fd_pr__nfet_01v8_lvt w=1.4 l=0.15
X1164 t_Xst2b_clki t_Xst2b_clkb vdd vdd sky130_fd_pr__pfet_01v8 w=3.4 l=0.15
X1165 t_l2h t_Xst2b_clkb t_Xst2b_m1 vss sky130_fd_pr__nfet_01v8_lvt w=1.5 l=0.15
X1166 t_l2h t_Xst2b_clki t_Xst2b_m1 vdd sky130_fd_pr__pfet_01v8 w=2.8 l=0.15
X1167 t_Xst2b_m2 t_Xst2b_m1 t_Xst2b_Xm2_mid vss sky130_fd_pr__nfet_01v8_lvt w=2.25 l=0.15
X1168 t_Xst2b_Xm2_mid rst_n vss vss sky130_fd_pr__nfet_01v8_lvt w=2.25 l=0.15
X1169 t_Xst2b_m2 t_Xst2b_m1 vdd vdd sky130_fd_pr__pfet_01v8 w=2.8 l=0.15
X1170 t_Xst2b_m2 rst_n vdd vdd sky130_fd_pr__pfet_01v8 w=2.8 l=0.15
X1171 t_Xst2b_m3 t_Xst2b_m2 vss vss sky130_fd_pr__nfet_01v8_lvt w=0.8 l=0.15
X1172 t_Xst2b_m3 t_Xst2b_m2 vdd vdd sky130_fd_pr__pfet_01v8 w=1.6 l=0.15
X1173 t_Xst2b_m3 t_Xst2b_clki t_Xst2b_m1 vss sky130_fd_pr__nfet_01v8_lvt w=0.8 l=0.15
X1174 t_Xst2b_m3 t_Xst2b_clkb t_Xst2b_m1 vdd sky130_fd_pr__pfet_01v8 w=1.6 l=0.15
X1175 t_Xst2b_m2 t_Xst2b_clki t_Xst2b_s1 vss sky130_fd_pr__nfet_01v8_lvt w=1.5 l=0.15
X1176 t_Xst2b_m2 t_Xst2b_clkb t_Xst2b_s1 vdd sky130_fd_pr__pfet_01v8 w=2.8 l=0.15
X1177 t_Xst2b_qi t_Xst2b_s1 vss vss sky130_fd_pr__nfet_01v8_lvt w=2.1 l=0.15
X1178 t_Xst2b_qi t_Xst2b_s1 vdd vdd sky130_fd_pr__pfet_01v8 w=5 l=0.15
X1179 t_Xst2b_s2 t_Xst2b_qi t_Xst2b_Xsfb_mid vss sky130_fd_pr__nfet_01v8_lvt w=1.2 l=0.15
X1180 t_Xst2b_Xsfb_mid rst_n vss vss sky130_fd_pr__nfet_01v8_lvt w=1.2 l=0.15
X1181 t_Xst2b_s2 t_Xst2b_qi vdd vdd sky130_fd_pr__pfet_01v8 w=1.6 l=0.15
X1182 t_Xst2b_s2 rst_n vdd vdd sky130_fd_pr__pfet_01v8 w=1.6 l=0.15
X1183 t_Xst2b_s2 t_Xst2b_clkb t_Xst2b_s1 vss sky130_fd_pr__nfet_01v8_lvt w=0.8 l=0.15
X1184 t_Xst2b_s2 t_Xst2b_clki t_Xst2b_s1 vdd sky130_fd_pr__pfet_01v8 w=1.6 l=0.15
X1185 d2 t_Xst2b_s1 vss vss sky130_fd_pr__nfet_01v8_lvt w=2.7 l=0.15
X1186 d2 t_Xst2b_s1 vdd vdd sky130_fd_pr__pfet_01v8 w=7.5 l=0.15
X1187 db2 t_Xst2b_qi vss vss sky130_fd_pr__nfet_01v8_lvt w=2.7 l=0.15
X1188 db2 t_Xst2b_qi vdd vdd sky130_fd_pr__pfet_01v8 w=7.5 l=0.15
X1189 t_Xst3a_clkb t_c180 vss vss sky130_fd_pr__nfet_01v8_lvt w=1.2 l=0.15
X1190 t_Xst3a_clkb t_c180 vdd vdd sky130_fd_pr__pfet_01v8 w=2.4 l=0.15
X1191 t_Xst3a_clki t_Xst3a_clkb vss vss sky130_fd_pr__nfet_01v8_lvt w=1.2 l=0.15
X1192 t_Xst3a_clki t_Xst3a_clkb vdd vdd sky130_fd_pr__pfet_01v8 w=2.4 l=0.15
X1193 t_l3 t_Xst3a_clkb t_Xst3a_m1 vss sky130_fd_pr__nfet_01v8_lvt w=1.5 l=0.15
X1194 t_l3 t_Xst3a_clki t_Xst3a_m1 vdd sky130_fd_pr__pfet_01v8 w=3 l=0.15
X1195 t_Xst3a_m2 t_Xst3a_m1 t_Xst3a_Xm2_mid vss sky130_fd_pr__nfet_01v8_lvt w=2.25 l=0.15
X1196 t_Xst3a_Xm2_mid rst_n vss vss sky130_fd_pr__nfet_01v8_lvt w=2.25 l=0.15
X1197 t_Xst3a_m2 t_Xst3a_m1 vdd vdd sky130_fd_pr__pfet_01v8 w=3 l=0.15
X1198 t_Xst3a_m2 rst_n vdd vdd sky130_fd_pr__pfet_01v8 w=3 l=0.15
X1199 t_Xst3a_m3 t_Xst3a_m2 vss vss sky130_fd_pr__nfet_01v8_lvt w=0.8 l=0.15
X1200 t_Xst3a_m3 t_Xst3a_m2 vdd vdd sky130_fd_pr__pfet_01v8 w=1.6 l=0.15
X1201 t_Xst3a_m3 t_Xst3a_clki t_Xst3a_m1 vss sky130_fd_pr__nfet_01v8_lvt w=0.8 l=0.15
X1202 t_Xst3a_m3 t_Xst3a_clkb t_Xst3a_m1 vdd sky130_fd_pr__pfet_01v8 w=1.6 l=0.15
X1203 t_Xst3a_m2 t_Xst3a_clki t_Xst3a_s1 vss sky130_fd_pr__nfet_01v8_lvt w=1.5 l=0.15
X1204 t_Xst3a_m2 t_Xst3a_clkb t_Xst3a_s1 vdd sky130_fd_pr__pfet_01v8 w=3 l=0.15
X1205 t_Xst3a_qi t_Xst3a_s1 vss vss sky130_fd_pr__nfet_01v8_lvt w=1.8 l=0.15
X1206 t_Xst3a_qi t_Xst3a_s1 vdd vdd sky130_fd_pr__pfet_01v8 w=3.6 l=0.15
X1207 t_Xst3a_s2 t_Xst3a_qi t_Xst3a_Xsfb_mid vss sky130_fd_pr__nfet_01v8_lvt w=1.2 l=0.15
X1208 t_Xst3a_Xsfb_mid rst_n vss vss sky130_fd_pr__nfet_01v8_lvt w=1.2 l=0.15
X1209 t_Xst3a_s2 t_Xst3a_qi vdd vdd sky130_fd_pr__pfet_01v8 w=1.6 l=0.15
X1210 t_Xst3a_s2 rst_n vdd vdd sky130_fd_pr__pfet_01v8 w=1.6 l=0.15
X1211 t_Xst3a_s2 t_Xst3a_clkb t_Xst3a_s1 vss sky130_fd_pr__nfet_01v8_lvt w=0.8 l=0.15
X1212 t_Xst3a_s2 t_Xst3a_clki t_Xst3a_s1 vdd sky130_fd_pr__pfet_01v8 w=1.6 l=0.15
X1213 t_l3h t_Xst3a_s1 vss vss sky130_fd_pr__nfet_01v8_lvt w=2.25 l=0.15
X1214 t_l3h t_Xst3a_s1 vdd vdd sky130_fd_pr__pfet_01v8 w=4.5 l=0.15
X1215 t_l3hb t_Xst3a_qi vss vss sky130_fd_pr__nfet_01v8_lvt w=2.25 l=0.15
X1216 t_l3hb t_Xst3a_qi vdd vdd sky130_fd_pr__pfet_01v8 w=4.5 l=0.15
X1217 t_Xst3b_clkb t_c90 vss vss sky130_fd_pr__nfet_01v8_lvt w=1.4 l=0.15
X1218 t_Xst3b_clkb t_c90 vdd vdd sky130_fd_pr__pfet_01v8 w=3.4 l=0.15
X1219 t_Xst3b_clki t_Xst3b_clkb vss vss sky130_fd_pr__nfet_01v8_lvt w=1.4 l=0.15
X1220 t_Xst3b_clki t_Xst3b_clkb vdd vdd sky130_fd_pr__pfet_01v8 w=3.4 l=0.15
X1221 t_l3h t_Xst3b_clkb t_Xst3b_m1 vss sky130_fd_pr__nfet_01v8_lvt w=1.5 l=0.15
X1222 t_l3h t_Xst3b_clki t_Xst3b_m1 vdd sky130_fd_pr__pfet_01v8 w=2.8 l=0.15
X1223 t_Xst3b_m2 t_Xst3b_m1 t_Xst3b_Xm2_mid vss sky130_fd_pr__nfet_01v8_lvt w=2.25 l=0.15
X1224 t_Xst3b_Xm2_mid rst_n vss vss sky130_fd_pr__nfet_01v8_lvt w=2.25 l=0.15
X1225 t_Xst3b_m2 t_Xst3b_m1 vdd vdd sky130_fd_pr__pfet_01v8 w=2.8 l=0.15
X1226 t_Xst3b_m2 rst_n vdd vdd sky130_fd_pr__pfet_01v8 w=2.8 l=0.15
X1227 t_Xst3b_m3 t_Xst3b_m2 vss vss sky130_fd_pr__nfet_01v8_lvt w=0.8 l=0.15
X1228 t_Xst3b_m3 t_Xst3b_m2 vdd vdd sky130_fd_pr__pfet_01v8 w=1.6 l=0.15
X1229 t_Xst3b_m3 t_Xst3b_clki t_Xst3b_m1 vss sky130_fd_pr__nfet_01v8_lvt w=0.8 l=0.15
X1230 t_Xst3b_m3 t_Xst3b_clkb t_Xst3b_m1 vdd sky130_fd_pr__pfet_01v8 w=1.6 l=0.15
X1231 t_Xst3b_m2 t_Xst3b_clki t_Xst3b_s1 vss sky130_fd_pr__nfet_01v8_lvt w=1.5 l=0.15
X1232 t_Xst3b_m2 t_Xst3b_clkb t_Xst3b_s1 vdd sky130_fd_pr__pfet_01v8 w=2.8 l=0.15
X1233 t_Xst3b_qi t_Xst3b_s1 vss vss sky130_fd_pr__nfet_01v8_lvt w=2.1 l=0.15
X1234 t_Xst3b_qi t_Xst3b_s1 vdd vdd sky130_fd_pr__pfet_01v8 w=5 l=0.15
X1235 t_Xst3b_s2 t_Xst3b_qi t_Xst3b_Xsfb_mid vss sky130_fd_pr__nfet_01v8_lvt w=1.2 l=0.15
X1236 t_Xst3b_Xsfb_mid rst_n vss vss sky130_fd_pr__nfet_01v8_lvt w=1.2 l=0.15
X1237 t_Xst3b_s2 t_Xst3b_qi vdd vdd sky130_fd_pr__pfet_01v8 w=1.6 l=0.15
X1238 t_Xst3b_s2 rst_n vdd vdd sky130_fd_pr__pfet_01v8 w=1.6 l=0.15
X1239 t_Xst3b_s2 t_Xst3b_clkb t_Xst3b_s1 vss sky130_fd_pr__nfet_01v8_lvt w=0.8 l=0.15
X1240 t_Xst3b_s2 t_Xst3b_clki t_Xst3b_s1 vdd sky130_fd_pr__pfet_01v8 w=1.6 l=0.15
X1241 d3 t_Xst3b_s1 vss vss sky130_fd_pr__nfet_01v8_lvt w=2.7 l=0.15
X1242 d3 t_Xst3b_s1 vdd vdd sky130_fd_pr__pfet_01v8 w=7.5 l=0.15
X1243 db3 t_Xst3b_qi vss vss sky130_fd_pr__nfet_01v8_lvt w=2.7 l=0.15
X1244 db3 t_Xst3b_qi vdd vdd sky130_fd_pr__pfet_01v8 w=7.5 l=0.15
.ends serdes_tx_sst_serializer16_pdk
