* Exact flattened LVS reference netlist for serdes_tx_sst_top_pdk
* Source subckt: serdes_tx_sst_top_5g (v5_5g hardened analog/tx/sst/spice/*_5g.spice)
.subckt serdes_tx_sst_top_pdk din0 din1 din2 din3 din4 din5 din6 din7 din8 din9 din10 din11 din12 din13 din14 din15 phi0 phi90 phi180 phi270 rst_n m0 m1 m2 m3 m4 f0 f1 f2 ffe_en vbg pad_p pad_n vdrv clk500_out clk250_out vdd vss
X1 t_Xser_c0b phi0 vss vss sky130_fd_pr__nfet_01v8_lvt w=2.6 l=0.15
X2 t_Xser_c0b phi0 vdd vdd sky130_fd_pr__pfet_01v8 w=6 l=0.15
X3 t_Xser_c0 t_Xser_c0b vss vss sky130_fd_pr__nfet_01v8_lvt w=5 l=0.15
X4 t_Xser_c0 t_Xser_c0b vdd vdd sky130_fd_pr__pfet_01v8 w=12.5 l=0.15
X5 t_Xser_c90b phi90 vss vss sky130_fd_pr__nfet_01v8_lvt w=2 l=0.15
X6 t_Xser_c90b phi90 vdd vdd sky130_fd_pr__pfet_01v8 w=4.8 l=0.15
X7 t_Xser_c90 t_Xser_c90b vss vss sky130_fd_pr__nfet_01v8_lvt w=3.6 l=0.15
X8 t_Xser_c90 t_Xser_c90b vdd vdd sky130_fd_pr__pfet_01v8 w=9 l=0.15
X9 t_Xser_c18b phi180 vss vss sky130_fd_pr__nfet_01v8_lvt w=2.2 l=0.15
X10 t_Xser_c18b phi180 vdd vdd sky130_fd_pr__pfet_01v8 w=5.4 l=0.15
X11 t_Xser_c180 t_Xser_c18b vss vss sky130_fd_pr__nfet_01v8_lvt w=4.2 l=0.15
X12 t_Xser_c180 t_Xser_c18b vdd vdd sky130_fd_pr__pfet_01v8 w=10.5 l=0.15
X13 t_Xser_c27b phi270 vss vss sky130_fd_pr__nfet_01v8_lvt w=2 l=0.15
X14 t_Xser_c27b phi270 vdd vdd sky130_fd_pr__pfet_01v8 w=4.8 l=0.15
X15 t_Xser_c270 t_Xser_c27b vss vss sky130_fd_pr__nfet_01v8_lvt w=3.6 l=0.15
X16 t_Xser_c270 t_Xser_c27b vdd vdd sky130_fd_pr__pfet_01v8 w=9 l=0.15
X17 t_Xser_Xdiv500_clkb t_Xser_c0 vss vss sky130_fd_pr__nfet_01v8_lvt w=1.2 l=0.15
X18 t_Xser_Xdiv500_clkb t_Xser_c0 vdd vdd sky130_fd_pr__pfet_01v8 w=2.4 l=0.15
X19 t_Xser_Xdiv500_clki t_Xser_Xdiv500_clkb vss vss sky130_fd_pr__nfet_01v8_lvt w=1.2 l=0.15
X20 t_Xser_Xdiv500_clki t_Xser_Xdiv500_clkb vdd vdd sky130_fd_pr__pfet_01v8 w=2.4 l=0.15
X21 t_Xser_clk500b_i t_Xser_Xdiv500_clkb t_Xser_Xdiv500_m1 vss sky130_fd_pr__nfet_01v8_lvt w=1.5 l=0.15
X22 t_Xser_clk500b_i t_Xser_Xdiv500_clki t_Xser_Xdiv500_m1 vdd sky130_fd_pr__pfet_01v8 w=3 l=0.15
X23 t_Xser_Xdiv500_m2 t_Xser_Xdiv500_m1 t_Xser_Xdiv500_Xm2_mid vss sky130_fd_pr__nfet_01v8_lvt w=2.25 l=0.15
X24 t_Xser_Xdiv500_Xm2_mid rst_n vss vss sky130_fd_pr__nfet_01v8_lvt w=2.25 l=0.15
X25 t_Xser_Xdiv500_m2 t_Xser_Xdiv500_m1 vdd vdd sky130_fd_pr__pfet_01v8 w=3 l=0.15
X26 t_Xser_Xdiv500_m2 rst_n vdd vdd sky130_fd_pr__pfet_01v8 w=3 l=0.15
X27 t_Xser_Xdiv500_m3 t_Xser_Xdiv500_m2 vss vss sky130_fd_pr__nfet_01v8_lvt w=0.8 l=0.15
X28 t_Xser_Xdiv500_m3 t_Xser_Xdiv500_m2 vdd vdd sky130_fd_pr__pfet_01v8 w=1.6 l=0.15
X29 t_Xser_Xdiv500_m3 t_Xser_Xdiv500_clki t_Xser_Xdiv500_m1 vss sky130_fd_pr__nfet_01v8_lvt w=0.8 l=0.15
X30 t_Xser_Xdiv500_m3 t_Xser_Xdiv500_clkb t_Xser_Xdiv500_m1 vdd sky130_fd_pr__pfet_01v8 w=1.6 l=0.15
X31 t_Xser_Xdiv500_m2 t_Xser_Xdiv500_clki t_Xser_Xdiv500_s1 vss sky130_fd_pr__nfet_01v8_lvt w=1.5 l=0.15
X32 t_Xser_Xdiv500_m2 t_Xser_Xdiv500_clkb t_Xser_Xdiv500_s1 vdd sky130_fd_pr__pfet_01v8 w=3 l=0.15
X33 t_Xser_Xdiv500_qi t_Xser_Xdiv500_s1 vss vss sky130_fd_pr__nfet_01v8_lvt w=1.8 l=0.15
X34 t_Xser_Xdiv500_qi t_Xser_Xdiv500_s1 vdd vdd sky130_fd_pr__pfet_01v8 w=3.6 l=0.15
X35 t_Xser_Xdiv500_s2 t_Xser_Xdiv500_qi t_Xser_Xdiv500_Xsfb_mid vss sky130_fd_pr__nfet_01v8_lvt w=1.2 l=0.15
X36 t_Xser_Xdiv500_Xsfb_mid rst_n vss vss sky130_fd_pr__nfet_01v8_lvt w=1.2 l=0.15
X37 t_Xser_Xdiv500_s2 t_Xser_Xdiv500_qi vdd vdd sky130_fd_pr__pfet_01v8 w=1.6 l=0.15
X38 t_Xser_Xdiv500_s2 rst_n vdd vdd sky130_fd_pr__pfet_01v8 w=1.6 l=0.15
X39 t_Xser_Xdiv500_s2 t_Xser_Xdiv500_clkb t_Xser_Xdiv500_s1 vss sky130_fd_pr__nfet_01v8_lvt w=0.8 l=0.15
X40 t_Xser_Xdiv500_s2 t_Xser_Xdiv500_clki t_Xser_Xdiv500_s1 vdd sky130_fd_pr__pfet_01v8 w=1.6 l=0.15
X41 t_Xser_clk500_i t_Xser_Xdiv500_s1 vss vss sky130_fd_pr__nfet_01v8_lvt w=2.25 l=0.15
X42 t_Xser_clk500_i t_Xser_Xdiv500_s1 vdd vdd sky130_fd_pr__pfet_01v8 w=4.5 l=0.15
X43 t_Xser_clk500b_i t_Xser_Xdiv500_qi vss vss sky130_fd_pr__nfet_01v8_lvt w=2.25 l=0.15
X44 t_Xser_clk500b_i t_Xser_Xdiv500_qi vdd vdd sky130_fd_pr__pfet_01v8 w=4.5 l=0.15
X45 t_Xser_Xdiv250_clkb t_Xser_clk500_i vss vss sky130_fd_pr__nfet_01v8_lvt w=1.2 l=0.15
X46 t_Xser_Xdiv250_clkb t_Xser_clk500_i vdd vdd sky130_fd_pr__pfet_01v8 w=2.4 l=0.15
X47 t_Xser_Xdiv250_clki t_Xser_Xdiv250_clkb vss vss sky130_fd_pr__nfet_01v8_lvt w=1.2 l=0.15
X48 t_Xser_Xdiv250_clki t_Xser_Xdiv250_clkb vdd vdd sky130_fd_pr__pfet_01v8 w=2.4 l=0.15
X49 t_Xser_clk250b_i t_Xser_Xdiv250_clkb t_Xser_Xdiv250_m1 vss sky130_fd_pr__nfet_01v8_lvt w=1.5 l=0.15
X50 t_Xser_clk250b_i t_Xser_Xdiv250_clki t_Xser_Xdiv250_m1 vdd sky130_fd_pr__pfet_01v8 w=3 l=0.15
X51 t_Xser_Xdiv250_m2 t_Xser_Xdiv250_m1 t_Xser_Xdiv250_Xm2_mid vss sky130_fd_pr__nfet_01v8_lvt w=2.25 l=0.15
X52 t_Xser_Xdiv250_Xm2_mid rst_n vss vss sky130_fd_pr__nfet_01v8_lvt w=2.25 l=0.15
X53 t_Xser_Xdiv250_m2 t_Xser_Xdiv250_m1 vdd vdd sky130_fd_pr__pfet_01v8 w=3 l=0.15
X54 t_Xser_Xdiv250_m2 rst_n vdd vdd sky130_fd_pr__pfet_01v8 w=3 l=0.15
X55 t_Xser_Xdiv250_m3 t_Xser_Xdiv250_m2 vss vss sky130_fd_pr__nfet_01v8_lvt w=0.8 l=0.15
X56 t_Xser_Xdiv250_m3 t_Xser_Xdiv250_m2 vdd vdd sky130_fd_pr__pfet_01v8 w=1.6 l=0.15
X57 t_Xser_Xdiv250_m3 t_Xser_Xdiv250_clki t_Xser_Xdiv250_m1 vss sky130_fd_pr__nfet_01v8_lvt w=0.8 l=0.15
X58 t_Xser_Xdiv250_m3 t_Xser_Xdiv250_clkb t_Xser_Xdiv250_m1 vdd sky130_fd_pr__pfet_01v8 w=1.6 l=0.15
X59 t_Xser_Xdiv250_m2 t_Xser_Xdiv250_clki t_Xser_Xdiv250_s1 vss sky130_fd_pr__nfet_01v8_lvt w=1.5 l=0.15
X60 t_Xser_Xdiv250_m2 t_Xser_Xdiv250_clkb t_Xser_Xdiv250_s1 vdd sky130_fd_pr__pfet_01v8 w=3 l=0.15
X61 t_Xser_Xdiv250_qi t_Xser_Xdiv250_s1 vss vss sky130_fd_pr__nfet_01v8_lvt w=1.8 l=0.15
X62 t_Xser_Xdiv250_qi t_Xser_Xdiv250_s1 vdd vdd sky130_fd_pr__pfet_01v8 w=3.6 l=0.15
X63 t_Xser_Xdiv250_s2 t_Xser_Xdiv250_qi t_Xser_Xdiv250_Xsfb_mid vss sky130_fd_pr__nfet_01v8_lvt w=1.2 l=0.15
X64 t_Xser_Xdiv250_Xsfb_mid rst_n vss vss sky130_fd_pr__nfet_01v8_lvt w=1.2 l=0.15
X65 t_Xser_Xdiv250_s2 t_Xser_Xdiv250_qi vdd vdd sky130_fd_pr__pfet_01v8 w=1.6 l=0.15
X66 t_Xser_Xdiv250_s2 rst_n vdd vdd sky130_fd_pr__pfet_01v8 w=1.6 l=0.15
X67 t_Xser_Xdiv250_s2 t_Xser_Xdiv250_clkb t_Xser_Xdiv250_s1 vss sky130_fd_pr__nfet_01v8_lvt w=0.8 l=0.15
X68 t_Xser_Xdiv250_s2 t_Xser_Xdiv250_clki t_Xser_Xdiv250_s1 vdd sky130_fd_pr__pfet_01v8 w=1.6 l=0.15
X69 t_Xser_clk250_i t_Xser_Xdiv250_s1 vss vss sky130_fd_pr__nfet_01v8_lvt w=2.25 l=0.15
X70 t_Xser_clk250_i t_Xser_Xdiv250_s1 vdd vdd sky130_fd_pr__pfet_01v8 w=4.5 l=0.15
X71 t_Xser_clk250b_i t_Xser_Xdiv250_qi vss vss sky130_fd_pr__nfet_01v8_lvt w=2.25 l=0.15
X72 t_Xser_clk250b_i t_Xser_Xdiv250_qi vdd vdd sky130_fd_pr__pfet_01v8 w=4.5 l=0.15
X73 t_Xser_clk500b t_Xser_clk500_i vss vss sky130_fd_pr__nfet_01v8_lvt w=4 l=0.15
X74 t_Xser_clk500b t_Xser_clk500_i vdd vdd sky130_fd_pr__pfet_01v8 w=8 l=0.15
X75 t_Xser_clk500 t_Xser_clk500b_i vss vss sky130_fd_pr__nfet_01v8_lvt w=4 l=0.15
X76 t_Xser_clk500 t_Xser_clk500b_i vdd vdd sky130_fd_pr__pfet_01v8 w=8 l=0.15
X77 t_Xser_clk250b t_Xser_clk250_i vss vss sky130_fd_pr__nfet_01v8_lvt w=4 l=0.15
X78 t_Xser_clk250b t_Xser_clk250_i vdd vdd sky130_fd_pr__pfet_01v8 w=8 l=0.15
X79 t_Xser_clk250 t_Xser_clk250b_i vss vss sky130_fd_pr__nfet_01v8_lvt w=3 l=0.15
X80 t_Xser_clk250 t_Xser_clk250b_i vdd vdd sky130_fd_pr__pfet_01v8 w=6 l=0.15
X81 clk500_out t_Xser_clk500b vss vss sky130_fd_pr__nfet_01v8_lvt w=1.5 l=0.15
X82 clk500_out t_Xser_clk500b vdd vdd sky130_fd_pr__pfet_01v8 w=3 l=0.15
X83 clk250_out t_Xser_clk250 vss vss sky130_fd_pr__nfet_01v8_lvt w=1.5 l=0.15
X84 clk250_out t_Xser_clk250 vdd vdd sky130_fd_pr__pfet_01v8 w=3 l=0.15
X85 t_Xser_Xlane0_Xr0_clkb t_Xser_clk250b vss vss sky130_fd_pr__nfet_01v8_lvt w=1.2 l=0.15
X86 t_Xser_Xlane0_Xr0_clkb t_Xser_clk250b vdd vdd sky130_fd_pr__pfet_01v8 w=2.4 l=0.15
X87 t_Xser_Xlane0_Xr0_clki t_Xser_Xlane0_Xr0_clkb vss vss sky130_fd_pr__nfet_01v8_lvt w=1.2 l=0.15
X88 t_Xser_Xlane0_Xr0_clki t_Xser_Xlane0_Xr0_clkb vdd vdd sky130_fd_pr__pfet_01v8 w=2.4 l=0.15
X89 din0 t_Xser_Xlane0_Xr0_clkb t_Xser_Xlane0_Xr0_m1 vss sky130_fd_pr__nfet_01v8_lvt w=0.8 l=0.15
X90 din0 t_Xser_Xlane0_Xr0_clki t_Xser_Xlane0_Xr0_m1 vdd sky130_fd_pr__pfet_01v8 w=1.6 l=0.15
X91 t_Xser_Xlane0_Xr0_m2 t_Xser_Xlane0_Xr0_m1 t_Xser_Xlane0_Xr0_Xm2_mid vss sky130_fd_pr__nfet_01v8_lvt w=1.2 l=0.15
X92 t_Xser_Xlane0_Xr0_Xm2_mid rst_n vss vss sky130_fd_pr__nfet_01v8_lvt w=1.2 l=0.15
X93 t_Xser_Xlane0_Xr0_m2 t_Xser_Xlane0_Xr0_m1 vdd vdd sky130_fd_pr__pfet_01v8 w=1.6 l=0.15
X94 t_Xser_Xlane0_Xr0_m2 rst_n vdd vdd sky130_fd_pr__pfet_01v8 w=1.6 l=0.15
X95 t_Xser_Xlane0_Xr0_m3 t_Xser_Xlane0_Xr0_m2 vss vss sky130_fd_pr__nfet_01v8_lvt w=0.8 l=0.15
X96 t_Xser_Xlane0_Xr0_m3 t_Xser_Xlane0_Xr0_m2 vdd vdd sky130_fd_pr__pfet_01v8 w=1.6 l=0.15
X97 t_Xser_Xlane0_Xr0_m3 t_Xser_Xlane0_Xr0_clki t_Xser_Xlane0_Xr0_m1 vss sky130_fd_pr__nfet_01v8_lvt w=0.8 l=0.15
X98 t_Xser_Xlane0_Xr0_m3 t_Xser_Xlane0_Xr0_clkb t_Xser_Xlane0_Xr0_m1 vdd sky130_fd_pr__pfet_01v8 w=1.6 l=0.15
X99 t_Xser_Xlane0_Xr0_m2 t_Xser_Xlane0_Xr0_clki t_Xser_Xlane0_Xr0_s1 vss sky130_fd_pr__nfet_01v8_lvt w=0.8 l=0.15
X100 t_Xser_Xlane0_Xr0_m2 t_Xser_Xlane0_Xr0_clkb t_Xser_Xlane0_Xr0_s1 vdd sky130_fd_pr__pfet_01v8 w=1.6 l=0.15
X101 t_Xser_Xlane0_Xr0_qi t_Xser_Xlane0_Xr0_s1 vss vss sky130_fd_pr__nfet_01v8_lvt w=0.96 l=0.15
X102 t_Xser_Xlane0_Xr0_qi t_Xser_Xlane0_Xr0_s1 vdd vdd sky130_fd_pr__pfet_01v8 w=1.92 l=0.15
X103 t_Xser_Xlane0_Xr0_s2 t_Xser_Xlane0_Xr0_qi t_Xser_Xlane0_Xr0_Xsfb_mid vss sky130_fd_pr__nfet_01v8_lvt w=1.2 l=0.15
X104 t_Xser_Xlane0_Xr0_Xsfb_mid rst_n vss vss sky130_fd_pr__nfet_01v8_lvt w=1.2 l=0.15
X105 t_Xser_Xlane0_Xr0_s2 t_Xser_Xlane0_Xr0_qi vdd vdd sky130_fd_pr__pfet_01v8 w=1.6 l=0.15
X106 t_Xser_Xlane0_Xr0_s2 rst_n vdd vdd sky130_fd_pr__pfet_01v8 w=1.6 l=0.15
X107 t_Xser_Xlane0_Xr0_s2 t_Xser_Xlane0_Xr0_clkb t_Xser_Xlane0_Xr0_s1 vss sky130_fd_pr__nfet_01v8_lvt w=0.8 l=0.15
X108 t_Xser_Xlane0_Xr0_s2 t_Xser_Xlane0_Xr0_clki t_Xser_Xlane0_Xr0_s1 vdd sky130_fd_pr__pfet_01v8 w=1.6 l=0.15
X109 t_Xser_Xlane0_r0 t_Xser_Xlane0_Xr0_s1 vss vss sky130_fd_pr__nfet_01v8_lvt w=1.2 l=0.15
X110 t_Xser_Xlane0_r0 t_Xser_Xlane0_Xr0_s1 vdd vdd sky130_fd_pr__pfet_01v8 w=2.4 l=0.15
X111 t_Xser_Xlane0_r0b t_Xser_Xlane0_Xr0_qi vss vss sky130_fd_pr__nfet_01v8_lvt w=1.2 l=0.15
X112 t_Xser_Xlane0_r0b t_Xser_Xlane0_Xr0_qi vdd vdd sky130_fd_pr__pfet_01v8 w=2.4 l=0.15
X113 t_Xser_Xlane0_Xr1_clkb t_Xser_clk250b vss vss sky130_fd_pr__nfet_01v8_lvt w=1.2 l=0.15
X114 t_Xser_Xlane0_Xr1_clkb t_Xser_clk250b vdd vdd sky130_fd_pr__pfet_01v8 w=2.4 l=0.15
X115 t_Xser_Xlane0_Xr1_clki t_Xser_Xlane0_Xr1_clkb vss vss sky130_fd_pr__nfet_01v8_lvt w=1.2 l=0.15
X116 t_Xser_Xlane0_Xr1_clki t_Xser_Xlane0_Xr1_clkb vdd vdd sky130_fd_pr__pfet_01v8 w=2.4 l=0.15
X117 din4 t_Xser_Xlane0_Xr1_clkb t_Xser_Xlane0_Xr1_m1 vss sky130_fd_pr__nfet_01v8_lvt w=0.8 l=0.15
X118 din4 t_Xser_Xlane0_Xr1_clki t_Xser_Xlane0_Xr1_m1 vdd sky130_fd_pr__pfet_01v8 w=1.6 l=0.15
X119 t_Xser_Xlane0_Xr1_m2 t_Xser_Xlane0_Xr1_m1 t_Xser_Xlane0_Xr1_Xm2_mid vss sky130_fd_pr__nfet_01v8_lvt w=1.2 l=0.15
X120 t_Xser_Xlane0_Xr1_Xm2_mid rst_n vss vss sky130_fd_pr__nfet_01v8_lvt w=1.2 l=0.15
X121 t_Xser_Xlane0_Xr1_m2 t_Xser_Xlane0_Xr1_m1 vdd vdd sky130_fd_pr__pfet_01v8 w=1.6 l=0.15
X122 t_Xser_Xlane0_Xr1_m2 rst_n vdd vdd sky130_fd_pr__pfet_01v8 w=1.6 l=0.15
X123 t_Xser_Xlane0_Xr1_m3 t_Xser_Xlane0_Xr1_m2 vss vss sky130_fd_pr__nfet_01v8_lvt w=0.8 l=0.15
X124 t_Xser_Xlane0_Xr1_m3 t_Xser_Xlane0_Xr1_m2 vdd vdd sky130_fd_pr__pfet_01v8 w=1.6 l=0.15
X125 t_Xser_Xlane0_Xr1_m3 t_Xser_Xlane0_Xr1_clki t_Xser_Xlane0_Xr1_m1 vss sky130_fd_pr__nfet_01v8_lvt w=0.8 l=0.15
X126 t_Xser_Xlane0_Xr1_m3 t_Xser_Xlane0_Xr1_clkb t_Xser_Xlane0_Xr1_m1 vdd sky130_fd_pr__pfet_01v8 w=1.6 l=0.15
X127 t_Xser_Xlane0_Xr1_m2 t_Xser_Xlane0_Xr1_clki t_Xser_Xlane0_Xr1_s1 vss sky130_fd_pr__nfet_01v8_lvt w=0.8 l=0.15
X128 t_Xser_Xlane0_Xr1_m2 t_Xser_Xlane0_Xr1_clkb t_Xser_Xlane0_Xr1_s1 vdd sky130_fd_pr__pfet_01v8 w=1.6 l=0.15
X129 t_Xser_Xlane0_Xr1_qi t_Xser_Xlane0_Xr1_s1 vss vss sky130_fd_pr__nfet_01v8_lvt w=0.96 l=0.15
X130 t_Xser_Xlane0_Xr1_qi t_Xser_Xlane0_Xr1_s1 vdd vdd sky130_fd_pr__pfet_01v8 w=1.92 l=0.15
X131 t_Xser_Xlane0_Xr1_s2 t_Xser_Xlane0_Xr1_qi t_Xser_Xlane0_Xr1_Xsfb_mid vss sky130_fd_pr__nfet_01v8_lvt w=1.2 l=0.15
X132 t_Xser_Xlane0_Xr1_Xsfb_mid rst_n vss vss sky130_fd_pr__nfet_01v8_lvt w=1.2 l=0.15
X133 t_Xser_Xlane0_Xr1_s2 t_Xser_Xlane0_Xr1_qi vdd vdd sky130_fd_pr__pfet_01v8 w=1.6 l=0.15
X134 t_Xser_Xlane0_Xr1_s2 rst_n vdd vdd sky130_fd_pr__pfet_01v8 w=1.6 l=0.15
X135 t_Xser_Xlane0_Xr1_s2 t_Xser_Xlane0_Xr1_clkb t_Xser_Xlane0_Xr1_s1 vss sky130_fd_pr__nfet_01v8_lvt w=0.8 l=0.15
X136 t_Xser_Xlane0_Xr1_s2 t_Xser_Xlane0_Xr1_clki t_Xser_Xlane0_Xr1_s1 vdd sky130_fd_pr__pfet_01v8 w=1.6 l=0.15
X137 t_Xser_Xlane0_r1 t_Xser_Xlane0_Xr1_s1 vss vss sky130_fd_pr__nfet_01v8_lvt w=1.2 l=0.15
X138 t_Xser_Xlane0_r1 t_Xser_Xlane0_Xr1_s1 vdd vdd sky130_fd_pr__pfet_01v8 w=2.4 l=0.15
X139 t_Xser_Xlane0_r1b t_Xser_Xlane0_Xr1_qi vss vss sky130_fd_pr__nfet_01v8_lvt w=1.2 l=0.15
X140 t_Xser_Xlane0_r1b t_Xser_Xlane0_Xr1_qi vdd vdd sky130_fd_pr__pfet_01v8 w=2.4 l=0.15
X141 t_Xser_Xlane0_Xr2_clkb t_Xser_clk250b vss vss sky130_fd_pr__nfet_01v8_lvt w=1.2 l=0.15
X142 t_Xser_Xlane0_Xr2_clkb t_Xser_clk250b vdd vdd sky130_fd_pr__pfet_01v8 w=2.4 l=0.15
X143 t_Xser_Xlane0_Xr2_clki t_Xser_Xlane0_Xr2_clkb vss vss sky130_fd_pr__nfet_01v8_lvt w=1.2 l=0.15
X144 t_Xser_Xlane0_Xr2_clki t_Xser_Xlane0_Xr2_clkb vdd vdd sky130_fd_pr__pfet_01v8 w=2.4 l=0.15
X145 din8 t_Xser_Xlane0_Xr2_clkb t_Xser_Xlane0_Xr2_m1 vss sky130_fd_pr__nfet_01v8_lvt w=0.8 l=0.15
X146 din8 t_Xser_Xlane0_Xr2_clki t_Xser_Xlane0_Xr2_m1 vdd sky130_fd_pr__pfet_01v8 w=1.6 l=0.15
X147 t_Xser_Xlane0_Xr2_m2 t_Xser_Xlane0_Xr2_m1 t_Xser_Xlane0_Xr2_Xm2_mid vss sky130_fd_pr__nfet_01v8_lvt w=1.2 l=0.15
X148 t_Xser_Xlane0_Xr2_Xm2_mid rst_n vss vss sky130_fd_pr__nfet_01v8_lvt w=1.2 l=0.15
X149 t_Xser_Xlane0_Xr2_m2 t_Xser_Xlane0_Xr2_m1 vdd vdd sky130_fd_pr__pfet_01v8 w=1.6 l=0.15
X150 t_Xser_Xlane0_Xr2_m2 rst_n vdd vdd sky130_fd_pr__pfet_01v8 w=1.6 l=0.15
X151 t_Xser_Xlane0_Xr2_m3 t_Xser_Xlane0_Xr2_m2 vss vss sky130_fd_pr__nfet_01v8_lvt w=0.8 l=0.15
X152 t_Xser_Xlane0_Xr2_m3 t_Xser_Xlane0_Xr2_m2 vdd vdd sky130_fd_pr__pfet_01v8 w=1.6 l=0.15
X153 t_Xser_Xlane0_Xr2_m3 t_Xser_Xlane0_Xr2_clki t_Xser_Xlane0_Xr2_m1 vss sky130_fd_pr__nfet_01v8_lvt w=0.8 l=0.15
X154 t_Xser_Xlane0_Xr2_m3 t_Xser_Xlane0_Xr2_clkb t_Xser_Xlane0_Xr2_m1 vdd sky130_fd_pr__pfet_01v8 w=1.6 l=0.15
X155 t_Xser_Xlane0_Xr2_m2 t_Xser_Xlane0_Xr2_clki t_Xser_Xlane0_Xr2_s1 vss sky130_fd_pr__nfet_01v8_lvt w=0.8 l=0.15
X156 t_Xser_Xlane0_Xr2_m2 t_Xser_Xlane0_Xr2_clkb t_Xser_Xlane0_Xr2_s1 vdd sky130_fd_pr__pfet_01v8 w=1.6 l=0.15
X157 t_Xser_Xlane0_Xr2_qi t_Xser_Xlane0_Xr2_s1 vss vss sky130_fd_pr__nfet_01v8_lvt w=0.96 l=0.15
X158 t_Xser_Xlane0_Xr2_qi t_Xser_Xlane0_Xr2_s1 vdd vdd sky130_fd_pr__pfet_01v8 w=1.92 l=0.15
X159 t_Xser_Xlane0_Xr2_s2 t_Xser_Xlane0_Xr2_qi t_Xser_Xlane0_Xr2_Xsfb_mid vss sky130_fd_pr__nfet_01v8_lvt w=1.2 l=0.15
X160 t_Xser_Xlane0_Xr2_Xsfb_mid rst_n vss vss sky130_fd_pr__nfet_01v8_lvt w=1.2 l=0.15
X161 t_Xser_Xlane0_Xr2_s2 t_Xser_Xlane0_Xr2_qi vdd vdd sky130_fd_pr__pfet_01v8 w=1.6 l=0.15
X162 t_Xser_Xlane0_Xr2_s2 rst_n vdd vdd sky130_fd_pr__pfet_01v8 w=1.6 l=0.15
X163 t_Xser_Xlane0_Xr2_s2 t_Xser_Xlane0_Xr2_clkb t_Xser_Xlane0_Xr2_s1 vss sky130_fd_pr__nfet_01v8_lvt w=0.8 l=0.15
X164 t_Xser_Xlane0_Xr2_s2 t_Xser_Xlane0_Xr2_clki t_Xser_Xlane0_Xr2_s1 vdd sky130_fd_pr__pfet_01v8 w=1.6 l=0.15
X165 t_Xser_Xlane0_r2 t_Xser_Xlane0_Xr2_s1 vss vss sky130_fd_pr__nfet_01v8_lvt w=1.2 l=0.15
X166 t_Xser_Xlane0_r2 t_Xser_Xlane0_Xr2_s1 vdd vdd sky130_fd_pr__pfet_01v8 w=2.4 l=0.15
X167 t_Xser_Xlane0_r2b t_Xser_Xlane0_Xr2_qi vss vss sky130_fd_pr__nfet_01v8_lvt w=1.2 l=0.15
X168 t_Xser_Xlane0_r2b t_Xser_Xlane0_Xr2_qi vdd vdd sky130_fd_pr__pfet_01v8 w=2.4 l=0.15
X169 t_Xser_Xlane0_Xr3_m_clkb t_Xser_clk250b vss vss sky130_fd_pr__nfet_01v8_lvt w=1.2 l=0.15
X170 t_Xser_Xlane0_Xr3_m_clkb t_Xser_clk250b vdd vdd sky130_fd_pr__pfet_01v8 w=2.4 l=0.15
X171 t_Xser_Xlane0_Xr3_m_clki t_Xser_Xlane0_Xr3_m_clkb vss vss sky130_fd_pr__nfet_01v8_lvt w=1.2 l=0.15
X172 t_Xser_Xlane0_Xr3_m_clki t_Xser_Xlane0_Xr3_m_clkb vdd vdd sky130_fd_pr__pfet_01v8 w=2.4 l=0.15
X173 din12 t_Xser_Xlane0_Xr3_m_clkb t_Xser_Xlane0_Xr3_m_m1 vss sky130_fd_pr__nfet_01v8_lvt w=0.8 l=0.15
X174 din12 t_Xser_Xlane0_Xr3_m_clki t_Xser_Xlane0_Xr3_m_m1 vdd sky130_fd_pr__pfet_01v8 w=1.6 l=0.15
X175 t_Xser_Xlane0_Xr3_m_m2 t_Xser_Xlane0_Xr3_m_m1 t_Xser_Xlane0_Xr3_m_Xm2_mid vss sky130_fd_pr__nfet_01v8_lvt w=1.2 l=0.15
X176 t_Xser_Xlane0_Xr3_m_Xm2_mid rst_n vss vss sky130_fd_pr__nfet_01v8_lvt w=1.2 l=0.15
X177 t_Xser_Xlane0_Xr3_m_m2 t_Xser_Xlane0_Xr3_m_m1 vdd vdd sky130_fd_pr__pfet_01v8 w=1.6 l=0.15
X178 t_Xser_Xlane0_Xr3_m_m2 rst_n vdd vdd sky130_fd_pr__pfet_01v8 w=1.6 l=0.15
X179 t_Xser_Xlane0_Xr3_m_m3 t_Xser_Xlane0_Xr3_m_m2 vss vss sky130_fd_pr__nfet_01v8_lvt w=0.8 l=0.15
X180 t_Xser_Xlane0_Xr3_m_m3 t_Xser_Xlane0_Xr3_m_m2 vdd vdd sky130_fd_pr__pfet_01v8 w=1.6 l=0.15
X181 t_Xser_Xlane0_Xr3_m_m3 t_Xser_Xlane0_Xr3_m_clki t_Xser_Xlane0_Xr3_m_m1 vss sky130_fd_pr__nfet_01v8_lvt w=0.8 l=0.15
X182 t_Xser_Xlane0_Xr3_m_m3 t_Xser_Xlane0_Xr3_m_clkb t_Xser_Xlane0_Xr3_m_m1 vdd sky130_fd_pr__pfet_01v8 w=1.6 l=0.15
X183 t_Xser_Xlane0_Xr3_m_m2 t_Xser_Xlane0_Xr3_m_clki t_Xser_Xlane0_Xr3_m_s1 vss sky130_fd_pr__nfet_01v8_lvt w=0.8 l=0.15
X184 t_Xser_Xlane0_Xr3_m_m2 t_Xser_Xlane0_Xr3_m_clkb t_Xser_Xlane0_Xr3_m_s1 vdd sky130_fd_pr__pfet_01v8 w=1.6 l=0.15
X185 t_Xser_Xlane0_Xr3_m_qi t_Xser_Xlane0_Xr3_m_s1 vss vss sky130_fd_pr__nfet_01v8_lvt w=0.96 l=0.15
X186 t_Xser_Xlane0_Xr3_m_qi t_Xser_Xlane0_Xr3_m_s1 vdd vdd sky130_fd_pr__pfet_01v8 w=1.92 l=0.15
X187 t_Xser_Xlane0_Xr3_m_s2 t_Xser_Xlane0_Xr3_m_qi t_Xser_Xlane0_Xr3_m_Xsfb_mid vss sky130_fd_pr__nfet_01v8_lvt w=1.2 l=0.15
X188 t_Xser_Xlane0_Xr3_m_Xsfb_mid rst_n vss vss sky130_fd_pr__nfet_01v8_lvt w=1.2 l=0.15
X189 t_Xser_Xlane0_Xr3_m_s2 t_Xser_Xlane0_Xr3_m_qi vdd vdd sky130_fd_pr__pfet_01v8 w=1.6 l=0.15
X190 t_Xser_Xlane0_Xr3_m_s2 rst_n vdd vdd sky130_fd_pr__pfet_01v8 w=1.6 l=0.15
X191 t_Xser_Xlane0_Xr3_m_s2 t_Xser_Xlane0_Xr3_m_clkb t_Xser_Xlane0_Xr3_m_s1 vss sky130_fd_pr__nfet_01v8_lvt w=0.8 l=0.15
X192 t_Xser_Xlane0_Xr3_m_s2 t_Xser_Xlane0_Xr3_m_clki t_Xser_Xlane0_Xr3_m_s1 vdd sky130_fd_pr__pfet_01v8 w=1.6 l=0.15
X193 t_Xser_Xlane0_r3_m t_Xser_Xlane0_Xr3_m_s1 vss vss sky130_fd_pr__nfet_01v8_lvt w=1.2 l=0.15
X194 t_Xser_Xlane0_r3_m t_Xser_Xlane0_Xr3_m_s1 vdd vdd sky130_fd_pr__pfet_01v8 w=2.4 l=0.15
X195 t_Xser_Xlane0_r3_mb t_Xser_Xlane0_Xr3_m_qi vss vss sky130_fd_pr__nfet_01v8_lvt w=1.2 l=0.15
X196 t_Xser_Xlane0_r3_mb t_Xser_Xlane0_Xr3_m_qi vdd vdd sky130_fd_pr__pfet_01v8 w=2.4 l=0.15
X197 t_Xser_Xlane0_Xr3_clkb t_Xser_clk250 vss vss sky130_fd_pr__nfet_01v8_lvt w=1.2 l=0.15
X198 t_Xser_Xlane0_Xr3_clkb t_Xser_clk250 vdd vdd sky130_fd_pr__pfet_01v8 w=2.4 l=0.15
X199 t_Xser_Xlane0_Xr3_clki t_Xser_Xlane0_Xr3_clkb vss vss sky130_fd_pr__nfet_01v8_lvt w=1.2 l=0.15
X200 t_Xser_Xlane0_Xr3_clki t_Xser_Xlane0_Xr3_clkb vdd vdd sky130_fd_pr__pfet_01v8 w=2.4 l=0.15
X201 t_Xser_Xlane0_r3_m t_Xser_Xlane0_Xr3_clkb t_Xser_Xlane0_Xr3_m1 vss sky130_fd_pr__nfet_01v8_lvt w=0.8 l=0.15
X202 t_Xser_Xlane0_r3_m t_Xser_Xlane0_Xr3_clki t_Xser_Xlane0_Xr3_m1 vdd sky130_fd_pr__pfet_01v8 w=1.6 l=0.15
X203 t_Xser_Xlane0_Xr3_m2 t_Xser_Xlane0_Xr3_m1 t_Xser_Xlane0_Xr3_Xm2_mid vss sky130_fd_pr__nfet_01v8_lvt w=1.2 l=0.15
X204 t_Xser_Xlane0_Xr3_Xm2_mid rst_n vss vss sky130_fd_pr__nfet_01v8_lvt w=1.2 l=0.15
X205 t_Xser_Xlane0_Xr3_m2 t_Xser_Xlane0_Xr3_m1 vdd vdd sky130_fd_pr__pfet_01v8 w=1.6 l=0.15
X206 t_Xser_Xlane0_Xr3_m2 rst_n vdd vdd sky130_fd_pr__pfet_01v8 w=1.6 l=0.15
X207 t_Xser_Xlane0_Xr3_m3 t_Xser_Xlane0_Xr3_m2 vss vss sky130_fd_pr__nfet_01v8_lvt w=0.8 l=0.15
X208 t_Xser_Xlane0_Xr3_m3 t_Xser_Xlane0_Xr3_m2 vdd vdd sky130_fd_pr__pfet_01v8 w=1.6 l=0.15
X209 t_Xser_Xlane0_Xr3_m3 t_Xser_Xlane0_Xr3_clki t_Xser_Xlane0_Xr3_m1 vss sky130_fd_pr__nfet_01v8_lvt w=0.8 l=0.15
X210 t_Xser_Xlane0_Xr3_m3 t_Xser_Xlane0_Xr3_clkb t_Xser_Xlane0_Xr3_m1 vdd sky130_fd_pr__pfet_01v8 w=1.6 l=0.15
X211 t_Xser_Xlane0_Xr3_m2 t_Xser_Xlane0_Xr3_clki t_Xser_Xlane0_Xr3_s1 vss sky130_fd_pr__nfet_01v8_lvt w=0.8 l=0.15
X212 t_Xser_Xlane0_Xr3_m2 t_Xser_Xlane0_Xr3_clkb t_Xser_Xlane0_Xr3_s1 vdd sky130_fd_pr__pfet_01v8 w=1.6 l=0.15
X213 t_Xser_Xlane0_Xr3_qi t_Xser_Xlane0_Xr3_s1 vss vss sky130_fd_pr__nfet_01v8_lvt w=0.96 l=0.15
X214 t_Xser_Xlane0_Xr3_qi t_Xser_Xlane0_Xr3_s1 vdd vdd sky130_fd_pr__pfet_01v8 w=1.92 l=0.15
X215 t_Xser_Xlane0_Xr3_s2 t_Xser_Xlane0_Xr3_qi t_Xser_Xlane0_Xr3_Xsfb_mid vss sky130_fd_pr__nfet_01v8_lvt w=1.2 l=0.15
X216 t_Xser_Xlane0_Xr3_Xsfb_mid rst_n vss vss sky130_fd_pr__nfet_01v8_lvt w=1.2 l=0.15
X217 t_Xser_Xlane0_Xr3_s2 t_Xser_Xlane0_Xr3_qi vdd vdd sky130_fd_pr__pfet_01v8 w=1.6 l=0.15
X218 t_Xser_Xlane0_Xr3_s2 rst_n vdd vdd sky130_fd_pr__pfet_01v8 w=1.6 l=0.15
X219 t_Xser_Xlane0_Xr3_s2 t_Xser_Xlane0_Xr3_clkb t_Xser_Xlane0_Xr3_s1 vss sky130_fd_pr__nfet_01v8_lvt w=0.8 l=0.15
X220 t_Xser_Xlane0_Xr3_s2 t_Xser_Xlane0_Xr3_clki t_Xser_Xlane0_Xr3_s1 vdd sky130_fd_pr__pfet_01v8 w=1.6 l=0.15
X221 t_Xser_Xlane0_r3 t_Xser_Xlane0_Xr3_s1 vss vss sky130_fd_pr__nfet_01v8_lvt w=1.2 l=0.15
X222 t_Xser_Xlane0_r3 t_Xser_Xlane0_Xr3_s1 vdd vdd sky130_fd_pr__pfet_01v8 w=2.4 l=0.15
X223 t_Xser_Xlane0_r3b t_Xser_Xlane0_Xr3_qi vss vss sky130_fd_pr__nfet_01v8_lvt w=1.2 l=0.15
X224 t_Xser_Xlane0_r3b t_Xser_Xlane0_Xr3_qi vdd vdd sky130_fd_pr__pfet_01v8 w=2.4 l=0.15
X225 t_Xser_Xlane0_r2 t_Xser_clk250 t_Xser_Xlane0_Xma_mid vss sky130_fd_pr__nfet_01v8_lvt w=0.9 l=0.15
X226 t_Xser_Xlane0_r2 t_Xser_clk250b t_Xser_Xlane0_Xma_mid vdd sky130_fd_pr__pfet_01v8 w=1.8 l=0.15
X227 t_Xser_Xlane0_r0 t_Xser_clk250b t_Xser_Xlane0_Xma_mid vss sky130_fd_pr__nfet_01v8_lvt w=0.9 l=0.15
X228 t_Xser_Xlane0_r0 t_Xser_clk250 t_Xser_Xlane0_Xma_mid vdd sky130_fd_pr__pfet_01v8 w=1.8 l=0.15
X229 t_Xser_Xlane0_Xma_yb t_Xser_Xlane0_Xma_mid vss vss sky130_fd_pr__nfet_01v8_lvt w=0.9 l=0.15
X230 t_Xser_Xlane0_Xma_yb t_Xser_Xlane0_Xma_mid vdd vdd sky130_fd_pr__pfet_01v8 w=1.8 l=0.15
X231 t_Xser_Xlane0_ma t_Xser_Xlane0_Xma_yb vss vss sky130_fd_pr__nfet_01v8_lvt w=0.9 l=0.15
X232 t_Xser_Xlane0_ma t_Xser_Xlane0_Xma_yb vdd vdd sky130_fd_pr__pfet_01v8 w=1.8 l=0.15
X233 t_Xser_Xlane0_r1 t_Xser_clk250 t_Xser_Xlane0_Xmb_mid vss sky130_fd_pr__nfet_01v8_lvt w=0.9 l=0.15
X234 t_Xser_Xlane0_r1 t_Xser_clk250b t_Xser_Xlane0_Xmb_mid vdd sky130_fd_pr__pfet_01v8 w=1.8 l=0.15
X235 t_Xser_Xlane0_r3 t_Xser_clk250b t_Xser_Xlane0_Xmb_mid vss sky130_fd_pr__nfet_01v8_lvt w=0.9 l=0.15
X236 t_Xser_Xlane0_r3 t_Xser_clk250 t_Xser_Xlane0_Xmb_mid vdd sky130_fd_pr__pfet_01v8 w=1.8 l=0.15
X237 t_Xser_Xlane0_Xmb_yb t_Xser_Xlane0_Xmb_mid vss vss sky130_fd_pr__nfet_01v8_lvt w=0.9 l=0.15
X238 t_Xser_Xlane0_Xmb_yb t_Xser_Xlane0_Xmb_mid vdd vdd sky130_fd_pr__pfet_01v8 w=1.8 l=0.15
X239 t_Xser_Xlane0_mb t_Xser_Xlane0_Xmb_yb vss vss sky130_fd_pr__nfet_01v8_lvt w=0.9 l=0.15
X240 t_Xser_Xlane0_mb t_Xser_Xlane0_Xmb_yb vdd vdd sky130_fd_pr__pfet_01v8 w=1.8 l=0.15
X241 t_Xser_Xlane0_Xda_clkb t_Xser_clk500 vss vss sky130_fd_pr__nfet_01v8_lvt w=1.2 l=0.15
X242 t_Xser_Xlane0_Xda_clkb t_Xser_clk500 vdd vdd sky130_fd_pr__pfet_01v8 w=2.4 l=0.15
X243 t_Xser_Xlane0_Xda_clki t_Xser_Xlane0_Xda_clkb vss vss sky130_fd_pr__nfet_01v8_lvt w=1.2 l=0.15
X244 t_Xser_Xlane0_Xda_clki t_Xser_Xlane0_Xda_clkb vdd vdd sky130_fd_pr__pfet_01v8 w=2.4 l=0.15
X245 t_Xser_Xlane0_ma t_Xser_Xlane0_Xda_clkb t_Xser_Xlane0_Xda_m1 vss sky130_fd_pr__nfet_01v8_lvt w=1.2 l=0.15
X246 t_Xser_Xlane0_ma t_Xser_Xlane0_Xda_clki t_Xser_Xlane0_Xda_m1 vdd sky130_fd_pr__pfet_01v8 w=2.4 l=0.15
X247 t_Xser_Xlane0_Xda_m2 t_Xser_Xlane0_Xda_m1 t_Xser_Xlane0_Xda_Xm2_mid vss sky130_fd_pr__nfet_01v8_lvt w=1.8 l=0.15
X248 t_Xser_Xlane0_Xda_Xm2_mid rst_n vss vss sky130_fd_pr__nfet_01v8_lvt w=1.8 l=0.15
X249 t_Xser_Xlane0_Xda_m2 t_Xser_Xlane0_Xda_m1 vdd vdd sky130_fd_pr__pfet_01v8 w=2.4 l=0.15
X250 t_Xser_Xlane0_Xda_m2 rst_n vdd vdd sky130_fd_pr__pfet_01v8 w=2.4 l=0.15
X251 t_Xser_Xlane0_Xda_m3 t_Xser_Xlane0_Xda_m2 vss vss sky130_fd_pr__nfet_01v8_lvt w=0.8 l=0.15
X252 t_Xser_Xlane0_Xda_m3 t_Xser_Xlane0_Xda_m2 vdd vdd sky130_fd_pr__pfet_01v8 w=1.6 l=0.15
X253 t_Xser_Xlane0_Xda_m3 t_Xser_Xlane0_Xda_clki t_Xser_Xlane0_Xda_m1 vss sky130_fd_pr__nfet_01v8_lvt w=0.8 l=0.15
X254 t_Xser_Xlane0_Xda_m3 t_Xser_Xlane0_Xda_clkb t_Xser_Xlane0_Xda_m1 vdd sky130_fd_pr__pfet_01v8 w=1.6 l=0.15
X255 t_Xser_Xlane0_Xda_m2 t_Xser_Xlane0_Xda_clki t_Xser_Xlane0_Xda_s1 vss sky130_fd_pr__nfet_01v8_lvt w=1.2 l=0.15
X256 t_Xser_Xlane0_Xda_m2 t_Xser_Xlane0_Xda_clkb t_Xser_Xlane0_Xda_s1 vdd sky130_fd_pr__pfet_01v8 w=2.4 l=0.15
X257 t_Xser_Xlane0_Xda_qi t_Xser_Xlane0_Xda_s1 vss vss sky130_fd_pr__nfet_01v8_lvt w=1.44 l=0.15
X258 t_Xser_Xlane0_Xda_qi t_Xser_Xlane0_Xda_s1 vdd vdd sky130_fd_pr__pfet_01v8 w=2.88 l=0.15
X259 t_Xser_Xlane0_Xda_s2 t_Xser_Xlane0_Xda_qi t_Xser_Xlane0_Xda_Xsfb_mid vss sky130_fd_pr__nfet_01v8_lvt w=1.2 l=0.15
X260 t_Xser_Xlane0_Xda_Xsfb_mid rst_n vss vss sky130_fd_pr__nfet_01v8_lvt w=1.2 l=0.15
X261 t_Xser_Xlane0_Xda_s2 t_Xser_Xlane0_Xda_qi vdd vdd sky130_fd_pr__pfet_01v8 w=1.6 l=0.15
X262 t_Xser_Xlane0_Xda_s2 rst_n vdd vdd sky130_fd_pr__pfet_01v8 w=1.6 l=0.15
X263 t_Xser_Xlane0_Xda_s2 t_Xser_Xlane0_Xda_clkb t_Xser_Xlane0_Xda_s1 vss sky130_fd_pr__nfet_01v8_lvt w=0.8 l=0.15
X264 t_Xser_Xlane0_Xda_s2 t_Xser_Xlane0_Xda_clki t_Xser_Xlane0_Xda_s1 vdd sky130_fd_pr__pfet_01v8 w=1.6 l=0.15
X265 t_Xser_Xlane0_da t_Xser_Xlane0_Xda_s1 vss vss sky130_fd_pr__nfet_01v8_lvt w=1.8 l=0.15
X266 t_Xser_Xlane0_da t_Xser_Xlane0_Xda_s1 vdd vdd sky130_fd_pr__pfet_01v8 w=3.6 l=0.15
X267 t_Xser_Xlane0_dab t_Xser_Xlane0_Xda_qi vss vss sky130_fd_pr__nfet_01v8_lvt w=1.8 l=0.15
X268 t_Xser_Xlane0_dab t_Xser_Xlane0_Xda_qi vdd vdd sky130_fd_pr__pfet_01v8 w=3.6 l=0.15
X269 t_Xser_Xlane0_Xdb_clkb t_Xser_clk500b vss vss sky130_fd_pr__nfet_01v8_lvt w=1.2 l=0.15
X270 t_Xser_Xlane0_Xdb_clkb t_Xser_clk500b vdd vdd sky130_fd_pr__pfet_01v8 w=2.4 l=0.15
X271 t_Xser_Xlane0_Xdb_clki t_Xser_Xlane0_Xdb_clkb vss vss sky130_fd_pr__nfet_01v8_lvt w=1.2 l=0.15
X272 t_Xser_Xlane0_Xdb_clki t_Xser_Xlane0_Xdb_clkb vdd vdd sky130_fd_pr__pfet_01v8 w=2.4 l=0.15
X273 t_Xser_Xlane0_mb t_Xser_Xlane0_Xdb_clkb t_Xser_Xlane0_Xdb_m1 vss sky130_fd_pr__nfet_01v8_lvt w=1.2 l=0.15
X274 t_Xser_Xlane0_mb t_Xser_Xlane0_Xdb_clki t_Xser_Xlane0_Xdb_m1 vdd sky130_fd_pr__pfet_01v8 w=2.4 l=0.15
X275 t_Xser_Xlane0_Xdb_m2 t_Xser_Xlane0_Xdb_m1 t_Xser_Xlane0_Xdb_Xm2_mid vss sky130_fd_pr__nfet_01v8_lvt w=1.8 l=0.15
X276 t_Xser_Xlane0_Xdb_Xm2_mid rst_n vss vss sky130_fd_pr__nfet_01v8_lvt w=1.8 l=0.15
X277 t_Xser_Xlane0_Xdb_m2 t_Xser_Xlane0_Xdb_m1 vdd vdd sky130_fd_pr__pfet_01v8 w=2.4 l=0.15
X278 t_Xser_Xlane0_Xdb_m2 rst_n vdd vdd sky130_fd_pr__pfet_01v8 w=2.4 l=0.15
X279 t_Xser_Xlane0_Xdb_m3 t_Xser_Xlane0_Xdb_m2 vss vss sky130_fd_pr__nfet_01v8_lvt w=0.8 l=0.15
X280 t_Xser_Xlane0_Xdb_m3 t_Xser_Xlane0_Xdb_m2 vdd vdd sky130_fd_pr__pfet_01v8 w=1.6 l=0.15
X281 t_Xser_Xlane0_Xdb_m3 t_Xser_Xlane0_Xdb_clki t_Xser_Xlane0_Xdb_m1 vss sky130_fd_pr__nfet_01v8_lvt w=0.8 l=0.15
X282 t_Xser_Xlane0_Xdb_m3 t_Xser_Xlane0_Xdb_clkb t_Xser_Xlane0_Xdb_m1 vdd sky130_fd_pr__pfet_01v8 w=1.6 l=0.15
X283 t_Xser_Xlane0_Xdb_m2 t_Xser_Xlane0_Xdb_clki t_Xser_Xlane0_Xdb_s1 vss sky130_fd_pr__nfet_01v8_lvt w=1.2 l=0.15
X284 t_Xser_Xlane0_Xdb_m2 t_Xser_Xlane0_Xdb_clkb t_Xser_Xlane0_Xdb_s1 vdd sky130_fd_pr__pfet_01v8 w=2.4 l=0.15
X285 t_Xser_Xlane0_Xdb_qi t_Xser_Xlane0_Xdb_s1 vss vss sky130_fd_pr__nfet_01v8_lvt w=1.44 l=0.15
X286 t_Xser_Xlane0_Xdb_qi t_Xser_Xlane0_Xdb_s1 vdd vdd sky130_fd_pr__pfet_01v8 w=2.88 l=0.15
X287 t_Xser_Xlane0_Xdb_s2 t_Xser_Xlane0_Xdb_qi t_Xser_Xlane0_Xdb_Xsfb_mid vss sky130_fd_pr__nfet_01v8_lvt w=1.2 l=0.15
X288 t_Xser_Xlane0_Xdb_Xsfb_mid rst_n vss vss sky130_fd_pr__nfet_01v8_lvt w=1.2 l=0.15
X289 t_Xser_Xlane0_Xdb_s2 t_Xser_Xlane0_Xdb_qi vdd vdd sky130_fd_pr__pfet_01v8 w=1.6 l=0.15
X290 t_Xser_Xlane0_Xdb_s2 rst_n vdd vdd sky130_fd_pr__pfet_01v8 w=1.6 l=0.15
X291 t_Xser_Xlane0_Xdb_s2 t_Xser_Xlane0_Xdb_clkb t_Xser_Xlane0_Xdb_s1 vss sky130_fd_pr__nfet_01v8_lvt w=0.8 l=0.15
X292 t_Xser_Xlane0_Xdb_s2 t_Xser_Xlane0_Xdb_clki t_Xser_Xlane0_Xdb_s1 vdd sky130_fd_pr__pfet_01v8 w=1.6 l=0.15
X293 t_Xser_Xlane0_db t_Xser_Xlane0_Xdb_s1 vss vss sky130_fd_pr__nfet_01v8_lvt w=1.8 l=0.15
X294 t_Xser_Xlane0_db t_Xser_Xlane0_Xdb_s1 vdd vdd sky130_fd_pr__pfet_01v8 w=3.6 l=0.15
X295 t_Xser_Xlane0_dbb t_Xser_Xlane0_Xdb_qi vss vss sky130_fd_pr__nfet_01v8_lvt w=1.8 l=0.15
X296 t_Xser_Xlane0_dbb t_Xser_Xlane0_Xdb_qi vdd vdd sky130_fd_pr__pfet_01v8 w=3.6 l=0.15
X297 t_Xser_Xlane0_da t_Xser_clk500b t_Xser_Xlane0_Xmc_mid vss sky130_fd_pr__nfet_01v8_lvt w=1.5 l=0.15
X298 t_Xser_Xlane0_da t_Xser_clk500 t_Xser_Xlane0_Xmc_mid vdd sky130_fd_pr__pfet_01v8 w=3 l=0.15
X299 t_Xser_Xlane0_db t_Xser_clk500 t_Xser_Xlane0_Xmc_mid vss sky130_fd_pr__nfet_01v8_lvt w=1.5 l=0.15
X300 t_Xser_Xlane0_db t_Xser_clk500b t_Xser_Xlane0_Xmc_mid vdd sky130_fd_pr__pfet_01v8 w=3 l=0.15
X301 t_Xser_Xlane0_Xmc_yb t_Xser_Xlane0_Xmc_mid vss vss sky130_fd_pr__nfet_01v8_lvt w=1.5 l=0.15
X302 t_Xser_Xlane0_Xmc_yb t_Xser_Xlane0_Xmc_mid vdd vdd sky130_fd_pr__pfet_01v8 w=3 l=0.15
X303 t_Xser_Xlane0_mc t_Xser_Xlane0_Xmc_yb vss vss sky130_fd_pr__nfet_01v8_lvt w=1.5 l=0.15
X304 t_Xser_Xlane0_mc t_Xser_Xlane0_Xmc_yb vdd vdd sky130_fd_pr__pfet_01v8 w=3 l=0.15
X305 t_Xser_Xlane0_Xd1g_clkb t_Xser_c0 vss vss sky130_fd_pr__nfet_01v8_lvt w=1.2 l=0.15
X306 t_Xser_Xlane0_Xd1g_clkb t_Xser_c0 vdd vdd sky130_fd_pr__pfet_01v8 w=2.4 l=0.15
X307 t_Xser_Xlane0_Xd1g_clki t_Xser_Xlane0_Xd1g_clkb vss vss sky130_fd_pr__nfet_01v8_lvt w=1.2 l=0.15
X308 t_Xser_Xlane0_Xd1g_clki t_Xser_Xlane0_Xd1g_clkb vdd vdd sky130_fd_pr__pfet_01v8 w=2.4 l=0.15
X309 t_Xser_Xlane0_mc t_Xser_Xlane0_Xd1g_clkb t_Xser_Xlane0_Xd1g_m1 vss sky130_fd_pr__nfet_01v8_lvt w=1.5 l=0.15
X310 t_Xser_Xlane0_mc t_Xser_Xlane0_Xd1g_clki t_Xser_Xlane0_Xd1g_m1 vdd sky130_fd_pr__pfet_01v8 w=3 l=0.15
X311 t_Xser_Xlane0_Xd1g_m2 t_Xser_Xlane0_Xd1g_m1 t_Xser_Xlane0_Xd1g_Xm2_mid vss sky130_fd_pr__nfet_01v8_lvt w=2.25 l=0.15
X312 t_Xser_Xlane0_Xd1g_Xm2_mid rst_n vss vss sky130_fd_pr__nfet_01v8_lvt w=2.25 l=0.15
X313 t_Xser_Xlane0_Xd1g_m2 t_Xser_Xlane0_Xd1g_m1 vdd vdd sky130_fd_pr__pfet_01v8 w=3 l=0.15
X314 t_Xser_Xlane0_Xd1g_m2 rst_n vdd vdd sky130_fd_pr__pfet_01v8 w=3 l=0.15
X315 t_Xser_Xlane0_Xd1g_m3 t_Xser_Xlane0_Xd1g_m2 vss vss sky130_fd_pr__nfet_01v8_lvt w=0.8 l=0.15
X316 t_Xser_Xlane0_Xd1g_m3 t_Xser_Xlane0_Xd1g_m2 vdd vdd sky130_fd_pr__pfet_01v8 w=1.6 l=0.15
X317 t_Xser_Xlane0_Xd1g_m3 t_Xser_Xlane0_Xd1g_clki t_Xser_Xlane0_Xd1g_m1 vss sky130_fd_pr__nfet_01v8_lvt w=0.8 l=0.15
X318 t_Xser_Xlane0_Xd1g_m3 t_Xser_Xlane0_Xd1g_clkb t_Xser_Xlane0_Xd1g_m1 vdd sky130_fd_pr__pfet_01v8 w=1.6 l=0.15
X319 t_Xser_Xlane0_Xd1g_m2 t_Xser_Xlane0_Xd1g_clki t_Xser_Xlane0_Xd1g_s1 vss sky130_fd_pr__nfet_01v8_lvt w=1.5 l=0.15
X320 t_Xser_Xlane0_Xd1g_m2 t_Xser_Xlane0_Xd1g_clkb t_Xser_Xlane0_Xd1g_s1 vdd sky130_fd_pr__pfet_01v8 w=3 l=0.15
X321 t_Xser_Xlane0_Xd1g_qi t_Xser_Xlane0_Xd1g_s1 vss vss sky130_fd_pr__nfet_01v8_lvt w=1.8 l=0.15
X322 t_Xser_Xlane0_Xd1g_qi t_Xser_Xlane0_Xd1g_s1 vdd vdd sky130_fd_pr__pfet_01v8 w=3.6 l=0.15
X323 t_Xser_Xlane0_Xd1g_s2 t_Xser_Xlane0_Xd1g_qi t_Xser_Xlane0_Xd1g_Xsfb_mid vss sky130_fd_pr__nfet_01v8_lvt w=1.2 l=0.15
X324 t_Xser_Xlane0_Xd1g_Xsfb_mid rst_n vss vss sky130_fd_pr__nfet_01v8_lvt w=1.2 l=0.15
X325 t_Xser_Xlane0_Xd1g_s2 t_Xser_Xlane0_Xd1g_qi vdd vdd sky130_fd_pr__pfet_01v8 w=1.6 l=0.15
X326 t_Xser_Xlane0_Xd1g_s2 rst_n vdd vdd sky130_fd_pr__pfet_01v8 w=1.6 l=0.15
X327 t_Xser_Xlane0_Xd1g_s2 t_Xser_Xlane0_Xd1g_clkb t_Xser_Xlane0_Xd1g_s1 vss sky130_fd_pr__nfet_01v8_lvt w=0.8 l=0.15
X328 t_Xser_Xlane0_Xd1g_s2 t_Xser_Xlane0_Xd1g_clki t_Xser_Xlane0_Xd1g_s1 vdd sky130_fd_pr__pfet_01v8 w=1.6 l=0.15
X329 t_Xser_l0 t_Xser_Xlane0_Xd1g_s1 vss vss sky130_fd_pr__nfet_01v8_lvt w=2.25 l=0.15
X330 t_Xser_l0 t_Xser_Xlane0_Xd1g_s1 vdd vdd sky130_fd_pr__pfet_01v8 w=4.5 l=0.15
X331 t_Xser_Xlane0_l_outb t_Xser_Xlane0_Xd1g_qi vss vss sky130_fd_pr__nfet_01v8_lvt w=2.25 l=0.15
X332 t_Xser_Xlane0_l_outb t_Xser_Xlane0_Xd1g_qi vdd vdd sky130_fd_pr__pfet_01v8 w=4.5 l=0.15
X333 t_Xser_Xlane1_Xr0_clkb t_Xser_clk250b vss vss sky130_fd_pr__nfet_01v8_lvt w=1.2 l=0.15
X334 t_Xser_Xlane1_Xr0_clkb t_Xser_clk250b vdd vdd sky130_fd_pr__pfet_01v8 w=2.4 l=0.15
X335 t_Xser_Xlane1_Xr0_clki t_Xser_Xlane1_Xr0_clkb vss vss sky130_fd_pr__nfet_01v8_lvt w=1.2 l=0.15
X336 t_Xser_Xlane1_Xr0_clki t_Xser_Xlane1_Xr0_clkb vdd vdd sky130_fd_pr__pfet_01v8 w=2.4 l=0.15
X337 din1 t_Xser_Xlane1_Xr0_clkb t_Xser_Xlane1_Xr0_m1 vss sky130_fd_pr__nfet_01v8_lvt w=0.8 l=0.15
X338 din1 t_Xser_Xlane1_Xr0_clki t_Xser_Xlane1_Xr0_m1 vdd sky130_fd_pr__pfet_01v8 w=1.6 l=0.15
X339 t_Xser_Xlane1_Xr0_m2 t_Xser_Xlane1_Xr0_m1 t_Xser_Xlane1_Xr0_Xm2_mid vss sky130_fd_pr__nfet_01v8_lvt w=1.2 l=0.15
X340 t_Xser_Xlane1_Xr0_Xm2_mid rst_n vss vss sky130_fd_pr__nfet_01v8_lvt w=1.2 l=0.15
X341 t_Xser_Xlane1_Xr0_m2 t_Xser_Xlane1_Xr0_m1 vdd vdd sky130_fd_pr__pfet_01v8 w=1.6 l=0.15
X342 t_Xser_Xlane1_Xr0_m2 rst_n vdd vdd sky130_fd_pr__pfet_01v8 w=1.6 l=0.15
X343 t_Xser_Xlane1_Xr0_m3 t_Xser_Xlane1_Xr0_m2 vss vss sky130_fd_pr__nfet_01v8_lvt w=0.8 l=0.15
X344 t_Xser_Xlane1_Xr0_m3 t_Xser_Xlane1_Xr0_m2 vdd vdd sky130_fd_pr__pfet_01v8 w=1.6 l=0.15
X345 t_Xser_Xlane1_Xr0_m3 t_Xser_Xlane1_Xr0_clki t_Xser_Xlane1_Xr0_m1 vss sky130_fd_pr__nfet_01v8_lvt w=0.8 l=0.15
X346 t_Xser_Xlane1_Xr0_m3 t_Xser_Xlane1_Xr0_clkb t_Xser_Xlane1_Xr0_m1 vdd sky130_fd_pr__pfet_01v8 w=1.6 l=0.15
X347 t_Xser_Xlane1_Xr0_m2 t_Xser_Xlane1_Xr0_clki t_Xser_Xlane1_Xr0_s1 vss sky130_fd_pr__nfet_01v8_lvt w=0.8 l=0.15
X348 t_Xser_Xlane1_Xr0_m2 t_Xser_Xlane1_Xr0_clkb t_Xser_Xlane1_Xr0_s1 vdd sky130_fd_pr__pfet_01v8 w=1.6 l=0.15
X349 t_Xser_Xlane1_Xr0_qi t_Xser_Xlane1_Xr0_s1 vss vss sky130_fd_pr__nfet_01v8_lvt w=0.96 l=0.15
X350 t_Xser_Xlane1_Xr0_qi t_Xser_Xlane1_Xr0_s1 vdd vdd sky130_fd_pr__pfet_01v8 w=1.92 l=0.15
X351 t_Xser_Xlane1_Xr0_s2 t_Xser_Xlane1_Xr0_qi t_Xser_Xlane1_Xr0_Xsfb_mid vss sky130_fd_pr__nfet_01v8_lvt w=1.2 l=0.15
X352 t_Xser_Xlane1_Xr0_Xsfb_mid rst_n vss vss sky130_fd_pr__nfet_01v8_lvt w=1.2 l=0.15
X353 t_Xser_Xlane1_Xr0_s2 t_Xser_Xlane1_Xr0_qi vdd vdd sky130_fd_pr__pfet_01v8 w=1.6 l=0.15
X354 t_Xser_Xlane1_Xr0_s2 rst_n vdd vdd sky130_fd_pr__pfet_01v8 w=1.6 l=0.15
X355 t_Xser_Xlane1_Xr0_s2 t_Xser_Xlane1_Xr0_clkb t_Xser_Xlane1_Xr0_s1 vss sky130_fd_pr__nfet_01v8_lvt w=0.8 l=0.15
X356 t_Xser_Xlane1_Xr0_s2 t_Xser_Xlane1_Xr0_clki t_Xser_Xlane1_Xr0_s1 vdd sky130_fd_pr__pfet_01v8 w=1.6 l=0.15
X357 t_Xser_Xlane1_r0 t_Xser_Xlane1_Xr0_s1 vss vss sky130_fd_pr__nfet_01v8_lvt w=1.2 l=0.15
X358 t_Xser_Xlane1_r0 t_Xser_Xlane1_Xr0_s1 vdd vdd sky130_fd_pr__pfet_01v8 w=2.4 l=0.15
X359 t_Xser_Xlane1_r0b t_Xser_Xlane1_Xr0_qi vss vss sky130_fd_pr__nfet_01v8_lvt w=1.2 l=0.15
X360 t_Xser_Xlane1_r0b t_Xser_Xlane1_Xr0_qi vdd vdd sky130_fd_pr__pfet_01v8 w=2.4 l=0.15
X361 t_Xser_Xlane1_Xr1_clkb t_Xser_clk250b vss vss sky130_fd_pr__nfet_01v8_lvt w=1.2 l=0.15
X362 t_Xser_Xlane1_Xr1_clkb t_Xser_clk250b vdd vdd sky130_fd_pr__pfet_01v8 w=2.4 l=0.15
X363 t_Xser_Xlane1_Xr1_clki t_Xser_Xlane1_Xr1_clkb vss vss sky130_fd_pr__nfet_01v8_lvt w=1.2 l=0.15
X364 t_Xser_Xlane1_Xr1_clki t_Xser_Xlane1_Xr1_clkb vdd vdd sky130_fd_pr__pfet_01v8 w=2.4 l=0.15
X365 din5 t_Xser_Xlane1_Xr1_clkb t_Xser_Xlane1_Xr1_m1 vss sky130_fd_pr__nfet_01v8_lvt w=0.8 l=0.15
X366 din5 t_Xser_Xlane1_Xr1_clki t_Xser_Xlane1_Xr1_m1 vdd sky130_fd_pr__pfet_01v8 w=1.6 l=0.15
X367 t_Xser_Xlane1_Xr1_m2 t_Xser_Xlane1_Xr1_m1 t_Xser_Xlane1_Xr1_Xm2_mid vss sky130_fd_pr__nfet_01v8_lvt w=1.2 l=0.15
X368 t_Xser_Xlane1_Xr1_Xm2_mid rst_n vss vss sky130_fd_pr__nfet_01v8_lvt w=1.2 l=0.15
X369 t_Xser_Xlane1_Xr1_m2 t_Xser_Xlane1_Xr1_m1 vdd vdd sky130_fd_pr__pfet_01v8 w=1.6 l=0.15
X370 t_Xser_Xlane1_Xr1_m2 rst_n vdd vdd sky130_fd_pr__pfet_01v8 w=1.6 l=0.15
X371 t_Xser_Xlane1_Xr1_m3 t_Xser_Xlane1_Xr1_m2 vss vss sky130_fd_pr__nfet_01v8_lvt w=0.8 l=0.15
X372 t_Xser_Xlane1_Xr1_m3 t_Xser_Xlane1_Xr1_m2 vdd vdd sky130_fd_pr__pfet_01v8 w=1.6 l=0.15
X373 t_Xser_Xlane1_Xr1_m3 t_Xser_Xlane1_Xr1_clki t_Xser_Xlane1_Xr1_m1 vss sky130_fd_pr__nfet_01v8_lvt w=0.8 l=0.15
X374 t_Xser_Xlane1_Xr1_m3 t_Xser_Xlane1_Xr1_clkb t_Xser_Xlane1_Xr1_m1 vdd sky130_fd_pr__pfet_01v8 w=1.6 l=0.15
X375 t_Xser_Xlane1_Xr1_m2 t_Xser_Xlane1_Xr1_clki t_Xser_Xlane1_Xr1_s1 vss sky130_fd_pr__nfet_01v8_lvt w=0.8 l=0.15
X376 t_Xser_Xlane1_Xr1_m2 t_Xser_Xlane1_Xr1_clkb t_Xser_Xlane1_Xr1_s1 vdd sky130_fd_pr__pfet_01v8 w=1.6 l=0.15
X377 t_Xser_Xlane1_Xr1_qi t_Xser_Xlane1_Xr1_s1 vss vss sky130_fd_pr__nfet_01v8_lvt w=0.96 l=0.15
X378 t_Xser_Xlane1_Xr1_qi t_Xser_Xlane1_Xr1_s1 vdd vdd sky130_fd_pr__pfet_01v8 w=1.92 l=0.15
X379 t_Xser_Xlane1_Xr1_s2 t_Xser_Xlane1_Xr1_qi t_Xser_Xlane1_Xr1_Xsfb_mid vss sky130_fd_pr__nfet_01v8_lvt w=1.2 l=0.15
X380 t_Xser_Xlane1_Xr1_Xsfb_mid rst_n vss vss sky130_fd_pr__nfet_01v8_lvt w=1.2 l=0.15
X381 t_Xser_Xlane1_Xr1_s2 t_Xser_Xlane1_Xr1_qi vdd vdd sky130_fd_pr__pfet_01v8 w=1.6 l=0.15
X382 t_Xser_Xlane1_Xr1_s2 rst_n vdd vdd sky130_fd_pr__pfet_01v8 w=1.6 l=0.15
X383 t_Xser_Xlane1_Xr1_s2 t_Xser_Xlane1_Xr1_clkb t_Xser_Xlane1_Xr1_s1 vss sky130_fd_pr__nfet_01v8_lvt w=0.8 l=0.15
X384 t_Xser_Xlane1_Xr1_s2 t_Xser_Xlane1_Xr1_clki t_Xser_Xlane1_Xr1_s1 vdd sky130_fd_pr__pfet_01v8 w=1.6 l=0.15
X385 t_Xser_Xlane1_r1 t_Xser_Xlane1_Xr1_s1 vss vss sky130_fd_pr__nfet_01v8_lvt w=1.2 l=0.15
X386 t_Xser_Xlane1_r1 t_Xser_Xlane1_Xr1_s1 vdd vdd sky130_fd_pr__pfet_01v8 w=2.4 l=0.15
X387 t_Xser_Xlane1_r1b t_Xser_Xlane1_Xr1_qi vss vss sky130_fd_pr__nfet_01v8_lvt w=1.2 l=0.15
X388 t_Xser_Xlane1_r1b t_Xser_Xlane1_Xr1_qi vdd vdd sky130_fd_pr__pfet_01v8 w=2.4 l=0.15
X389 t_Xser_Xlane1_Xr2_clkb t_Xser_clk250b vss vss sky130_fd_pr__nfet_01v8_lvt w=1.2 l=0.15
X390 t_Xser_Xlane1_Xr2_clkb t_Xser_clk250b vdd vdd sky130_fd_pr__pfet_01v8 w=2.4 l=0.15
X391 t_Xser_Xlane1_Xr2_clki t_Xser_Xlane1_Xr2_clkb vss vss sky130_fd_pr__nfet_01v8_lvt w=1.2 l=0.15
X392 t_Xser_Xlane1_Xr2_clki t_Xser_Xlane1_Xr2_clkb vdd vdd sky130_fd_pr__pfet_01v8 w=2.4 l=0.15
X393 din9 t_Xser_Xlane1_Xr2_clkb t_Xser_Xlane1_Xr2_m1 vss sky130_fd_pr__nfet_01v8_lvt w=0.8 l=0.15
X394 din9 t_Xser_Xlane1_Xr2_clki t_Xser_Xlane1_Xr2_m1 vdd sky130_fd_pr__pfet_01v8 w=1.6 l=0.15
X395 t_Xser_Xlane1_Xr2_m2 t_Xser_Xlane1_Xr2_m1 t_Xser_Xlane1_Xr2_Xm2_mid vss sky130_fd_pr__nfet_01v8_lvt w=1.2 l=0.15
X396 t_Xser_Xlane1_Xr2_Xm2_mid rst_n vss vss sky130_fd_pr__nfet_01v8_lvt w=1.2 l=0.15
X397 t_Xser_Xlane1_Xr2_m2 t_Xser_Xlane1_Xr2_m1 vdd vdd sky130_fd_pr__pfet_01v8 w=1.6 l=0.15
X398 t_Xser_Xlane1_Xr2_m2 rst_n vdd vdd sky130_fd_pr__pfet_01v8 w=1.6 l=0.15
X399 t_Xser_Xlane1_Xr2_m3 t_Xser_Xlane1_Xr2_m2 vss vss sky130_fd_pr__nfet_01v8_lvt w=0.8 l=0.15
X400 t_Xser_Xlane1_Xr2_m3 t_Xser_Xlane1_Xr2_m2 vdd vdd sky130_fd_pr__pfet_01v8 w=1.6 l=0.15
X401 t_Xser_Xlane1_Xr2_m3 t_Xser_Xlane1_Xr2_clki t_Xser_Xlane1_Xr2_m1 vss sky130_fd_pr__nfet_01v8_lvt w=0.8 l=0.15
X402 t_Xser_Xlane1_Xr2_m3 t_Xser_Xlane1_Xr2_clkb t_Xser_Xlane1_Xr2_m1 vdd sky130_fd_pr__pfet_01v8 w=1.6 l=0.15
X403 t_Xser_Xlane1_Xr2_m2 t_Xser_Xlane1_Xr2_clki t_Xser_Xlane1_Xr2_s1 vss sky130_fd_pr__nfet_01v8_lvt w=0.8 l=0.15
X404 t_Xser_Xlane1_Xr2_m2 t_Xser_Xlane1_Xr2_clkb t_Xser_Xlane1_Xr2_s1 vdd sky130_fd_pr__pfet_01v8 w=1.6 l=0.15
X405 t_Xser_Xlane1_Xr2_qi t_Xser_Xlane1_Xr2_s1 vss vss sky130_fd_pr__nfet_01v8_lvt w=0.96 l=0.15
X406 t_Xser_Xlane1_Xr2_qi t_Xser_Xlane1_Xr2_s1 vdd vdd sky130_fd_pr__pfet_01v8 w=1.92 l=0.15
X407 t_Xser_Xlane1_Xr2_s2 t_Xser_Xlane1_Xr2_qi t_Xser_Xlane1_Xr2_Xsfb_mid vss sky130_fd_pr__nfet_01v8_lvt w=1.2 l=0.15
X408 t_Xser_Xlane1_Xr2_Xsfb_mid rst_n vss vss sky130_fd_pr__nfet_01v8_lvt w=1.2 l=0.15
X409 t_Xser_Xlane1_Xr2_s2 t_Xser_Xlane1_Xr2_qi vdd vdd sky130_fd_pr__pfet_01v8 w=1.6 l=0.15
X410 t_Xser_Xlane1_Xr2_s2 rst_n vdd vdd sky130_fd_pr__pfet_01v8 w=1.6 l=0.15
X411 t_Xser_Xlane1_Xr2_s2 t_Xser_Xlane1_Xr2_clkb t_Xser_Xlane1_Xr2_s1 vss sky130_fd_pr__nfet_01v8_lvt w=0.8 l=0.15
X412 t_Xser_Xlane1_Xr2_s2 t_Xser_Xlane1_Xr2_clki t_Xser_Xlane1_Xr2_s1 vdd sky130_fd_pr__pfet_01v8 w=1.6 l=0.15
X413 t_Xser_Xlane1_r2 t_Xser_Xlane1_Xr2_s1 vss vss sky130_fd_pr__nfet_01v8_lvt w=1.2 l=0.15
X414 t_Xser_Xlane1_r2 t_Xser_Xlane1_Xr2_s1 vdd vdd sky130_fd_pr__pfet_01v8 w=2.4 l=0.15
X415 t_Xser_Xlane1_r2b t_Xser_Xlane1_Xr2_qi vss vss sky130_fd_pr__nfet_01v8_lvt w=1.2 l=0.15
X416 t_Xser_Xlane1_r2b t_Xser_Xlane1_Xr2_qi vdd vdd sky130_fd_pr__pfet_01v8 w=2.4 l=0.15
X417 t_Xser_Xlane1_Xr3_m_clkb t_Xser_clk250b vss vss sky130_fd_pr__nfet_01v8_lvt w=1.2 l=0.15
X418 t_Xser_Xlane1_Xr3_m_clkb t_Xser_clk250b vdd vdd sky130_fd_pr__pfet_01v8 w=2.4 l=0.15
X419 t_Xser_Xlane1_Xr3_m_clki t_Xser_Xlane1_Xr3_m_clkb vss vss sky130_fd_pr__nfet_01v8_lvt w=1.2 l=0.15
X420 t_Xser_Xlane1_Xr3_m_clki t_Xser_Xlane1_Xr3_m_clkb vdd vdd sky130_fd_pr__pfet_01v8 w=2.4 l=0.15
X421 din13 t_Xser_Xlane1_Xr3_m_clkb t_Xser_Xlane1_Xr3_m_m1 vss sky130_fd_pr__nfet_01v8_lvt w=0.8 l=0.15
X422 din13 t_Xser_Xlane1_Xr3_m_clki t_Xser_Xlane1_Xr3_m_m1 vdd sky130_fd_pr__pfet_01v8 w=1.6 l=0.15
X423 t_Xser_Xlane1_Xr3_m_m2 t_Xser_Xlane1_Xr3_m_m1 t_Xser_Xlane1_Xr3_m_Xm2_mid vss sky130_fd_pr__nfet_01v8_lvt w=1.2 l=0.15
X424 t_Xser_Xlane1_Xr3_m_Xm2_mid rst_n vss vss sky130_fd_pr__nfet_01v8_lvt w=1.2 l=0.15
X425 t_Xser_Xlane1_Xr3_m_m2 t_Xser_Xlane1_Xr3_m_m1 vdd vdd sky130_fd_pr__pfet_01v8 w=1.6 l=0.15
X426 t_Xser_Xlane1_Xr3_m_m2 rst_n vdd vdd sky130_fd_pr__pfet_01v8 w=1.6 l=0.15
X427 t_Xser_Xlane1_Xr3_m_m3 t_Xser_Xlane1_Xr3_m_m2 vss vss sky130_fd_pr__nfet_01v8_lvt w=0.8 l=0.15
X428 t_Xser_Xlane1_Xr3_m_m3 t_Xser_Xlane1_Xr3_m_m2 vdd vdd sky130_fd_pr__pfet_01v8 w=1.6 l=0.15
X429 t_Xser_Xlane1_Xr3_m_m3 t_Xser_Xlane1_Xr3_m_clki t_Xser_Xlane1_Xr3_m_m1 vss sky130_fd_pr__nfet_01v8_lvt w=0.8 l=0.15
X430 t_Xser_Xlane1_Xr3_m_m3 t_Xser_Xlane1_Xr3_m_clkb t_Xser_Xlane1_Xr3_m_m1 vdd sky130_fd_pr__pfet_01v8 w=1.6 l=0.15
X431 t_Xser_Xlane1_Xr3_m_m2 t_Xser_Xlane1_Xr3_m_clki t_Xser_Xlane1_Xr3_m_s1 vss sky130_fd_pr__nfet_01v8_lvt w=0.8 l=0.15
X432 t_Xser_Xlane1_Xr3_m_m2 t_Xser_Xlane1_Xr3_m_clkb t_Xser_Xlane1_Xr3_m_s1 vdd sky130_fd_pr__pfet_01v8 w=1.6 l=0.15
X433 t_Xser_Xlane1_Xr3_m_qi t_Xser_Xlane1_Xr3_m_s1 vss vss sky130_fd_pr__nfet_01v8_lvt w=0.96 l=0.15
X434 t_Xser_Xlane1_Xr3_m_qi t_Xser_Xlane1_Xr3_m_s1 vdd vdd sky130_fd_pr__pfet_01v8 w=1.92 l=0.15
X435 t_Xser_Xlane1_Xr3_m_s2 t_Xser_Xlane1_Xr3_m_qi t_Xser_Xlane1_Xr3_m_Xsfb_mid vss sky130_fd_pr__nfet_01v8_lvt w=1.2 l=0.15
X436 t_Xser_Xlane1_Xr3_m_Xsfb_mid rst_n vss vss sky130_fd_pr__nfet_01v8_lvt w=1.2 l=0.15
X437 t_Xser_Xlane1_Xr3_m_s2 t_Xser_Xlane1_Xr3_m_qi vdd vdd sky130_fd_pr__pfet_01v8 w=1.6 l=0.15
X438 t_Xser_Xlane1_Xr3_m_s2 rst_n vdd vdd sky130_fd_pr__pfet_01v8 w=1.6 l=0.15
X439 t_Xser_Xlane1_Xr3_m_s2 t_Xser_Xlane1_Xr3_m_clkb t_Xser_Xlane1_Xr3_m_s1 vss sky130_fd_pr__nfet_01v8_lvt w=0.8 l=0.15
X440 t_Xser_Xlane1_Xr3_m_s2 t_Xser_Xlane1_Xr3_m_clki t_Xser_Xlane1_Xr3_m_s1 vdd sky130_fd_pr__pfet_01v8 w=1.6 l=0.15
X441 t_Xser_Xlane1_r3_m t_Xser_Xlane1_Xr3_m_s1 vss vss sky130_fd_pr__nfet_01v8_lvt w=1.2 l=0.15
X442 t_Xser_Xlane1_r3_m t_Xser_Xlane1_Xr3_m_s1 vdd vdd sky130_fd_pr__pfet_01v8 w=2.4 l=0.15
X443 t_Xser_Xlane1_r3_mb t_Xser_Xlane1_Xr3_m_qi vss vss sky130_fd_pr__nfet_01v8_lvt w=1.2 l=0.15
X444 t_Xser_Xlane1_r3_mb t_Xser_Xlane1_Xr3_m_qi vdd vdd sky130_fd_pr__pfet_01v8 w=2.4 l=0.15
X445 t_Xser_Xlane1_Xr3_clkb t_Xser_clk250 vss vss sky130_fd_pr__nfet_01v8_lvt w=1.2 l=0.15
X446 t_Xser_Xlane1_Xr3_clkb t_Xser_clk250 vdd vdd sky130_fd_pr__pfet_01v8 w=2.4 l=0.15
X447 t_Xser_Xlane1_Xr3_clki t_Xser_Xlane1_Xr3_clkb vss vss sky130_fd_pr__nfet_01v8_lvt w=1.2 l=0.15
X448 t_Xser_Xlane1_Xr3_clki t_Xser_Xlane1_Xr3_clkb vdd vdd sky130_fd_pr__pfet_01v8 w=2.4 l=0.15
X449 t_Xser_Xlane1_r3_m t_Xser_Xlane1_Xr3_clkb t_Xser_Xlane1_Xr3_m1 vss sky130_fd_pr__nfet_01v8_lvt w=0.8 l=0.15
X450 t_Xser_Xlane1_r3_m t_Xser_Xlane1_Xr3_clki t_Xser_Xlane1_Xr3_m1 vdd sky130_fd_pr__pfet_01v8 w=1.6 l=0.15
X451 t_Xser_Xlane1_Xr3_m2 t_Xser_Xlane1_Xr3_m1 t_Xser_Xlane1_Xr3_Xm2_mid vss sky130_fd_pr__nfet_01v8_lvt w=1.2 l=0.15
X452 t_Xser_Xlane1_Xr3_Xm2_mid rst_n vss vss sky130_fd_pr__nfet_01v8_lvt w=1.2 l=0.15
X453 t_Xser_Xlane1_Xr3_m2 t_Xser_Xlane1_Xr3_m1 vdd vdd sky130_fd_pr__pfet_01v8 w=1.6 l=0.15
X454 t_Xser_Xlane1_Xr3_m2 rst_n vdd vdd sky130_fd_pr__pfet_01v8 w=1.6 l=0.15
X455 t_Xser_Xlane1_Xr3_m3 t_Xser_Xlane1_Xr3_m2 vss vss sky130_fd_pr__nfet_01v8_lvt w=0.8 l=0.15
X456 t_Xser_Xlane1_Xr3_m3 t_Xser_Xlane1_Xr3_m2 vdd vdd sky130_fd_pr__pfet_01v8 w=1.6 l=0.15
X457 t_Xser_Xlane1_Xr3_m3 t_Xser_Xlane1_Xr3_clki t_Xser_Xlane1_Xr3_m1 vss sky130_fd_pr__nfet_01v8_lvt w=0.8 l=0.15
X458 t_Xser_Xlane1_Xr3_m3 t_Xser_Xlane1_Xr3_clkb t_Xser_Xlane1_Xr3_m1 vdd sky130_fd_pr__pfet_01v8 w=1.6 l=0.15
X459 t_Xser_Xlane1_Xr3_m2 t_Xser_Xlane1_Xr3_clki t_Xser_Xlane1_Xr3_s1 vss sky130_fd_pr__nfet_01v8_lvt w=0.8 l=0.15
X460 t_Xser_Xlane1_Xr3_m2 t_Xser_Xlane1_Xr3_clkb t_Xser_Xlane1_Xr3_s1 vdd sky130_fd_pr__pfet_01v8 w=1.6 l=0.15
X461 t_Xser_Xlane1_Xr3_qi t_Xser_Xlane1_Xr3_s1 vss vss sky130_fd_pr__nfet_01v8_lvt w=0.96 l=0.15
X462 t_Xser_Xlane1_Xr3_qi t_Xser_Xlane1_Xr3_s1 vdd vdd sky130_fd_pr__pfet_01v8 w=1.92 l=0.15
X463 t_Xser_Xlane1_Xr3_s2 t_Xser_Xlane1_Xr3_qi t_Xser_Xlane1_Xr3_Xsfb_mid vss sky130_fd_pr__nfet_01v8_lvt w=1.2 l=0.15
X464 t_Xser_Xlane1_Xr3_Xsfb_mid rst_n vss vss sky130_fd_pr__nfet_01v8_lvt w=1.2 l=0.15
X465 t_Xser_Xlane1_Xr3_s2 t_Xser_Xlane1_Xr3_qi vdd vdd sky130_fd_pr__pfet_01v8 w=1.6 l=0.15
X466 t_Xser_Xlane1_Xr3_s2 rst_n vdd vdd sky130_fd_pr__pfet_01v8 w=1.6 l=0.15
X467 t_Xser_Xlane1_Xr3_s2 t_Xser_Xlane1_Xr3_clkb t_Xser_Xlane1_Xr3_s1 vss sky130_fd_pr__nfet_01v8_lvt w=0.8 l=0.15
X468 t_Xser_Xlane1_Xr3_s2 t_Xser_Xlane1_Xr3_clki t_Xser_Xlane1_Xr3_s1 vdd sky130_fd_pr__pfet_01v8 w=1.6 l=0.15
X469 t_Xser_Xlane1_r3 t_Xser_Xlane1_Xr3_s1 vss vss sky130_fd_pr__nfet_01v8_lvt w=1.2 l=0.15
X470 t_Xser_Xlane1_r3 t_Xser_Xlane1_Xr3_s1 vdd vdd sky130_fd_pr__pfet_01v8 w=2.4 l=0.15
X471 t_Xser_Xlane1_r3b t_Xser_Xlane1_Xr3_qi vss vss sky130_fd_pr__nfet_01v8_lvt w=1.2 l=0.15
X472 t_Xser_Xlane1_r3b t_Xser_Xlane1_Xr3_qi vdd vdd sky130_fd_pr__pfet_01v8 w=2.4 l=0.15
X473 t_Xser_Xlane1_r2 t_Xser_clk250 t_Xser_Xlane1_Xma_mid vss sky130_fd_pr__nfet_01v8_lvt w=0.9 l=0.15
X474 t_Xser_Xlane1_r2 t_Xser_clk250b t_Xser_Xlane1_Xma_mid vdd sky130_fd_pr__pfet_01v8 w=1.8 l=0.15
X475 t_Xser_Xlane1_r0 t_Xser_clk250b t_Xser_Xlane1_Xma_mid vss sky130_fd_pr__nfet_01v8_lvt w=0.9 l=0.15
X476 t_Xser_Xlane1_r0 t_Xser_clk250 t_Xser_Xlane1_Xma_mid vdd sky130_fd_pr__pfet_01v8 w=1.8 l=0.15
X477 t_Xser_Xlane1_Xma_yb t_Xser_Xlane1_Xma_mid vss vss sky130_fd_pr__nfet_01v8_lvt w=0.9 l=0.15
X478 t_Xser_Xlane1_Xma_yb t_Xser_Xlane1_Xma_mid vdd vdd sky130_fd_pr__pfet_01v8 w=1.8 l=0.15
X479 t_Xser_Xlane1_ma t_Xser_Xlane1_Xma_yb vss vss sky130_fd_pr__nfet_01v8_lvt w=0.9 l=0.15
X480 t_Xser_Xlane1_ma t_Xser_Xlane1_Xma_yb vdd vdd sky130_fd_pr__pfet_01v8 w=1.8 l=0.15
X481 t_Xser_Xlane1_r1 t_Xser_clk250 t_Xser_Xlane1_Xmb_mid vss sky130_fd_pr__nfet_01v8_lvt w=0.9 l=0.15
X482 t_Xser_Xlane1_r1 t_Xser_clk250b t_Xser_Xlane1_Xmb_mid vdd sky130_fd_pr__pfet_01v8 w=1.8 l=0.15
X483 t_Xser_Xlane1_r3 t_Xser_clk250b t_Xser_Xlane1_Xmb_mid vss sky130_fd_pr__nfet_01v8_lvt w=0.9 l=0.15
X484 t_Xser_Xlane1_r3 t_Xser_clk250 t_Xser_Xlane1_Xmb_mid vdd sky130_fd_pr__pfet_01v8 w=1.8 l=0.15
X485 t_Xser_Xlane1_Xmb_yb t_Xser_Xlane1_Xmb_mid vss vss sky130_fd_pr__nfet_01v8_lvt w=0.9 l=0.15
X486 t_Xser_Xlane1_Xmb_yb t_Xser_Xlane1_Xmb_mid vdd vdd sky130_fd_pr__pfet_01v8 w=1.8 l=0.15
X487 t_Xser_Xlane1_mb t_Xser_Xlane1_Xmb_yb vss vss sky130_fd_pr__nfet_01v8_lvt w=0.9 l=0.15
X488 t_Xser_Xlane1_mb t_Xser_Xlane1_Xmb_yb vdd vdd sky130_fd_pr__pfet_01v8 w=1.8 l=0.15
X489 t_Xser_Xlane1_Xda_clkb t_Xser_clk500 vss vss sky130_fd_pr__nfet_01v8_lvt w=1.2 l=0.15
X490 t_Xser_Xlane1_Xda_clkb t_Xser_clk500 vdd vdd sky130_fd_pr__pfet_01v8 w=2.4 l=0.15
X491 t_Xser_Xlane1_Xda_clki t_Xser_Xlane1_Xda_clkb vss vss sky130_fd_pr__nfet_01v8_lvt w=1.2 l=0.15
X492 t_Xser_Xlane1_Xda_clki t_Xser_Xlane1_Xda_clkb vdd vdd sky130_fd_pr__pfet_01v8 w=2.4 l=0.15
X493 t_Xser_Xlane1_ma t_Xser_Xlane1_Xda_clkb t_Xser_Xlane1_Xda_m1 vss sky130_fd_pr__nfet_01v8_lvt w=1.2 l=0.15
X494 t_Xser_Xlane1_ma t_Xser_Xlane1_Xda_clki t_Xser_Xlane1_Xda_m1 vdd sky130_fd_pr__pfet_01v8 w=2.4 l=0.15
X495 t_Xser_Xlane1_Xda_m2 t_Xser_Xlane1_Xda_m1 t_Xser_Xlane1_Xda_Xm2_mid vss sky130_fd_pr__nfet_01v8_lvt w=1.8 l=0.15
X496 t_Xser_Xlane1_Xda_Xm2_mid rst_n vss vss sky130_fd_pr__nfet_01v8_lvt w=1.8 l=0.15
X497 t_Xser_Xlane1_Xda_m2 t_Xser_Xlane1_Xda_m1 vdd vdd sky130_fd_pr__pfet_01v8 w=2.4 l=0.15
X498 t_Xser_Xlane1_Xda_m2 rst_n vdd vdd sky130_fd_pr__pfet_01v8 w=2.4 l=0.15
X499 t_Xser_Xlane1_Xda_m3 t_Xser_Xlane1_Xda_m2 vss vss sky130_fd_pr__nfet_01v8_lvt w=0.8 l=0.15
X500 t_Xser_Xlane1_Xda_m3 t_Xser_Xlane1_Xda_m2 vdd vdd sky130_fd_pr__pfet_01v8 w=1.6 l=0.15
X501 t_Xser_Xlane1_Xda_m3 t_Xser_Xlane1_Xda_clki t_Xser_Xlane1_Xda_m1 vss sky130_fd_pr__nfet_01v8_lvt w=0.8 l=0.15
X502 t_Xser_Xlane1_Xda_m3 t_Xser_Xlane1_Xda_clkb t_Xser_Xlane1_Xda_m1 vdd sky130_fd_pr__pfet_01v8 w=1.6 l=0.15
X503 t_Xser_Xlane1_Xda_m2 t_Xser_Xlane1_Xda_clki t_Xser_Xlane1_Xda_s1 vss sky130_fd_pr__nfet_01v8_lvt w=1.2 l=0.15
X504 t_Xser_Xlane1_Xda_m2 t_Xser_Xlane1_Xda_clkb t_Xser_Xlane1_Xda_s1 vdd sky130_fd_pr__pfet_01v8 w=2.4 l=0.15
X505 t_Xser_Xlane1_Xda_qi t_Xser_Xlane1_Xda_s1 vss vss sky130_fd_pr__nfet_01v8_lvt w=1.44 l=0.15
X506 t_Xser_Xlane1_Xda_qi t_Xser_Xlane1_Xda_s1 vdd vdd sky130_fd_pr__pfet_01v8 w=2.88 l=0.15
X507 t_Xser_Xlane1_Xda_s2 t_Xser_Xlane1_Xda_qi t_Xser_Xlane1_Xda_Xsfb_mid vss sky130_fd_pr__nfet_01v8_lvt w=1.2 l=0.15
X508 t_Xser_Xlane1_Xda_Xsfb_mid rst_n vss vss sky130_fd_pr__nfet_01v8_lvt w=1.2 l=0.15
X509 t_Xser_Xlane1_Xda_s2 t_Xser_Xlane1_Xda_qi vdd vdd sky130_fd_pr__pfet_01v8 w=1.6 l=0.15
X510 t_Xser_Xlane1_Xda_s2 rst_n vdd vdd sky130_fd_pr__pfet_01v8 w=1.6 l=0.15
X511 t_Xser_Xlane1_Xda_s2 t_Xser_Xlane1_Xda_clkb t_Xser_Xlane1_Xda_s1 vss sky130_fd_pr__nfet_01v8_lvt w=0.8 l=0.15
X512 t_Xser_Xlane1_Xda_s2 t_Xser_Xlane1_Xda_clki t_Xser_Xlane1_Xda_s1 vdd sky130_fd_pr__pfet_01v8 w=1.6 l=0.15
X513 t_Xser_Xlane1_da t_Xser_Xlane1_Xda_s1 vss vss sky130_fd_pr__nfet_01v8_lvt w=1.8 l=0.15
X514 t_Xser_Xlane1_da t_Xser_Xlane1_Xda_s1 vdd vdd sky130_fd_pr__pfet_01v8 w=3.6 l=0.15
X515 t_Xser_Xlane1_dab t_Xser_Xlane1_Xda_qi vss vss sky130_fd_pr__nfet_01v8_lvt w=1.8 l=0.15
X516 t_Xser_Xlane1_dab t_Xser_Xlane1_Xda_qi vdd vdd sky130_fd_pr__pfet_01v8 w=3.6 l=0.15
X517 t_Xser_Xlane1_Xdb_clkb t_Xser_clk500b vss vss sky130_fd_pr__nfet_01v8_lvt w=1.2 l=0.15
X518 t_Xser_Xlane1_Xdb_clkb t_Xser_clk500b vdd vdd sky130_fd_pr__pfet_01v8 w=2.4 l=0.15
X519 t_Xser_Xlane1_Xdb_clki t_Xser_Xlane1_Xdb_clkb vss vss sky130_fd_pr__nfet_01v8_lvt w=1.2 l=0.15
X520 t_Xser_Xlane1_Xdb_clki t_Xser_Xlane1_Xdb_clkb vdd vdd sky130_fd_pr__pfet_01v8 w=2.4 l=0.15
X521 t_Xser_Xlane1_mb t_Xser_Xlane1_Xdb_clkb t_Xser_Xlane1_Xdb_m1 vss sky130_fd_pr__nfet_01v8_lvt w=1.2 l=0.15
X522 t_Xser_Xlane1_mb t_Xser_Xlane1_Xdb_clki t_Xser_Xlane1_Xdb_m1 vdd sky130_fd_pr__pfet_01v8 w=2.4 l=0.15
X523 t_Xser_Xlane1_Xdb_m2 t_Xser_Xlane1_Xdb_m1 t_Xser_Xlane1_Xdb_Xm2_mid vss sky130_fd_pr__nfet_01v8_lvt w=1.8 l=0.15
X524 t_Xser_Xlane1_Xdb_Xm2_mid rst_n vss vss sky130_fd_pr__nfet_01v8_lvt w=1.8 l=0.15
X525 t_Xser_Xlane1_Xdb_m2 t_Xser_Xlane1_Xdb_m1 vdd vdd sky130_fd_pr__pfet_01v8 w=2.4 l=0.15
X526 t_Xser_Xlane1_Xdb_m2 rst_n vdd vdd sky130_fd_pr__pfet_01v8 w=2.4 l=0.15
X527 t_Xser_Xlane1_Xdb_m3 t_Xser_Xlane1_Xdb_m2 vss vss sky130_fd_pr__nfet_01v8_lvt w=0.8 l=0.15
X528 t_Xser_Xlane1_Xdb_m3 t_Xser_Xlane1_Xdb_m2 vdd vdd sky130_fd_pr__pfet_01v8 w=1.6 l=0.15
X529 t_Xser_Xlane1_Xdb_m3 t_Xser_Xlane1_Xdb_clki t_Xser_Xlane1_Xdb_m1 vss sky130_fd_pr__nfet_01v8_lvt w=0.8 l=0.15
X530 t_Xser_Xlane1_Xdb_m3 t_Xser_Xlane1_Xdb_clkb t_Xser_Xlane1_Xdb_m1 vdd sky130_fd_pr__pfet_01v8 w=1.6 l=0.15
X531 t_Xser_Xlane1_Xdb_m2 t_Xser_Xlane1_Xdb_clki t_Xser_Xlane1_Xdb_s1 vss sky130_fd_pr__nfet_01v8_lvt w=1.2 l=0.15
X532 t_Xser_Xlane1_Xdb_m2 t_Xser_Xlane1_Xdb_clkb t_Xser_Xlane1_Xdb_s1 vdd sky130_fd_pr__pfet_01v8 w=2.4 l=0.15
X533 t_Xser_Xlane1_Xdb_qi t_Xser_Xlane1_Xdb_s1 vss vss sky130_fd_pr__nfet_01v8_lvt w=1.44 l=0.15
X534 t_Xser_Xlane1_Xdb_qi t_Xser_Xlane1_Xdb_s1 vdd vdd sky130_fd_pr__pfet_01v8 w=2.88 l=0.15
X535 t_Xser_Xlane1_Xdb_s2 t_Xser_Xlane1_Xdb_qi t_Xser_Xlane1_Xdb_Xsfb_mid vss sky130_fd_pr__nfet_01v8_lvt w=1.2 l=0.15
X536 t_Xser_Xlane1_Xdb_Xsfb_mid rst_n vss vss sky130_fd_pr__nfet_01v8_lvt w=1.2 l=0.15
X537 t_Xser_Xlane1_Xdb_s2 t_Xser_Xlane1_Xdb_qi vdd vdd sky130_fd_pr__pfet_01v8 w=1.6 l=0.15
X538 t_Xser_Xlane1_Xdb_s2 rst_n vdd vdd sky130_fd_pr__pfet_01v8 w=1.6 l=0.15
X539 t_Xser_Xlane1_Xdb_s2 t_Xser_Xlane1_Xdb_clkb t_Xser_Xlane1_Xdb_s1 vss sky130_fd_pr__nfet_01v8_lvt w=0.8 l=0.15
X540 t_Xser_Xlane1_Xdb_s2 t_Xser_Xlane1_Xdb_clki t_Xser_Xlane1_Xdb_s1 vdd sky130_fd_pr__pfet_01v8 w=1.6 l=0.15
X541 t_Xser_Xlane1_db t_Xser_Xlane1_Xdb_s1 vss vss sky130_fd_pr__nfet_01v8_lvt w=1.8 l=0.15
X542 t_Xser_Xlane1_db t_Xser_Xlane1_Xdb_s1 vdd vdd sky130_fd_pr__pfet_01v8 w=3.6 l=0.15
X543 t_Xser_Xlane1_dbb t_Xser_Xlane1_Xdb_qi vss vss sky130_fd_pr__nfet_01v8_lvt w=1.8 l=0.15
X544 t_Xser_Xlane1_dbb t_Xser_Xlane1_Xdb_qi vdd vdd sky130_fd_pr__pfet_01v8 w=3.6 l=0.15
X545 t_Xser_Xlane1_da t_Xser_clk500b t_Xser_Xlane1_Xmc_mid vss sky130_fd_pr__nfet_01v8_lvt w=1.5 l=0.15
X546 t_Xser_Xlane1_da t_Xser_clk500 t_Xser_Xlane1_Xmc_mid vdd sky130_fd_pr__pfet_01v8 w=3 l=0.15
X547 t_Xser_Xlane1_db t_Xser_clk500 t_Xser_Xlane1_Xmc_mid vss sky130_fd_pr__nfet_01v8_lvt w=1.5 l=0.15
X548 t_Xser_Xlane1_db t_Xser_clk500b t_Xser_Xlane1_Xmc_mid vdd sky130_fd_pr__pfet_01v8 w=3 l=0.15
X549 t_Xser_Xlane1_Xmc_yb t_Xser_Xlane1_Xmc_mid vss vss sky130_fd_pr__nfet_01v8_lvt w=1.5 l=0.15
X550 t_Xser_Xlane1_Xmc_yb t_Xser_Xlane1_Xmc_mid vdd vdd sky130_fd_pr__pfet_01v8 w=3 l=0.15
X551 t_Xser_Xlane1_mc t_Xser_Xlane1_Xmc_yb vss vss sky130_fd_pr__nfet_01v8_lvt w=1.5 l=0.15
X552 t_Xser_Xlane1_mc t_Xser_Xlane1_Xmc_yb vdd vdd sky130_fd_pr__pfet_01v8 w=3 l=0.15
X553 t_Xser_Xlane1_Xd1g_clkb t_Xser_c0 vss vss sky130_fd_pr__nfet_01v8_lvt w=1.2 l=0.15
X554 t_Xser_Xlane1_Xd1g_clkb t_Xser_c0 vdd vdd sky130_fd_pr__pfet_01v8 w=2.4 l=0.15
X555 t_Xser_Xlane1_Xd1g_clki t_Xser_Xlane1_Xd1g_clkb vss vss sky130_fd_pr__nfet_01v8_lvt w=1.2 l=0.15
X556 t_Xser_Xlane1_Xd1g_clki t_Xser_Xlane1_Xd1g_clkb vdd vdd sky130_fd_pr__pfet_01v8 w=2.4 l=0.15
X557 t_Xser_Xlane1_mc t_Xser_Xlane1_Xd1g_clkb t_Xser_Xlane1_Xd1g_m1 vss sky130_fd_pr__nfet_01v8_lvt w=1.5 l=0.15
X558 t_Xser_Xlane1_mc t_Xser_Xlane1_Xd1g_clki t_Xser_Xlane1_Xd1g_m1 vdd sky130_fd_pr__pfet_01v8 w=3 l=0.15
X559 t_Xser_Xlane1_Xd1g_m2 t_Xser_Xlane1_Xd1g_m1 t_Xser_Xlane1_Xd1g_Xm2_mid vss sky130_fd_pr__nfet_01v8_lvt w=2.25 l=0.15
X560 t_Xser_Xlane1_Xd1g_Xm2_mid rst_n vss vss sky130_fd_pr__nfet_01v8_lvt w=2.25 l=0.15
X561 t_Xser_Xlane1_Xd1g_m2 t_Xser_Xlane1_Xd1g_m1 vdd vdd sky130_fd_pr__pfet_01v8 w=3 l=0.15
X562 t_Xser_Xlane1_Xd1g_m2 rst_n vdd vdd sky130_fd_pr__pfet_01v8 w=3 l=0.15
X563 t_Xser_Xlane1_Xd1g_m3 t_Xser_Xlane1_Xd1g_m2 vss vss sky130_fd_pr__nfet_01v8_lvt w=0.8 l=0.15
X564 t_Xser_Xlane1_Xd1g_m3 t_Xser_Xlane1_Xd1g_m2 vdd vdd sky130_fd_pr__pfet_01v8 w=1.6 l=0.15
X565 t_Xser_Xlane1_Xd1g_m3 t_Xser_Xlane1_Xd1g_clki t_Xser_Xlane1_Xd1g_m1 vss sky130_fd_pr__nfet_01v8_lvt w=0.8 l=0.15
X566 t_Xser_Xlane1_Xd1g_m3 t_Xser_Xlane1_Xd1g_clkb t_Xser_Xlane1_Xd1g_m1 vdd sky130_fd_pr__pfet_01v8 w=1.6 l=0.15
X567 t_Xser_Xlane1_Xd1g_m2 t_Xser_Xlane1_Xd1g_clki t_Xser_Xlane1_Xd1g_s1 vss sky130_fd_pr__nfet_01v8_lvt w=1.5 l=0.15
X568 t_Xser_Xlane1_Xd1g_m2 t_Xser_Xlane1_Xd1g_clkb t_Xser_Xlane1_Xd1g_s1 vdd sky130_fd_pr__pfet_01v8 w=3 l=0.15
X569 t_Xser_Xlane1_Xd1g_qi t_Xser_Xlane1_Xd1g_s1 vss vss sky130_fd_pr__nfet_01v8_lvt w=1.8 l=0.15
X570 t_Xser_Xlane1_Xd1g_qi t_Xser_Xlane1_Xd1g_s1 vdd vdd sky130_fd_pr__pfet_01v8 w=3.6 l=0.15
X571 t_Xser_Xlane1_Xd1g_s2 t_Xser_Xlane1_Xd1g_qi t_Xser_Xlane1_Xd1g_Xsfb_mid vss sky130_fd_pr__nfet_01v8_lvt w=1.2 l=0.15
X572 t_Xser_Xlane1_Xd1g_Xsfb_mid rst_n vss vss sky130_fd_pr__nfet_01v8_lvt w=1.2 l=0.15
X573 t_Xser_Xlane1_Xd1g_s2 t_Xser_Xlane1_Xd1g_qi vdd vdd sky130_fd_pr__pfet_01v8 w=1.6 l=0.15
X574 t_Xser_Xlane1_Xd1g_s2 rst_n vdd vdd sky130_fd_pr__pfet_01v8 w=1.6 l=0.15
X575 t_Xser_Xlane1_Xd1g_s2 t_Xser_Xlane1_Xd1g_clkb t_Xser_Xlane1_Xd1g_s1 vss sky130_fd_pr__nfet_01v8_lvt w=0.8 l=0.15
X576 t_Xser_Xlane1_Xd1g_s2 t_Xser_Xlane1_Xd1g_clki t_Xser_Xlane1_Xd1g_s1 vdd sky130_fd_pr__pfet_01v8 w=1.6 l=0.15
X577 t_Xser_l1 t_Xser_Xlane1_Xd1g_s1 vss vss sky130_fd_pr__nfet_01v8_lvt w=2.25 l=0.15
X578 t_Xser_l1 t_Xser_Xlane1_Xd1g_s1 vdd vdd sky130_fd_pr__pfet_01v8 w=4.5 l=0.15
X579 t_Xser_Xlane1_l_outb t_Xser_Xlane1_Xd1g_qi vss vss sky130_fd_pr__nfet_01v8_lvt w=2.25 l=0.15
X580 t_Xser_Xlane1_l_outb t_Xser_Xlane1_Xd1g_qi vdd vdd sky130_fd_pr__pfet_01v8 w=4.5 l=0.15
X581 t_Xser_Xlane2_Xr0_clkb t_Xser_clk250b vss vss sky130_fd_pr__nfet_01v8_lvt w=1.2 l=0.15
X582 t_Xser_Xlane2_Xr0_clkb t_Xser_clk250b vdd vdd sky130_fd_pr__pfet_01v8 w=2.4 l=0.15
X583 t_Xser_Xlane2_Xr0_clki t_Xser_Xlane2_Xr0_clkb vss vss sky130_fd_pr__nfet_01v8_lvt w=1.2 l=0.15
X584 t_Xser_Xlane2_Xr0_clki t_Xser_Xlane2_Xr0_clkb vdd vdd sky130_fd_pr__pfet_01v8 w=2.4 l=0.15
X585 din2 t_Xser_Xlane2_Xr0_clkb t_Xser_Xlane2_Xr0_m1 vss sky130_fd_pr__nfet_01v8_lvt w=0.8 l=0.15
X586 din2 t_Xser_Xlane2_Xr0_clki t_Xser_Xlane2_Xr0_m1 vdd sky130_fd_pr__pfet_01v8 w=1.6 l=0.15
X587 t_Xser_Xlane2_Xr0_m2 t_Xser_Xlane2_Xr0_m1 t_Xser_Xlane2_Xr0_Xm2_mid vss sky130_fd_pr__nfet_01v8_lvt w=1.2 l=0.15
X588 t_Xser_Xlane2_Xr0_Xm2_mid rst_n vss vss sky130_fd_pr__nfet_01v8_lvt w=1.2 l=0.15
X589 t_Xser_Xlane2_Xr0_m2 t_Xser_Xlane2_Xr0_m1 vdd vdd sky130_fd_pr__pfet_01v8 w=1.6 l=0.15
X590 t_Xser_Xlane2_Xr0_m2 rst_n vdd vdd sky130_fd_pr__pfet_01v8 w=1.6 l=0.15
X591 t_Xser_Xlane2_Xr0_m3 t_Xser_Xlane2_Xr0_m2 vss vss sky130_fd_pr__nfet_01v8_lvt w=0.8 l=0.15
X592 t_Xser_Xlane2_Xr0_m3 t_Xser_Xlane2_Xr0_m2 vdd vdd sky130_fd_pr__pfet_01v8 w=1.6 l=0.15
X593 t_Xser_Xlane2_Xr0_m3 t_Xser_Xlane2_Xr0_clki t_Xser_Xlane2_Xr0_m1 vss sky130_fd_pr__nfet_01v8_lvt w=0.8 l=0.15
X594 t_Xser_Xlane2_Xr0_m3 t_Xser_Xlane2_Xr0_clkb t_Xser_Xlane2_Xr0_m1 vdd sky130_fd_pr__pfet_01v8 w=1.6 l=0.15
X595 t_Xser_Xlane2_Xr0_m2 t_Xser_Xlane2_Xr0_clki t_Xser_Xlane2_Xr0_s1 vss sky130_fd_pr__nfet_01v8_lvt w=0.8 l=0.15
X596 t_Xser_Xlane2_Xr0_m2 t_Xser_Xlane2_Xr0_clkb t_Xser_Xlane2_Xr0_s1 vdd sky130_fd_pr__pfet_01v8 w=1.6 l=0.15
X597 t_Xser_Xlane2_Xr0_qi t_Xser_Xlane2_Xr0_s1 vss vss sky130_fd_pr__nfet_01v8_lvt w=0.96 l=0.15
X598 t_Xser_Xlane2_Xr0_qi t_Xser_Xlane2_Xr0_s1 vdd vdd sky130_fd_pr__pfet_01v8 w=1.92 l=0.15
X599 t_Xser_Xlane2_Xr0_s2 t_Xser_Xlane2_Xr0_qi t_Xser_Xlane2_Xr0_Xsfb_mid vss sky130_fd_pr__nfet_01v8_lvt w=1.2 l=0.15
X600 t_Xser_Xlane2_Xr0_Xsfb_mid rst_n vss vss sky130_fd_pr__nfet_01v8_lvt w=1.2 l=0.15
X601 t_Xser_Xlane2_Xr0_s2 t_Xser_Xlane2_Xr0_qi vdd vdd sky130_fd_pr__pfet_01v8 w=1.6 l=0.15
X602 t_Xser_Xlane2_Xr0_s2 rst_n vdd vdd sky130_fd_pr__pfet_01v8 w=1.6 l=0.15
X603 t_Xser_Xlane2_Xr0_s2 t_Xser_Xlane2_Xr0_clkb t_Xser_Xlane2_Xr0_s1 vss sky130_fd_pr__nfet_01v8_lvt w=0.8 l=0.15
X604 t_Xser_Xlane2_Xr0_s2 t_Xser_Xlane2_Xr0_clki t_Xser_Xlane2_Xr0_s1 vdd sky130_fd_pr__pfet_01v8 w=1.6 l=0.15
X605 t_Xser_Xlane2_r0 t_Xser_Xlane2_Xr0_s1 vss vss sky130_fd_pr__nfet_01v8_lvt w=1.2 l=0.15
X606 t_Xser_Xlane2_r0 t_Xser_Xlane2_Xr0_s1 vdd vdd sky130_fd_pr__pfet_01v8 w=2.4 l=0.15
X607 t_Xser_Xlane2_r0b t_Xser_Xlane2_Xr0_qi vss vss sky130_fd_pr__nfet_01v8_lvt w=1.2 l=0.15
X608 t_Xser_Xlane2_r0b t_Xser_Xlane2_Xr0_qi vdd vdd sky130_fd_pr__pfet_01v8 w=2.4 l=0.15
X609 t_Xser_Xlane2_Xr1_clkb t_Xser_clk250b vss vss sky130_fd_pr__nfet_01v8_lvt w=1.2 l=0.15
X610 t_Xser_Xlane2_Xr1_clkb t_Xser_clk250b vdd vdd sky130_fd_pr__pfet_01v8 w=2.4 l=0.15
X611 t_Xser_Xlane2_Xr1_clki t_Xser_Xlane2_Xr1_clkb vss vss sky130_fd_pr__nfet_01v8_lvt w=1.2 l=0.15
X612 t_Xser_Xlane2_Xr1_clki t_Xser_Xlane2_Xr1_clkb vdd vdd sky130_fd_pr__pfet_01v8 w=2.4 l=0.15
X613 din6 t_Xser_Xlane2_Xr1_clkb t_Xser_Xlane2_Xr1_m1 vss sky130_fd_pr__nfet_01v8_lvt w=0.8 l=0.15
X614 din6 t_Xser_Xlane2_Xr1_clki t_Xser_Xlane2_Xr1_m1 vdd sky130_fd_pr__pfet_01v8 w=1.6 l=0.15
X615 t_Xser_Xlane2_Xr1_m2 t_Xser_Xlane2_Xr1_m1 t_Xser_Xlane2_Xr1_Xm2_mid vss sky130_fd_pr__nfet_01v8_lvt w=1.2 l=0.15
X616 t_Xser_Xlane2_Xr1_Xm2_mid rst_n vss vss sky130_fd_pr__nfet_01v8_lvt w=1.2 l=0.15
X617 t_Xser_Xlane2_Xr1_m2 t_Xser_Xlane2_Xr1_m1 vdd vdd sky130_fd_pr__pfet_01v8 w=1.6 l=0.15
X618 t_Xser_Xlane2_Xr1_m2 rst_n vdd vdd sky130_fd_pr__pfet_01v8 w=1.6 l=0.15
X619 t_Xser_Xlane2_Xr1_m3 t_Xser_Xlane2_Xr1_m2 vss vss sky130_fd_pr__nfet_01v8_lvt w=0.8 l=0.15
X620 t_Xser_Xlane2_Xr1_m3 t_Xser_Xlane2_Xr1_m2 vdd vdd sky130_fd_pr__pfet_01v8 w=1.6 l=0.15
X621 t_Xser_Xlane2_Xr1_m3 t_Xser_Xlane2_Xr1_clki t_Xser_Xlane2_Xr1_m1 vss sky130_fd_pr__nfet_01v8_lvt w=0.8 l=0.15
X622 t_Xser_Xlane2_Xr1_m3 t_Xser_Xlane2_Xr1_clkb t_Xser_Xlane2_Xr1_m1 vdd sky130_fd_pr__pfet_01v8 w=1.6 l=0.15
X623 t_Xser_Xlane2_Xr1_m2 t_Xser_Xlane2_Xr1_clki t_Xser_Xlane2_Xr1_s1 vss sky130_fd_pr__nfet_01v8_lvt w=0.8 l=0.15
X624 t_Xser_Xlane2_Xr1_m2 t_Xser_Xlane2_Xr1_clkb t_Xser_Xlane2_Xr1_s1 vdd sky130_fd_pr__pfet_01v8 w=1.6 l=0.15
X625 t_Xser_Xlane2_Xr1_qi t_Xser_Xlane2_Xr1_s1 vss vss sky130_fd_pr__nfet_01v8_lvt w=0.96 l=0.15
X626 t_Xser_Xlane2_Xr1_qi t_Xser_Xlane2_Xr1_s1 vdd vdd sky130_fd_pr__pfet_01v8 w=1.92 l=0.15
X627 t_Xser_Xlane2_Xr1_s2 t_Xser_Xlane2_Xr1_qi t_Xser_Xlane2_Xr1_Xsfb_mid vss sky130_fd_pr__nfet_01v8_lvt w=1.2 l=0.15
X628 t_Xser_Xlane2_Xr1_Xsfb_mid rst_n vss vss sky130_fd_pr__nfet_01v8_lvt w=1.2 l=0.15
X629 t_Xser_Xlane2_Xr1_s2 t_Xser_Xlane2_Xr1_qi vdd vdd sky130_fd_pr__pfet_01v8 w=1.6 l=0.15
X630 t_Xser_Xlane2_Xr1_s2 rst_n vdd vdd sky130_fd_pr__pfet_01v8 w=1.6 l=0.15
X631 t_Xser_Xlane2_Xr1_s2 t_Xser_Xlane2_Xr1_clkb t_Xser_Xlane2_Xr1_s1 vss sky130_fd_pr__nfet_01v8_lvt w=0.8 l=0.15
X632 t_Xser_Xlane2_Xr1_s2 t_Xser_Xlane2_Xr1_clki t_Xser_Xlane2_Xr1_s1 vdd sky130_fd_pr__pfet_01v8 w=1.6 l=0.15
X633 t_Xser_Xlane2_r1 t_Xser_Xlane2_Xr1_s1 vss vss sky130_fd_pr__nfet_01v8_lvt w=1.2 l=0.15
X634 t_Xser_Xlane2_r1 t_Xser_Xlane2_Xr1_s1 vdd vdd sky130_fd_pr__pfet_01v8 w=2.4 l=0.15
X635 t_Xser_Xlane2_r1b t_Xser_Xlane2_Xr1_qi vss vss sky130_fd_pr__nfet_01v8_lvt w=1.2 l=0.15
X636 t_Xser_Xlane2_r1b t_Xser_Xlane2_Xr1_qi vdd vdd sky130_fd_pr__pfet_01v8 w=2.4 l=0.15
X637 t_Xser_Xlane2_Xr2_clkb t_Xser_clk250b vss vss sky130_fd_pr__nfet_01v8_lvt w=1.2 l=0.15
X638 t_Xser_Xlane2_Xr2_clkb t_Xser_clk250b vdd vdd sky130_fd_pr__pfet_01v8 w=2.4 l=0.15
X639 t_Xser_Xlane2_Xr2_clki t_Xser_Xlane2_Xr2_clkb vss vss sky130_fd_pr__nfet_01v8_lvt w=1.2 l=0.15
X640 t_Xser_Xlane2_Xr2_clki t_Xser_Xlane2_Xr2_clkb vdd vdd sky130_fd_pr__pfet_01v8 w=2.4 l=0.15
X641 din10 t_Xser_Xlane2_Xr2_clkb t_Xser_Xlane2_Xr2_m1 vss sky130_fd_pr__nfet_01v8_lvt w=0.8 l=0.15
X642 din10 t_Xser_Xlane2_Xr2_clki t_Xser_Xlane2_Xr2_m1 vdd sky130_fd_pr__pfet_01v8 w=1.6 l=0.15
X643 t_Xser_Xlane2_Xr2_m2 t_Xser_Xlane2_Xr2_m1 t_Xser_Xlane2_Xr2_Xm2_mid vss sky130_fd_pr__nfet_01v8_lvt w=1.2 l=0.15
X644 t_Xser_Xlane2_Xr2_Xm2_mid rst_n vss vss sky130_fd_pr__nfet_01v8_lvt w=1.2 l=0.15
X645 t_Xser_Xlane2_Xr2_m2 t_Xser_Xlane2_Xr2_m1 vdd vdd sky130_fd_pr__pfet_01v8 w=1.6 l=0.15
X646 t_Xser_Xlane2_Xr2_m2 rst_n vdd vdd sky130_fd_pr__pfet_01v8 w=1.6 l=0.15
X647 t_Xser_Xlane2_Xr2_m3 t_Xser_Xlane2_Xr2_m2 vss vss sky130_fd_pr__nfet_01v8_lvt w=0.8 l=0.15
X648 t_Xser_Xlane2_Xr2_m3 t_Xser_Xlane2_Xr2_m2 vdd vdd sky130_fd_pr__pfet_01v8 w=1.6 l=0.15
X649 t_Xser_Xlane2_Xr2_m3 t_Xser_Xlane2_Xr2_clki t_Xser_Xlane2_Xr2_m1 vss sky130_fd_pr__nfet_01v8_lvt w=0.8 l=0.15
X650 t_Xser_Xlane2_Xr2_m3 t_Xser_Xlane2_Xr2_clkb t_Xser_Xlane2_Xr2_m1 vdd sky130_fd_pr__pfet_01v8 w=1.6 l=0.15
X651 t_Xser_Xlane2_Xr2_m2 t_Xser_Xlane2_Xr2_clki t_Xser_Xlane2_Xr2_s1 vss sky130_fd_pr__nfet_01v8_lvt w=0.8 l=0.15
X652 t_Xser_Xlane2_Xr2_m2 t_Xser_Xlane2_Xr2_clkb t_Xser_Xlane2_Xr2_s1 vdd sky130_fd_pr__pfet_01v8 w=1.6 l=0.15
X653 t_Xser_Xlane2_Xr2_qi t_Xser_Xlane2_Xr2_s1 vss vss sky130_fd_pr__nfet_01v8_lvt w=0.96 l=0.15
X654 t_Xser_Xlane2_Xr2_qi t_Xser_Xlane2_Xr2_s1 vdd vdd sky130_fd_pr__pfet_01v8 w=1.92 l=0.15
X655 t_Xser_Xlane2_Xr2_s2 t_Xser_Xlane2_Xr2_qi t_Xser_Xlane2_Xr2_Xsfb_mid vss sky130_fd_pr__nfet_01v8_lvt w=1.2 l=0.15
X656 t_Xser_Xlane2_Xr2_Xsfb_mid rst_n vss vss sky130_fd_pr__nfet_01v8_lvt w=1.2 l=0.15
X657 t_Xser_Xlane2_Xr2_s2 t_Xser_Xlane2_Xr2_qi vdd vdd sky130_fd_pr__pfet_01v8 w=1.6 l=0.15
X658 t_Xser_Xlane2_Xr2_s2 rst_n vdd vdd sky130_fd_pr__pfet_01v8 w=1.6 l=0.15
X659 t_Xser_Xlane2_Xr2_s2 t_Xser_Xlane2_Xr2_clkb t_Xser_Xlane2_Xr2_s1 vss sky130_fd_pr__nfet_01v8_lvt w=0.8 l=0.15
X660 t_Xser_Xlane2_Xr2_s2 t_Xser_Xlane2_Xr2_clki t_Xser_Xlane2_Xr2_s1 vdd sky130_fd_pr__pfet_01v8 w=1.6 l=0.15
X661 t_Xser_Xlane2_r2 t_Xser_Xlane2_Xr2_s1 vss vss sky130_fd_pr__nfet_01v8_lvt w=1.2 l=0.15
X662 t_Xser_Xlane2_r2 t_Xser_Xlane2_Xr2_s1 vdd vdd sky130_fd_pr__pfet_01v8 w=2.4 l=0.15
X663 t_Xser_Xlane2_r2b t_Xser_Xlane2_Xr2_qi vss vss sky130_fd_pr__nfet_01v8_lvt w=1.2 l=0.15
X664 t_Xser_Xlane2_r2b t_Xser_Xlane2_Xr2_qi vdd vdd sky130_fd_pr__pfet_01v8 w=2.4 l=0.15
X665 t_Xser_Xlane2_Xr3_m_clkb t_Xser_clk250b vss vss sky130_fd_pr__nfet_01v8_lvt w=1.2 l=0.15
X666 t_Xser_Xlane2_Xr3_m_clkb t_Xser_clk250b vdd vdd sky130_fd_pr__pfet_01v8 w=2.4 l=0.15
X667 t_Xser_Xlane2_Xr3_m_clki t_Xser_Xlane2_Xr3_m_clkb vss vss sky130_fd_pr__nfet_01v8_lvt w=1.2 l=0.15
X668 t_Xser_Xlane2_Xr3_m_clki t_Xser_Xlane2_Xr3_m_clkb vdd vdd sky130_fd_pr__pfet_01v8 w=2.4 l=0.15
X669 din14 t_Xser_Xlane2_Xr3_m_clkb t_Xser_Xlane2_Xr3_m_m1 vss sky130_fd_pr__nfet_01v8_lvt w=0.8 l=0.15
X670 din14 t_Xser_Xlane2_Xr3_m_clki t_Xser_Xlane2_Xr3_m_m1 vdd sky130_fd_pr__pfet_01v8 w=1.6 l=0.15
X671 t_Xser_Xlane2_Xr3_m_m2 t_Xser_Xlane2_Xr3_m_m1 t_Xser_Xlane2_Xr3_m_Xm2_mid vss sky130_fd_pr__nfet_01v8_lvt w=1.2 l=0.15
X672 t_Xser_Xlane2_Xr3_m_Xm2_mid rst_n vss vss sky130_fd_pr__nfet_01v8_lvt w=1.2 l=0.15
X673 t_Xser_Xlane2_Xr3_m_m2 t_Xser_Xlane2_Xr3_m_m1 vdd vdd sky130_fd_pr__pfet_01v8 w=1.6 l=0.15
X674 t_Xser_Xlane2_Xr3_m_m2 rst_n vdd vdd sky130_fd_pr__pfet_01v8 w=1.6 l=0.15
X675 t_Xser_Xlane2_Xr3_m_m3 t_Xser_Xlane2_Xr3_m_m2 vss vss sky130_fd_pr__nfet_01v8_lvt w=0.8 l=0.15
X676 t_Xser_Xlane2_Xr3_m_m3 t_Xser_Xlane2_Xr3_m_m2 vdd vdd sky130_fd_pr__pfet_01v8 w=1.6 l=0.15
X677 t_Xser_Xlane2_Xr3_m_m3 t_Xser_Xlane2_Xr3_m_clki t_Xser_Xlane2_Xr3_m_m1 vss sky130_fd_pr__nfet_01v8_lvt w=0.8 l=0.15
X678 t_Xser_Xlane2_Xr3_m_m3 t_Xser_Xlane2_Xr3_m_clkb t_Xser_Xlane2_Xr3_m_m1 vdd sky130_fd_pr__pfet_01v8 w=1.6 l=0.15
X679 t_Xser_Xlane2_Xr3_m_m2 t_Xser_Xlane2_Xr3_m_clki t_Xser_Xlane2_Xr3_m_s1 vss sky130_fd_pr__nfet_01v8_lvt w=0.8 l=0.15
X680 t_Xser_Xlane2_Xr3_m_m2 t_Xser_Xlane2_Xr3_m_clkb t_Xser_Xlane2_Xr3_m_s1 vdd sky130_fd_pr__pfet_01v8 w=1.6 l=0.15
X681 t_Xser_Xlane2_Xr3_m_qi t_Xser_Xlane2_Xr3_m_s1 vss vss sky130_fd_pr__nfet_01v8_lvt w=0.96 l=0.15
X682 t_Xser_Xlane2_Xr3_m_qi t_Xser_Xlane2_Xr3_m_s1 vdd vdd sky130_fd_pr__pfet_01v8 w=1.92 l=0.15
X683 t_Xser_Xlane2_Xr3_m_s2 t_Xser_Xlane2_Xr3_m_qi t_Xser_Xlane2_Xr3_m_Xsfb_mid vss sky130_fd_pr__nfet_01v8_lvt w=1.2 l=0.15
X684 t_Xser_Xlane2_Xr3_m_Xsfb_mid rst_n vss vss sky130_fd_pr__nfet_01v8_lvt w=1.2 l=0.15
X685 t_Xser_Xlane2_Xr3_m_s2 t_Xser_Xlane2_Xr3_m_qi vdd vdd sky130_fd_pr__pfet_01v8 w=1.6 l=0.15
X686 t_Xser_Xlane2_Xr3_m_s2 rst_n vdd vdd sky130_fd_pr__pfet_01v8 w=1.6 l=0.15
X687 t_Xser_Xlane2_Xr3_m_s2 t_Xser_Xlane2_Xr3_m_clkb t_Xser_Xlane2_Xr3_m_s1 vss sky130_fd_pr__nfet_01v8_lvt w=0.8 l=0.15
X688 t_Xser_Xlane2_Xr3_m_s2 t_Xser_Xlane2_Xr3_m_clki t_Xser_Xlane2_Xr3_m_s1 vdd sky130_fd_pr__pfet_01v8 w=1.6 l=0.15
X689 t_Xser_Xlane2_r3_m t_Xser_Xlane2_Xr3_m_s1 vss vss sky130_fd_pr__nfet_01v8_lvt w=1.2 l=0.15
X690 t_Xser_Xlane2_r3_m t_Xser_Xlane2_Xr3_m_s1 vdd vdd sky130_fd_pr__pfet_01v8 w=2.4 l=0.15
X691 t_Xser_Xlane2_r3_mb t_Xser_Xlane2_Xr3_m_qi vss vss sky130_fd_pr__nfet_01v8_lvt w=1.2 l=0.15
X692 t_Xser_Xlane2_r3_mb t_Xser_Xlane2_Xr3_m_qi vdd vdd sky130_fd_pr__pfet_01v8 w=2.4 l=0.15
X693 t_Xser_Xlane2_Xr3_clkb t_Xser_clk250 vss vss sky130_fd_pr__nfet_01v8_lvt w=1.2 l=0.15
X694 t_Xser_Xlane2_Xr3_clkb t_Xser_clk250 vdd vdd sky130_fd_pr__pfet_01v8 w=2.4 l=0.15
X695 t_Xser_Xlane2_Xr3_clki t_Xser_Xlane2_Xr3_clkb vss vss sky130_fd_pr__nfet_01v8_lvt w=1.2 l=0.15
X696 t_Xser_Xlane2_Xr3_clki t_Xser_Xlane2_Xr3_clkb vdd vdd sky130_fd_pr__pfet_01v8 w=2.4 l=0.15
X697 t_Xser_Xlane2_r3_m t_Xser_Xlane2_Xr3_clkb t_Xser_Xlane2_Xr3_m1 vss sky130_fd_pr__nfet_01v8_lvt w=0.8 l=0.15
X698 t_Xser_Xlane2_r3_m t_Xser_Xlane2_Xr3_clki t_Xser_Xlane2_Xr3_m1 vdd sky130_fd_pr__pfet_01v8 w=1.6 l=0.15
X699 t_Xser_Xlane2_Xr3_m2 t_Xser_Xlane2_Xr3_m1 t_Xser_Xlane2_Xr3_Xm2_mid vss sky130_fd_pr__nfet_01v8_lvt w=1.2 l=0.15
X700 t_Xser_Xlane2_Xr3_Xm2_mid rst_n vss vss sky130_fd_pr__nfet_01v8_lvt w=1.2 l=0.15
X701 t_Xser_Xlane2_Xr3_m2 t_Xser_Xlane2_Xr3_m1 vdd vdd sky130_fd_pr__pfet_01v8 w=1.6 l=0.15
X702 t_Xser_Xlane2_Xr3_m2 rst_n vdd vdd sky130_fd_pr__pfet_01v8 w=1.6 l=0.15
X703 t_Xser_Xlane2_Xr3_m3 t_Xser_Xlane2_Xr3_m2 vss vss sky130_fd_pr__nfet_01v8_lvt w=0.8 l=0.15
X704 t_Xser_Xlane2_Xr3_m3 t_Xser_Xlane2_Xr3_m2 vdd vdd sky130_fd_pr__pfet_01v8 w=1.6 l=0.15
X705 t_Xser_Xlane2_Xr3_m3 t_Xser_Xlane2_Xr3_clki t_Xser_Xlane2_Xr3_m1 vss sky130_fd_pr__nfet_01v8_lvt w=0.8 l=0.15
X706 t_Xser_Xlane2_Xr3_m3 t_Xser_Xlane2_Xr3_clkb t_Xser_Xlane2_Xr3_m1 vdd sky130_fd_pr__pfet_01v8 w=1.6 l=0.15
X707 t_Xser_Xlane2_Xr3_m2 t_Xser_Xlane2_Xr3_clki t_Xser_Xlane2_Xr3_s1 vss sky130_fd_pr__nfet_01v8_lvt w=0.8 l=0.15
X708 t_Xser_Xlane2_Xr3_m2 t_Xser_Xlane2_Xr3_clkb t_Xser_Xlane2_Xr3_s1 vdd sky130_fd_pr__pfet_01v8 w=1.6 l=0.15
X709 t_Xser_Xlane2_Xr3_qi t_Xser_Xlane2_Xr3_s1 vss vss sky130_fd_pr__nfet_01v8_lvt w=0.96 l=0.15
X710 t_Xser_Xlane2_Xr3_qi t_Xser_Xlane2_Xr3_s1 vdd vdd sky130_fd_pr__pfet_01v8 w=1.92 l=0.15
X711 t_Xser_Xlane2_Xr3_s2 t_Xser_Xlane2_Xr3_qi t_Xser_Xlane2_Xr3_Xsfb_mid vss sky130_fd_pr__nfet_01v8_lvt w=1.2 l=0.15
X712 t_Xser_Xlane2_Xr3_Xsfb_mid rst_n vss vss sky130_fd_pr__nfet_01v8_lvt w=1.2 l=0.15
X713 t_Xser_Xlane2_Xr3_s2 t_Xser_Xlane2_Xr3_qi vdd vdd sky130_fd_pr__pfet_01v8 w=1.6 l=0.15
X714 t_Xser_Xlane2_Xr3_s2 rst_n vdd vdd sky130_fd_pr__pfet_01v8 w=1.6 l=0.15
X715 t_Xser_Xlane2_Xr3_s2 t_Xser_Xlane2_Xr3_clkb t_Xser_Xlane2_Xr3_s1 vss sky130_fd_pr__nfet_01v8_lvt w=0.8 l=0.15
X716 t_Xser_Xlane2_Xr3_s2 t_Xser_Xlane2_Xr3_clki t_Xser_Xlane2_Xr3_s1 vdd sky130_fd_pr__pfet_01v8 w=1.6 l=0.15
X717 t_Xser_Xlane2_r3 t_Xser_Xlane2_Xr3_s1 vss vss sky130_fd_pr__nfet_01v8_lvt w=1.2 l=0.15
X718 t_Xser_Xlane2_r3 t_Xser_Xlane2_Xr3_s1 vdd vdd sky130_fd_pr__pfet_01v8 w=2.4 l=0.15
X719 t_Xser_Xlane2_r3b t_Xser_Xlane2_Xr3_qi vss vss sky130_fd_pr__nfet_01v8_lvt w=1.2 l=0.15
X720 t_Xser_Xlane2_r3b t_Xser_Xlane2_Xr3_qi vdd vdd sky130_fd_pr__pfet_01v8 w=2.4 l=0.15
X721 t_Xser_Xlane2_r2 t_Xser_clk250 t_Xser_Xlane2_Xma_mid vss sky130_fd_pr__nfet_01v8_lvt w=0.9 l=0.15
X722 t_Xser_Xlane2_r2 t_Xser_clk250b t_Xser_Xlane2_Xma_mid vdd sky130_fd_pr__pfet_01v8 w=1.8 l=0.15
X723 t_Xser_Xlane2_r0 t_Xser_clk250b t_Xser_Xlane2_Xma_mid vss sky130_fd_pr__nfet_01v8_lvt w=0.9 l=0.15
X724 t_Xser_Xlane2_r0 t_Xser_clk250 t_Xser_Xlane2_Xma_mid vdd sky130_fd_pr__pfet_01v8 w=1.8 l=0.15
X725 t_Xser_Xlane2_Xma_yb t_Xser_Xlane2_Xma_mid vss vss sky130_fd_pr__nfet_01v8_lvt w=0.9 l=0.15
X726 t_Xser_Xlane2_Xma_yb t_Xser_Xlane2_Xma_mid vdd vdd sky130_fd_pr__pfet_01v8 w=1.8 l=0.15
X727 t_Xser_Xlane2_ma t_Xser_Xlane2_Xma_yb vss vss sky130_fd_pr__nfet_01v8_lvt w=0.9 l=0.15
X728 t_Xser_Xlane2_ma t_Xser_Xlane2_Xma_yb vdd vdd sky130_fd_pr__pfet_01v8 w=1.8 l=0.15
X729 t_Xser_Xlane2_r1 t_Xser_clk250 t_Xser_Xlane2_Xmb_mid vss sky130_fd_pr__nfet_01v8_lvt w=0.9 l=0.15
X730 t_Xser_Xlane2_r1 t_Xser_clk250b t_Xser_Xlane2_Xmb_mid vdd sky130_fd_pr__pfet_01v8 w=1.8 l=0.15
X731 t_Xser_Xlane2_r3 t_Xser_clk250b t_Xser_Xlane2_Xmb_mid vss sky130_fd_pr__nfet_01v8_lvt w=0.9 l=0.15
X732 t_Xser_Xlane2_r3 t_Xser_clk250 t_Xser_Xlane2_Xmb_mid vdd sky130_fd_pr__pfet_01v8 w=1.8 l=0.15
X733 t_Xser_Xlane2_Xmb_yb t_Xser_Xlane2_Xmb_mid vss vss sky130_fd_pr__nfet_01v8_lvt w=0.9 l=0.15
X734 t_Xser_Xlane2_Xmb_yb t_Xser_Xlane2_Xmb_mid vdd vdd sky130_fd_pr__pfet_01v8 w=1.8 l=0.15
X735 t_Xser_Xlane2_mb t_Xser_Xlane2_Xmb_yb vss vss sky130_fd_pr__nfet_01v8_lvt w=0.9 l=0.15
X736 t_Xser_Xlane2_mb t_Xser_Xlane2_Xmb_yb vdd vdd sky130_fd_pr__pfet_01v8 w=1.8 l=0.15
X737 t_Xser_Xlane2_Xda_clkb t_Xser_clk500 vss vss sky130_fd_pr__nfet_01v8_lvt w=1.2 l=0.15
X738 t_Xser_Xlane2_Xda_clkb t_Xser_clk500 vdd vdd sky130_fd_pr__pfet_01v8 w=2.4 l=0.15
X739 t_Xser_Xlane2_Xda_clki t_Xser_Xlane2_Xda_clkb vss vss sky130_fd_pr__nfet_01v8_lvt w=1.2 l=0.15
X740 t_Xser_Xlane2_Xda_clki t_Xser_Xlane2_Xda_clkb vdd vdd sky130_fd_pr__pfet_01v8 w=2.4 l=0.15
X741 t_Xser_Xlane2_ma t_Xser_Xlane2_Xda_clkb t_Xser_Xlane2_Xda_m1 vss sky130_fd_pr__nfet_01v8_lvt w=1.2 l=0.15
X742 t_Xser_Xlane2_ma t_Xser_Xlane2_Xda_clki t_Xser_Xlane2_Xda_m1 vdd sky130_fd_pr__pfet_01v8 w=2.4 l=0.15
X743 t_Xser_Xlane2_Xda_m2 t_Xser_Xlane2_Xda_m1 t_Xser_Xlane2_Xda_Xm2_mid vss sky130_fd_pr__nfet_01v8_lvt w=1.8 l=0.15
X744 t_Xser_Xlane2_Xda_Xm2_mid rst_n vss vss sky130_fd_pr__nfet_01v8_lvt w=1.8 l=0.15
X745 t_Xser_Xlane2_Xda_m2 t_Xser_Xlane2_Xda_m1 vdd vdd sky130_fd_pr__pfet_01v8 w=2.4 l=0.15
X746 t_Xser_Xlane2_Xda_m2 rst_n vdd vdd sky130_fd_pr__pfet_01v8 w=2.4 l=0.15
X747 t_Xser_Xlane2_Xda_m3 t_Xser_Xlane2_Xda_m2 vss vss sky130_fd_pr__nfet_01v8_lvt w=0.8 l=0.15
X748 t_Xser_Xlane2_Xda_m3 t_Xser_Xlane2_Xda_m2 vdd vdd sky130_fd_pr__pfet_01v8 w=1.6 l=0.15
X749 t_Xser_Xlane2_Xda_m3 t_Xser_Xlane2_Xda_clki t_Xser_Xlane2_Xda_m1 vss sky130_fd_pr__nfet_01v8_lvt w=0.8 l=0.15
X750 t_Xser_Xlane2_Xda_m3 t_Xser_Xlane2_Xda_clkb t_Xser_Xlane2_Xda_m1 vdd sky130_fd_pr__pfet_01v8 w=1.6 l=0.15
X751 t_Xser_Xlane2_Xda_m2 t_Xser_Xlane2_Xda_clki t_Xser_Xlane2_Xda_s1 vss sky130_fd_pr__nfet_01v8_lvt w=1.2 l=0.15
X752 t_Xser_Xlane2_Xda_m2 t_Xser_Xlane2_Xda_clkb t_Xser_Xlane2_Xda_s1 vdd sky130_fd_pr__pfet_01v8 w=2.4 l=0.15
X753 t_Xser_Xlane2_Xda_qi t_Xser_Xlane2_Xda_s1 vss vss sky130_fd_pr__nfet_01v8_lvt w=1.44 l=0.15
X754 t_Xser_Xlane2_Xda_qi t_Xser_Xlane2_Xda_s1 vdd vdd sky130_fd_pr__pfet_01v8 w=2.88 l=0.15
X755 t_Xser_Xlane2_Xda_s2 t_Xser_Xlane2_Xda_qi t_Xser_Xlane2_Xda_Xsfb_mid vss sky130_fd_pr__nfet_01v8_lvt w=1.2 l=0.15
X756 t_Xser_Xlane2_Xda_Xsfb_mid rst_n vss vss sky130_fd_pr__nfet_01v8_lvt w=1.2 l=0.15
X757 t_Xser_Xlane2_Xda_s2 t_Xser_Xlane2_Xda_qi vdd vdd sky130_fd_pr__pfet_01v8 w=1.6 l=0.15
X758 t_Xser_Xlane2_Xda_s2 rst_n vdd vdd sky130_fd_pr__pfet_01v8 w=1.6 l=0.15
X759 t_Xser_Xlane2_Xda_s2 t_Xser_Xlane2_Xda_clkb t_Xser_Xlane2_Xda_s1 vss sky130_fd_pr__nfet_01v8_lvt w=0.8 l=0.15
X760 t_Xser_Xlane2_Xda_s2 t_Xser_Xlane2_Xda_clki t_Xser_Xlane2_Xda_s1 vdd sky130_fd_pr__pfet_01v8 w=1.6 l=0.15
X761 t_Xser_Xlane2_da t_Xser_Xlane2_Xda_s1 vss vss sky130_fd_pr__nfet_01v8_lvt w=1.8 l=0.15
X762 t_Xser_Xlane2_da t_Xser_Xlane2_Xda_s1 vdd vdd sky130_fd_pr__pfet_01v8 w=3.6 l=0.15
X763 t_Xser_Xlane2_dab t_Xser_Xlane2_Xda_qi vss vss sky130_fd_pr__nfet_01v8_lvt w=1.8 l=0.15
X764 t_Xser_Xlane2_dab t_Xser_Xlane2_Xda_qi vdd vdd sky130_fd_pr__pfet_01v8 w=3.6 l=0.15
X765 t_Xser_Xlane2_Xdb_clkb t_Xser_clk500b vss vss sky130_fd_pr__nfet_01v8_lvt w=1.2 l=0.15
X766 t_Xser_Xlane2_Xdb_clkb t_Xser_clk500b vdd vdd sky130_fd_pr__pfet_01v8 w=2.4 l=0.15
X767 t_Xser_Xlane2_Xdb_clki t_Xser_Xlane2_Xdb_clkb vss vss sky130_fd_pr__nfet_01v8_lvt w=1.2 l=0.15
X768 t_Xser_Xlane2_Xdb_clki t_Xser_Xlane2_Xdb_clkb vdd vdd sky130_fd_pr__pfet_01v8 w=2.4 l=0.15
X769 t_Xser_Xlane2_mb t_Xser_Xlane2_Xdb_clkb t_Xser_Xlane2_Xdb_m1 vss sky130_fd_pr__nfet_01v8_lvt w=1.2 l=0.15
X770 t_Xser_Xlane2_mb t_Xser_Xlane2_Xdb_clki t_Xser_Xlane2_Xdb_m1 vdd sky130_fd_pr__pfet_01v8 w=2.4 l=0.15
X771 t_Xser_Xlane2_Xdb_m2 t_Xser_Xlane2_Xdb_m1 t_Xser_Xlane2_Xdb_Xm2_mid vss sky130_fd_pr__nfet_01v8_lvt w=1.8 l=0.15
X772 t_Xser_Xlane2_Xdb_Xm2_mid rst_n vss vss sky130_fd_pr__nfet_01v8_lvt w=1.8 l=0.15
X773 t_Xser_Xlane2_Xdb_m2 t_Xser_Xlane2_Xdb_m1 vdd vdd sky130_fd_pr__pfet_01v8 w=2.4 l=0.15
X774 t_Xser_Xlane2_Xdb_m2 rst_n vdd vdd sky130_fd_pr__pfet_01v8 w=2.4 l=0.15
X775 t_Xser_Xlane2_Xdb_m3 t_Xser_Xlane2_Xdb_m2 vss vss sky130_fd_pr__nfet_01v8_lvt w=0.8 l=0.15
X776 t_Xser_Xlane2_Xdb_m3 t_Xser_Xlane2_Xdb_m2 vdd vdd sky130_fd_pr__pfet_01v8 w=1.6 l=0.15
X777 t_Xser_Xlane2_Xdb_m3 t_Xser_Xlane2_Xdb_clki t_Xser_Xlane2_Xdb_m1 vss sky130_fd_pr__nfet_01v8_lvt w=0.8 l=0.15
X778 t_Xser_Xlane2_Xdb_m3 t_Xser_Xlane2_Xdb_clkb t_Xser_Xlane2_Xdb_m1 vdd sky130_fd_pr__pfet_01v8 w=1.6 l=0.15
X779 t_Xser_Xlane2_Xdb_m2 t_Xser_Xlane2_Xdb_clki t_Xser_Xlane2_Xdb_s1 vss sky130_fd_pr__nfet_01v8_lvt w=1.2 l=0.15
X780 t_Xser_Xlane2_Xdb_m2 t_Xser_Xlane2_Xdb_clkb t_Xser_Xlane2_Xdb_s1 vdd sky130_fd_pr__pfet_01v8 w=2.4 l=0.15
X781 t_Xser_Xlane2_Xdb_qi t_Xser_Xlane2_Xdb_s1 vss vss sky130_fd_pr__nfet_01v8_lvt w=1.44 l=0.15
X782 t_Xser_Xlane2_Xdb_qi t_Xser_Xlane2_Xdb_s1 vdd vdd sky130_fd_pr__pfet_01v8 w=2.88 l=0.15
X783 t_Xser_Xlane2_Xdb_s2 t_Xser_Xlane2_Xdb_qi t_Xser_Xlane2_Xdb_Xsfb_mid vss sky130_fd_pr__nfet_01v8_lvt w=1.2 l=0.15
X784 t_Xser_Xlane2_Xdb_Xsfb_mid rst_n vss vss sky130_fd_pr__nfet_01v8_lvt w=1.2 l=0.15
X785 t_Xser_Xlane2_Xdb_s2 t_Xser_Xlane2_Xdb_qi vdd vdd sky130_fd_pr__pfet_01v8 w=1.6 l=0.15
X786 t_Xser_Xlane2_Xdb_s2 rst_n vdd vdd sky130_fd_pr__pfet_01v8 w=1.6 l=0.15
X787 t_Xser_Xlane2_Xdb_s2 t_Xser_Xlane2_Xdb_clkb t_Xser_Xlane2_Xdb_s1 vss sky130_fd_pr__nfet_01v8_lvt w=0.8 l=0.15
X788 t_Xser_Xlane2_Xdb_s2 t_Xser_Xlane2_Xdb_clki t_Xser_Xlane2_Xdb_s1 vdd sky130_fd_pr__pfet_01v8 w=1.6 l=0.15
X789 t_Xser_Xlane2_db t_Xser_Xlane2_Xdb_s1 vss vss sky130_fd_pr__nfet_01v8_lvt w=1.8 l=0.15
X790 t_Xser_Xlane2_db t_Xser_Xlane2_Xdb_s1 vdd vdd sky130_fd_pr__pfet_01v8 w=3.6 l=0.15
X791 t_Xser_Xlane2_dbb t_Xser_Xlane2_Xdb_qi vss vss sky130_fd_pr__nfet_01v8_lvt w=1.8 l=0.15
X792 t_Xser_Xlane2_dbb t_Xser_Xlane2_Xdb_qi vdd vdd sky130_fd_pr__pfet_01v8 w=3.6 l=0.15
X793 t_Xser_Xlane2_da t_Xser_clk500b t_Xser_Xlane2_Xmc_mid vss sky130_fd_pr__nfet_01v8_lvt w=1.5 l=0.15
X794 t_Xser_Xlane2_da t_Xser_clk500 t_Xser_Xlane2_Xmc_mid vdd sky130_fd_pr__pfet_01v8 w=3 l=0.15
X795 t_Xser_Xlane2_db t_Xser_clk500 t_Xser_Xlane2_Xmc_mid vss sky130_fd_pr__nfet_01v8_lvt w=1.5 l=0.15
X796 t_Xser_Xlane2_db t_Xser_clk500b t_Xser_Xlane2_Xmc_mid vdd sky130_fd_pr__pfet_01v8 w=3 l=0.15
X797 t_Xser_Xlane2_Xmc_yb t_Xser_Xlane2_Xmc_mid vss vss sky130_fd_pr__nfet_01v8_lvt w=1.5 l=0.15
X798 t_Xser_Xlane2_Xmc_yb t_Xser_Xlane2_Xmc_mid vdd vdd sky130_fd_pr__pfet_01v8 w=3 l=0.15
X799 t_Xser_Xlane2_mc t_Xser_Xlane2_Xmc_yb vss vss sky130_fd_pr__nfet_01v8_lvt w=1.5 l=0.15
X800 t_Xser_Xlane2_mc t_Xser_Xlane2_Xmc_yb vdd vdd sky130_fd_pr__pfet_01v8 w=3 l=0.15
X801 t_Xser_Xlane2_Xd1g_clkb t_Xser_c0 vss vss sky130_fd_pr__nfet_01v8_lvt w=1.2 l=0.15
X802 t_Xser_Xlane2_Xd1g_clkb t_Xser_c0 vdd vdd sky130_fd_pr__pfet_01v8 w=2.4 l=0.15
X803 t_Xser_Xlane2_Xd1g_clki t_Xser_Xlane2_Xd1g_clkb vss vss sky130_fd_pr__nfet_01v8_lvt w=1.2 l=0.15
X804 t_Xser_Xlane2_Xd1g_clki t_Xser_Xlane2_Xd1g_clkb vdd vdd sky130_fd_pr__pfet_01v8 w=2.4 l=0.15
X805 t_Xser_Xlane2_mc t_Xser_Xlane2_Xd1g_clkb t_Xser_Xlane2_Xd1g_m1 vss sky130_fd_pr__nfet_01v8_lvt w=1.5 l=0.15
X806 t_Xser_Xlane2_mc t_Xser_Xlane2_Xd1g_clki t_Xser_Xlane2_Xd1g_m1 vdd sky130_fd_pr__pfet_01v8 w=3 l=0.15
X807 t_Xser_Xlane2_Xd1g_m2 t_Xser_Xlane2_Xd1g_m1 t_Xser_Xlane2_Xd1g_Xm2_mid vss sky130_fd_pr__nfet_01v8_lvt w=2.25 l=0.15
X808 t_Xser_Xlane2_Xd1g_Xm2_mid rst_n vss vss sky130_fd_pr__nfet_01v8_lvt w=2.25 l=0.15
X809 t_Xser_Xlane2_Xd1g_m2 t_Xser_Xlane2_Xd1g_m1 vdd vdd sky130_fd_pr__pfet_01v8 w=3 l=0.15
X810 t_Xser_Xlane2_Xd1g_m2 rst_n vdd vdd sky130_fd_pr__pfet_01v8 w=3 l=0.15
X811 t_Xser_Xlane2_Xd1g_m3 t_Xser_Xlane2_Xd1g_m2 vss vss sky130_fd_pr__nfet_01v8_lvt w=0.8 l=0.15
X812 t_Xser_Xlane2_Xd1g_m3 t_Xser_Xlane2_Xd1g_m2 vdd vdd sky130_fd_pr__pfet_01v8 w=1.6 l=0.15
X813 t_Xser_Xlane2_Xd1g_m3 t_Xser_Xlane2_Xd1g_clki t_Xser_Xlane2_Xd1g_m1 vss sky130_fd_pr__nfet_01v8_lvt w=0.8 l=0.15
X814 t_Xser_Xlane2_Xd1g_m3 t_Xser_Xlane2_Xd1g_clkb t_Xser_Xlane2_Xd1g_m1 vdd sky130_fd_pr__pfet_01v8 w=1.6 l=0.15
X815 t_Xser_Xlane2_Xd1g_m2 t_Xser_Xlane2_Xd1g_clki t_Xser_Xlane2_Xd1g_s1 vss sky130_fd_pr__nfet_01v8_lvt w=1.5 l=0.15
X816 t_Xser_Xlane2_Xd1g_m2 t_Xser_Xlane2_Xd1g_clkb t_Xser_Xlane2_Xd1g_s1 vdd sky130_fd_pr__pfet_01v8 w=3 l=0.15
X817 t_Xser_Xlane2_Xd1g_qi t_Xser_Xlane2_Xd1g_s1 vss vss sky130_fd_pr__nfet_01v8_lvt w=1.8 l=0.15
X818 t_Xser_Xlane2_Xd1g_qi t_Xser_Xlane2_Xd1g_s1 vdd vdd sky130_fd_pr__pfet_01v8 w=3.6 l=0.15
X819 t_Xser_Xlane2_Xd1g_s2 t_Xser_Xlane2_Xd1g_qi t_Xser_Xlane2_Xd1g_Xsfb_mid vss sky130_fd_pr__nfet_01v8_lvt w=1.2 l=0.15
X820 t_Xser_Xlane2_Xd1g_Xsfb_mid rst_n vss vss sky130_fd_pr__nfet_01v8_lvt w=1.2 l=0.15
X821 t_Xser_Xlane2_Xd1g_s2 t_Xser_Xlane2_Xd1g_qi vdd vdd sky130_fd_pr__pfet_01v8 w=1.6 l=0.15
X822 t_Xser_Xlane2_Xd1g_s2 rst_n vdd vdd sky130_fd_pr__pfet_01v8 w=1.6 l=0.15
X823 t_Xser_Xlane2_Xd1g_s2 t_Xser_Xlane2_Xd1g_clkb t_Xser_Xlane2_Xd1g_s1 vss sky130_fd_pr__nfet_01v8_lvt w=0.8 l=0.15
X824 t_Xser_Xlane2_Xd1g_s2 t_Xser_Xlane2_Xd1g_clki t_Xser_Xlane2_Xd1g_s1 vdd sky130_fd_pr__pfet_01v8 w=1.6 l=0.15
X825 t_Xser_l2 t_Xser_Xlane2_Xd1g_s1 vss vss sky130_fd_pr__nfet_01v8_lvt w=2.25 l=0.15
X826 t_Xser_l2 t_Xser_Xlane2_Xd1g_s1 vdd vdd sky130_fd_pr__pfet_01v8 w=4.5 l=0.15
X827 t_Xser_Xlane2_l_outb t_Xser_Xlane2_Xd1g_qi vss vss sky130_fd_pr__nfet_01v8_lvt w=2.25 l=0.15
X828 t_Xser_Xlane2_l_outb t_Xser_Xlane2_Xd1g_qi vdd vdd sky130_fd_pr__pfet_01v8 w=4.5 l=0.15
X829 t_Xser_Xlane3_Xr0_clkb t_Xser_clk250b vss vss sky130_fd_pr__nfet_01v8_lvt w=1.2 l=0.15
X830 t_Xser_Xlane3_Xr0_clkb t_Xser_clk250b vdd vdd sky130_fd_pr__pfet_01v8 w=2.4 l=0.15
X831 t_Xser_Xlane3_Xr0_clki t_Xser_Xlane3_Xr0_clkb vss vss sky130_fd_pr__nfet_01v8_lvt w=1.2 l=0.15
X832 t_Xser_Xlane3_Xr0_clki t_Xser_Xlane3_Xr0_clkb vdd vdd sky130_fd_pr__pfet_01v8 w=2.4 l=0.15
X833 din3 t_Xser_Xlane3_Xr0_clkb t_Xser_Xlane3_Xr0_m1 vss sky130_fd_pr__nfet_01v8_lvt w=0.8 l=0.15
X834 din3 t_Xser_Xlane3_Xr0_clki t_Xser_Xlane3_Xr0_m1 vdd sky130_fd_pr__pfet_01v8 w=1.6 l=0.15
X835 t_Xser_Xlane3_Xr0_m2 t_Xser_Xlane3_Xr0_m1 t_Xser_Xlane3_Xr0_Xm2_mid vss sky130_fd_pr__nfet_01v8_lvt w=1.2 l=0.15
X836 t_Xser_Xlane3_Xr0_Xm2_mid rst_n vss vss sky130_fd_pr__nfet_01v8_lvt w=1.2 l=0.15
X837 t_Xser_Xlane3_Xr0_m2 t_Xser_Xlane3_Xr0_m1 vdd vdd sky130_fd_pr__pfet_01v8 w=1.6 l=0.15
X838 t_Xser_Xlane3_Xr0_m2 rst_n vdd vdd sky130_fd_pr__pfet_01v8 w=1.6 l=0.15
X839 t_Xser_Xlane3_Xr0_m3 t_Xser_Xlane3_Xr0_m2 vss vss sky130_fd_pr__nfet_01v8_lvt w=0.8 l=0.15
X840 t_Xser_Xlane3_Xr0_m3 t_Xser_Xlane3_Xr0_m2 vdd vdd sky130_fd_pr__pfet_01v8 w=1.6 l=0.15
X841 t_Xser_Xlane3_Xr0_m3 t_Xser_Xlane3_Xr0_clki t_Xser_Xlane3_Xr0_m1 vss sky130_fd_pr__nfet_01v8_lvt w=0.8 l=0.15
X842 t_Xser_Xlane3_Xr0_m3 t_Xser_Xlane3_Xr0_clkb t_Xser_Xlane3_Xr0_m1 vdd sky130_fd_pr__pfet_01v8 w=1.6 l=0.15
X843 t_Xser_Xlane3_Xr0_m2 t_Xser_Xlane3_Xr0_clki t_Xser_Xlane3_Xr0_s1 vss sky130_fd_pr__nfet_01v8_lvt w=0.8 l=0.15
X844 t_Xser_Xlane3_Xr0_m2 t_Xser_Xlane3_Xr0_clkb t_Xser_Xlane3_Xr0_s1 vdd sky130_fd_pr__pfet_01v8 w=1.6 l=0.15
X845 t_Xser_Xlane3_Xr0_qi t_Xser_Xlane3_Xr0_s1 vss vss sky130_fd_pr__nfet_01v8_lvt w=0.96 l=0.15
X846 t_Xser_Xlane3_Xr0_qi t_Xser_Xlane3_Xr0_s1 vdd vdd sky130_fd_pr__pfet_01v8 w=1.92 l=0.15
X847 t_Xser_Xlane3_Xr0_s2 t_Xser_Xlane3_Xr0_qi t_Xser_Xlane3_Xr0_Xsfb_mid vss sky130_fd_pr__nfet_01v8_lvt w=1.2 l=0.15
X848 t_Xser_Xlane3_Xr0_Xsfb_mid rst_n vss vss sky130_fd_pr__nfet_01v8_lvt w=1.2 l=0.15
X849 t_Xser_Xlane3_Xr0_s2 t_Xser_Xlane3_Xr0_qi vdd vdd sky130_fd_pr__pfet_01v8 w=1.6 l=0.15
X850 t_Xser_Xlane3_Xr0_s2 rst_n vdd vdd sky130_fd_pr__pfet_01v8 w=1.6 l=0.15
X851 t_Xser_Xlane3_Xr0_s2 t_Xser_Xlane3_Xr0_clkb t_Xser_Xlane3_Xr0_s1 vss sky130_fd_pr__nfet_01v8_lvt w=0.8 l=0.15
X852 t_Xser_Xlane3_Xr0_s2 t_Xser_Xlane3_Xr0_clki t_Xser_Xlane3_Xr0_s1 vdd sky130_fd_pr__pfet_01v8 w=1.6 l=0.15
X853 t_Xser_Xlane3_r0 t_Xser_Xlane3_Xr0_s1 vss vss sky130_fd_pr__nfet_01v8_lvt w=1.2 l=0.15
X854 t_Xser_Xlane3_r0 t_Xser_Xlane3_Xr0_s1 vdd vdd sky130_fd_pr__pfet_01v8 w=2.4 l=0.15
X855 t_Xser_Xlane3_r0b t_Xser_Xlane3_Xr0_qi vss vss sky130_fd_pr__nfet_01v8_lvt w=1.2 l=0.15
X856 t_Xser_Xlane3_r0b t_Xser_Xlane3_Xr0_qi vdd vdd sky130_fd_pr__pfet_01v8 w=2.4 l=0.15
X857 t_Xser_Xlane3_Xr1_clkb t_Xser_clk250b vss vss sky130_fd_pr__nfet_01v8_lvt w=1.2 l=0.15
X858 t_Xser_Xlane3_Xr1_clkb t_Xser_clk250b vdd vdd sky130_fd_pr__pfet_01v8 w=2.4 l=0.15
X859 t_Xser_Xlane3_Xr1_clki t_Xser_Xlane3_Xr1_clkb vss vss sky130_fd_pr__nfet_01v8_lvt w=1.2 l=0.15
X860 t_Xser_Xlane3_Xr1_clki t_Xser_Xlane3_Xr1_clkb vdd vdd sky130_fd_pr__pfet_01v8 w=2.4 l=0.15
X861 din7 t_Xser_Xlane3_Xr1_clkb t_Xser_Xlane3_Xr1_m1 vss sky130_fd_pr__nfet_01v8_lvt w=0.8 l=0.15
X862 din7 t_Xser_Xlane3_Xr1_clki t_Xser_Xlane3_Xr1_m1 vdd sky130_fd_pr__pfet_01v8 w=1.6 l=0.15
X863 t_Xser_Xlane3_Xr1_m2 t_Xser_Xlane3_Xr1_m1 t_Xser_Xlane3_Xr1_Xm2_mid vss sky130_fd_pr__nfet_01v8_lvt w=1.2 l=0.15
X864 t_Xser_Xlane3_Xr1_Xm2_mid rst_n vss vss sky130_fd_pr__nfet_01v8_lvt w=1.2 l=0.15
X865 t_Xser_Xlane3_Xr1_m2 t_Xser_Xlane3_Xr1_m1 vdd vdd sky130_fd_pr__pfet_01v8 w=1.6 l=0.15
X866 t_Xser_Xlane3_Xr1_m2 rst_n vdd vdd sky130_fd_pr__pfet_01v8 w=1.6 l=0.15
X867 t_Xser_Xlane3_Xr1_m3 t_Xser_Xlane3_Xr1_m2 vss vss sky130_fd_pr__nfet_01v8_lvt w=0.8 l=0.15
X868 t_Xser_Xlane3_Xr1_m3 t_Xser_Xlane3_Xr1_m2 vdd vdd sky130_fd_pr__pfet_01v8 w=1.6 l=0.15
X869 t_Xser_Xlane3_Xr1_m3 t_Xser_Xlane3_Xr1_clki t_Xser_Xlane3_Xr1_m1 vss sky130_fd_pr__nfet_01v8_lvt w=0.8 l=0.15
X870 t_Xser_Xlane3_Xr1_m3 t_Xser_Xlane3_Xr1_clkb t_Xser_Xlane3_Xr1_m1 vdd sky130_fd_pr__pfet_01v8 w=1.6 l=0.15
X871 t_Xser_Xlane3_Xr1_m2 t_Xser_Xlane3_Xr1_clki t_Xser_Xlane3_Xr1_s1 vss sky130_fd_pr__nfet_01v8_lvt w=0.8 l=0.15
X872 t_Xser_Xlane3_Xr1_m2 t_Xser_Xlane3_Xr1_clkb t_Xser_Xlane3_Xr1_s1 vdd sky130_fd_pr__pfet_01v8 w=1.6 l=0.15
X873 t_Xser_Xlane3_Xr1_qi t_Xser_Xlane3_Xr1_s1 vss vss sky130_fd_pr__nfet_01v8_lvt w=0.96 l=0.15
X874 t_Xser_Xlane3_Xr1_qi t_Xser_Xlane3_Xr1_s1 vdd vdd sky130_fd_pr__pfet_01v8 w=1.92 l=0.15
X875 t_Xser_Xlane3_Xr1_s2 t_Xser_Xlane3_Xr1_qi t_Xser_Xlane3_Xr1_Xsfb_mid vss sky130_fd_pr__nfet_01v8_lvt w=1.2 l=0.15
X876 t_Xser_Xlane3_Xr1_Xsfb_mid rst_n vss vss sky130_fd_pr__nfet_01v8_lvt w=1.2 l=0.15
X877 t_Xser_Xlane3_Xr1_s2 t_Xser_Xlane3_Xr1_qi vdd vdd sky130_fd_pr__pfet_01v8 w=1.6 l=0.15
X878 t_Xser_Xlane3_Xr1_s2 rst_n vdd vdd sky130_fd_pr__pfet_01v8 w=1.6 l=0.15
X879 t_Xser_Xlane3_Xr1_s2 t_Xser_Xlane3_Xr1_clkb t_Xser_Xlane3_Xr1_s1 vss sky130_fd_pr__nfet_01v8_lvt w=0.8 l=0.15
X880 t_Xser_Xlane3_Xr1_s2 t_Xser_Xlane3_Xr1_clki t_Xser_Xlane3_Xr1_s1 vdd sky130_fd_pr__pfet_01v8 w=1.6 l=0.15
X881 t_Xser_Xlane3_r1 t_Xser_Xlane3_Xr1_s1 vss vss sky130_fd_pr__nfet_01v8_lvt w=1.2 l=0.15
X882 t_Xser_Xlane3_r1 t_Xser_Xlane3_Xr1_s1 vdd vdd sky130_fd_pr__pfet_01v8 w=2.4 l=0.15
X883 t_Xser_Xlane3_r1b t_Xser_Xlane3_Xr1_qi vss vss sky130_fd_pr__nfet_01v8_lvt w=1.2 l=0.15
X884 t_Xser_Xlane3_r1b t_Xser_Xlane3_Xr1_qi vdd vdd sky130_fd_pr__pfet_01v8 w=2.4 l=0.15
X885 t_Xser_Xlane3_Xr2_clkb t_Xser_clk250b vss vss sky130_fd_pr__nfet_01v8_lvt w=1.2 l=0.15
X886 t_Xser_Xlane3_Xr2_clkb t_Xser_clk250b vdd vdd sky130_fd_pr__pfet_01v8 w=2.4 l=0.15
X887 t_Xser_Xlane3_Xr2_clki t_Xser_Xlane3_Xr2_clkb vss vss sky130_fd_pr__nfet_01v8_lvt w=1.2 l=0.15
X888 t_Xser_Xlane3_Xr2_clki t_Xser_Xlane3_Xr2_clkb vdd vdd sky130_fd_pr__pfet_01v8 w=2.4 l=0.15
X889 din11 t_Xser_Xlane3_Xr2_clkb t_Xser_Xlane3_Xr2_m1 vss sky130_fd_pr__nfet_01v8_lvt w=0.8 l=0.15
X890 din11 t_Xser_Xlane3_Xr2_clki t_Xser_Xlane3_Xr2_m1 vdd sky130_fd_pr__pfet_01v8 w=1.6 l=0.15
X891 t_Xser_Xlane3_Xr2_m2 t_Xser_Xlane3_Xr2_m1 t_Xser_Xlane3_Xr2_Xm2_mid vss sky130_fd_pr__nfet_01v8_lvt w=1.2 l=0.15
X892 t_Xser_Xlane3_Xr2_Xm2_mid rst_n vss vss sky130_fd_pr__nfet_01v8_lvt w=1.2 l=0.15
X893 t_Xser_Xlane3_Xr2_m2 t_Xser_Xlane3_Xr2_m1 vdd vdd sky130_fd_pr__pfet_01v8 w=1.6 l=0.15
X894 t_Xser_Xlane3_Xr2_m2 rst_n vdd vdd sky130_fd_pr__pfet_01v8 w=1.6 l=0.15
X895 t_Xser_Xlane3_Xr2_m3 t_Xser_Xlane3_Xr2_m2 vss vss sky130_fd_pr__nfet_01v8_lvt w=0.8 l=0.15
X896 t_Xser_Xlane3_Xr2_m3 t_Xser_Xlane3_Xr2_m2 vdd vdd sky130_fd_pr__pfet_01v8 w=1.6 l=0.15
X897 t_Xser_Xlane3_Xr2_m3 t_Xser_Xlane3_Xr2_clki t_Xser_Xlane3_Xr2_m1 vss sky130_fd_pr__nfet_01v8_lvt w=0.8 l=0.15
X898 t_Xser_Xlane3_Xr2_m3 t_Xser_Xlane3_Xr2_clkb t_Xser_Xlane3_Xr2_m1 vdd sky130_fd_pr__pfet_01v8 w=1.6 l=0.15
X899 t_Xser_Xlane3_Xr2_m2 t_Xser_Xlane3_Xr2_clki t_Xser_Xlane3_Xr2_s1 vss sky130_fd_pr__nfet_01v8_lvt w=0.8 l=0.15
X900 t_Xser_Xlane3_Xr2_m2 t_Xser_Xlane3_Xr2_clkb t_Xser_Xlane3_Xr2_s1 vdd sky130_fd_pr__pfet_01v8 w=1.6 l=0.15
X901 t_Xser_Xlane3_Xr2_qi t_Xser_Xlane3_Xr2_s1 vss vss sky130_fd_pr__nfet_01v8_lvt w=0.96 l=0.15
X902 t_Xser_Xlane3_Xr2_qi t_Xser_Xlane3_Xr2_s1 vdd vdd sky130_fd_pr__pfet_01v8 w=1.92 l=0.15
X903 t_Xser_Xlane3_Xr2_s2 t_Xser_Xlane3_Xr2_qi t_Xser_Xlane3_Xr2_Xsfb_mid vss sky130_fd_pr__nfet_01v8_lvt w=1.2 l=0.15
X904 t_Xser_Xlane3_Xr2_Xsfb_mid rst_n vss vss sky130_fd_pr__nfet_01v8_lvt w=1.2 l=0.15
X905 t_Xser_Xlane3_Xr2_s2 t_Xser_Xlane3_Xr2_qi vdd vdd sky130_fd_pr__pfet_01v8 w=1.6 l=0.15
X906 t_Xser_Xlane3_Xr2_s2 rst_n vdd vdd sky130_fd_pr__pfet_01v8 w=1.6 l=0.15
X907 t_Xser_Xlane3_Xr2_s2 t_Xser_Xlane3_Xr2_clkb t_Xser_Xlane3_Xr2_s1 vss sky130_fd_pr__nfet_01v8_lvt w=0.8 l=0.15
X908 t_Xser_Xlane3_Xr2_s2 t_Xser_Xlane3_Xr2_clki t_Xser_Xlane3_Xr2_s1 vdd sky130_fd_pr__pfet_01v8 w=1.6 l=0.15
X909 t_Xser_Xlane3_r2 t_Xser_Xlane3_Xr2_s1 vss vss sky130_fd_pr__nfet_01v8_lvt w=1.2 l=0.15
X910 t_Xser_Xlane3_r2 t_Xser_Xlane3_Xr2_s1 vdd vdd sky130_fd_pr__pfet_01v8 w=2.4 l=0.15
X911 t_Xser_Xlane3_r2b t_Xser_Xlane3_Xr2_qi vss vss sky130_fd_pr__nfet_01v8_lvt w=1.2 l=0.15
X912 t_Xser_Xlane3_r2b t_Xser_Xlane3_Xr2_qi vdd vdd sky130_fd_pr__pfet_01v8 w=2.4 l=0.15
X913 t_Xser_Xlane3_Xr3_m_clkb t_Xser_clk250b vss vss sky130_fd_pr__nfet_01v8_lvt w=1.2 l=0.15
X914 t_Xser_Xlane3_Xr3_m_clkb t_Xser_clk250b vdd vdd sky130_fd_pr__pfet_01v8 w=2.4 l=0.15
X915 t_Xser_Xlane3_Xr3_m_clki t_Xser_Xlane3_Xr3_m_clkb vss vss sky130_fd_pr__nfet_01v8_lvt w=1.2 l=0.15
X916 t_Xser_Xlane3_Xr3_m_clki t_Xser_Xlane3_Xr3_m_clkb vdd vdd sky130_fd_pr__pfet_01v8 w=2.4 l=0.15
X917 din15 t_Xser_Xlane3_Xr3_m_clkb t_Xser_Xlane3_Xr3_m_m1 vss sky130_fd_pr__nfet_01v8_lvt w=0.8 l=0.15
X918 din15 t_Xser_Xlane3_Xr3_m_clki t_Xser_Xlane3_Xr3_m_m1 vdd sky130_fd_pr__pfet_01v8 w=1.6 l=0.15
X919 t_Xser_Xlane3_Xr3_m_m2 t_Xser_Xlane3_Xr3_m_m1 t_Xser_Xlane3_Xr3_m_Xm2_mid vss sky130_fd_pr__nfet_01v8_lvt w=1.2 l=0.15
X920 t_Xser_Xlane3_Xr3_m_Xm2_mid rst_n vss vss sky130_fd_pr__nfet_01v8_lvt w=1.2 l=0.15
X921 t_Xser_Xlane3_Xr3_m_m2 t_Xser_Xlane3_Xr3_m_m1 vdd vdd sky130_fd_pr__pfet_01v8 w=1.6 l=0.15
X922 t_Xser_Xlane3_Xr3_m_m2 rst_n vdd vdd sky130_fd_pr__pfet_01v8 w=1.6 l=0.15
X923 t_Xser_Xlane3_Xr3_m_m3 t_Xser_Xlane3_Xr3_m_m2 vss vss sky130_fd_pr__nfet_01v8_lvt w=0.8 l=0.15
X924 t_Xser_Xlane3_Xr3_m_m3 t_Xser_Xlane3_Xr3_m_m2 vdd vdd sky130_fd_pr__pfet_01v8 w=1.6 l=0.15
X925 t_Xser_Xlane3_Xr3_m_m3 t_Xser_Xlane3_Xr3_m_clki t_Xser_Xlane3_Xr3_m_m1 vss sky130_fd_pr__nfet_01v8_lvt w=0.8 l=0.15
X926 t_Xser_Xlane3_Xr3_m_m3 t_Xser_Xlane3_Xr3_m_clkb t_Xser_Xlane3_Xr3_m_m1 vdd sky130_fd_pr__pfet_01v8 w=1.6 l=0.15
X927 t_Xser_Xlane3_Xr3_m_m2 t_Xser_Xlane3_Xr3_m_clki t_Xser_Xlane3_Xr3_m_s1 vss sky130_fd_pr__nfet_01v8_lvt w=0.8 l=0.15
X928 t_Xser_Xlane3_Xr3_m_m2 t_Xser_Xlane3_Xr3_m_clkb t_Xser_Xlane3_Xr3_m_s1 vdd sky130_fd_pr__pfet_01v8 w=1.6 l=0.15
X929 t_Xser_Xlane3_Xr3_m_qi t_Xser_Xlane3_Xr3_m_s1 vss vss sky130_fd_pr__nfet_01v8_lvt w=0.96 l=0.15
X930 t_Xser_Xlane3_Xr3_m_qi t_Xser_Xlane3_Xr3_m_s1 vdd vdd sky130_fd_pr__pfet_01v8 w=1.92 l=0.15
X931 t_Xser_Xlane3_Xr3_m_s2 t_Xser_Xlane3_Xr3_m_qi t_Xser_Xlane3_Xr3_m_Xsfb_mid vss sky130_fd_pr__nfet_01v8_lvt w=1.2 l=0.15
X932 t_Xser_Xlane3_Xr3_m_Xsfb_mid rst_n vss vss sky130_fd_pr__nfet_01v8_lvt w=1.2 l=0.15
X933 t_Xser_Xlane3_Xr3_m_s2 t_Xser_Xlane3_Xr3_m_qi vdd vdd sky130_fd_pr__pfet_01v8 w=1.6 l=0.15
X934 t_Xser_Xlane3_Xr3_m_s2 rst_n vdd vdd sky130_fd_pr__pfet_01v8 w=1.6 l=0.15
X935 t_Xser_Xlane3_Xr3_m_s2 t_Xser_Xlane3_Xr3_m_clkb t_Xser_Xlane3_Xr3_m_s1 vss sky130_fd_pr__nfet_01v8_lvt w=0.8 l=0.15
X936 t_Xser_Xlane3_Xr3_m_s2 t_Xser_Xlane3_Xr3_m_clki t_Xser_Xlane3_Xr3_m_s1 vdd sky130_fd_pr__pfet_01v8 w=1.6 l=0.15
X937 t_Xser_Xlane3_r3_m t_Xser_Xlane3_Xr3_m_s1 vss vss sky130_fd_pr__nfet_01v8_lvt w=1.2 l=0.15
X938 t_Xser_Xlane3_r3_m t_Xser_Xlane3_Xr3_m_s1 vdd vdd sky130_fd_pr__pfet_01v8 w=2.4 l=0.15
X939 t_Xser_Xlane3_r3_mb t_Xser_Xlane3_Xr3_m_qi vss vss sky130_fd_pr__nfet_01v8_lvt w=1.2 l=0.15
X940 t_Xser_Xlane3_r3_mb t_Xser_Xlane3_Xr3_m_qi vdd vdd sky130_fd_pr__pfet_01v8 w=2.4 l=0.15
X941 t_Xser_Xlane3_Xr3_clkb t_Xser_clk250 vss vss sky130_fd_pr__nfet_01v8_lvt w=1.2 l=0.15
X942 t_Xser_Xlane3_Xr3_clkb t_Xser_clk250 vdd vdd sky130_fd_pr__pfet_01v8 w=2.4 l=0.15
X943 t_Xser_Xlane3_Xr3_clki t_Xser_Xlane3_Xr3_clkb vss vss sky130_fd_pr__nfet_01v8_lvt w=1.2 l=0.15
X944 t_Xser_Xlane3_Xr3_clki t_Xser_Xlane3_Xr3_clkb vdd vdd sky130_fd_pr__pfet_01v8 w=2.4 l=0.15
X945 t_Xser_Xlane3_r3_m t_Xser_Xlane3_Xr3_clkb t_Xser_Xlane3_Xr3_m1 vss sky130_fd_pr__nfet_01v8_lvt w=0.8 l=0.15
X946 t_Xser_Xlane3_r3_m t_Xser_Xlane3_Xr3_clki t_Xser_Xlane3_Xr3_m1 vdd sky130_fd_pr__pfet_01v8 w=1.6 l=0.15
X947 t_Xser_Xlane3_Xr3_m2 t_Xser_Xlane3_Xr3_m1 t_Xser_Xlane3_Xr3_Xm2_mid vss sky130_fd_pr__nfet_01v8_lvt w=1.2 l=0.15
X948 t_Xser_Xlane3_Xr3_Xm2_mid rst_n vss vss sky130_fd_pr__nfet_01v8_lvt w=1.2 l=0.15
X949 t_Xser_Xlane3_Xr3_m2 t_Xser_Xlane3_Xr3_m1 vdd vdd sky130_fd_pr__pfet_01v8 w=1.6 l=0.15
X950 t_Xser_Xlane3_Xr3_m2 rst_n vdd vdd sky130_fd_pr__pfet_01v8 w=1.6 l=0.15
X951 t_Xser_Xlane3_Xr3_m3 t_Xser_Xlane3_Xr3_m2 vss vss sky130_fd_pr__nfet_01v8_lvt w=0.8 l=0.15
X952 t_Xser_Xlane3_Xr3_m3 t_Xser_Xlane3_Xr3_m2 vdd vdd sky130_fd_pr__pfet_01v8 w=1.6 l=0.15
X953 t_Xser_Xlane3_Xr3_m3 t_Xser_Xlane3_Xr3_clki t_Xser_Xlane3_Xr3_m1 vss sky130_fd_pr__nfet_01v8_lvt w=0.8 l=0.15
X954 t_Xser_Xlane3_Xr3_m3 t_Xser_Xlane3_Xr3_clkb t_Xser_Xlane3_Xr3_m1 vdd sky130_fd_pr__pfet_01v8 w=1.6 l=0.15
X955 t_Xser_Xlane3_Xr3_m2 t_Xser_Xlane3_Xr3_clki t_Xser_Xlane3_Xr3_s1 vss sky130_fd_pr__nfet_01v8_lvt w=0.8 l=0.15
X956 t_Xser_Xlane3_Xr3_m2 t_Xser_Xlane3_Xr3_clkb t_Xser_Xlane3_Xr3_s1 vdd sky130_fd_pr__pfet_01v8 w=1.6 l=0.15
X957 t_Xser_Xlane3_Xr3_qi t_Xser_Xlane3_Xr3_s1 vss vss sky130_fd_pr__nfet_01v8_lvt w=0.96 l=0.15
X958 t_Xser_Xlane3_Xr3_qi t_Xser_Xlane3_Xr3_s1 vdd vdd sky130_fd_pr__pfet_01v8 w=1.92 l=0.15
X959 t_Xser_Xlane3_Xr3_s2 t_Xser_Xlane3_Xr3_qi t_Xser_Xlane3_Xr3_Xsfb_mid vss sky130_fd_pr__nfet_01v8_lvt w=1.2 l=0.15
X960 t_Xser_Xlane3_Xr3_Xsfb_mid rst_n vss vss sky130_fd_pr__nfet_01v8_lvt w=1.2 l=0.15
X961 t_Xser_Xlane3_Xr3_s2 t_Xser_Xlane3_Xr3_qi vdd vdd sky130_fd_pr__pfet_01v8 w=1.6 l=0.15
X962 t_Xser_Xlane3_Xr3_s2 rst_n vdd vdd sky130_fd_pr__pfet_01v8 w=1.6 l=0.15
X963 t_Xser_Xlane3_Xr3_s2 t_Xser_Xlane3_Xr3_clkb t_Xser_Xlane3_Xr3_s1 vss sky130_fd_pr__nfet_01v8_lvt w=0.8 l=0.15
X964 t_Xser_Xlane3_Xr3_s2 t_Xser_Xlane3_Xr3_clki t_Xser_Xlane3_Xr3_s1 vdd sky130_fd_pr__pfet_01v8 w=1.6 l=0.15
X965 t_Xser_Xlane3_r3 t_Xser_Xlane3_Xr3_s1 vss vss sky130_fd_pr__nfet_01v8_lvt w=1.2 l=0.15
X966 t_Xser_Xlane3_r3 t_Xser_Xlane3_Xr3_s1 vdd vdd sky130_fd_pr__pfet_01v8 w=2.4 l=0.15
X967 t_Xser_Xlane3_r3b t_Xser_Xlane3_Xr3_qi vss vss sky130_fd_pr__nfet_01v8_lvt w=1.2 l=0.15
X968 t_Xser_Xlane3_r3b t_Xser_Xlane3_Xr3_qi vdd vdd sky130_fd_pr__pfet_01v8 w=2.4 l=0.15
X969 t_Xser_Xlane3_r2 t_Xser_clk250 t_Xser_Xlane3_Xma_mid vss sky130_fd_pr__nfet_01v8_lvt w=0.9 l=0.15
X970 t_Xser_Xlane3_r2 t_Xser_clk250b t_Xser_Xlane3_Xma_mid vdd sky130_fd_pr__pfet_01v8 w=1.8 l=0.15
X971 t_Xser_Xlane3_r0 t_Xser_clk250b t_Xser_Xlane3_Xma_mid vss sky130_fd_pr__nfet_01v8_lvt w=0.9 l=0.15
X972 t_Xser_Xlane3_r0 t_Xser_clk250 t_Xser_Xlane3_Xma_mid vdd sky130_fd_pr__pfet_01v8 w=1.8 l=0.15
X973 t_Xser_Xlane3_Xma_yb t_Xser_Xlane3_Xma_mid vss vss sky130_fd_pr__nfet_01v8_lvt w=0.9 l=0.15
X974 t_Xser_Xlane3_Xma_yb t_Xser_Xlane3_Xma_mid vdd vdd sky130_fd_pr__pfet_01v8 w=1.8 l=0.15
X975 t_Xser_Xlane3_ma t_Xser_Xlane3_Xma_yb vss vss sky130_fd_pr__nfet_01v8_lvt w=0.9 l=0.15
X976 t_Xser_Xlane3_ma t_Xser_Xlane3_Xma_yb vdd vdd sky130_fd_pr__pfet_01v8 w=1.8 l=0.15
X977 t_Xser_Xlane3_r1 t_Xser_clk250 t_Xser_Xlane3_Xmb_mid vss sky130_fd_pr__nfet_01v8_lvt w=0.9 l=0.15
X978 t_Xser_Xlane3_r1 t_Xser_clk250b t_Xser_Xlane3_Xmb_mid vdd sky130_fd_pr__pfet_01v8 w=1.8 l=0.15
X979 t_Xser_Xlane3_r3 t_Xser_clk250b t_Xser_Xlane3_Xmb_mid vss sky130_fd_pr__nfet_01v8_lvt w=0.9 l=0.15
X980 t_Xser_Xlane3_r3 t_Xser_clk250 t_Xser_Xlane3_Xmb_mid vdd sky130_fd_pr__pfet_01v8 w=1.8 l=0.15
X981 t_Xser_Xlane3_Xmb_yb t_Xser_Xlane3_Xmb_mid vss vss sky130_fd_pr__nfet_01v8_lvt w=0.9 l=0.15
X982 t_Xser_Xlane3_Xmb_yb t_Xser_Xlane3_Xmb_mid vdd vdd sky130_fd_pr__pfet_01v8 w=1.8 l=0.15
X983 t_Xser_Xlane3_mb t_Xser_Xlane3_Xmb_yb vss vss sky130_fd_pr__nfet_01v8_lvt w=0.9 l=0.15
X984 t_Xser_Xlane3_mb t_Xser_Xlane3_Xmb_yb vdd vdd sky130_fd_pr__pfet_01v8 w=1.8 l=0.15
X985 t_Xser_Xlane3_Xda_clkb t_Xser_clk500 vss vss sky130_fd_pr__nfet_01v8_lvt w=1.2 l=0.15
X986 t_Xser_Xlane3_Xda_clkb t_Xser_clk500 vdd vdd sky130_fd_pr__pfet_01v8 w=2.4 l=0.15
X987 t_Xser_Xlane3_Xda_clki t_Xser_Xlane3_Xda_clkb vss vss sky130_fd_pr__nfet_01v8_lvt w=1.2 l=0.15
X988 t_Xser_Xlane3_Xda_clki t_Xser_Xlane3_Xda_clkb vdd vdd sky130_fd_pr__pfet_01v8 w=2.4 l=0.15
X989 t_Xser_Xlane3_ma t_Xser_Xlane3_Xda_clkb t_Xser_Xlane3_Xda_m1 vss sky130_fd_pr__nfet_01v8_lvt w=1.2 l=0.15
X990 t_Xser_Xlane3_ma t_Xser_Xlane3_Xda_clki t_Xser_Xlane3_Xda_m1 vdd sky130_fd_pr__pfet_01v8 w=2.4 l=0.15
X991 t_Xser_Xlane3_Xda_m2 t_Xser_Xlane3_Xda_m1 t_Xser_Xlane3_Xda_Xm2_mid vss sky130_fd_pr__nfet_01v8_lvt w=1.8 l=0.15
X992 t_Xser_Xlane3_Xda_Xm2_mid rst_n vss vss sky130_fd_pr__nfet_01v8_lvt w=1.8 l=0.15
X993 t_Xser_Xlane3_Xda_m2 t_Xser_Xlane3_Xda_m1 vdd vdd sky130_fd_pr__pfet_01v8 w=2.4 l=0.15
X994 t_Xser_Xlane3_Xda_m2 rst_n vdd vdd sky130_fd_pr__pfet_01v8 w=2.4 l=0.15
X995 t_Xser_Xlane3_Xda_m3 t_Xser_Xlane3_Xda_m2 vss vss sky130_fd_pr__nfet_01v8_lvt w=0.8 l=0.15
X996 t_Xser_Xlane3_Xda_m3 t_Xser_Xlane3_Xda_m2 vdd vdd sky130_fd_pr__pfet_01v8 w=1.6 l=0.15
X997 t_Xser_Xlane3_Xda_m3 t_Xser_Xlane3_Xda_clki t_Xser_Xlane3_Xda_m1 vss sky130_fd_pr__nfet_01v8_lvt w=0.8 l=0.15
X998 t_Xser_Xlane3_Xda_m3 t_Xser_Xlane3_Xda_clkb t_Xser_Xlane3_Xda_m1 vdd sky130_fd_pr__pfet_01v8 w=1.6 l=0.15
X999 t_Xser_Xlane3_Xda_m2 t_Xser_Xlane3_Xda_clki t_Xser_Xlane3_Xda_s1 vss sky130_fd_pr__nfet_01v8_lvt w=1.2 l=0.15
X1000 t_Xser_Xlane3_Xda_m2 t_Xser_Xlane3_Xda_clkb t_Xser_Xlane3_Xda_s1 vdd sky130_fd_pr__pfet_01v8 w=2.4 l=0.15
X1001 t_Xser_Xlane3_Xda_qi t_Xser_Xlane3_Xda_s1 vss vss sky130_fd_pr__nfet_01v8_lvt w=1.44 l=0.15
X1002 t_Xser_Xlane3_Xda_qi t_Xser_Xlane3_Xda_s1 vdd vdd sky130_fd_pr__pfet_01v8 w=2.88 l=0.15
X1003 t_Xser_Xlane3_Xda_s2 t_Xser_Xlane3_Xda_qi t_Xser_Xlane3_Xda_Xsfb_mid vss sky130_fd_pr__nfet_01v8_lvt w=1.2 l=0.15
X1004 t_Xser_Xlane3_Xda_Xsfb_mid rst_n vss vss sky130_fd_pr__nfet_01v8_lvt w=1.2 l=0.15
X1005 t_Xser_Xlane3_Xda_s2 t_Xser_Xlane3_Xda_qi vdd vdd sky130_fd_pr__pfet_01v8 w=1.6 l=0.15
X1006 t_Xser_Xlane3_Xda_s2 rst_n vdd vdd sky130_fd_pr__pfet_01v8 w=1.6 l=0.15
X1007 t_Xser_Xlane3_Xda_s2 t_Xser_Xlane3_Xda_clkb t_Xser_Xlane3_Xda_s1 vss sky130_fd_pr__nfet_01v8_lvt w=0.8 l=0.15
X1008 t_Xser_Xlane3_Xda_s2 t_Xser_Xlane3_Xda_clki t_Xser_Xlane3_Xda_s1 vdd sky130_fd_pr__pfet_01v8 w=1.6 l=0.15
X1009 t_Xser_Xlane3_da t_Xser_Xlane3_Xda_s1 vss vss sky130_fd_pr__nfet_01v8_lvt w=1.8 l=0.15
X1010 t_Xser_Xlane3_da t_Xser_Xlane3_Xda_s1 vdd vdd sky130_fd_pr__pfet_01v8 w=3.6 l=0.15
X1011 t_Xser_Xlane3_dab t_Xser_Xlane3_Xda_qi vss vss sky130_fd_pr__nfet_01v8_lvt w=1.8 l=0.15
X1012 t_Xser_Xlane3_dab t_Xser_Xlane3_Xda_qi vdd vdd sky130_fd_pr__pfet_01v8 w=3.6 l=0.15
X1013 t_Xser_Xlane3_Xdb_clkb t_Xser_clk500b vss vss sky130_fd_pr__nfet_01v8_lvt w=1.2 l=0.15
X1014 t_Xser_Xlane3_Xdb_clkb t_Xser_clk500b vdd vdd sky130_fd_pr__pfet_01v8 w=2.4 l=0.15
X1015 t_Xser_Xlane3_Xdb_clki t_Xser_Xlane3_Xdb_clkb vss vss sky130_fd_pr__nfet_01v8_lvt w=1.2 l=0.15
X1016 t_Xser_Xlane3_Xdb_clki t_Xser_Xlane3_Xdb_clkb vdd vdd sky130_fd_pr__pfet_01v8 w=2.4 l=0.15
X1017 t_Xser_Xlane3_mb t_Xser_Xlane3_Xdb_clkb t_Xser_Xlane3_Xdb_m1 vss sky130_fd_pr__nfet_01v8_lvt w=1.2 l=0.15
X1018 t_Xser_Xlane3_mb t_Xser_Xlane3_Xdb_clki t_Xser_Xlane3_Xdb_m1 vdd sky130_fd_pr__pfet_01v8 w=2.4 l=0.15
X1019 t_Xser_Xlane3_Xdb_m2 t_Xser_Xlane3_Xdb_m1 t_Xser_Xlane3_Xdb_Xm2_mid vss sky130_fd_pr__nfet_01v8_lvt w=1.8 l=0.15
X1020 t_Xser_Xlane3_Xdb_Xm2_mid rst_n vss vss sky130_fd_pr__nfet_01v8_lvt w=1.8 l=0.15
X1021 t_Xser_Xlane3_Xdb_m2 t_Xser_Xlane3_Xdb_m1 vdd vdd sky130_fd_pr__pfet_01v8 w=2.4 l=0.15
X1022 t_Xser_Xlane3_Xdb_m2 rst_n vdd vdd sky130_fd_pr__pfet_01v8 w=2.4 l=0.15
X1023 t_Xser_Xlane3_Xdb_m3 t_Xser_Xlane3_Xdb_m2 vss vss sky130_fd_pr__nfet_01v8_lvt w=0.8 l=0.15
X1024 t_Xser_Xlane3_Xdb_m3 t_Xser_Xlane3_Xdb_m2 vdd vdd sky130_fd_pr__pfet_01v8 w=1.6 l=0.15
X1025 t_Xser_Xlane3_Xdb_m3 t_Xser_Xlane3_Xdb_clki t_Xser_Xlane3_Xdb_m1 vss sky130_fd_pr__nfet_01v8_lvt w=0.8 l=0.15
X1026 t_Xser_Xlane3_Xdb_m3 t_Xser_Xlane3_Xdb_clkb t_Xser_Xlane3_Xdb_m1 vdd sky130_fd_pr__pfet_01v8 w=1.6 l=0.15
X1027 t_Xser_Xlane3_Xdb_m2 t_Xser_Xlane3_Xdb_clki t_Xser_Xlane3_Xdb_s1 vss sky130_fd_pr__nfet_01v8_lvt w=1.2 l=0.15
X1028 t_Xser_Xlane3_Xdb_m2 t_Xser_Xlane3_Xdb_clkb t_Xser_Xlane3_Xdb_s1 vdd sky130_fd_pr__pfet_01v8 w=2.4 l=0.15
X1029 t_Xser_Xlane3_Xdb_qi t_Xser_Xlane3_Xdb_s1 vss vss sky130_fd_pr__nfet_01v8_lvt w=1.44 l=0.15
X1030 t_Xser_Xlane3_Xdb_qi t_Xser_Xlane3_Xdb_s1 vdd vdd sky130_fd_pr__pfet_01v8 w=2.88 l=0.15
X1031 t_Xser_Xlane3_Xdb_s2 t_Xser_Xlane3_Xdb_qi t_Xser_Xlane3_Xdb_Xsfb_mid vss sky130_fd_pr__nfet_01v8_lvt w=1.2 l=0.15
X1032 t_Xser_Xlane3_Xdb_Xsfb_mid rst_n vss vss sky130_fd_pr__nfet_01v8_lvt w=1.2 l=0.15
X1033 t_Xser_Xlane3_Xdb_s2 t_Xser_Xlane3_Xdb_qi vdd vdd sky130_fd_pr__pfet_01v8 w=1.6 l=0.15
X1034 t_Xser_Xlane3_Xdb_s2 rst_n vdd vdd sky130_fd_pr__pfet_01v8 w=1.6 l=0.15
X1035 t_Xser_Xlane3_Xdb_s2 t_Xser_Xlane3_Xdb_clkb t_Xser_Xlane3_Xdb_s1 vss sky130_fd_pr__nfet_01v8_lvt w=0.8 l=0.15
X1036 t_Xser_Xlane3_Xdb_s2 t_Xser_Xlane3_Xdb_clki t_Xser_Xlane3_Xdb_s1 vdd sky130_fd_pr__pfet_01v8 w=1.6 l=0.15
X1037 t_Xser_Xlane3_db t_Xser_Xlane3_Xdb_s1 vss vss sky130_fd_pr__nfet_01v8_lvt w=1.8 l=0.15
X1038 t_Xser_Xlane3_db t_Xser_Xlane3_Xdb_s1 vdd vdd sky130_fd_pr__pfet_01v8 w=3.6 l=0.15
X1039 t_Xser_Xlane3_dbb t_Xser_Xlane3_Xdb_qi vss vss sky130_fd_pr__nfet_01v8_lvt w=1.8 l=0.15
X1040 t_Xser_Xlane3_dbb t_Xser_Xlane3_Xdb_qi vdd vdd sky130_fd_pr__pfet_01v8 w=3.6 l=0.15
X1041 t_Xser_Xlane3_da t_Xser_clk500b t_Xser_Xlane3_Xmc_mid vss sky130_fd_pr__nfet_01v8_lvt w=1.5 l=0.15
X1042 t_Xser_Xlane3_da t_Xser_clk500 t_Xser_Xlane3_Xmc_mid vdd sky130_fd_pr__pfet_01v8 w=3 l=0.15
X1043 t_Xser_Xlane3_db t_Xser_clk500 t_Xser_Xlane3_Xmc_mid vss sky130_fd_pr__nfet_01v8_lvt w=1.5 l=0.15
X1044 t_Xser_Xlane3_db t_Xser_clk500b t_Xser_Xlane3_Xmc_mid vdd sky130_fd_pr__pfet_01v8 w=3 l=0.15
X1045 t_Xser_Xlane3_Xmc_yb t_Xser_Xlane3_Xmc_mid vss vss sky130_fd_pr__nfet_01v8_lvt w=1.5 l=0.15
X1046 t_Xser_Xlane3_Xmc_yb t_Xser_Xlane3_Xmc_mid vdd vdd sky130_fd_pr__pfet_01v8 w=3 l=0.15
X1047 t_Xser_Xlane3_mc t_Xser_Xlane3_Xmc_yb vss vss sky130_fd_pr__nfet_01v8_lvt w=1.5 l=0.15
X1048 t_Xser_Xlane3_mc t_Xser_Xlane3_Xmc_yb vdd vdd sky130_fd_pr__pfet_01v8 w=3 l=0.15
X1049 t_Xser_Xlane3_Xd1g_clkb t_Xser_c0 vss vss sky130_fd_pr__nfet_01v8_lvt w=1.2 l=0.15
X1050 t_Xser_Xlane3_Xd1g_clkb t_Xser_c0 vdd vdd sky130_fd_pr__pfet_01v8 w=2.4 l=0.15
X1051 t_Xser_Xlane3_Xd1g_clki t_Xser_Xlane3_Xd1g_clkb vss vss sky130_fd_pr__nfet_01v8_lvt w=1.2 l=0.15
X1052 t_Xser_Xlane3_Xd1g_clki t_Xser_Xlane3_Xd1g_clkb vdd vdd sky130_fd_pr__pfet_01v8 w=2.4 l=0.15
X1053 t_Xser_Xlane3_mc t_Xser_Xlane3_Xd1g_clkb t_Xser_Xlane3_Xd1g_m1 vss sky130_fd_pr__nfet_01v8_lvt w=1.5 l=0.15
X1054 t_Xser_Xlane3_mc t_Xser_Xlane3_Xd1g_clki t_Xser_Xlane3_Xd1g_m1 vdd sky130_fd_pr__pfet_01v8 w=3 l=0.15
X1055 t_Xser_Xlane3_Xd1g_m2 t_Xser_Xlane3_Xd1g_m1 t_Xser_Xlane3_Xd1g_Xm2_mid vss sky130_fd_pr__nfet_01v8_lvt w=2.25 l=0.15
X1056 t_Xser_Xlane3_Xd1g_Xm2_mid rst_n vss vss sky130_fd_pr__nfet_01v8_lvt w=2.25 l=0.15
X1057 t_Xser_Xlane3_Xd1g_m2 t_Xser_Xlane3_Xd1g_m1 vdd vdd sky130_fd_pr__pfet_01v8 w=3 l=0.15
X1058 t_Xser_Xlane3_Xd1g_m2 rst_n vdd vdd sky130_fd_pr__pfet_01v8 w=3 l=0.15
X1059 t_Xser_Xlane3_Xd1g_m3 t_Xser_Xlane3_Xd1g_m2 vss vss sky130_fd_pr__nfet_01v8_lvt w=0.8 l=0.15
X1060 t_Xser_Xlane3_Xd1g_m3 t_Xser_Xlane3_Xd1g_m2 vdd vdd sky130_fd_pr__pfet_01v8 w=1.6 l=0.15
X1061 t_Xser_Xlane3_Xd1g_m3 t_Xser_Xlane3_Xd1g_clki t_Xser_Xlane3_Xd1g_m1 vss sky130_fd_pr__nfet_01v8_lvt w=0.8 l=0.15
X1062 t_Xser_Xlane3_Xd1g_m3 t_Xser_Xlane3_Xd1g_clkb t_Xser_Xlane3_Xd1g_m1 vdd sky130_fd_pr__pfet_01v8 w=1.6 l=0.15
X1063 t_Xser_Xlane3_Xd1g_m2 t_Xser_Xlane3_Xd1g_clki t_Xser_Xlane3_Xd1g_s1 vss sky130_fd_pr__nfet_01v8_lvt w=1.5 l=0.15
X1064 t_Xser_Xlane3_Xd1g_m2 t_Xser_Xlane3_Xd1g_clkb t_Xser_Xlane3_Xd1g_s1 vdd sky130_fd_pr__pfet_01v8 w=3 l=0.15
X1065 t_Xser_Xlane3_Xd1g_qi t_Xser_Xlane3_Xd1g_s1 vss vss sky130_fd_pr__nfet_01v8_lvt w=1.8 l=0.15
X1066 t_Xser_Xlane3_Xd1g_qi t_Xser_Xlane3_Xd1g_s1 vdd vdd sky130_fd_pr__pfet_01v8 w=3.6 l=0.15
X1067 t_Xser_Xlane3_Xd1g_s2 t_Xser_Xlane3_Xd1g_qi t_Xser_Xlane3_Xd1g_Xsfb_mid vss sky130_fd_pr__nfet_01v8_lvt w=1.2 l=0.15
X1068 t_Xser_Xlane3_Xd1g_Xsfb_mid rst_n vss vss sky130_fd_pr__nfet_01v8_lvt w=1.2 l=0.15
X1069 t_Xser_Xlane3_Xd1g_s2 t_Xser_Xlane3_Xd1g_qi vdd vdd sky130_fd_pr__pfet_01v8 w=1.6 l=0.15
X1070 t_Xser_Xlane3_Xd1g_s2 rst_n vdd vdd sky130_fd_pr__pfet_01v8 w=1.6 l=0.15
X1071 t_Xser_Xlane3_Xd1g_s2 t_Xser_Xlane3_Xd1g_clkb t_Xser_Xlane3_Xd1g_s1 vss sky130_fd_pr__nfet_01v8_lvt w=0.8 l=0.15
X1072 t_Xser_Xlane3_Xd1g_s2 t_Xser_Xlane3_Xd1g_clki t_Xser_Xlane3_Xd1g_s1 vdd sky130_fd_pr__pfet_01v8 w=1.6 l=0.15
X1073 t_Xser_l3 t_Xser_Xlane3_Xd1g_s1 vss vss sky130_fd_pr__nfet_01v8_lvt w=2.25 l=0.15
X1074 t_Xser_l3 t_Xser_Xlane3_Xd1g_s1 vdd vdd sky130_fd_pr__pfet_01v8 w=4.5 l=0.15
X1075 t_Xser_Xlane3_l_outb t_Xser_Xlane3_Xd1g_qi vss vss sky130_fd_pr__nfet_01v8_lvt w=2.25 l=0.15
X1076 t_Xser_Xlane3_l_outb t_Xser_Xlane3_Xd1g_qi vdd vdd sky130_fd_pr__pfet_01v8 w=4.5 l=0.15
X1077 t_Xser_Xst0_clkb t_Xser_c180 vss vss sky130_fd_pr__nfet_01v8_lvt w=1.4 l=0.15
X1078 t_Xser_Xst0_clkb t_Xser_c180 vdd vdd sky130_fd_pr__pfet_01v8 w=3.4 l=0.15
X1079 t_Xser_Xst0_clki t_Xser_Xst0_clkb vss vss sky130_fd_pr__nfet_01v8_lvt w=1.4 l=0.15
X1080 t_Xser_Xst0_clki t_Xser_Xst0_clkb vdd vdd sky130_fd_pr__pfet_01v8 w=3.4 l=0.15
X1081 t_Xser_l0 t_Xser_Xst0_clkb t_Xser_Xst0_m1 vss sky130_fd_pr__nfet_01v8_lvt w=1.5 l=0.15
X1082 t_Xser_l0 t_Xser_Xst0_clki t_Xser_Xst0_m1 vdd sky130_fd_pr__pfet_01v8 w=2.8 l=0.15
X1083 t_Xser_Xst0_m2 t_Xser_Xst0_m1 t_Xser_Xst0_Xm2_mid vss sky130_fd_pr__nfet_01v8_lvt w=2.25 l=0.15
X1084 t_Xser_Xst0_Xm2_mid rst_n vss vss sky130_fd_pr__nfet_01v8_lvt w=2.25 l=0.15
X1085 t_Xser_Xst0_m2 t_Xser_Xst0_m1 vdd vdd sky130_fd_pr__pfet_01v8 w=2.8 l=0.15
X1086 t_Xser_Xst0_m2 rst_n vdd vdd sky130_fd_pr__pfet_01v8 w=2.8 l=0.15
X1087 t_Xser_Xst0_m3 t_Xser_Xst0_m2 vss vss sky130_fd_pr__nfet_01v8_lvt w=0.8 l=0.15
X1088 t_Xser_Xst0_m3 t_Xser_Xst0_m2 vdd vdd sky130_fd_pr__pfet_01v8 w=1.6 l=0.15
X1089 t_Xser_Xst0_m3 t_Xser_Xst0_clki t_Xser_Xst0_m1 vss sky130_fd_pr__nfet_01v8_lvt w=0.8 l=0.15
X1090 t_Xser_Xst0_m3 t_Xser_Xst0_clkb t_Xser_Xst0_m1 vdd sky130_fd_pr__pfet_01v8 w=1.6 l=0.15
X1091 t_Xser_Xst0_m2 t_Xser_Xst0_clki t_Xser_Xst0_s1 vss sky130_fd_pr__nfet_01v8_lvt w=1.5 l=0.15
X1092 t_Xser_Xst0_m2 t_Xser_Xst0_clkb t_Xser_Xst0_s1 vdd sky130_fd_pr__pfet_01v8 w=2.8 l=0.15
X1093 t_Xser_Xst0_qi t_Xser_Xst0_s1 vss vss sky130_fd_pr__nfet_01v8_lvt w=2.1 l=0.15
X1094 t_Xser_Xst0_qi t_Xser_Xst0_s1 vdd vdd sky130_fd_pr__pfet_01v8 w=5 l=0.15
X1095 t_Xser_Xst0_s2 t_Xser_Xst0_qi t_Xser_Xst0_Xsfb_mid vss sky130_fd_pr__nfet_01v8_lvt w=1.2 l=0.15
X1096 t_Xser_Xst0_Xsfb_mid rst_n vss vss sky130_fd_pr__nfet_01v8_lvt w=1.2 l=0.15
X1097 t_Xser_Xst0_s2 t_Xser_Xst0_qi vdd vdd sky130_fd_pr__pfet_01v8 w=1.6 l=0.15
X1098 t_Xser_Xst0_s2 rst_n vdd vdd sky130_fd_pr__pfet_01v8 w=1.6 l=0.15
X1099 t_Xser_Xst0_s2 t_Xser_Xst0_clkb t_Xser_Xst0_s1 vss sky130_fd_pr__nfet_01v8_lvt w=0.8 l=0.15
X1100 t_Xser_Xst0_s2 t_Xser_Xst0_clki t_Xser_Xst0_s1 vdd sky130_fd_pr__pfet_01v8 w=1.6 l=0.15
X1101 t_d0 t_Xser_Xst0_s1 vss vss sky130_fd_pr__nfet_01v8_lvt w=2.7 l=0.15
X1102 t_d0 t_Xser_Xst0_s1 vdd vdd sky130_fd_pr__pfet_01v8 w=7.5 l=0.15
X1103 t_db0 t_Xser_Xst0_qi vss vss sky130_fd_pr__nfet_01v8_lvt w=2.7 l=0.15
X1104 t_db0 t_Xser_Xst0_qi vdd vdd sky130_fd_pr__pfet_01v8 w=7.5 l=0.15
X1105 t_Xser_Xst1_clkb t_Xser_c270 vss vss sky130_fd_pr__nfet_01v8_lvt w=1.4 l=0.15
X1106 t_Xser_Xst1_clkb t_Xser_c270 vdd vdd sky130_fd_pr__pfet_01v8 w=3.4 l=0.15
X1107 t_Xser_Xst1_clki t_Xser_Xst1_clkb vss vss sky130_fd_pr__nfet_01v8_lvt w=1.4 l=0.15
X1108 t_Xser_Xst1_clki t_Xser_Xst1_clkb vdd vdd sky130_fd_pr__pfet_01v8 w=3.4 l=0.15
X1109 t_Xser_l1 t_Xser_Xst1_clkb t_Xser_Xst1_m1 vss sky130_fd_pr__nfet_01v8_lvt w=1.5 l=0.15
X1110 t_Xser_l1 t_Xser_Xst1_clki t_Xser_Xst1_m1 vdd sky130_fd_pr__pfet_01v8 w=2.8 l=0.15
X1111 t_Xser_Xst1_m2 t_Xser_Xst1_m1 t_Xser_Xst1_Xm2_mid vss sky130_fd_pr__nfet_01v8_lvt w=2.25 l=0.15
X1112 t_Xser_Xst1_Xm2_mid rst_n vss vss sky130_fd_pr__nfet_01v8_lvt w=2.25 l=0.15
X1113 t_Xser_Xst1_m2 t_Xser_Xst1_m1 vdd vdd sky130_fd_pr__pfet_01v8 w=2.8 l=0.15
X1114 t_Xser_Xst1_m2 rst_n vdd vdd sky130_fd_pr__pfet_01v8 w=2.8 l=0.15
X1115 t_Xser_Xst1_m3 t_Xser_Xst1_m2 vss vss sky130_fd_pr__nfet_01v8_lvt w=0.8 l=0.15
X1116 t_Xser_Xst1_m3 t_Xser_Xst1_m2 vdd vdd sky130_fd_pr__pfet_01v8 w=1.6 l=0.15
X1117 t_Xser_Xst1_m3 t_Xser_Xst1_clki t_Xser_Xst1_m1 vss sky130_fd_pr__nfet_01v8_lvt w=0.8 l=0.15
X1118 t_Xser_Xst1_m3 t_Xser_Xst1_clkb t_Xser_Xst1_m1 vdd sky130_fd_pr__pfet_01v8 w=1.6 l=0.15
X1119 t_Xser_Xst1_m2 t_Xser_Xst1_clki t_Xser_Xst1_s1 vss sky130_fd_pr__nfet_01v8_lvt w=1.5 l=0.15
X1120 t_Xser_Xst1_m2 t_Xser_Xst1_clkb t_Xser_Xst1_s1 vdd sky130_fd_pr__pfet_01v8 w=2.8 l=0.15
X1121 t_Xser_Xst1_qi t_Xser_Xst1_s1 vss vss sky130_fd_pr__nfet_01v8_lvt w=2.1 l=0.15
X1122 t_Xser_Xst1_qi t_Xser_Xst1_s1 vdd vdd sky130_fd_pr__pfet_01v8 w=5 l=0.15
X1123 t_Xser_Xst1_s2 t_Xser_Xst1_qi t_Xser_Xst1_Xsfb_mid vss sky130_fd_pr__nfet_01v8_lvt w=1.2 l=0.15
X1124 t_Xser_Xst1_Xsfb_mid rst_n vss vss sky130_fd_pr__nfet_01v8_lvt w=1.2 l=0.15
X1125 t_Xser_Xst1_s2 t_Xser_Xst1_qi vdd vdd sky130_fd_pr__pfet_01v8 w=1.6 l=0.15
X1126 t_Xser_Xst1_s2 rst_n vdd vdd sky130_fd_pr__pfet_01v8 w=1.6 l=0.15
X1127 t_Xser_Xst1_s2 t_Xser_Xst1_clkb t_Xser_Xst1_s1 vss sky130_fd_pr__nfet_01v8_lvt w=0.8 l=0.15
X1128 t_Xser_Xst1_s2 t_Xser_Xst1_clki t_Xser_Xst1_s1 vdd sky130_fd_pr__pfet_01v8 w=1.6 l=0.15
X1129 t_d1 t_Xser_Xst1_s1 vss vss sky130_fd_pr__nfet_01v8_lvt w=2.7 l=0.15
X1130 t_d1 t_Xser_Xst1_s1 vdd vdd sky130_fd_pr__pfet_01v8 w=7.5 l=0.15
X1131 t_db1 t_Xser_Xst1_qi vss vss sky130_fd_pr__nfet_01v8_lvt w=2.7 l=0.15
X1132 t_db1 t_Xser_Xst1_qi vdd vdd sky130_fd_pr__pfet_01v8 w=7.5 l=0.15
X1133 t_Xser_Xst2a_clkb t_Xser_c180 vss vss sky130_fd_pr__nfet_01v8_lvt w=1.2 l=0.15
X1134 t_Xser_Xst2a_clkb t_Xser_c180 vdd vdd sky130_fd_pr__pfet_01v8 w=2.4 l=0.15
X1135 t_Xser_Xst2a_clki t_Xser_Xst2a_clkb vss vss sky130_fd_pr__nfet_01v8_lvt w=1.2 l=0.15
X1136 t_Xser_Xst2a_clki t_Xser_Xst2a_clkb vdd vdd sky130_fd_pr__pfet_01v8 w=2.4 l=0.15
X1137 t_Xser_l2 t_Xser_Xst2a_clkb t_Xser_Xst2a_m1 vss sky130_fd_pr__nfet_01v8_lvt w=1.5 l=0.15
X1138 t_Xser_l2 t_Xser_Xst2a_clki t_Xser_Xst2a_m1 vdd sky130_fd_pr__pfet_01v8 w=3 l=0.15
X1139 t_Xser_Xst2a_m2 t_Xser_Xst2a_m1 t_Xser_Xst2a_Xm2_mid vss sky130_fd_pr__nfet_01v8_lvt w=2.25 l=0.15
X1140 t_Xser_Xst2a_Xm2_mid rst_n vss vss sky130_fd_pr__nfet_01v8_lvt w=2.25 l=0.15
X1141 t_Xser_Xst2a_m2 t_Xser_Xst2a_m1 vdd vdd sky130_fd_pr__pfet_01v8 w=3 l=0.15
X1142 t_Xser_Xst2a_m2 rst_n vdd vdd sky130_fd_pr__pfet_01v8 w=3 l=0.15
X1143 t_Xser_Xst2a_m3 t_Xser_Xst2a_m2 vss vss sky130_fd_pr__nfet_01v8_lvt w=0.8 l=0.15
X1144 t_Xser_Xst2a_m3 t_Xser_Xst2a_m2 vdd vdd sky130_fd_pr__pfet_01v8 w=1.6 l=0.15
X1145 t_Xser_Xst2a_m3 t_Xser_Xst2a_clki t_Xser_Xst2a_m1 vss sky130_fd_pr__nfet_01v8_lvt w=0.8 l=0.15
X1146 t_Xser_Xst2a_m3 t_Xser_Xst2a_clkb t_Xser_Xst2a_m1 vdd sky130_fd_pr__pfet_01v8 w=1.6 l=0.15
X1147 t_Xser_Xst2a_m2 t_Xser_Xst2a_clki t_Xser_Xst2a_s1 vss sky130_fd_pr__nfet_01v8_lvt w=1.5 l=0.15
X1148 t_Xser_Xst2a_m2 t_Xser_Xst2a_clkb t_Xser_Xst2a_s1 vdd sky130_fd_pr__pfet_01v8 w=3 l=0.15
X1149 t_Xser_Xst2a_qi t_Xser_Xst2a_s1 vss vss sky130_fd_pr__nfet_01v8_lvt w=1.8 l=0.15
X1150 t_Xser_Xst2a_qi t_Xser_Xst2a_s1 vdd vdd sky130_fd_pr__pfet_01v8 w=3.6 l=0.15
X1151 t_Xser_Xst2a_s2 t_Xser_Xst2a_qi t_Xser_Xst2a_Xsfb_mid vss sky130_fd_pr__nfet_01v8_lvt w=1.2 l=0.15
X1152 t_Xser_Xst2a_Xsfb_mid rst_n vss vss sky130_fd_pr__nfet_01v8_lvt w=1.2 l=0.15
X1153 t_Xser_Xst2a_s2 t_Xser_Xst2a_qi vdd vdd sky130_fd_pr__pfet_01v8 w=1.6 l=0.15
X1154 t_Xser_Xst2a_s2 rst_n vdd vdd sky130_fd_pr__pfet_01v8 w=1.6 l=0.15
X1155 t_Xser_Xst2a_s2 t_Xser_Xst2a_clkb t_Xser_Xst2a_s1 vss sky130_fd_pr__nfet_01v8_lvt w=0.8 l=0.15
X1156 t_Xser_Xst2a_s2 t_Xser_Xst2a_clki t_Xser_Xst2a_s1 vdd sky130_fd_pr__pfet_01v8 w=1.6 l=0.15
X1157 t_Xser_l2h t_Xser_Xst2a_s1 vss vss sky130_fd_pr__nfet_01v8_lvt w=2.25 l=0.15
X1158 t_Xser_l2h t_Xser_Xst2a_s1 vdd vdd sky130_fd_pr__pfet_01v8 w=4.5 l=0.15
X1159 t_Xser_l2hb t_Xser_Xst2a_qi vss vss sky130_fd_pr__nfet_01v8_lvt w=2.25 l=0.15
X1160 t_Xser_l2hb t_Xser_Xst2a_qi vdd vdd sky130_fd_pr__pfet_01v8 w=4.5 l=0.15
X1161 t_Xser_Xst2b_clkb t_Xser_c0 vss vss sky130_fd_pr__nfet_01v8_lvt w=1.4 l=0.15
X1162 t_Xser_Xst2b_clkb t_Xser_c0 vdd vdd sky130_fd_pr__pfet_01v8 w=3.4 l=0.15
X1163 t_Xser_Xst2b_clki t_Xser_Xst2b_clkb vss vss sky130_fd_pr__nfet_01v8_lvt w=1.4 l=0.15
X1164 t_Xser_Xst2b_clki t_Xser_Xst2b_clkb vdd vdd sky130_fd_pr__pfet_01v8 w=3.4 l=0.15
X1165 t_Xser_l2h t_Xser_Xst2b_clkb t_Xser_Xst2b_m1 vss sky130_fd_pr__nfet_01v8_lvt w=1.5 l=0.15
X1166 t_Xser_l2h t_Xser_Xst2b_clki t_Xser_Xst2b_m1 vdd sky130_fd_pr__pfet_01v8 w=2.8 l=0.15
X1167 t_Xser_Xst2b_m2 t_Xser_Xst2b_m1 t_Xser_Xst2b_Xm2_mid vss sky130_fd_pr__nfet_01v8_lvt w=2.25 l=0.15
X1168 t_Xser_Xst2b_Xm2_mid rst_n vss vss sky130_fd_pr__nfet_01v8_lvt w=2.25 l=0.15
X1169 t_Xser_Xst2b_m2 t_Xser_Xst2b_m1 vdd vdd sky130_fd_pr__pfet_01v8 w=2.8 l=0.15
X1170 t_Xser_Xst2b_m2 rst_n vdd vdd sky130_fd_pr__pfet_01v8 w=2.8 l=0.15
X1171 t_Xser_Xst2b_m3 t_Xser_Xst2b_m2 vss vss sky130_fd_pr__nfet_01v8_lvt w=0.8 l=0.15
X1172 t_Xser_Xst2b_m3 t_Xser_Xst2b_m2 vdd vdd sky130_fd_pr__pfet_01v8 w=1.6 l=0.15
X1173 t_Xser_Xst2b_m3 t_Xser_Xst2b_clki t_Xser_Xst2b_m1 vss sky130_fd_pr__nfet_01v8_lvt w=0.8 l=0.15
X1174 t_Xser_Xst2b_m3 t_Xser_Xst2b_clkb t_Xser_Xst2b_m1 vdd sky130_fd_pr__pfet_01v8 w=1.6 l=0.15
X1175 t_Xser_Xst2b_m2 t_Xser_Xst2b_clki t_Xser_Xst2b_s1 vss sky130_fd_pr__nfet_01v8_lvt w=1.5 l=0.15
X1176 t_Xser_Xst2b_m2 t_Xser_Xst2b_clkb t_Xser_Xst2b_s1 vdd sky130_fd_pr__pfet_01v8 w=2.8 l=0.15
X1177 t_Xser_Xst2b_qi t_Xser_Xst2b_s1 vss vss sky130_fd_pr__nfet_01v8_lvt w=2.1 l=0.15
X1178 t_Xser_Xst2b_qi t_Xser_Xst2b_s1 vdd vdd sky130_fd_pr__pfet_01v8 w=5 l=0.15
X1179 t_Xser_Xst2b_s2 t_Xser_Xst2b_qi t_Xser_Xst2b_Xsfb_mid vss sky130_fd_pr__nfet_01v8_lvt w=1.2 l=0.15
X1180 t_Xser_Xst2b_Xsfb_mid rst_n vss vss sky130_fd_pr__nfet_01v8_lvt w=1.2 l=0.15
X1181 t_Xser_Xst2b_s2 t_Xser_Xst2b_qi vdd vdd sky130_fd_pr__pfet_01v8 w=1.6 l=0.15
X1182 t_Xser_Xst2b_s2 rst_n vdd vdd sky130_fd_pr__pfet_01v8 w=1.6 l=0.15
X1183 t_Xser_Xst2b_s2 t_Xser_Xst2b_clkb t_Xser_Xst2b_s1 vss sky130_fd_pr__nfet_01v8_lvt w=0.8 l=0.15
X1184 t_Xser_Xst2b_s2 t_Xser_Xst2b_clki t_Xser_Xst2b_s1 vdd sky130_fd_pr__pfet_01v8 w=1.6 l=0.15
X1185 t_d2 t_Xser_Xst2b_s1 vss vss sky130_fd_pr__nfet_01v8_lvt w=2.7 l=0.15
X1186 t_d2 t_Xser_Xst2b_s1 vdd vdd sky130_fd_pr__pfet_01v8 w=7.5 l=0.15
X1187 t_db2 t_Xser_Xst2b_qi vss vss sky130_fd_pr__nfet_01v8_lvt w=2.7 l=0.15
X1188 t_db2 t_Xser_Xst2b_qi vdd vdd sky130_fd_pr__pfet_01v8 w=7.5 l=0.15
X1189 t_Xser_Xst3a_clkb t_Xser_c180 vss vss sky130_fd_pr__nfet_01v8_lvt w=1.2 l=0.15
X1190 t_Xser_Xst3a_clkb t_Xser_c180 vdd vdd sky130_fd_pr__pfet_01v8 w=2.4 l=0.15
X1191 t_Xser_Xst3a_clki t_Xser_Xst3a_clkb vss vss sky130_fd_pr__nfet_01v8_lvt w=1.2 l=0.15
X1192 t_Xser_Xst3a_clki t_Xser_Xst3a_clkb vdd vdd sky130_fd_pr__pfet_01v8 w=2.4 l=0.15
X1193 t_Xser_l3 t_Xser_Xst3a_clkb t_Xser_Xst3a_m1 vss sky130_fd_pr__nfet_01v8_lvt w=1.5 l=0.15
X1194 t_Xser_l3 t_Xser_Xst3a_clki t_Xser_Xst3a_m1 vdd sky130_fd_pr__pfet_01v8 w=3 l=0.15
X1195 t_Xser_Xst3a_m2 t_Xser_Xst3a_m1 t_Xser_Xst3a_Xm2_mid vss sky130_fd_pr__nfet_01v8_lvt w=2.25 l=0.15
X1196 t_Xser_Xst3a_Xm2_mid rst_n vss vss sky130_fd_pr__nfet_01v8_lvt w=2.25 l=0.15
X1197 t_Xser_Xst3a_m2 t_Xser_Xst3a_m1 vdd vdd sky130_fd_pr__pfet_01v8 w=3 l=0.15
X1198 t_Xser_Xst3a_m2 rst_n vdd vdd sky130_fd_pr__pfet_01v8 w=3 l=0.15
X1199 t_Xser_Xst3a_m3 t_Xser_Xst3a_m2 vss vss sky130_fd_pr__nfet_01v8_lvt w=0.8 l=0.15
X1200 t_Xser_Xst3a_m3 t_Xser_Xst3a_m2 vdd vdd sky130_fd_pr__pfet_01v8 w=1.6 l=0.15
X1201 t_Xser_Xst3a_m3 t_Xser_Xst3a_clki t_Xser_Xst3a_m1 vss sky130_fd_pr__nfet_01v8_lvt w=0.8 l=0.15
X1202 t_Xser_Xst3a_m3 t_Xser_Xst3a_clkb t_Xser_Xst3a_m1 vdd sky130_fd_pr__pfet_01v8 w=1.6 l=0.15
X1203 t_Xser_Xst3a_m2 t_Xser_Xst3a_clki t_Xser_Xst3a_s1 vss sky130_fd_pr__nfet_01v8_lvt w=1.5 l=0.15
X1204 t_Xser_Xst3a_m2 t_Xser_Xst3a_clkb t_Xser_Xst3a_s1 vdd sky130_fd_pr__pfet_01v8 w=3 l=0.15
X1205 t_Xser_Xst3a_qi t_Xser_Xst3a_s1 vss vss sky130_fd_pr__nfet_01v8_lvt w=1.8 l=0.15
X1206 t_Xser_Xst3a_qi t_Xser_Xst3a_s1 vdd vdd sky130_fd_pr__pfet_01v8 w=3.6 l=0.15
X1207 t_Xser_Xst3a_s2 t_Xser_Xst3a_qi t_Xser_Xst3a_Xsfb_mid vss sky130_fd_pr__nfet_01v8_lvt w=1.2 l=0.15
X1208 t_Xser_Xst3a_Xsfb_mid rst_n vss vss sky130_fd_pr__nfet_01v8_lvt w=1.2 l=0.15
X1209 t_Xser_Xst3a_s2 t_Xser_Xst3a_qi vdd vdd sky130_fd_pr__pfet_01v8 w=1.6 l=0.15
X1210 t_Xser_Xst3a_s2 rst_n vdd vdd sky130_fd_pr__pfet_01v8 w=1.6 l=0.15
X1211 t_Xser_Xst3a_s2 t_Xser_Xst3a_clkb t_Xser_Xst3a_s1 vss sky130_fd_pr__nfet_01v8_lvt w=0.8 l=0.15
X1212 t_Xser_Xst3a_s2 t_Xser_Xst3a_clki t_Xser_Xst3a_s1 vdd sky130_fd_pr__pfet_01v8 w=1.6 l=0.15
X1213 t_Xser_l3h t_Xser_Xst3a_s1 vss vss sky130_fd_pr__nfet_01v8_lvt w=2.25 l=0.15
X1214 t_Xser_l3h t_Xser_Xst3a_s1 vdd vdd sky130_fd_pr__pfet_01v8 w=4.5 l=0.15
X1215 t_Xser_l3hb t_Xser_Xst3a_qi vss vss sky130_fd_pr__nfet_01v8_lvt w=2.25 l=0.15
X1216 t_Xser_l3hb t_Xser_Xst3a_qi vdd vdd sky130_fd_pr__pfet_01v8 w=4.5 l=0.15
X1217 t_Xser_Xst3b_clkb t_Xser_c90 vss vss sky130_fd_pr__nfet_01v8_lvt w=1.4 l=0.15
X1218 t_Xser_Xst3b_clkb t_Xser_c90 vdd vdd sky130_fd_pr__pfet_01v8 w=3.4 l=0.15
X1219 t_Xser_Xst3b_clki t_Xser_Xst3b_clkb vss vss sky130_fd_pr__nfet_01v8_lvt w=1.4 l=0.15
X1220 t_Xser_Xst3b_clki t_Xser_Xst3b_clkb vdd vdd sky130_fd_pr__pfet_01v8 w=3.4 l=0.15
X1221 t_Xser_l3h t_Xser_Xst3b_clkb t_Xser_Xst3b_m1 vss sky130_fd_pr__nfet_01v8_lvt w=1.5 l=0.15
X1222 t_Xser_l3h t_Xser_Xst3b_clki t_Xser_Xst3b_m1 vdd sky130_fd_pr__pfet_01v8 w=2.8 l=0.15
X1223 t_Xser_Xst3b_m2 t_Xser_Xst3b_m1 t_Xser_Xst3b_Xm2_mid vss sky130_fd_pr__nfet_01v8_lvt w=2.25 l=0.15
X1224 t_Xser_Xst3b_Xm2_mid rst_n vss vss sky130_fd_pr__nfet_01v8_lvt w=2.25 l=0.15
X1225 t_Xser_Xst3b_m2 t_Xser_Xst3b_m1 vdd vdd sky130_fd_pr__pfet_01v8 w=2.8 l=0.15
X1226 t_Xser_Xst3b_m2 rst_n vdd vdd sky130_fd_pr__pfet_01v8 w=2.8 l=0.15
X1227 t_Xser_Xst3b_m3 t_Xser_Xst3b_m2 vss vss sky130_fd_pr__nfet_01v8_lvt w=0.8 l=0.15
X1228 t_Xser_Xst3b_m3 t_Xser_Xst3b_m2 vdd vdd sky130_fd_pr__pfet_01v8 w=1.6 l=0.15
X1229 t_Xser_Xst3b_m3 t_Xser_Xst3b_clki t_Xser_Xst3b_m1 vss sky130_fd_pr__nfet_01v8_lvt w=0.8 l=0.15
X1230 t_Xser_Xst3b_m3 t_Xser_Xst3b_clkb t_Xser_Xst3b_m1 vdd sky130_fd_pr__pfet_01v8 w=1.6 l=0.15
X1231 t_Xser_Xst3b_m2 t_Xser_Xst3b_clki t_Xser_Xst3b_s1 vss sky130_fd_pr__nfet_01v8_lvt w=1.5 l=0.15
X1232 t_Xser_Xst3b_m2 t_Xser_Xst3b_clkb t_Xser_Xst3b_s1 vdd sky130_fd_pr__pfet_01v8 w=2.8 l=0.15
X1233 t_Xser_Xst3b_qi t_Xser_Xst3b_s1 vss vss sky130_fd_pr__nfet_01v8_lvt w=2.1 l=0.15
X1234 t_Xser_Xst3b_qi t_Xser_Xst3b_s1 vdd vdd sky130_fd_pr__pfet_01v8 w=5 l=0.15
X1235 t_Xser_Xst3b_s2 t_Xser_Xst3b_qi t_Xser_Xst3b_Xsfb_mid vss sky130_fd_pr__nfet_01v8_lvt w=1.2 l=0.15
X1236 t_Xser_Xst3b_Xsfb_mid rst_n vss vss sky130_fd_pr__nfet_01v8_lvt w=1.2 l=0.15
X1237 t_Xser_Xst3b_s2 t_Xser_Xst3b_qi vdd vdd sky130_fd_pr__pfet_01v8 w=1.6 l=0.15
X1238 t_Xser_Xst3b_s2 rst_n vdd vdd sky130_fd_pr__pfet_01v8 w=1.6 l=0.15
X1239 t_Xser_Xst3b_s2 t_Xser_Xst3b_clkb t_Xser_Xst3b_s1 vss sky130_fd_pr__nfet_01v8_lvt w=0.8 l=0.15
X1240 t_Xser_Xst3b_s2 t_Xser_Xst3b_clki t_Xser_Xst3b_s1 vdd sky130_fd_pr__pfet_01v8 w=1.6 l=0.15
X1241 t_d3 t_Xser_Xst3b_s1 vss vss sky130_fd_pr__nfet_01v8_lvt w=2.7 l=0.15
X1242 t_d3 t_Xser_Xst3b_s1 vdd vdd sky130_fd_pr__pfet_01v8 w=7.5 l=0.15
X1243 t_db3 t_Xser_Xst3b_qi vss vss sky130_fd_pr__nfet_01v8_lvt w=2.7 l=0.15
X1244 t_db3 t_Xser_Xst3b_qi vdd vdd sky130_fd_pr__pfet_01v8 w=7.5 l=0.15
X1245 t_Xdrv_Xldo_vbp t_Xdrv_Xldo_vbp vdd vdd sky130_fd_pr__pfet_01v8 w=20 l=0.35
X1246 t_Xdrv_Xldo_vbp vss vss sky130_fd_pr__res_high_po_1p41 l=80
X1247 t_Xdrv_Xldo_vbn_b t_Xdrv_Xldo_vbp vdd vdd sky130_fd_pr__pfet_01v8 w=5 l=0.35
X1248 t_Xdrv_Xldo_vbn_b t_Xdrv_Xldo_vbn_b vss vss sky130_fd_pr__nfet_01v8 w=4 l=0.5
X1249 t_Xdrv_Xldo_tail_b t_Xdrv_Xldo_vbn_b vss vss sky130_fd_pr__nfet_01v8 w=8 l=0.5
X1250 t_Xdrv_Xldo_nd_b t_Xdrv_Xldo_vbg_buf t_Xdrv_Xldo_tail_b vss sky130_fd_pr__nfet_01v8 w=16 l=1
X1251 t_Xdrv_Xldo_vg_b vbg t_Xdrv_Xldo_tail_b vss sky130_fd_pr__nfet_01v8 w=16 l=1
X1252 t_Xdrv_Xldo_nd_b t_Xdrv_Xldo_nd_b vdd vdd sky130_fd_pr__pfet_01v8_lvt w=16 l=1
X1253 t_Xdrv_Xldo_vg_b t_Xdrv_Xldo_nd_b vdd vdd sky130_fd_pr__pfet_01v8_lvt w=16 l=1
X1254 t_Xdrv_Xldo_vbg_buf t_Xdrv_Xldo_vg_b vdd vdd sky130_fd_pr__pfet_01v8_lvt w=24 l=0.7
X1255 t_Xdrv_Xldo_vg_b t_Xdrv_Xldo_cm_mid sky130_fd_pr__cap_mim_m3_1 w=10 l=10
X1256 t_Xdrv_Xldo_cm_mid t_Xdrv_Xldo_vg_b sky130_fd_pr__cap_mim_m3_2 w=10 l=10
X1257 t_Xdrv_Xldo_cm_mid t_Xdrv_Xldo_vbg_buf vss sky130_fd_pr__res_high_po_1p41 l=15
X1258 t_Xdrv_Xldo_vbg_buf t_Xdrv_Xldo_vref vss sky130_fd_pr__res_high_po_1p41 l=63
X1259 t_Xdrv_Xldo_vref vss vss sky130_fd_pr__res_high_po_1p41 l=37
X1260 t_Xdrv_Xldo_tail t_Xdrv_Xldo_vbp vdd vdd sky130_fd_pr__pfet_01v8 w=40 l=0.35
X1261 t_Xdrv_Xldo_nd t_Xdrv_Xldo_vref t_Xdrv_Xldo_tail vdd sky130_fd_pr__pfet_01v8 w=48 l=0.35
X1262 t_Xdrv_Xldo_vgate vdrv t_Xdrv_Xldo_tail vdd sky130_fd_pr__pfet_01v8 w=48 l=0.35
X1263 t_Xdrv_Xldo_nd t_Xdrv_Xldo_nd vss vss sky130_fd_pr__nfet_01v8 w=16 l=0.5
X1264 t_Xdrv_Xldo_vgate t_Xdrv_Xldo_nd vss vss sky130_fd_pr__nfet_01v8 w=16 l=0.5
X1265 t_Xdrv_Xldo_vgate vss sky130_fd_pr__cap_mim_m3_1 w=17 l=17
X1266 vss t_Xdrv_Xldo_vgate sky130_fd_pr__cap_mim_m3_2 w=17 l=17
X1267 vdd t_Xdrv_Xldo_vgate vdrv vss sky130_fd_pr__nfet_01v8_lvt w=240 l=0.15
X1268 vdrv vss vss sky130_fd_pr__res_high_po_1p41 l=5
X1269 vdrv vss sky130_fd_pr__cap_mim_m3_1 w=24.8 l=24.8
X1270 vss vdrv sky130_fd_pr__cap_mim_m3_2 w=24.8 l=24.8
X1271 vdrv vss sky130_fd_pr__cap_mim_m3_1 w=24.8 l=24.8
X1272 vss vdrv sky130_fd_pr__cap_mim_m3_2 w=24.8 l=24.8
X1273 vdrv vss sky130_fd_pr__cap_mim_m3_1 w=24.8 l=24.8
X1274 vss vdrv sky130_fd_pr__cap_mim_m3_2 w=24.8 l=24.8
X1275 vdrv vss sky130_fd_pr__cap_mim_m3_1 w=24.8 l=24.8
X1276 vss vdrv sky130_fd_pr__cap_mim_m3_2 w=24.8 l=24.8
X1277 vdrv vss sky130_fd_pr__cap_mim_m3_1 w=24.8 l=24.8
X1278 vss vdrv sky130_fd_pr__cap_mim_m3_2 w=24.8 l=24.8
X1279 vdrv vss sky130_fd_pr__cap_mim_m3_1 w=24.8 l=24.8
X1280 vss vdrv sky130_fd_pr__cap_mim_m3_2 w=24.8 l=24.8
X1281 t_Xdrv_Xpg_b0 phi0 vss vss sky130_fd_pr__nfet_01v8_lvt w=3 l=0.15
X1282 t_Xdrv_Xpg_b0 phi0 vdd vdd sky130_fd_pr__pfet_01v8 w=8.4 l=0.15
X1283 t_Xdrv_Xpg_b90 phi90 vss vss sky130_fd_pr__nfet_01v8_lvt w=3 l=0.15
X1284 t_Xdrv_Xpg_b90 phi90 vdd vdd sky130_fd_pr__pfet_01v8 w=8.4 l=0.15
X1285 t_Xdrv_Xpg_b180 phi180 vss vss sky130_fd_pr__nfet_01v8_lvt w=3 l=0.15
X1286 t_Xdrv_Xpg_b180 phi180 vdd vdd sky130_fd_pr__pfet_01v8 w=8.4 l=0.15
X1287 t_Xdrv_Xpg_b270 phi270 vss vss sky130_fd_pr__nfet_01v8_lvt w=3 l=0.15
X1288 t_Xdrv_Xpg_b270 phi270 vdd vdd sky130_fd_pr__pfet_01v8 w=8.4 l=0.15
X1289 t_Xdrv_Xpg_b180 t_Xdrv_Xpg_b0 vss vss sky130_fd_pr__nfet_01v8_lvt w=0.6 l=0.15
X1290 t_Xdrv_Xpg_b180 t_Xdrv_Xpg_b0 vdd vdd sky130_fd_pr__pfet_01v8 w=1.6 l=0.15
X1291 t_Xdrv_Xpg_b0 t_Xdrv_Xpg_b180 vss vss sky130_fd_pr__nfet_01v8_lvt w=0.6 l=0.15
X1292 t_Xdrv_Xpg_b0 t_Xdrv_Xpg_b180 vdd vdd sky130_fd_pr__pfet_01v8 w=1.6 l=0.15
X1293 t_Xdrv_Xpg_b270 t_Xdrv_Xpg_b90 vss vss sky130_fd_pr__nfet_01v8_lvt w=0.6 l=0.15
X1294 t_Xdrv_Xpg_b270 t_Xdrv_Xpg_b90 vdd vdd sky130_fd_pr__pfet_01v8 w=1.6 l=0.15
X1295 t_Xdrv_Xpg_b90 t_Xdrv_Xpg_b270 vss vss sky130_fd_pr__nfet_01v8_lvt w=0.6 l=0.15
X1296 t_Xdrv_Xpg_b90 t_Xdrv_Xpg_b270 vdd vdd sky130_fd_pr__pfet_01v8 w=1.6 l=0.15
X1297 t_Xdrv_Xpg_c0 t_Xdrv_Xpg_b0 vss vss sky130_fd_pr__nfet_01v8_lvt w=5 l=0.15
X1298 t_Xdrv_Xpg_c0 t_Xdrv_Xpg_b0 vdd vdd sky130_fd_pr__pfet_01v8 w=14 l=0.15
X1299 t_Xdrv_Xpg_c90 t_Xdrv_Xpg_b90 vss vss sky130_fd_pr__nfet_01v8_lvt w=5 l=0.15
X1300 t_Xdrv_Xpg_c90 t_Xdrv_Xpg_b90 vdd vdd sky130_fd_pr__pfet_01v8 w=14 l=0.15
X1301 t_Xdrv_Xpg_c180 t_Xdrv_Xpg_b180 vss vss sky130_fd_pr__nfet_01v8_lvt w=5 l=0.15
X1302 t_Xdrv_Xpg_c180 t_Xdrv_Xpg_b180 vdd vdd sky130_fd_pr__pfet_01v8 w=14 l=0.15
X1303 t_Xdrv_Xpg_c270 t_Xdrv_Xpg_b270 vss vss sky130_fd_pr__nfet_01v8_lvt w=5 l=0.15
X1304 t_Xdrv_Xpg_c270 t_Xdrv_Xpg_b270 vdd vdd sky130_fd_pr__pfet_01v8 w=14 l=0.15
X1305 t_Xdrv_Xpg_c180 t_Xdrv_Xpg_c0 vss vss sky130_fd_pr__nfet_01v8_lvt w=0.8 l=0.15
X1306 t_Xdrv_Xpg_c180 t_Xdrv_Xpg_c0 vdd vdd sky130_fd_pr__pfet_01v8 w=2.2 l=0.15
X1307 t_Xdrv_Xpg_c0 t_Xdrv_Xpg_c180 vss vss sky130_fd_pr__nfet_01v8_lvt w=0.8 l=0.15
X1308 t_Xdrv_Xpg_c0 t_Xdrv_Xpg_c180 vdd vdd sky130_fd_pr__pfet_01v8 w=2.2 l=0.15
X1309 t_Xdrv_Xpg_c270 t_Xdrv_Xpg_c90 vss vss sky130_fd_pr__nfet_01v8_lvt w=0.8 l=0.15
X1310 t_Xdrv_Xpg_c270 t_Xdrv_Xpg_c90 vdd vdd sky130_fd_pr__pfet_01v8 w=2.2 l=0.15
X1311 t_Xdrv_Xpg_c90 t_Xdrv_Xpg_c270 vss vss sky130_fd_pr__nfet_01v8_lvt w=0.8 l=0.15
X1312 t_Xdrv_Xpg_c90 t_Xdrv_Xpg_c270 vdd vdd sky130_fd_pr__pfet_01v8 w=2.2 l=0.15
X1313 t_Xdrv_Xpg_pb0 t_Xdrv_Xpg_c0 t_Xdrv_Xpg_Xpb0_mid vss sky130_fd_pr__nfet_01v8_lvt w=5.6 l=0.15
X1314 t_Xdrv_Xpg_Xpb0_mid t_Xdrv_Xpg_c270 vss vss sky130_fd_pr__nfet_01v8_lvt w=5.6 l=0.15
X1315 t_Xdrv_Xpg_pb0 t_Xdrv_Xpg_c0 vdd vdd sky130_fd_pr__pfet_01v8 w=10.4 l=0.15
X1316 t_Xdrv_Xpg_pb0 t_Xdrv_Xpg_c270 vdd vdd sky130_fd_pr__pfet_01v8 w=10.4 l=0.15
X1317 t_Xdrv_Xpg_pb1 t_Xdrv_Xpg_c90 t_Xdrv_Xpg_Xpb1_mid vss sky130_fd_pr__nfet_01v8_lvt w=5.6 l=0.15
X1318 t_Xdrv_Xpg_Xpb1_mid t_Xdrv_Xpg_c0 vss vss sky130_fd_pr__nfet_01v8_lvt w=5.6 l=0.15
X1319 t_Xdrv_Xpg_pb1 t_Xdrv_Xpg_c90 vdd vdd sky130_fd_pr__pfet_01v8 w=10.4 l=0.15
X1320 t_Xdrv_Xpg_pb1 t_Xdrv_Xpg_c0 vdd vdd sky130_fd_pr__pfet_01v8 w=10.4 l=0.15
X1321 t_Xdrv_Xpg_pb2 t_Xdrv_Xpg_c180 t_Xdrv_Xpg_Xpb2_mid vss sky130_fd_pr__nfet_01v8_lvt w=5.6 l=0.15
X1322 t_Xdrv_Xpg_Xpb2_mid t_Xdrv_Xpg_c90 vss vss sky130_fd_pr__nfet_01v8_lvt w=5.6 l=0.15
X1323 t_Xdrv_Xpg_pb2 t_Xdrv_Xpg_c180 vdd vdd sky130_fd_pr__pfet_01v8 w=10.4 l=0.15
X1324 t_Xdrv_Xpg_pb2 t_Xdrv_Xpg_c90 vdd vdd sky130_fd_pr__pfet_01v8 w=10.4 l=0.15
X1325 t_Xdrv_Xpg_pb3 t_Xdrv_Xpg_c270 t_Xdrv_Xpg_Xpb3_mid vss sky130_fd_pr__nfet_01v8_lvt w=5.6 l=0.15
X1326 t_Xdrv_Xpg_Xpb3_mid t_Xdrv_Xpg_c180 vss vss sky130_fd_pr__nfet_01v8_lvt w=5.6 l=0.15
X1327 t_Xdrv_Xpg_pb3 t_Xdrv_Xpg_c270 vdd vdd sky130_fd_pr__pfet_01v8 w=10.4 l=0.15
X1328 t_Xdrv_Xpg_pb3 t_Xdrv_Xpg_c180 vdd vdd sky130_fd_pr__pfet_01v8 w=10.4 l=0.15
X1329 t_Xdrv_p0 t_Xdrv_Xpg_pb0 vss vss sky130_fd_pr__nfet_01v8_lvt w=6.6 l=0.15
X1330 t_Xdrv_p0 t_Xdrv_Xpg_pb0 vdd vdd sky130_fd_pr__pfet_01v8 w=15.9 l=0.15
X1331 t_Xdrv_p1 t_Xdrv_Xpg_pb1 vss vss sky130_fd_pr__nfet_01v8_lvt w=6.6 l=0.15
X1332 t_Xdrv_p1 t_Xdrv_Xpg_pb1 vdd vdd sky130_fd_pr__pfet_01v8 w=15.9 l=0.15
X1333 t_Xdrv_p2 t_Xdrv_Xpg_pb2 vss vss sky130_fd_pr__nfet_01v8_lvt w=6.6 l=0.15
X1334 t_Xdrv_p2 t_Xdrv_Xpg_pb2 vdd vdd sky130_fd_pr__pfet_01v8 w=15.9 l=0.15
X1335 t_Xdrv_p3 t_Xdrv_Xpg_pb3 vss vss sky130_fd_pr__nfet_01v8_lvt w=6.6 l=0.15
X1336 t_Xdrv_p3 t_Xdrv_Xpg_pb3 vdd vdd sky130_fd_pr__pfet_01v8 w=15.9 l=0.15
X1337 t_Xdrv_Xmux_m_g0p t_Xdrv_p0 t_Xdrv_Xmux_m_Xg0p_mid vss sky130_fd_pr__nfet_01v8_lvt w=2.4 l=0.15
X1338 t_Xdrv_Xmux_m_Xg0p_mid t_d0 vss vss sky130_fd_pr__nfet_01v8_lvt w=2.4 l=0.15
X1339 t_Xdrv_Xmux_m_g0p t_Xdrv_p0 vdd vdd sky130_fd_pr__pfet_01v8 w=5.4 l=0.15
X1340 t_Xdrv_Xmux_m_g0p t_d0 vdd vdd sky130_fd_pr__pfet_01v8 w=5.4 l=0.15
X1341 t_Xdrv_Xmux_m_g1p t_Xdrv_p1 t_Xdrv_Xmux_m_Xg1p_mid vss sky130_fd_pr__nfet_01v8_lvt w=2.4 l=0.15
X1342 t_Xdrv_Xmux_m_Xg1p_mid t_d1 vss vss sky130_fd_pr__nfet_01v8_lvt w=2.4 l=0.15
X1343 t_Xdrv_Xmux_m_g1p t_Xdrv_p1 vdd vdd sky130_fd_pr__pfet_01v8 w=5.4 l=0.15
X1344 t_Xdrv_Xmux_m_g1p t_d1 vdd vdd sky130_fd_pr__pfet_01v8 w=5.4 l=0.15
X1345 t_Xdrv_Xmux_m_g2p t_Xdrv_p2 t_Xdrv_Xmux_m_Xg2p_mid vss sky130_fd_pr__nfet_01v8_lvt w=2.4 l=0.15
X1346 t_Xdrv_Xmux_m_Xg2p_mid t_d2 vss vss sky130_fd_pr__nfet_01v8_lvt w=2.4 l=0.15
X1347 t_Xdrv_Xmux_m_g2p t_Xdrv_p2 vdd vdd sky130_fd_pr__pfet_01v8 w=5.4 l=0.15
X1348 t_Xdrv_Xmux_m_g2p t_d2 vdd vdd sky130_fd_pr__pfet_01v8 w=5.4 l=0.15
X1349 t_Xdrv_Xmux_m_g3p t_Xdrv_p3 t_Xdrv_Xmux_m_Xg3p_mid vss sky130_fd_pr__nfet_01v8_lvt w=2.4 l=0.15
X1350 t_Xdrv_Xmux_m_Xg3p_mid t_d3 vss vss sky130_fd_pr__nfet_01v8_lvt w=2.4 l=0.15
X1351 t_Xdrv_Xmux_m_g3p t_Xdrv_p3 vdd vdd sky130_fd_pr__pfet_01v8 w=5.4 l=0.15
X1352 t_Xdrv_Xmux_m_g3p t_d3 vdd vdd sky130_fd_pr__pfet_01v8 w=5.4 l=0.15
X1353 t_Xdrv_Xmux_m_ep t_Xdrv_Xmux_m_g0p t_Xdrv_Xmux_m_Xepa_mid vss sky130_fd_pr__nfet_01v8_lvt w=1.8 l=0.15
X1354 t_Xdrv_Xmux_m_Xepa_mid t_Xdrv_Xmux_m_g2p vss vss sky130_fd_pr__nfet_01v8_lvt w=1.8 l=0.15
X1355 t_Xdrv_Xmux_m_ep t_Xdrv_Xmux_m_g0p vdd vdd sky130_fd_pr__pfet_01v8 w=3.6 l=0.15
X1356 t_Xdrv_Xmux_m_ep t_Xdrv_Xmux_m_g2p vdd vdd sky130_fd_pr__pfet_01v8 w=3.6 l=0.15
X1357 t_Xdrv_Xmux_m_ep t_Xdrv_Xmux_m_g2p t_Xdrv_Xmux_m_Xepb_mid vss sky130_fd_pr__nfet_01v8_lvt w=1.8 l=0.15
X1358 t_Xdrv_Xmux_m_Xepb_mid t_Xdrv_Xmux_m_g0p vss vss sky130_fd_pr__nfet_01v8_lvt w=1.8 l=0.15
X1359 t_Xdrv_Xmux_m_ep t_Xdrv_Xmux_m_g2p vdd vdd sky130_fd_pr__pfet_01v8 w=3.6 l=0.15
X1360 t_Xdrv_Xmux_m_ep t_Xdrv_Xmux_m_g0p vdd vdd sky130_fd_pr__pfet_01v8 w=3.6 l=0.15
X1361 t_Xdrv_Xmux_m_op t_Xdrv_Xmux_m_g1p t_Xdrv_Xmux_m_Xopa_mid vss sky130_fd_pr__nfet_01v8_lvt w=1.8 l=0.15
X1362 t_Xdrv_Xmux_m_Xopa_mid t_Xdrv_Xmux_m_g3p vss vss sky130_fd_pr__nfet_01v8_lvt w=1.8 l=0.15
X1363 t_Xdrv_Xmux_m_op t_Xdrv_Xmux_m_g1p vdd vdd sky130_fd_pr__pfet_01v8 w=3.6 l=0.15
X1364 t_Xdrv_Xmux_m_op t_Xdrv_Xmux_m_g3p vdd vdd sky130_fd_pr__pfet_01v8 w=3.6 l=0.15
X1365 t_Xdrv_Xmux_m_op t_Xdrv_Xmux_m_g3p t_Xdrv_Xmux_m_Xopb_mid vss sky130_fd_pr__nfet_01v8_lvt w=1.8 l=0.15
X1366 t_Xdrv_Xmux_m_Xopb_mid t_Xdrv_Xmux_m_g1p vss vss sky130_fd_pr__nfet_01v8_lvt w=1.8 l=0.15
X1367 t_Xdrv_Xmux_m_op t_Xdrv_Xmux_m_g3p vdd vdd sky130_fd_pr__pfet_01v8 w=3.6 l=0.15
X1368 t_Xdrv_Xmux_m_op t_Xdrv_Xmux_m_g1p vdd vdd sky130_fd_pr__pfet_01v8 w=3.6 l=0.15
X1369 t_Xdrv_Xmux_m_ep_b t_Xdrv_Xmux_m_ep vss vss sky130_fd_pr__nfet_01v8_lvt w=2.4 l=0.15
X1370 t_Xdrv_Xmux_m_ep_b t_Xdrv_Xmux_m_ep vdd vdd sky130_fd_pr__pfet_01v8 w=7.2 l=0.15
X1371 t_Xdrv_Xmux_m_op_b t_Xdrv_Xmux_m_op vss vss sky130_fd_pr__nfet_01v8_lvt w=2.4 l=0.15
X1372 t_Xdrv_Xmux_m_op_b t_Xdrv_Xmux_m_op vdd vdd sky130_fd_pr__pfet_01v8 w=7.2 l=0.15
X1373 t_Xdrv_Xmux_m_pre_p t_Xdrv_Xmux_m_ep_b t_Xdrv_Xmux_m_Xmp1a_mid vss sky130_fd_pr__nfet_01v8_lvt w=2.8 l=0.15
X1374 t_Xdrv_Xmux_m_Xmp1a_mid t_Xdrv_Xmux_m_op_b vss vss sky130_fd_pr__nfet_01v8_lvt w=2.8 l=0.15
X1375 t_Xdrv_Xmux_m_pre_p t_Xdrv_Xmux_m_ep_b vdd vdd sky130_fd_pr__pfet_01v8 w=5.2 l=0.15
X1376 t_Xdrv_Xmux_m_pre_p t_Xdrv_Xmux_m_op_b vdd vdd sky130_fd_pr__pfet_01v8 w=5.2 l=0.15
X1377 t_Xdrv_Xmux_m_pre_p t_Xdrv_Xmux_m_op_b t_Xdrv_Xmux_m_Xmp1b_mid vss sky130_fd_pr__nfet_01v8_lvt w=2.8 l=0.15
X1378 t_Xdrv_Xmux_m_Xmp1b_mid t_Xdrv_Xmux_m_ep_b vss vss sky130_fd_pr__nfet_01v8_lvt w=2.8 l=0.15
X1379 t_Xdrv_Xmux_m_pre_p t_Xdrv_Xmux_m_op_b vdd vdd sky130_fd_pr__pfet_01v8 w=5.2 l=0.15
X1380 t_Xdrv_Xmux_m_pre_p t_Xdrv_Xmux_m_ep_b vdd vdd sky130_fd_pr__pfet_01v8 w=5.2 l=0.15
X1381 t_Xdrv_Xmux_m_mid_p t_Xdrv_Xmux_m_pre_p vss vss sky130_fd_pr__nfet_01v8_lvt w=6 l=0.15
X1382 t_Xdrv_Xmux_m_mid_p t_Xdrv_Xmux_m_pre_p vdd vdd sky130_fd_pr__pfet_01v8 w=13.5 l=0.15
X1383 t_Xdrv_mp t_Xdrv_Xmux_m_mid_p vss vss sky130_fd_pr__nfet_01v8_lvt w=12.5 l=0.15
X1384 t_Xdrv_mp t_Xdrv_Xmux_m_mid_p vdd vdd sky130_fd_pr__pfet_01v8 w=39 l=0.15
X1385 t_Xdrv_Xmux_m_g0n t_Xdrv_p0 t_Xdrv_Xmux_m_Xg0n_mid vss sky130_fd_pr__nfet_01v8_lvt w=2.4 l=0.15
X1386 t_Xdrv_Xmux_m_Xg0n_mid t_db0 vss vss sky130_fd_pr__nfet_01v8_lvt w=2.4 l=0.15
X1387 t_Xdrv_Xmux_m_g0n t_Xdrv_p0 vdd vdd sky130_fd_pr__pfet_01v8 w=5.4 l=0.15
X1388 t_Xdrv_Xmux_m_g0n t_db0 vdd vdd sky130_fd_pr__pfet_01v8 w=5.4 l=0.15
X1389 t_Xdrv_Xmux_m_g1n t_Xdrv_p1 t_Xdrv_Xmux_m_Xg1n_mid vss sky130_fd_pr__nfet_01v8_lvt w=2.4 l=0.15
X1390 t_Xdrv_Xmux_m_Xg1n_mid t_db1 vss vss sky130_fd_pr__nfet_01v8_lvt w=2.4 l=0.15
X1391 t_Xdrv_Xmux_m_g1n t_Xdrv_p1 vdd vdd sky130_fd_pr__pfet_01v8 w=5.4 l=0.15
X1392 t_Xdrv_Xmux_m_g1n t_db1 vdd vdd sky130_fd_pr__pfet_01v8 w=5.4 l=0.15
X1393 t_Xdrv_Xmux_m_g2n t_Xdrv_p2 t_Xdrv_Xmux_m_Xg2n_mid vss sky130_fd_pr__nfet_01v8_lvt w=2.4 l=0.15
X1394 t_Xdrv_Xmux_m_Xg2n_mid t_db2 vss vss sky130_fd_pr__nfet_01v8_lvt w=2.4 l=0.15
X1395 t_Xdrv_Xmux_m_g2n t_Xdrv_p2 vdd vdd sky130_fd_pr__pfet_01v8 w=5.4 l=0.15
X1396 t_Xdrv_Xmux_m_g2n t_db2 vdd vdd sky130_fd_pr__pfet_01v8 w=5.4 l=0.15
X1397 t_Xdrv_Xmux_m_g3n t_Xdrv_p3 t_Xdrv_Xmux_m_Xg3n_mid vss sky130_fd_pr__nfet_01v8_lvt w=2.4 l=0.15
X1398 t_Xdrv_Xmux_m_Xg3n_mid t_db3 vss vss sky130_fd_pr__nfet_01v8_lvt w=2.4 l=0.15
X1399 t_Xdrv_Xmux_m_g3n t_Xdrv_p3 vdd vdd sky130_fd_pr__pfet_01v8 w=5.4 l=0.15
X1400 t_Xdrv_Xmux_m_g3n t_db3 vdd vdd sky130_fd_pr__pfet_01v8 w=5.4 l=0.15
X1401 t_Xdrv_Xmux_m_en_ t_Xdrv_Xmux_m_g0n t_Xdrv_Xmux_m_Xena_mid vss sky130_fd_pr__nfet_01v8_lvt w=1.8 l=0.15
X1402 t_Xdrv_Xmux_m_Xena_mid t_Xdrv_Xmux_m_g2n vss vss sky130_fd_pr__nfet_01v8_lvt w=1.8 l=0.15
X1403 t_Xdrv_Xmux_m_en_ t_Xdrv_Xmux_m_g0n vdd vdd sky130_fd_pr__pfet_01v8 w=3.6 l=0.15
X1404 t_Xdrv_Xmux_m_en_ t_Xdrv_Xmux_m_g2n vdd vdd sky130_fd_pr__pfet_01v8 w=3.6 l=0.15
X1405 t_Xdrv_Xmux_m_en_ t_Xdrv_Xmux_m_g2n t_Xdrv_Xmux_m_Xenb_mid vss sky130_fd_pr__nfet_01v8_lvt w=1.8 l=0.15
X1406 t_Xdrv_Xmux_m_Xenb_mid t_Xdrv_Xmux_m_g0n vss vss sky130_fd_pr__nfet_01v8_lvt w=1.8 l=0.15
X1407 t_Xdrv_Xmux_m_en_ t_Xdrv_Xmux_m_g2n vdd vdd sky130_fd_pr__pfet_01v8 w=3.6 l=0.15
X1408 t_Xdrv_Xmux_m_en_ t_Xdrv_Xmux_m_g0n vdd vdd sky130_fd_pr__pfet_01v8 w=3.6 l=0.15
X1409 t_Xdrv_Xmux_m_on_ t_Xdrv_Xmux_m_g1n t_Xdrv_Xmux_m_Xona_mid vss sky130_fd_pr__nfet_01v8_lvt w=1.8 l=0.15
X1410 t_Xdrv_Xmux_m_Xona_mid t_Xdrv_Xmux_m_g3n vss vss sky130_fd_pr__nfet_01v8_lvt w=1.8 l=0.15
X1411 t_Xdrv_Xmux_m_on_ t_Xdrv_Xmux_m_g1n vdd vdd sky130_fd_pr__pfet_01v8 w=3.6 l=0.15
X1412 t_Xdrv_Xmux_m_on_ t_Xdrv_Xmux_m_g3n vdd vdd sky130_fd_pr__pfet_01v8 w=3.6 l=0.15
X1413 t_Xdrv_Xmux_m_on_ t_Xdrv_Xmux_m_g3n t_Xdrv_Xmux_m_Xonb_mid vss sky130_fd_pr__nfet_01v8_lvt w=1.8 l=0.15
X1414 t_Xdrv_Xmux_m_Xonb_mid t_Xdrv_Xmux_m_g1n vss vss sky130_fd_pr__nfet_01v8_lvt w=1.8 l=0.15
X1415 t_Xdrv_Xmux_m_on_ t_Xdrv_Xmux_m_g3n vdd vdd sky130_fd_pr__pfet_01v8 w=3.6 l=0.15
X1416 t_Xdrv_Xmux_m_on_ t_Xdrv_Xmux_m_g1n vdd vdd sky130_fd_pr__pfet_01v8 w=3.6 l=0.15
X1417 t_Xdrv_Xmux_m_en_b t_Xdrv_Xmux_m_en_ vss vss sky130_fd_pr__nfet_01v8_lvt w=2.4 l=0.15
X1418 t_Xdrv_Xmux_m_en_b t_Xdrv_Xmux_m_en_ vdd vdd sky130_fd_pr__pfet_01v8 w=7.2 l=0.15
X1419 t_Xdrv_Xmux_m_on_b t_Xdrv_Xmux_m_on_ vss vss sky130_fd_pr__nfet_01v8_lvt w=2.4 l=0.15
X1420 t_Xdrv_Xmux_m_on_b t_Xdrv_Xmux_m_on_ vdd vdd sky130_fd_pr__pfet_01v8 w=7.2 l=0.15
X1421 t_Xdrv_Xmux_m_pre_n t_Xdrv_Xmux_m_en_b t_Xdrv_Xmux_m_Xmn1a_mid vss sky130_fd_pr__nfet_01v8_lvt w=2.8 l=0.15
X1422 t_Xdrv_Xmux_m_Xmn1a_mid t_Xdrv_Xmux_m_on_b vss vss sky130_fd_pr__nfet_01v8_lvt w=2.8 l=0.15
X1423 t_Xdrv_Xmux_m_pre_n t_Xdrv_Xmux_m_en_b vdd vdd sky130_fd_pr__pfet_01v8 w=5.2 l=0.15
X1424 t_Xdrv_Xmux_m_pre_n t_Xdrv_Xmux_m_on_b vdd vdd sky130_fd_pr__pfet_01v8 w=5.2 l=0.15
X1425 t_Xdrv_Xmux_m_pre_n t_Xdrv_Xmux_m_on_b t_Xdrv_Xmux_m_Xmn1b_mid vss sky130_fd_pr__nfet_01v8_lvt w=2.8 l=0.15
X1426 t_Xdrv_Xmux_m_Xmn1b_mid t_Xdrv_Xmux_m_en_b vss vss sky130_fd_pr__nfet_01v8_lvt w=2.8 l=0.15
X1427 t_Xdrv_Xmux_m_pre_n t_Xdrv_Xmux_m_on_b vdd vdd sky130_fd_pr__pfet_01v8 w=5.2 l=0.15
X1428 t_Xdrv_Xmux_m_pre_n t_Xdrv_Xmux_m_en_b vdd vdd sky130_fd_pr__pfet_01v8 w=5.2 l=0.15
X1429 t_Xdrv_Xmux_m_mid_n t_Xdrv_Xmux_m_pre_n vss vss sky130_fd_pr__nfet_01v8_lvt w=6 l=0.15
X1430 t_Xdrv_Xmux_m_mid_n t_Xdrv_Xmux_m_pre_n vdd vdd sky130_fd_pr__pfet_01v8 w=13.5 l=0.15
X1431 t_Xdrv_mn t_Xdrv_Xmux_m_mid_n vss vss sky130_fd_pr__nfet_01v8_lvt w=12.5 l=0.15
X1432 t_Xdrv_mn t_Xdrv_Xmux_m_mid_n vdd vdd sky130_fd_pr__pfet_01v8 w=39 l=0.15
X1433 t_Xdrv_Xmux_f_g0p t_Xdrv_p0 t_Xdrv_Xmux_f_Xg0p_mid vss sky130_fd_pr__nfet_01v8_lvt w=1.8 l=0.15
X1434 t_Xdrv_Xmux_f_Xg0p_mid t_db3 vss vss sky130_fd_pr__nfet_01v8_lvt w=1.8 l=0.15
X1435 t_Xdrv_Xmux_f_g0p t_Xdrv_p0 vdd vdd sky130_fd_pr__pfet_01v8 w=4.2 l=0.15
X1436 t_Xdrv_Xmux_f_g0p t_db3 vdd vdd sky130_fd_pr__pfet_01v8 w=4.2 l=0.15
X1437 t_Xdrv_Xmux_f_g1p t_Xdrv_p1 t_Xdrv_Xmux_f_Xg1p_mid vss sky130_fd_pr__nfet_01v8_lvt w=1.8 l=0.15
X1438 t_Xdrv_Xmux_f_Xg1p_mid t_db0 vss vss sky130_fd_pr__nfet_01v8_lvt w=1.8 l=0.15
X1439 t_Xdrv_Xmux_f_g1p t_Xdrv_p1 vdd vdd sky130_fd_pr__pfet_01v8 w=4.2 l=0.15
X1440 t_Xdrv_Xmux_f_g1p t_db0 vdd vdd sky130_fd_pr__pfet_01v8 w=4.2 l=0.15
X1441 t_Xdrv_Xmux_f_g2p t_Xdrv_p2 t_Xdrv_Xmux_f_Xg2p_mid vss sky130_fd_pr__nfet_01v8_lvt w=1.8 l=0.15
X1442 t_Xdrv_Xmux_f_Xg2p_mid t_db1 vss vss sky130_fd_pr__nfet_01v8_lvt w=1.8 l=0.15
X1443 t_Xdrv_Xmux_f_g2p t_Xdrv_p2 vdd vdd sky130_fd_pr__pfet_01v8 w=4.2 l=0.15
X1444 t_Xdrv_Xmux_f_g2p t_db1 vdd vdd sky130_fd_pr__pfet_01v8 w=4.2 l=0.15
X1445 t_Xdrv_Xmux_f_g3p t_Xdrv_p3 t_Xdrv_Xmux_f_Xg3p_mid vss sky130_fd_pr__nfet_01v8_lvt w=1.8 l=0.15
X1446 t_Xdrv_Xmux_f_Xg3p_mid t_db2 vss vss sky130_fd_pr__nfet_01v8_lvt w=1.8 l=0.15
X1447 t_Xdrv_Xmux_f_g3p t_Xdrv_p3 vdd vdd sky130_fd_pr__pfet_01v8 w=4.2 l=0.15
X1448 t_Xdrv_Xmux_f_g3p t_db2 vdd vdd sky130_fd_pr__pfet_01v8 w=4.2 l=0.15
X1449 t_Xdrv_Xmux_f_ep t_Xdrv_Xmux_f_g0p t_Xdrv_Xmux_f_Xepa_mid vss sky130_fd_pr__nfet_01v8_lvt w=1.4 l=0.15
X1450 t_Xdrv_Xmux_f_Xepa_mid t_Xdrv_Xmux_f_g2p vss vss sky130_fd_pr__nfet_01v8_lvt w=1.4 l=0.15
X1451 t_Xdrv_Xmux_f_ep t_Xdrv_Xmux_f_g0p vdd vdd sky130_fd_pr__pfet_01v8 w=2.8 l=0.15
X1452 t_Xdrv_Xmux_f_ep t_Xdrv_Xmux_f_g2p vdd vdd sky130_fd_pr__pfet_01v8 w=2.8 l=0.15
X1453 t_Xdrv_Xmux_f_ep t_Xdrv_Xmux_f_g2p t_Xdrv_Xmux_f_Xepb_mid vss sky130_fd_pr__nfet_01v8_lvt w=1.4 l=0.15
X1454 t_Xdrv_Xmux_f_Xepb_mid t_Xdrv_Xmux_f_g0p vss vss sky130_fd_pr__nfet_01v8_lvt w=1.4 l=0.15
X1455 t_Xdrv_Xmux_f_ep t_Xdrv_Xmux_f_g2p vdd vdd sky130_fd_pr__pfet_01v8 w=2.8 l=0.15
X1456 t_Xdrv_Xmux_f_ep t_Xdrv_Xmux_f_g0p vdd vdd sky130_fd_pr__pfet_01v8 w=2.8 l=0.15
X1457 t_Xdrv_Xmux_f_op t_Xdrv_Xmux_f_g1p t_Xdrv_Xmux_f_Xopa_mid vss sky130_fd_pr__nfet_01v8_lvt w=1.4 l=0.15
X1458 t_Xdrv_Xmux_f_Xopa_mid t_Xdrv_Xmux_f_g3p vss vss sky130_fd_pr__nfet_01v8_lvt w=1.4 l=0.15
X1459 t_Xdrv_Xmux_f_op t_Xdrv_Xmux_f_g1p vdd vdd sky130_fd_pr__pfet_01v8 w=2.8 l=0.15
X1460 t_Xdrv_Xmux_f_op t_Xdrv_Xmux_f_g3p vdd vdd sky130_fd_pr__pfet_01v8 w=2.8 l=0.15
X1461 t_Xdrv_Xmux_f_op t_Xdrv_Xmux_f_g3p t_Xdrv_Xmux_f_Xopb_mid vss sky130_fd_pr__nfet_01v8_lvt w=1.4 l=0.15
X1462 t_Xdrv_Xmux_f_Xopb_mid t_Xdrv_Xmux_f_g1p vss vss sky130_fd_pr__nfet_01v8_lvt w=1.4 l=0.15
X1463 t_Xdrv_Xmux_f_op t_Xdrv_Xmux_f_g3p vdd vdd sky130_fd_pr__pfet_01v8 w=2.8 l=0.15
X1464 t_Xdrv_Xmux_f_op t_Xdrv_Xmux_f_g1p vdd vdd sky130_fd_pr__pfet_01v8 w=2.8 l=0.15
X1465 t_Xdrv_Xmux_f_ep_b t_Xdrv_Xmux_f_ep vss vss sky130_fd_pr__nfet_01v8_lvt w=1.8 l=0.15
X1466 t_Xdrv_Xmux_f_ep_b t_Xdrv_Xmux_f_ep vdd vdd sky130_fd_pr__pfet_01v8 w=5.4 l=0.15
X1467 t_Xdrv_Xmux_f_op_b t_Xdrv_Xmux_f_op vss vss sky130_fd_pr__nfet_01v8_lvt w=1.8 l=0.15
X1468 t_Xdrv_Xmux_f_op_b t_Xdrv_Xmux_f_op vdd vdd sky130_fd_pr__pfet_01v8 w=5.4 l=0.15
X1469 t_Xdrv_Xmux_f_pre_p t_Xdrv_Xmux_f_ep_b t_Xdrv_Xmux_f_Xmp1a_mid vss sky130_fd_pr__nfet_01v8_lvt w=2.1 l=0.15
X1470 t_Xdrv_Xmux_f_Xmp1a_mid t_Xdrv_Xmux_f_op_b vss vss sky130_fd_pr__nfet_01v8_lvt w=2.1 l=0.15
X1471 t_Xdrv_Xmux_f_pre_p t_Xdrv_Xmux_f_ep_b vdd vdd sky130_fd_pr__pfet_01v8 w=3.9 l=0.15
X1472 t_Xdrv_Xmux_f_pre_p t_Xdrv_Xmux_f_op_b vdd vdd sky130_fd_pr__pfet_01v8 w=3.9 l=0.15
X1473 t_Xdrv_Xmux_f_pre_p t_Xdrv_Xmux_f_op_b t_Xdrv_Xmux_f_Xmp1b_mid vss sky130_fd_pr__nfet_01v8_lvt w=2.1 l=0.15
X1474 t_Xdrv_Xmux_f_Xmp1b_mid t_Xdrv_Xmux_f_ep_b vss vss sky130_fd_pr__nfet_01v8_lvt w=2.1 l=0.15
X1475 t_Xdrv_Xmux_f_pre_p t_Xdrv_Xmux_f_op_b vdd vdd sky130_fd_pr__pfet_01v8 w=3.9 l=0.15
X1476 t_Xdrv_Xmux_f_pre_p t_Xdrv_Xmux_f_ep_b vdd vdd sky130_fd_pr__pfet_01v8 w=3.9 l=0.15
X1477 t_Xdrv_Xmux_f_mid_p t_Xdrv_Xmux_f_pre_p t_Xdrv_Xmux_f_Xmbp_mid vss sky130_fd_pr__nfet_01v8_lvt w=8.4 l=0.15
X1478 t_Xdrv_Xmux_f_Xmbp_mid ffe_en vss vss sky130_fd_pr__nfet_01v8_lvt w=8.4 l=0.15
X1479 t_Xdrv_Xmux_f_mid_p t_Xdrv_Xmux_f_pre_p vdd vdd sky130_fd_pr__pfet_01v8 w=9.6 l=0.15
X1480 t_Xdrv_Xmux_f_mid_p ffe_en vdd vdd sky130_fd_pr__pfet_01v8 w=9.6 l=0.15
X1481 t_Xdrv_fp t_Xdrv_Xmux_f_mid_p vss vss sky130_fd_pr__nfet_01v8_lvt w=5.6 l=0.15
X1482 t_Xdrv_fp t_Xdrv_Xmux_f_mid_p vdd vdd sky130_fd_pr__pfet_01v8 w=19.6 l=0.15
X1483 t_Xdrv_Xmux_f_g0n t_Xdrv_p0 t_Xdrv_Xmux_f_Xg0n_mid vss sky130_fd_pr__nfet_01v8_lvt w=1.8 l=0.15
X1484 t_Xdrv_Xmux_f_Xg0n_mid t_d3 vss vss sky130_fd_pr__nfet_01v8_lvt w=1.8 l=0.15
X1485 t_Xdrv_Xmux_f_g0n t_Xdrv_p0 vdd vdd sky130_fd_pr__pfet_01v8 w=4.2 l=0.15
X1486 t_Xdrv_Xmux_f_g0n t_d3 vdd vdd sky130_fd_pr__pfet_01v8 w=4.2 l=0.15
X1487 t_Xdrv_Xmux_f_g1n t_Xdrv_p1 t_Xdrv_Xmux_f_Xg1n_mid vss sky130_fd_pr__nfet_01v8_lvt w=1.8 l=0.15
X1488 t_Xdrv_Xmux_f_Xg1n_mid t_d0 vss vss sky130_fd_pr__nfet_01v8_lvt w=1.8 l=0.15
X1489 t_Xdrv_Xmux_f_g1n t_Xdrv_p1 vdd vdd sky130_fd_pr__pfet_01v8 w=4.2 l=0.15
X1490 t_Xdrv_Xmux_f_g1n t_d0 vdd vdd sky130_fd_pr__pfet_01v8 w=4.2 l=0.15
X1491 t_Xdrv_Xmux_f_g2n t_Xdrv_p2 t_Xdrv_Xmux_f_Xg2n_mid vss sky130_fd_pr__nfet_01v8_lvt w=1.8 l=0.15
X1492 t_Xdrv_Xmux_f_Xg2n_mid t_d1 vss vss sky130_fd_pr__nfet_01v8_lvt w=1.8 l=0.15
X1493 t_Xdrv_Xmux_f_g2n t_Xdrv_p2 vdd vdd sky130_fd_pr__pfet_01v8 w=4.2 l=0.15
X1494 t_Xdrv_Xmux_f_g2n t_d1 vdd vdd sky130_fd_pr__pfet_01v8 w=4.2 l=0.15
X1495 t_Xdrv_Xmux_f_g3n t_Xdrv_p3 t_Xdrv_Xmux_f_Xg3n_mid vss sky130_fd_pr__nfet_01v8_lvt w=1.8 l=0.15
X1496 t_Xdrv_Xmux_f_Xg3n_mid t_d2 vss vss sky130_fd_pr__nfet_01v8_lvt w=1.8 l=0.15
X1497 t_Xdrv_Xmux_f_g3n t_Xdrv_p3 vdd vdd sky130_fd_pr__pfet_01v8 w=4.2 l=0.15
X1498 t_Xdrv_Xmux_f_g3n t_d2 vdd vdd sky130_fd_pr__pfet_01v8 w=4.2 l=0.15
X1499 t_Xdrv_Xmux_f_en_ t_Xdrv_Xmux_f_g0n t_Xdrv_Xmux_f_Xena_mid vss sky130_fd_pr__nfet_01v8_lvt w=1.4 l=0.15
X1500 t_Xdrv_Xmux_f_Xena_mid t_Xdrv_Xmux_f_g2n vss vss sky130_fd_pr__nfet_01v8_lvt w=1.4 l=0.15
X1501 t_Xdrv_Xmux_f_en_ t_Xdrv_Xmux_f_g0n vdd vdd sky130_fd_pr__pfet_01v8 w=2.8 l=0.15
X1502 t_Xdrv_Xmux_f_en_ t_Xdrv_Xmux_f_g2n vdd vdd sky130_fd_pr__pfet_01v8 w=2.8 l=0.15
X1503 t_Xdrv_Xmux_f_en_ t_Xdrv_Xmux_f_g2n t_Xdrv_Xmux_f_Xenb_mid vss sky130_fd_pr__nfet_01v8_lvt w=1.4 l=0.15
X1504 t_Xdrv_Xmux_f_Xenb_mid t_Xdrv_Xmux_f_g0n vss vss sky130_fd_pr__nfet_01v8_lvt w=1.4 l=0.15
X1505 t_Xdrv_Xmux_f_en_ t_Xdrv_Xmux_f_g2n vdd vdd sky130_fd_pr__pfet_01v8 w=2.8 l=0.15
X1506 t_Xdrv_Xmux_f_en_ t_Xdrv_Xmux_f_g0n vdd vdd sky130_fd_pr__pfet_01v8 w=2.8 l=0.15
X1507 t_Xdrv_Xmux_f_on_ t_Xdrv_Xmux_f_g1n t_Xdrv_Xmux_f_Xona_mid vss sky130_fd_pr__nfet_01v8_lvt w=1.4 l=0.15
X1508 t_Xdrv_Xmux_f_Xona_mid t_Xdrv_Xmux_f_g3n vss vss sky130_fd_pr__nfet_01v8_lvt w=1.4 l=0.15
X1509 t_Xdrv_Xmux_f_on_ t_Xdrv_Xmux_f_g1n vdd vdd sky130_fd_pr__pfet_01v8 w=2.8 l=0.15
X1510 t_Xdrv_Xmux_f_on_ t_Xdrv_Xmux_f_g3n vdd vdd sky130_fd_pr__pfet_01v8 w=2.8 l=0.15
X1511 t_Xdrv_Xmux_f_on_ t_Xdrv_Xmux_f_g3n t_Xdrv_Xmux_f_Xonb_mid vss sky130_fd_pr__nfet_01v8_lvt w=1.4 l=0.15
X1512 t_Xdrv_Xmux_f_Xonb_mid t_Xdrv_Xmux_f_g1n vss vss sky130_fd_pr__nfet_01v8_lvt w=1.4 l=0.15
X1513 t_Xdrv_Xmux_f_on_ t_Xdrv_Xmux_f_g3n vdd vdd sky130_fd_pr__pfet_01v8 w=2.8 l=0.15
X1514 t_Xdrv_Xmux_f_on_ t_Xdrv_Xmux_f_g1n vdd vdd sky130_fd_pr__pfet_01v8 w=2.8 l=0.15
X1515 t_Xdrv_Xmux_f_en_b t_Xdrv_Xmux_f_en_ vss vss sky130_fd_pr__nfet_01v8_lvt w=1.8 l=0.15
X1516 t_Xdrv_Xmux_f_en_b t_Xdrv_Xmux_f_en_ vdd vdd sky130_fd_pr__pfet_01v8 w=5.4 l=0.15
X1517 t_Xdrv_Xmux_f_on_b t_Xdrv_Xmux_f_on_ vss vss sky130_fd_pr__nfet_01v8_lvt w=1.8 l=0.15
X1518 t_Xdrv_Xmux_f_on_b t_Xdrv_Xmux_f_on_ vdd vdd sky130_fd_pr__pfet_01v8 w=5.4 l=0.15
X1519 t_Xdrv_Xmux_f_pre_n t_Xdrv_Xmux_f_en_b t_Xdrv_Xmux_f_Xmn1a_mid vss sky130_fd_pr__nfet_01v8_lvt w=2.1 l=0.15
X1520 t_Xdrv_Xmux_f_Xmn1a_mid t_Xdrv_Xmux_f_on_b vss vss sky130_fd_pr__nfet_01v8_lvt w=2.1 l=0.15
X1521 t_Xdrv_Xmux_f_pre_n t_Xdrv_Xmux_f_en_b vdd vdd sky130_fd_pr__pfet_01v8 w=3.9 l=0.15
X1522 t_Xdrv_Xmux_f_pre_n t_Xdrv_Xmux_f_on_b vdd vdd sky130_fd_pr__pfet_01v8 w=3.9 l=0.15
X1523 t_Xdrv_Xmux_f_pre_n t_Xdrv_Xmux_f_on_b t_Xdrv_Xmux_f_Xmn1b_mid vss sky130_fd_pr__nfet_01v8_lvt w=2.1 l=0.15
X1524 t_Xdrv_Xmux_f_Xmn1b_mid t_Xdrv_Xmux_f_en_b vss vss sky130_fd_pr__nfet_01v8_lvt w=2.1 l=0.15
X1525 t_Xdrv_Xmux_f_pre_n t_Xdrv_Xmux_f_on_b vdd vdd sky130_fd_pr__pfet_01v8 w=3.9 l=0.15
X1526 t_Xdrv_Xmux_f_pre_n t_Xdrv_Xmux_f_en_b vdd vdd sky130_fd_pr__pfet_01v8 w=3.9 l=0.15
X1527 t_Xdrv_Xmux_f_mid_n t_Xdrv_Xmux_f_pre_n t_Xdrv_Xmux_f_Xmbn_mid vss sky130_fd_pr__nfet_01v8_lvt w=8.4 l=0.15
X1528 t_Xdrv_Xmux_f_Xmbn_mid ffe_en vss vss sky130_fd_pr__nfet_01v8_lvt w=8.4 l=0.15
X1529 t_Xdrv_Xmux_f_mid_n t_Xdrv_Xmux_f_pre_n vdd vdd sky130_fd_pr__pfet_01v8 w=9.6 l=0.15
X1530 t_Xdrv_Xmux_f_mid_n ffe_en vdd vdd sky130_fd_pr__pfet_01v8 w=9.6 l=0.15
X1531 t_Xdrv_fn t_Xdrv_Xmux_f_mid_n vss vss sky130_fd_pr__nfet_01v8_lvt w=5.6 l=0.15
X1532 t_Xdrv_fn t_Xdrv_Xmux_f_mid_n vdd vdd sky130_fd_pr__pfet_01v8 w=19.6 l=0.15
X1533 t_Xdrv_Xm_1x_gpb t_Xdrv_mp t_Xdrv_Xm_1x_Xgpb_mid vss sky130_fd_pr__nfet_01v8_lvt w=0.85 l=0.15
X1534 t_Xdrv_Xm_1x_Xgpb_mid m0 vss vss sky130_fd_pr__nfet_01v8_lvt w=0.85 l=0.15
X1535 t_Xdrv_Xm_1x_gpb t_Xdrv_mp vdd vdd sky130_fd_pr__pfet_01v8 w=2.2 l=0.15
X1536 t_Xdrv_Xm_1x_gpb m0 vdd vdd sky130_fd_pr__pfet_01v8 w=2.2 l=0.15
X1537 t_Xdrv_Xm_1x_gnb t_Xdrv_mn t_Xdrv_Xm_1x_Xgnb_mid vss sky130_fd_pr__nfet_01v8_lvt w=0.85 l=0.15
X1538 t_Xdrv_Xm_1x_Xgnb_mid m0 vss vss sky130_fd_pr__nfet_01v8_lvt w=0.85 l=0.15
X1539 t_Xdrv_Xm_1x_gnb t_Xdrv_mn vdd vdd sky130_fd_pr__pfet_01v8 w=2.2 l=0.15
X1540 t_Xdrv_Xm_1x_gnb m0 vdd vdd sky130_fd_pr__pfet_01v8 w=2.2 l=0.15
X1541 t_Xdrv_Xm_1x_gp t_Xdrv_Xm_1x_gpb vss vss sky130_fd_pr__nfet_01v8_lvt w=1.8 l=0.15
X1542 t_Xdrv_Xm_1x_gp t_Xdrv_Xm_1x_gpb vdd vdd sky130_fd_pr__pfet_01v8 w=3.3 l=0.15
X1543 t_Xdrv_Xm_1x_gn t_Xdrv_Xm_1x_gnb vss vss sky130_fd_pr__nfet_01v8_lvt w=1.8 l=0.15
X1544 t_Xdrv_Xm_1x_gn t_Xdrv_Xm_1x_gnb vdd vdd sky130_fd_pr__pfet_01v8 w=3.3 l=0.15
X1545 vdrv t_Xdrv_Xm_1x_gp t_Xdrv_Xm_1x_swp vss sky130_fd_pr__nfet_01v8_lvt w=3.8 l=0.15
X1546 t_Xdrv_Xm_1x_swp t_Xdrv_Xm_1x_gn vss vss sky130_fd_pr__nfet_01v8_lvt w=2.6 l=0.15
X1547 t_Xdrv_Xm_1x_swp pad_p vss sky130_fd_pr__res_high_po_2p85 l=3.75
X1548 vdrv t_Xdrv_Xm_1x_gn t_Xdrv_Xm_1x_swn vss sky130_fd_pr__nfet_01v8_lvt w=3.8 l=0.15
X1549 t_Xdrv_Xm_1x_swn t_Xdrv_Xm_1x_gp vss vss sky130_fd_pr__nfet_01v8_lvt w=2.6 l=0.15
X1550 t_Xdrv_Xm_1x_swn pad_n vss sky130_fd_pr__res_high_po_2p85 l=3.75
X1551 t_Xdrv_Xm_2x_X0_gpb t_Xdrv_mp t_Xdrv_Xm_2x_X0_Xgpb_mid vss sky130_fd_pr__nfet_01v8_lvt w=0.85 l=0.15
X1552 t_Xdrv_Xm_2x_X0_Xgpb_mid m1 vss vss sky130_fd_pr__nfet_01v8_lvt w=0.85 l=0.15
X1553 t_Xdrv_Xm_2x_X0_gpb t_Xdrv_mp vdd vdd sky130_fd_pr__pfet_01v8 w=2.2 l=0.15
X1554 t_Xdrv_Xm_2x_X0_gpb m1 vdd vdd sky130_fd_pr__pfet_01v8 w=2.2 l=0.15
X1555 t_Xdrv_Xm_2x_X0_gnb t_Xdrv_mn t_Xdrv_Xm_2x_X0_Xgnb_mid vss sky130_fd_pr__nfet_01v8_lvt w=0.85 l=0.15
X1556 t_Xdrv_Xm_2x_X0_Xgnb_mid m1 vss vss sky130_fd_pr__nfet_01v8_lvt w=0.85 l=0.15
X1557 t_Xdrv_Xm_2x_X0_gnb t_Xdrv_mn vdd vdd sky130_fd_pr__pfet_01v8 w=2.2 l=0.15
X1558 t_Xdrv_Xm_2x_X0_gnb m1 vdd vdd sky130_fd_pr__pfet_01v8 w=2.2 l=0.15
X1559 t_Xdrv_Xm_2x_X0_gp t_Xdrv_Xm_2x_X0_gpb vss vss sky130_fd_pr__nfet_01v8_lvt w=1.8 l=0.15
X1560 t_Xdrv_Xm_2x_X0_gp t_Xdrv_Xm_2x_X0_gpb vdd vdd sky130_fd_pr__pfet_01v8 w=3.3 l=0.15
X1561 t_Xdrv_Xm_2x_X0_gn t_Xdrv_Xm_2x_X0_gnb vss vss sky130_fd_pr__nfet_01v8_lvt w=1.8 l=0.15
X1562 t_Xdrv_Xm_2x_X0_gn t_Xdrv_Xm_2x_X0_gnb vdd vdd sky130_fd_pr__pfet_01v8 w=3.3 l=0.15
X1563 vdrv t_Xdrv_Xm_2x_X0_gp t_Xdrv_Xm_2x_X0_swp vss sky130_fd_pr__nfet_01v8_lvt w=3.8 l=0.15
X1564 t_Xdrv_Xm_2x_X0_swp t_Xdrv_Xm_2x_X0_gn vss vss sky130_fd_pr__nfet_01v8_lvt w=2.6 l=0.15
X1565 t_Xdrv_Xm_2x_X0_swp pad_p vss sky130_fd_pr__res_high_po_2p85 l=3.75
X1566 vdrv t_Xdrv_Xm_2x_X0_gn t_Xdrv_Xm_2x_X0_swn vss sky130_fd_pr__nfet_01v8_lvt w=3.8 l=0.15
X1567 t_Xdrv_Xm_2x_X0_swn t_Xdrv_Xm_2x_X0_gp vss vss sky130_fd_pr__nfet_01v8_lvt w=2.6 l=0.15
X1568 t_Xdrv_Xm_2x_X0_swn pad_n vss sky130_fd_pr__res_high_po_2p85 l=3.75
X1569 t_Xdrv_Xm_2x_X1_gpb t_Xdrv_mp t_Xdrv_Xm_2x_X1_Xgpb_mid vss sky130_fd_pr__nfet_01v8_lvt w=0.85 l=0.15
X1570 t_Xdrv_Xm_2x_X1_Xgpb_mid m1 vss vss sky130_fd_pr__nfet_01v8_lvt w=0.85 l=0.15
X1571 t_Xdrv_Xm_2x_X1_gpb t_Xdrv_mp vdd vdd sky130_fd_pr__pfet_01v8 w=2.2 l=0.15
X1572 t_Xdrv_Xm_2x_X1_gpb m1 vdd vdd sky130_fd_pr__pfet_01v8 w=2.2 l=0.15
X1573 t_Xdrv_Xm_2x_X1_gnb t_Xdrv_mn t_Xdrv_Xm_2x_X1_Xgnb_mid vss sky130_fd_pr__nfet_01v8_lvt w=0.85 l=0.15
X1574 t_Xdrv_Xm_2x_X1_Xgnb_mid m1 vss vss sky130_fd_pr__nfet_01v8_lvt w=0.85 l=0.15
X1575 t_Xdrv_Xm_2x_X1_gnb t_Xdrv_mn vdd vdd sky130_fd_pr__pfet_01v8 w=2.2 l=0.15
X1576 t_Xdrv_Xm_2x_X1_gnb m1 vdd vdd sky130_fd_pr__pfet_01v8 w=2.2 l=0.15
X1577 t_Xdrv_Xm_2x_X1_gp t_Xdrv_Xm_2x_X1_gpb vss vss sky130_fd_pr__nfet_01v8_lvt w=1.8 l=0.15
X1578 t_Xdrv_Xm_2x_X1_gp t_Xdrv_Xm_2x_X1_gpb vdd vdd sky130_fd_pr__pfet_01v8 w=3.3 l=0.15
X1579 t_Xdrv_Xm_2x_X1_gn t_Xdrv_Xm_2x_X1_gnb vss vss sky130_fd_pr__nfet_01v8_lvt w=1.8 l=0.15
X1580 t_Xdrv_Xm_2x_X1_gn t_Xdrv_Xm_2x_X1_gnb vdd vdd sky130_fd_pr__pfet_01v8 w=3.3 l=0.15
X1581 vdrv t_Xdrv_Xm_2x_X1_gp t_Xdrv_Xm_2x_X1_swp vss sky130_fd_pr__nfet_01v8_lvt w=3.8 l=0.15
X1582 t_Xdrv_Xm_2x_X1_swp t_Xdrv_Xm_2x_X1_gn vss vss sky130_fd_pr__nfet_01v8_lvt w=2.6 l=0.15
X1583 t_Xdrv_Xm_2x_X1_swp pad_p vss sky130_fd_pr__res_high_po_2p85 l=3.75
X1584 vdrv t_Xdrv_Xm_2x_X1_gn t_Xdrv_Xm_2x_X1_swn vss sky130_fd_pr__nfet_01v8_lvt w=3.8 l=0.15
X1585 t_Xdrv_Xm_2x_X1_swn t_Xdrv_Xm_2x_X1_gp vss vss sky130_fd_pr__nfet_01v8_lvt w=2.6 l=0.15
X1586 t_Xdrv_Xm_2x_X1_swn pad_n vss sky130_fd_pr__res_high_po_2p85 l=3.75
X1587 t_Xdrv_Xm_4x_X0_X0_gpb t_Xdrv_mp t_Xdrv_Xm_4x_X0_X0_Xgpb_mid vss sky130_fd_pr__nfet_01v8_lvt w=0.85 l=0.15
X1588 t_Xdrv_Xm_4x_X0_X0_Xgpb_mid m2 vss vss sky130_fd_pr__nfet_01v8_lvt w=0.85 l=0.15
X1589 t_Xdrv_Xm_4x_X0_X0_gpb t_Xdrv_mp vdd vdd sky130_fd_pr__pfet_01v8 w=2.2 l=0.15
X1590 t_Xdrv_Xm_4x_X0_X0_gpb m2 vdd vdd sky130_fd_pr__pfet_01v8 w=2.2 l=0.15
X1591 t_Xdrv_Xm_4x_X0_X0_gnb t_Xdrv_mn t_Xdrv_Xm_4x_X0_X0_Xgnb_mid vss sky130_fd_pr__nfet_01v8_lvt w=0.85 l=0.15
X1592 t_Xdrv_Xm_4x_X0_X0_Xgnb_mid m2 vss vss sky130_fd_pr__nfet_01v8_lvt w=0.85 l=0.15
X1593 t_Xdrv_Xm_4x_X0_X0_gnb t_Xdrv_mn vdd vdd sky130_fd_pr__pfet_01v8 w=2.2 l=0.15
X1594 t_Xdrv_Xm_4x_X0_X0_gnb m2 vdd vdd sky130_fd_pr__pfet_01v8 w=2.2 l=0.15
X1595 t_Xdrv_Xm_4x_X0_X0_gp t_Xdrv_Xm_4x_X0_X0_gpb vss vss sky130_fd_pr__nfet_01v8_lvt w=1.8 l=0.15
X1596 t_Xdrv_Xm_4x_X0_X0_gp t_Xdrv_Xm_4x_X0_X0_gpb vdd vdd sky130_fd_pr__pfet_01v8 w=3.3 l=0.15
X1597 t_Xdrv_Xm_4x_X0_X0_gn t_Xdrv_Xm_4x_X0_X0_gnb vss vss sky130_fd_pr__nfet_01v8_lvt w=1.8 l=0.15
X1598 t_Xdrv_Xm_4x_X0_X0_gn t_Xdrv_Xm_4x_X0_X0_gnb vdd vdd sky130_fd_pr__pfet_01v8 w=3.3 l=0.15
X1599 vdrv t_Xdrv_Xm_4x_X0_X0_gp t_Xdrv_Xm_4x_X0_X0_swp vss sky130_fd_pr__nfet_01v8_lvt w=3.8 l=0.15
X1600 t_Xdrv_Xm_4x_X0_X0_swp t_Xdrv_Xm_4x_X0_X0_gn vss vss sky130_fd_pr__nfet_01v8_lvt w=2.6 l=0.15
X1601 t_Xdrv_Xm_4x_X0_X0_swp pad_p vss sky130_fd_pr__res_high_po_2p85 l=3.75
X1602 vdrv t_Xdrv_Xm_4x_X0_X0_gn t_Xdrv_Xm_4x_X0_X0_swn vss sky130_fd_pr__nfet_01v8_lvt w=3.8 l=0.15
X1603 t_Xdrv_Xm_4x_X0_X0_swn t_Xdrv_Xm_4x_X0_X0_gp vss vss sky130_fd_pr__nfet_01v8_lvt w=2.6 l=0.15
X1604 t_Xdrv_Xm_4x_X0_X0_swn pad_n vss sky130_fd_pr__res_high_po_2p85 l=3.75
X1605 t_Xdrv_Xm_4x_X0_X1_gpb t_Xdrv_mp t_Xdrv_Xm_4x_X0_X1_Xgpb_mid vss sky130_fd_pr__nfet_01v8_lvt w=0.85 l=0.15
X1606 t_Xdrv_Xm_4x_X0_X1_Xgpb_mid m2 vss vss sky130_fd_pr__nfet_01v8_lvt w=0.85 l=0.15
X1607 t_Xdrv_Xm_4x_X0_X1_gpb t_Xdrv_mp vdd vdd sky130_fd_pr__pfet_01v8 w=2.2 l=0.15
X1608 t_Xdrv_Xm_4x_X0_X1_gpb m2 vdd vdd sky130_fd_pr__pfet_01v8 w=2.2 l=0.15
X1609 t_Xdrv_Xm_4x_X0_X1_gnb t_Xdrv_mn t_Xdrv_Xm_4x_X0_X1_Xgnb_mid vss sky130_fd_pr__nfet_01v8_lvt w=0.85 l=0.15
X1610 t_Xdrv_Xm_4x_X0_X1_Xgnb_mid m2 vss vss sky130_fd_pr__nfet_01v8_lvt w=0.85 l=0.15
X1611 t_Xdrv_Xm_4x_X0_X1_gnb t_Xdrv_mn vdd vdd sky130_fd_pr__pfet_01v8 w=2.2 l=0.15
X1612 t_Xdrv_Xm_4x_X0_X1_gnb m2 vdd vdd sky130_fd_pr__pfet_01v8 w=2.2 l=0.15
X1613 t_Xdrv_Xm_4x_X0_X1_gp t_Xdrv_Xm_4x_X0_X1_gpb vss vss sky130_fd_pr__nfet_01v8_lvt w=1.8 l=0.15
X1614 t_Xdrv_Xm_4x_X0_X1_gp t_Xdrv_Xm_4x_X0_X1_gpb vdd vdd sky130_fd_pr__pfet_01v8 w=3.3 l=0.15
X1615 t_Xdrv_Xm_4x_X0_X1_gn t_Xdrv_Xm_4x_X0_X1_gnb vss vss sky130_fd_pr__nfet_01v8_lvt w=1.8 l=0.15
X1616 t_Xdrv_Xm_4x_X0_X1_gn t_Xdrv_Xm_4x_X0_X1_gnb vdd vdd sky130_fd_pr__pfet_01v8 w=3.3 l=0.15
X1617 vdrv t_Xdrv_Xm_4x_X0_X1_gp t_Xdrv_Xm_4x_X0_X1_swp vss sky130_fd_pr__nfet_01v8_lvt w=3.8 l=0.15
X1618 t_Xdrv_Xm_4x_X0_X1_swp t_Xdrv_Xm_4x_X0_X1_gn vss vss sky130_fd_pr__nfet_01v8_lvt w=2.6 l=0.15
X1619 t_Xdrv_Xm_4x_X0_X1_swp pad_p vss sky130_fd_pr__res_high_po_2p85 l=3.75
X1620 vdrv t_Xdrv_Xm_4x_X0_X1_gn t_Xdrv_Xm_4x_X0_X1_swn vss sky130_fd_pr__nfet_01v8_lvt w=3.8 l=0.15
X1621 t_Xdrv_Xm_4x_X0_X1_swn t_Xdrv_Xm_4x_X0_X1_gp vss vss sky130_fd_pr__nfet_01v8_lvt w=2.6 l=0.15
X1622 t_Xdrv_Xm_4x_X0_X1_swn pad_n vss sky130_fd_pr__res_high_po_2p85 l=3.75
X1623 t_Xdrv_Xm_4x_X1_X0_gpb t_Xdrv_mp t_Xdrv_Xm_4x_X1_X0_Xgpb_mid vss sky130_fd_pr__nfet_01v8_lvt w=0.85 l=0.15
X1624 t_Xdrv_Xm_4x_X1_X0_Xgpb_mid m2 vss vss sky130_fd_pr__nfet_01v8_lvt w=0.85 l=0.15
X1625 t_Xdrv_Xm_4x_X1_X0_gpb t_Xdrv_mp vdd vdd sky130_fd_pr__pfet_01v8 w=2.2 l=0.15
X1626 t_Xdrv_Xm_4x_X1_X0_gpb m2 vdd vdd sky130_fd_pr__pfet_01v8 w=2.2 l=0.15
X1627 t_Xdrv_Xm_4x_X1_X0_gnb t_Xdrv_mn t_Xdrv_Xm_4x_X1_X0_Xgnb_mid vss sky130_fd_pr__nfet_01v8_lvt w=0.85 l=0.15
X1628 t_Xdrv_Xm_4x_X1_X0_Xgnb_mid m2 vss vss sky130_fd_pr__nfet_01v8_lvt w=0.85 l=0.15
X1629 t_Xdrv_Xm_4x_X1_X0_gnb t_Xdrv_mn vdd vdd sky130_fd_pr__pfet_01v8 w=2.2 l=0.15
X1630 t_Xdrv_Xm_4x_X1_X0_gnb m2 vdd vdd sky130_fd_pr__pfet_01v8 w=2.2 l=0.15
X1631 t_Xdrv_Xm_4x_X1_X0_gp t_Xdrv_Xm_4x_X1_X0_gpb vss vss sky130_fd_pr__nfet_01v8_lvt w=1.8 l=0.15
X1632 t_Xdrv_Xm_4x_X1_X0_gp t_Xdrv_Xm_4x_X1_X0_gpb vdd vdd sky130_fd_pr__pfet_01v8 w=3.3 l=0.15
X1633 t_Xdrv_Xm_4x_X1_X0_gn t_Xdrv_Xm_4x_X1_X0_gnb vss vss sky130_fd_pr__nfet_01v8_lvt w=1.8 l=0.15
X1634 t_Xdrv_Xm_4x_X1_X0_gn t_Xdrv_Xm_4x_X1_X0_gnb vdd vdd sky130_fd_pr__pfet_01v8 w=3.3 l=0.15
X1635 vdrv t_Xdrv_Xm_4x_X1_X0_gp t_Xdrv_Xm_4x_X1_X0_swp vss sky130_fd_pr__nfet_01v8_lvt w=3.8 l=0.15
X1636 t_Xdrv_Xm_4x_X1_X0_swp t_Xdrv_Xm_4x_X1_X0_gn vss vss sky130_fd_pr__nfet_01v8_lvt w=2.6 l=0.15
X1637 t_Xdrv_Xm_4x_X1_X0_swp pad_p vss sky130_fd_pr__res_high_po_2p85 l=3.75
X1638 vdrv t_Xdrv_Xm_4x_X1_X0_gn t_Xdrv_Xm_4x_X1_X0_swn vss sky130_fd_pr__nfet_01v8_lvt w=3.8 l=0.15
X1639 t_Xdrv_Xm_4x_X1_X0_swn t_Xdrv_Xm_4x_X1_X0_gp vss vss sky130_fd_pr__nfet_01v8_lvt w=2.6 l=0.15
X1640 t_Xdrv_Xm_4x_X1_X0_swn pad_n vss sky130_fd_pr__res_high_po_2p85 l=3.75
X1641 t_Xdrv_Xm_4x_X1_X1_gpb t_Xdrv_mp t_Xdrv_Xm_4x_X1_X1_Xgpb_mid vss sky130_fd_pr__nfet_01v8_lvt w=0.85 l=0.15
X1642 t_Xdrv_Xm_4x_X1_X1_Xgpb_mid m2 vss vss sky130_fd_pr__nfet_01v8_lvt w=0.85 l=0.15
X1643 t_Xdrv_Xm_4x_X1_X1_gpb t_Xdrv_mp vdd vdd sky130_fd_pr__pfet_01v8 w=2.2 l=0.15
X1644 t_Xdrv_Xm_4x_X1_X1_gpb m2 vdd vdd sky130_fd_pr__pfet_01v8 w=2.2 l=0.15
X1645 t_Xdrv_Xm_4x_X1_X1_gnb t_Xdrv_mn t_Xdrv_Xm_4x_X1_X1_Xgnb_mid vss sky130_fd_pr__nfet_01v8_lvt w=0.85 l=0.15
X1646 t_Xdrv_Xm_4x_X1_X1_Xgnb_mid m2 vss vss sky130_fd_pr__nfet_01v8_lvt w=0.85 l=0.15
X1647 t_Xdrv_Xm_4x_X1_X1_gnb t_Xdrv_mn vdd vdd sky130_fd_pr__pfet_01v8 w=2.2 l=0.15
X1648 t_Xdrv_Xm_4x_X1_X1_gnb m2 vdd vdd sky130_fd_pr__pfet_01v8 w=2.2 l=0.15
X1649 t_Xdrv_Xm_4x_X1_X1_gp t_Xdrv_Xm_4x_X1_X1_gpb vss vss sky130_fd_pr__nfet_01v8_lvt w=1.8 l=0.15
X1650 t_Xdrv_Xm_4x_X1_X1_gp t_Xdrv_Xm_4x_X1_X1_gpb vdd vdd sky130_fd_pr__pfet_01v8 w=3.3 l=0.15
X1651 t_Xdrv_Xm_4x_X1_X1_gn t_Xdrv_Xm_4x_X1_X1_gnb vss vss sky130_fd_pr__nfet_01v8_lvt w=1.8 l=0.15
X1652 t_Xdrv_Xm_4x_X1_X1_gn t_Xdrv_Xm_4x_X1_X1_gnb vdd vdd sky130_fd_pr__pfet_01v8 w=3.3 l=0.15
X1653 vdrv t_Xdrv_Xm_4x_X1_X1_gp t_Xdrv_Xm_4x_X1_X1_swp vss sky130_fd_pr__nfet_01v8_lvt w=3.8 l=0.15
X1654 t_Xdrv_Xm_4x_X1_X1_swp t_Xdrv_Xm_4x_X1_X1_gn vss vss sky130_fd_pr__nfet_01v8_lvt w=2.6 l=0.15
X1655 t_Xdrv_Xm_4x_X1_X1_swp pad_p vss sky130_fd_pr__res_high_po_2p85 l=3.75
X1656 vdrv t_Xdrv_Xm_4x_X1_X1_gn t_Xdrv_Xm_4x_X1_X1_swn vss sky130_fd_pr__nfet_01v8_lvt w=3.8 l=0.15
X1657 t_Xdrv_Xm_4x_X1_X1_swn t_Xdrv_Xm_4x_X1_X1_gp vss vss sky130_fd_pr__nfet_01v8_lvt w=2.6 l=0.15
X1658 t_Xdrv_Xm_4x_X1_X1_swn pad_n vss sky130_fd_pr__res_high_po_2p85 l=3.75
X1659 t_Xdrv_Xm_8xa_X0_X0_X0_gpb t_Xdrv_mp t_Xdrv_Xm_8xa_X0_X0_X0_Xgpb_mid vss sky130_fd_pr__nfet_01v8_lvt w=0.85 l=0.15
X1660 t_Xdrv_Xm_8xa_X0_X0_X0_Xgpb_mid m3 vss vss sky130_fd_pr__nfet_01v8_lvt w=0.85 l=0.15
X1661 t_Xdrv_Xm_8xa_X0_X0_X0_gpb t_Xdrv_mp vdd vdd sky130_fd_pr__pfet_01v8 w=2.2 l=0.15
X1662 t_Xdrv_Xm_8xa_X0_X0_X0_gpb m3 vdd vdd sky130_fd_pr__pfet_01v8 w=2.2 l=0.15
X1663 t_Xdrv_Xm_8xa_X0_X0_X0_gnb t_Xdrv_mn t_Xdrv_Xm_8xa_X0_X0_X0_Xgnb_mid vss sky130_fd_pr__nfet_01v8_lvt w=0.85 l=0.15
X1664 t_Xdrv_Xm_8xa_X0_X0_X0_Xgnb_mid m3 vss vss sky130_fd_pr__nfet_01v8_lvt w=0.85 l=0.15
X1665 t_Xdrv_Xm_8xa_X0_X0_X0_gnb t_Xdrv_mn vdd vdd sky130_fd_pr__pfet_01v8 w=2.2 l=0.15
X1666 t_Xdrv_Xm_8xa_X0_X0_X0_gnb m3 vdd vdd sky130_fd_pr__pfet_01v8 w=2.2 l=0.15
X1667 t_Xdrv_Xm_8xa_X0_X0_X0_gp t_Xdrv_Xm_8xa_X0_X0_X0_gpb vss vss sky130_fd_pr__nfet_01v8_lvt w=1.8 l=0.15
X1668 t_Xdrv_Xm_8xa_X0_X0_X0_gp t_Xdrv_Xm_8xa_X0_X0_X0_gpb vdd vdd sky130_fd_pr__pfet_01v8 w=3.3 l=0.15
X1669 t_Xdrv_Xm_8xa_X0_X0_X0_gn t_Xdrv_Xm_8xa_X0_X0_X0_gnb vss vss sky130_fd_pr__nfet_01v8_lvt w=1.8 l=0.15
X1670 t_Xdrv_Xm_8xa_X0_X0_X0_gn t_Xdrv_Xm_8xa_X0_X0_X0_gnb vdd vdd sky130_fd_pr__pfet_01v8 w=3.3 l=0.15
X1671 vdrv t_Xdrv_Xm_8xa_X0_X0_X0_gp t_Xdrv_Xm_8xa_X0_X0_X0_swp vss sky130_fd_pr__nfet_01v8_lvt w=3.8 l=0.15
X1672 t_Xdrv_Xm_8xa_X0_X0_X0_swp t_Xdrv_Xm_8xa_X0_X0_X0_gn vss vss sky130_fd_pr__nfet_01v8_lvt w=2.6 l=0.15
X1673 t_Xdrv_Xm_8xa_X0_X0_X0_swp pad_p vss sky130_fd_pr__res_high_po_2p85 l=3.75
X1674 vdrv t_Xdrv_Xm_8xa_X0_X0_X0_gn t_Xdrv_Xm_8xa_X0_X0_X0_swn vss sky130_fd_pr__nfet_01v8_lvt w=3.8 l=0.15
X1675 t_Xdrv_Xm_8xa_X0_X0_X0_swn t_Xdrv_Xm_8xa_X0_X0_X0_gp vss vss sky130_fd_pr__nfet_01v8_lvt w=2.6 l=0.15
X1676 t_Xdrv_Xm_8xa_X0_X0_X0_swn pad_n vss sky130_fd_pr__res_high_po_2p85 l=3.75
X1677 t_Xdrv_Xm_8xa_X0_X0_X1_gpb t_Xdrv_mp t_Xdrv_Xm_8xa_X0_X0_X1_Xgpb_mid vss sky130_fd_pr__nfet_01v8_lvt w=0.85 l=0.15
X1678 t_Xdrv_Xm_8xa_X0_X0_X1_Xgpb_mid m3 vss vss sky130_fd_pr__nfet_01v8_lvt w=0.85 l=0.15
X1679 t_Xdrv_Xm_8xa_X0_X0_X1_gpb t_Xdrv_mp vdd vdd sky130_fd_pr__pfet_01v8 w=2.2 l=0.15
X1680 t_Xdrv_Xm_8xa_X0_X0_X1_gpb m3 vdd vdd sky130_fd_pr__pfet_01v8 w=2.2 l=0.15
X1681 t_Xdrv_Xm_8xa_X0_X0_X1_gnb t_Xdrv_mn t_Xdrv_Xm_8xa_X0_X0_X1_Xgnb_mid vss sky130_fd_pr__nfet_01v8_lvt w=0.85 l=0.15
X1682 t_Xdrv_Xm_8xa_X0_X0_X1_Xgnb_mid m3 vss vss sky130_fd_pr__nfet_01v8_lvt w=0.85 l=0.15
X1683 t_Xdrv_Xm_8xa_X0_X0_X1_gnb t_Xdrv_mn vdd vdd sky130_fd_pr__pfet_01v8 w=2.2 l=0.15
X1684 t_Xdrv_Xm_8xa_X0_X0_X1_gnb m3 vdd vdd sky130_fd_pr__pfet_01v8 w=2.2 l=0.15
X1685 t_Xdrv_Xm_8xa_X0_X0_X1_gp t_Xdrv_Xm_8xa_X0_X0_X1_gpb vss vss sky130_fd_pr__nfet_01v8_lvt w=1.8 l=0.15
X1686 t_Xdrv_Xm_8xa_X0_X0_X1_gp t_Xdrv_Xm_8xa_X0_X0_X1_gpb vdd vdd sky130_fd_pr__pfet_01v8 w=3.3 l=0.15
X1687 t_Xdrv_Xm_8xa_X0_X0_X1_gn t_Xdrv_Xm_8xa_X0_X0_X1_gnb vss vss sky130_fd_pr__nfet_01v8_lvt w=1.8 l=0.15
X1688 t_Xdrv_Xm_8xa_X0_X0_X1_gn t_Xdrv_Xm_8xa_X0_X0_X1_gnb vdd vdd sky130_fd_pr__pfet_01v8 w=3.3 l=0.15
X1689 vdrv t_Xdrv_Xm_8xa_X0_X0_X1_gp t_Xdrv_Xm_8xa_X0_X0_X1_swp vss sky130_fd_pr__nfet_01v8_lvt w=3.8 l=0.15
X1690 t_Xdrv_Xm_8xa_X0_X0_X1_swp t_Xdrv_Xm_8xa_X0_X0_X1_gn vss vss sky130_fd_pr__nfet_01v8_lvt w=2.6 l=0.15
X1691 t_Xdrv_Xm_8xa_X0_X0_X1_swp pad_p vss sky130_fd_pr__res_high_po_2p85 l=3.75
X1692 vdrv t_Xdrv_Xm_8xa_X0_X0_X1_gn t_Xdrv_Xm_8xa_X0_X0_X1_swn vss sky130_fd_pr__nfet_01v8_lvt w=3.8 l=0.15
X1693 t_Xdrv_Xm_8xa_X0_X0_X1_swn t_Xdrv_Xm_8xa_X0_X0_X1_gp vss vss sky130_fd_pr__nfet_01v8_lvt w=2.6 l=0.15
X1694 t_Xdrv_Xm_8xa_X0_X0_X1_swn pad_n vss sky130_fd_pr__res_high_po_2p85 l=3.75
X1695 t_Xdrv_Xm_8xa_X0_X1_X0_gpb t_Xdrv_mp t_Xdrv_Xm_8xa_X0_X1_X0_Xgpb_mid vss sky130_fd_pr__nfet_01v8_lvt w=0.85 l=0.15
X1696 t_Xdrv_Xm_8xa_X0_X1_X0_Xgpb_mid m3 vss vss sky130_fd_pr__nfet_01v8_lvt w=0.85 l=0.15
X1697 t_Xdrv_Xm_8xa_X0_X1_X0_gpb t_Xdrv_mp vdd vdd sky130_fd_pr__pfet_01v8 w=2.2 l=0.15
X1698 t_Xdrv_Xm_8xa_X0_X1_X0_gpb m3 vdd vdd sky130_fd_pr__pfet_01v8 w=2.2 l=0.15
X1699 t_Xdrv_Xm_8xa_X0_X1_X0_gnb t_Xdrv_mn t_Xdrv_Xm_8xa_X0_X1_X0_Xgnb_mid vss sky130_fd_pr__nfet_01v8_lvt w=0.85 l=0.15
X1700 t_Xdrv_Xm_8xa_X0_X1_X0_Xgnb_mid m3 vss vss sky130_fd_pr__nfet_01v8_lvt w=0.85 l=0.15
X1701 t_Xdrv_Xm_8xa_X0_X1_X0_gnb t_Xdrv_mn vdd vdd sky130_fd_pr__pfet_01v8 w=2.2 l=0.15
X1702 t_Xdrv_Xm_8xa_X0_X1_X0_gnb m3 vdd vdd sky130_fd_pr__pfet_01v8 w=2.2 l=0.15
X1703 t_Xdrv_Xm_8xa_X0_X1_X0_gp t_Xdrv_Xm_8xa_X0_X1_X0_gpb vss vss sky130_fd_pr__nfet_01v8_lvt w=1.8 l=0.15
X1704 t_Xdrv_Xm_8xa_X0_X1_X0_gp t_Xdrv_Xm_8xa_X0_X1_X0_gpb vdd vdd sky130_fd_pr__pfet_01v8 w=3.3 l=0.15
X1705 t_Xdrv_Xm_8xa_X0_X1_X0_gn t_Xdrv_Xm_8xa_X0_X1_X0_gnb vss vss sky130_fd_pr__nfet_01v8_lvt w=1.8 l=0.15
X1706 t_Xdrv_Xm_8xa_X0_X1_X0_gn t_Xdrv_Xm_8xa_X0_X1_X0_gnb vdd vdd sky130_fd_pr__pfet_01v8 w=3.3 l=0.15
X1707 vdrv t_Xdrv_Xm_8xa_X0_X1_X0_gp t_Xdrv_Xm_8xa_X0_X1_X0_swp vss sky130_fd_pr__nfet_01v8_lvt w=3.8 l=0.15
X1708 t_Xdrv_Xm_8xa_X0_X1_X0_swp t_Xdrv_Xm_8xa_X0_X1_X0_gn vss vss sky130_fd_pr__nfet_01v8_lvt w=2.6 l=0.15
X1709 t_Xdrv_Xm_8xa_X0_X1_X0_swp pad_p vss sky130_fd_pr__res_high_po_2p85 l=3.75
X1710 vdrv t_Xdrv_Xm_8xa_X0_X1_X0_gn t_Xdrv_Xm_8xa_X0_X1_X0_swn vss sky130_fd_pr__nfet_01v8_lvt w=3.8 l=0.15
X1711 t_Xdrv_Xm_8xa_X0_X1_X0_swn t_Xdrv_Xm_8xa_X0_X1_X0_gp vss vss sky130_fd_pr__nfet_01v8_lvt w=2.6 l=0.15
X1712 t_Xdrv_Xm_8xa_X0_X1_X0_swn pad_n vss sky130_fd_pr__res_high_po_2p85 l=3.75
X1713 t_Xdrv_Xm_8xa_X0_X1_X1_gpb t_Xdrv_mp t_Xdrv_Xm_8xa_X0_X1_X1_Xgpb_mid vss sky130_fd_pr__nfet_01v8_lvt w=0.85 l=0.15
X1714 t_Xdrv_Xm_8xa_X0_X1_X1_Xgpb_mid m3 vss vss sky130_fd_pr__nfet_01v8_lvt w=0.85 l=0.15
X1715 t_Xdrv_Xm_8xa_X0_X1_X1_gpb t_Xdrv_mp vdd vdd sky130_fd_pr__pfet_01v8 w=2.2 l=0.15
X1716 t_Xdrv_Xm_8xa_X0_X1_X1_gpb m3 vdd vdd sky130_fd_pr__pfet_01v8 w=2.2 l=0.15
X1717 t_Xdrv_Xm_8xa_X0_X1_X1_gnb t_Xdrv_mn t_Xdrv_Xm_8xa_X0_X1_X1_Xgnb_mid vss sky130_fd_pr__nfet_01v8_lvt w=0.85 l=0.15
X1718 t_Xdrv_Xm_8xa_X0_X1_X1_Xgnb_mid m3 vss vss sky130_fd_pr__nfet_01v8_lvt w=0.85 l=0.15
X1719 t_Xdrv_Xm_8xa_X0_X1_X1_gnb t_Xdrv_mn vdd vdd sky130_fd_pr__pfet_01v8 w=2.2 l=0.15
X1720 t_Xdrv_Xm_8xa_X0_X1_X1_gnb m3 vdd vdd sky130_fd_pr__pfet_01v8 w=2.2 l=0.15
X1721 t_Xdrv_Xm_8xa_X0_X1_X1_gp t_Xdrv_Xm_8xa_X0_X1_X1_gpb vss vss sky130_fd_pr__nfet_01v8_lvt w=1.8 l=0.15
X1722 t_Xdrv_Xm_8xa_X0_X1_X1_gp t_Xdrv_Xm_8xa_X0_X1_X1_gpb vdd vdd sky130_fd_pr__pfet_01v8 w=3.3 l=0.15
X1723 t_Xdrv_Xm_8xa_X0_X1_X1_gn t_Xdrv_Xm_8xa_X0_X1_X1_gnb vss vss sky130_fd_pr__nfet_01v8_lvt w=1.8 l=0.15
X1724 t_Xdrv_Xm_8xa_X0_X1_X1_gn t_Xdrv_Xm_8xa_X0_X1_X1_gnb vdd vdd sky130_fd_pr__pfet_01v8 w=3.3 l=0.15
X1725 vdrv t_Xdrv_Xm_8xa_X0_X1_X1_gp t_Xdrv_Xm_8xa_X0_X1_X1_swp vss sky130_fd_pr__nfet_01v8_lvt w=3.8 l=0.15
X1726 t_Xdrv_Xm_8xa_X0_X1_X1_swp t_Xdrv_Xm_8xa_X0_X1_X1_gn vss vss sky130_fd_pr__nfet_01v8_lvt w=2.6 l=0.15
X1727 t_Xdrv_Xm_8xa_X0_X1_X1_swp pad_p vss sky130_fd_pr__res_high_po_2p85 l=3.75
X1728 vdrv t_Xdrv_Xm_8xa_X0_X1_X1_gn t_Xdrv_Xm_8xa_X0_X1_X1_swn vss sky130_fd_pr__nfet_01v8_lvt w=3.8 l=0.15
X1729 t_Xdrv_Xm_8xa_X0_X1_X1_swn t_Xdrv_Xm_8xa_X0_X1_X1_gp vss vss sky130_fd_pr__nfet_01v8_lvt w=2.6 l=0.15
X1730 t_Xdrv_Xm_8xa_X0_X1_X1_swn pad_n vss sky130_fd_pr__res_high_po_2p85 l=3.75
X1731 t_Xdrv_Xm_8xa_X1_X0_X0_gpb t_Xdrv_mp t_Xdrv_Xm_8xa_X1_X0_X0_Xgpb_mid vss sky130_fd_pr__nfet_01v8_lvt w=0.85 l=0.15
X1732 t_Xdrv_Xm_8xa_X1_X0_X0_Xgpb_mid m3 vss vss sky130_fd_pr__nfet_01v8_lvt w=0.85 l=0.15
X1733 t_Xdrv_Xm_8xa_X1_X0_X0_gpb t_Xdrv_mp vdd vdd sky130_fd_pr__pfet_01v8 w=2.2 l=0.15
X1734 t_Xdrv_Xm_8xa_X1_X0_X0_gpb m3 vdd vdd sky130_fd_pr__pfet_01v8 w=2.2 l=0.15
X1735 t_Xdrv_Xm_8xa_X1_X0_X0_gnb t_Xdrv_mn t_Xdrv_Xm_8xa_X1_X0_X0_Xgnb_mid vss sky130_fd_pr__nfet_01v8_lvt w=0.85 l=0.15
X1736 t_Xdrv_Xm_8xa_X1_X0_X0_Xgnb_mid m3 vss vss sky130_fd_pr__nfet_01v8_lvt w=0.85 l=0.15
X1737 t_Xdrv_Xm_8xa_X1_X0_X0_gnb t_Xdrv_mn vdd vdd sky130_fd_pr__pfet_01v8 w=2.2 l=0.15
X1738 t_Xdrv_Xm_8xa_X1_X0_X0_gnb m3 vdd vdd sky130_fd_pr__pfet_01v8 w=2.2 l=0.15
X1739 t_Xdrv_Xm_8xa_X1_X0_X0_gp t_Xdrv_Xm_8xa_X1_X0_X0_gpb vss vss sky130_fd_pr__nfet_01v8_lvt w=1.8 l=0.15
X1740 t_Xdrv_Xm_8xa_X1_X0_X0_gp t_Xdrv_Xm_8xa_X1_X0_X0_gpb vdd vdd sky130_fd_pr__pfet_01v8 w=3.3 l=0.15
X1741 t_Xdrv_Xm_8xa_X1_X0_X0_gn t_Xdrv_Xm_8xa_X1_X0_X0_gnb vss vss sky130_fd_pr__nfet_01v8_lvt w=1.8 l=0.15
X1742 t_Xdrv_Xm_8xa_X1_X0_X0_gn t_Xdrv_Xm_8xa_X1_X0_X0_gnb vdd vdd sky130_fd_pr__pfet_01v8 w=3.3 l=0.15
X1743 vdrv t_Xdrv_Xm_8xa_X1_X0_X0_gp t_Xdrv_Xm_8xa_X1_X0_X0_swp vss sky130_fd_pr__nfet_01v8_lvt w=3.8 l=0.15
X1744 t_Xdrv_Xm_8xa_X1_X0_X0_swp t_Xdrv_Xm_8xa_X1_X0_X0_gn vss vss sky130_fd_pr__nfet_01v8_lvt w=2.6 l=0.15
X1745 t_Xdrv_Xm_8xa_X1_X0_X0_swp pad_p vss sky130_fd_pr__res_high_po_2p85 l=3.75
X1746 vdrv t_Xdrv_Xm_8xa_X1_X0_X0_gn t_Xdrv_Xm_8xa_X1_X0_X0_swn vss sky130_fd_pr__nfet_01v8_lvt w=3.8 l=0.15
X1747 t_Xdrv_Xm_8xa_X1_X0_X0_swn t_Xdrv_Xm_8xa_X1_X0_X0_gp vss vss sky130_fd_pr__nfet_01v8_lvt w=2.6 l=0.15
X1748 t_Xdrv_Xm_8xa_X1_X0_X0_swn pad_n vss sky130_fd_pr__res_high_po_2p85 l=3.75
X1749 t_Xdrv_Xm_8xa_X1_X0_X1_gpb t_Xdrv_mp t_Xdrv_Xm_8xa_X1_X0_X1_Xgpb_mid vss sky130_fd_pr__nfet_01v8_lvt w=0.85 l=0.15
X1750 t_Xdrv_Xm_8xa_X1_X0_X1_Xgpb_mid m3 vss vss sky130_fd_pr__nfet_01v8_lvt w=0.85 l=0.15
X1751 t_Xdrv_Xm_8xa_X1_X0_X1_gpb t_Xdrv_mp vdd vdd sky130_fd_pr__pfet_01v8 w=2.2 l=0.15
X1752 t_Xdrv_Xm_8xa_X1_X0_X1_gpb m3 vdd vdd sky130_fd_pr__pfet_01v8 w=2.2 l=0.15
X1753 t_Xdrv_Xm_8xa_X1_X0_X1_gnb t_Xdrv_mn t_Xdrv_Xm_8xa_X1_X0_X1_Xgnb_mid vss sky130_fd_pr__nfet_01v8_lvt w=0.85 l=0.15
X1754 t_Xdrv_Xm_8xa_X1_X0_X1_Xgnb_mid m3 vss vss sky130_fd_pr__nfet_01v8_lvt w=0.85 l=0.15
X1755 t_Xdrv_Xm_8xa_X1_X0_X1_gnb t_Xdrv_mn vdd vdd sky130_fd_pr__pfet_01v8 w=2.2 l=0.15
X1756 t_Xdrv_Xm_8xa_X1_X0_X1_gnb m3 vdd vdd sky130_fd_pr__pfet_01v8 w=2.2 l=0.15
X1757 t_Xdrv_Xm_8xa_X1_X0_X1_gp t_Xdrv_Xm_8xa_X1_X0_X1_gpb vss vss sky130_fd_pr__nfet_01v8_lvt w=1.8 l=0.15
X1758 t_Xdrv_Xm_8xa_X1_X0_X1_gp t_Xdrv_Xm_8xa_X1_X0_X1_gpb vdd vdd sky130_fd_pr__pfet_01v8 w=3.3 l=0.15
X1759 t_Xdrv_Xm_8xa_X1_X0_X1_gn t_Xdrv_Xm_8xa_X1_X0_X1_gnb vss vss sky130_fd_pr__nfet_01v8_lvt w=1.8 l=0.15
X1760 t_Xdrv_Xm_8xa_X1_X0_X1_gn t_Xdrv_Xm_8xa_X1_X0_X1_gnb vdd vdd sky130_fd_pr__pfet_01v8 w=3.3 l=0.15
X1761 vdrv t_Xdrv_Xm_8xa_X1_X0_X1_gp t_Xdrv_Xm_8xa_X1_X0_X1_swp vss sky130_fd_pr__nfet_01v8_lvt w=3.8 l=0.15
X1762 t_Xdrv_Xm_8xa_X1_X0_X1_swp t_Xdrv_Xm_8xa_X1_X0_X1_gn vss vss sky130_fd_pr__nfet_01v8_lvt w=2.6 l=0.15
X1763 t_Xdrv_Xm_8xa_X1_X0_X1_swp pad_p vss sky130_fd_pr__res_high_po_2p85 l=3.75
X1764 vdrv t_Xdrv_Xm_8xa_X1_X0_X1_gn t_Xdrv_Xm_8xa_X1_X0_X1_swn vss sky130_fd_pr__nfet_01v8_lvt w=3.8 l=0.15
X1765 t_Xdrv_Xm_8xa_X1_X0_X1_swn t_Xdrv_Xm_8xa_X1_X0_X1_gp vss vss sky130_fd_pr__nfet_01v8_lvt w=2.6 l=0.15
X1766 t_Xdrv_Xm_8xa_X1_X0_X1_swn pad_n vss sky130_fd_pr__res_high_po_2p85 l=3.75
X1767 t_Xdrv_Xm_8xa_X1_X1_X0_gpb t_Xdrv_mp t_Xdrv_Xm_8xa_X1_X1_X0_Xgpb_mid vss sky130_fd_pr__nfet_01v8_lvt w=0.85 l=0.15
X1768 t_Xdrv_Xm_8xa_X1_X1_X0_Xgpb_mid m3 vss vss sky130_fd_pr__nfet_01v8_lvt w=0.85 l=0.15
X1769 t_Xdrv_Xm_8xa_X1_X1_X0_gpb t_Xdrv_mp vdd vdd sky130_fd_pr__pfet_01v8 w=2.2 l=0.15
X1770 t_Xdrv_Xm_8xa_X1_X1_X0_gpb m3 vdd vdd sky130_fd_pr__pfet_01v8 w=2.2 l=0.15
X1771 t_Xdrv_Xm_8xa_X1_X1_X0_gnb t_Xdrv_mn t_Xdrv_Xm_8xa_X1_X1_X0_Xgnb_mid vss sky130_fd_pr__nfet_01v8_lvt w=0.85 l=0.15
X1772 t_Xdrv_Xm_8xa_X1_X1_X0_Xgnb_mid m3 vss vss sky130_fd_pr__nfet_01v8_lvt w=0.85 l=0.15
X1773 t_Xdrv_Xm_8xa_X1_X1_X0_gnb t_Xdrv_mn vdd vdd sky130_fd_pr__pfet_01v8 w=2.2 l=0.15
X1774 t_Xdrv_Xm_8xa_X1_X1_X0_gnb m3 vdd vdd sky130_fd_pr__pfet_01v8 w=2.2 l=0.15
X1775 t_Xdrv_Xm_8xa_X1_X1_X0_gp t_Xdrv_Xm_8xa_X1_X1_X0_gpb vss vss sky130_fd_pr__nfet_01v8_lvt w=1.8 l=0.15
X1776 t_Xdrv_Xm_8xa_X1_X1_X0_gp t_Xdrv_Xm_8xa_X1_X1_X0_gpb vdd vdd sky130_fd_pr__pfet_01v8 w=3.3 l=0.15
X1777 t_Xdrv_Xm_8xa_X1_X1_X0_gn t_Xdrv_Xm_8xa_X1_X1_X0_gnb vss vss sky130_fd_pr__nfet_01v8_lvt w=1.8 l=0.15
X1778 t_Xdrv_Xm_8xa_X1_X1_X0_gn t_Xdrv_Xm_8xa_X1_X1_X0_gnb vdd vdd sky130_fd_pr__pfet_01v8 w=3.3 l=0.15
X1779 vdrv t_Xdrv_Xm_8xa_X1_X1_X0_gp t_Xdrv_Xm_8xa_X1_X1_X0_swp vss sky130_fd_pr__nfet_01v8_lvt w=3.8 l=0.15
X1780 t_Xdrv_Xm_8xa_X1_X1_X0_swp t_Xdrv_Xm_8xa_X1_X1_X0_gn vss vss sky130_fd_pr__nfet_01v8_lvt w=2.6 l=0.15
X1781 t_Xdrv_Xm_8xa_X1_X1_X0_swp pad_p vss sky130_fd_pr__res_high_po_2p85 l=3.75
X1782 vdrv t_Xdrv_Xm_8xa_X1_X1_X0_gn t_Xdrv_Xm_8xa_X1_X1_X0_swn vss sky130_fd_pr__nfet_01v8_lvt w=3.8 l=0.15
X1783 t_Xdrv_Xm_8xa_X1_X1_X0_swn t_Xdrv_Xm_8xa_X1_X1_X0_gp vss vss sky130_fd_pr__nfet_01v8_lvt w=2.6 l=0.15
X1784 t_Xdrv_Xm_8xa_X1_X1_X0_swn pad_n vss sky130_fd_pr__res_high_po_2p85 l=3.75
X1785 t_Xdrv_Xm_8xa_X1_X1_X1_gpb t_Xdrv_mp t_Xdrv_Xm_8xa_X1_X1_X1_Xgpb_mid vss sky130_fd_pr__nfet_01v8_lvt w=0.85 l=0.15
X1786 t_Xdrv_Xm_8xa_X1_X1_X1_Xgpb_mid m3 vss vss sky130_fd_pr__nfet_01v8_lvt w=0.85 l=0.15
X1787 t_Xdrv_Xm_8xa_X1_X1_X1_gpb t_Xdrv_mp vdd vdd sky130_fd_pr__pfet_01v8 w=2.2 l=0.15
X1788 t_Xdrv_Xm_8xa_X1_X1_X1_gpb m3 vdd vdd sky130_fd_pr__pfet_01v8 w=2.2 l=0.15
X1789 t_Xdrv_Xm_8xa_X1_X1_X1_gnb t_Xdrv_mn t_Xdrv_Xm_8xa_X1_X1_X1_Xgnb_mid vss sky130_fd_pr__nfet_01v8_lvt w=0.85 l=0.15
X1790 t_Xdrv_Xm_8xa_X1_X1_X1_Xgnb_mid m3 vss vss sky130_fd_pr__nfet_01v8_lvt w=0.85 l=0.15
X1791 t_Xdrv_Xm_8xa_X1_X1_X1_gnb t_Xdrv_mn vdd vdd sky130_fd_pr__pfet_01v8 w=2.2 l=0.15
X1792 t_Xdrv_Xm_8xa_X1_X1_X1_gnb m3 vdd vdd sky130_fd_pr__pfet_01v8 w=2.2 l=0.15
X1793 t_Xdrv_Xm_8xa_X1_X1_X1_gp t_Xdrv_Xm_8xa_X1_X1_X1_gpb vss vss sky130_fd_pr__nfet_01v8_lvt w=1.8 l=0.15
X1794 t_Xdrv_Xm_8xa_X1_X1_X1_gp t_Xdrv_Xm_8xa_X1_X1_X1_gpb vdd vdd sky130_fd_pr__pfet_01v8 w=3.3 l=0.15
X1795 t_Xdrv_Xm_8xa_X1_X1_X1_gn t_Xdrv_Xm_8xa_X1_X1_X1_gnb vss vss sky130_fd_pr__nfet_01v8_lvt w=1.8 l=0.15
X1796 t_Xdrv_Xm_8xa_X1_X1_X1_gn t_Xdrv_Xm_8xa_X1_X1_X1_gnb vdd vdd sky130_fd_pr__pfet_01v8 w=3.3 l=0.15
X1797 vdrv t_Xdrv_Xm_8xa_X1_X1_X1_gp t_Xdrv_Xm_8xa_X1_X1_X1_swp vss sky130_fd_pr__nfet_01v8_lvt w=3.8 l=0.15
X1798 t_Xdrv_Xm_8xa_X1_X1_X1_swp t_Xdrv_Xm_8xa_X1_X1_X1_gn vss vss sky130_fd_pr__nfet_01v8_lvt w=2.6 l=0.15
X1799 t_Xdrv_Xm_8xa_X1_X1_X1_swp pad_p vss sky130_fd_pr__res_high_po_2p85 l=3.75
X1800 vdrv t_Xdrv_Xm_8xa_X1_X1_X1_gn t_Xdrv_Xm_8xa_X1_X1_X1_swn vss sky130_fd_pr__nfet_01v8_lvt w=3.8 l=0.15
X1801 t_Xdrv_Xm_8xa_X1_X1_X1_swn t_Xdrv_Xm_8xa_X1_X1_X1_gp vss vss sky130_fd_pr__nfet_01v8_lvt w=2.6 l=0.15
X1802 t_Xdrv_Xm_8xa_X1_X1_X1_swn pad_n vss sky130_fd_pr__res_high_po_2p85 l=3.75
X1803 t_Xdrv_Xm_8xb_X0_X0_X0_gpb t_Xdrv_mp t_Xdrv_Xm_8xb_X0_X0_X0_Xgpb_mid vss sky130_fd_pr__nfet_01v8_lvt w=0.85 l=0.15
X1804 t_Xdrv_Xm_8xb_X0_X0_X0_Xgpb_mid m4 vss vss sky130_fd_pr__nfet_01v8_lvt w=0.85 l=0.15
X1805 t_Xdrv_Xm_8xb_X0_X0_X0_gpb t_Xdrv_mp vdd vdd sky130_fd_pr__pfet_01v8 w=2.2 l=0.15
X1806 t_Xdrv_Xm_8xb_X0_X0_X0_gpb m4 vdd vdd sky130_fd_pr__pfet_01v8 w=2.2 l=0.15
X1807 t_Xdrv_Xm_8xb_X0_X0_X0_gnb t_Xdrv_mn t_Xdrv_Xm_8xb_X0_X0_X0_Xgnb_mid vss sky130_fd_pr__nfet_01v8_lvt w=0.85 l=0.15
X1808 t_Xdrv_Xm_8xb_X0_X0_X0_Xgnb_mid m4 vss vss sky130_fd_pr__nfet_01v8_lvt w=0.85 l=0.15
X1809 t_Xdrv_Xm_8xb_X0_X0_X0_gnb t_Xdrv_mn vdd vdd sky130_fd_pr__pfet_01v8 w=2.2 l=0.15
X1810 t_Xdrv_Xm_8xb_X0_X0_X0_gnb m4 vdd vdd sky130_fd_pr__pfet_01v8 w=2.2 l=0.15
X1811 t_Xdrv_Xm_8xb_X0_X0_X0_gp t_Xdrv_Xm_8xb_X0_X0_X0_gpb vss vss sky130_fd_pr__nfet_01v8_lvt w=1.8 l=0.15
X1812 t_Xdrv_Xm_8xb_X0_X0_X0_gp t_Xdrv_Xm_8xb_X0_X0_X0_gpb vdd vdd sky130_fd_pr__pfet_01v8 w=3.3 l=0.15
X1813 t_Xdrv_Xm_8xb_X0_X0_X0_gn t_Xdrv_Xm_8xb_X0_X0_X0_gnb vss vss sky130_fd_pr__nfet_01v8_lvt w=1.8 l=0.15
X1814 t_Xdrv_Xm_8xb_X0_X0_X0_gn t_Xdrv_Xm_8xb_X0_X0_X0_gnb vdd vdd sky130_fd_pr__pfet_01v8 w=3.3 l=0.15
X1815 vdrv t_Xdrv_Xm_8xb_X0_X0_X0_gp t_Xdrv_Xm_8xb_X0_X0_X0_swp vss sky130_fd_pr__nfet_01v8_lvt w=3.8 l=0.15
X1816 t_Xdrv_Xm_8xb_X0_X0_X0_swp t_Xdrv_Xm_8xb_X0_X0_X0_gn vss vss sky130_fd_pr__nfet_01v8_lvt w=2.6 l=0.15
X1817 t_Xdrv_Xm_8xb_X0_X0_X0_swp pad_p vss sky130_fd_pr__res_high_po_2p85 l=3.75
X1818 vdrv t_Xdrv_Xm_8xb_X0_X0_X0_gn t_Xdrv_Xm_8xb_X0_X0_X0_swn vss sky130_fd_pr__nfet_01v8_lvt w=3.8 l=0.15
X1819 t_Xdrv_Xm_8xb_X0_X0_X0_swn t_Xdrv_Xm_8xb_X0_X0_X0_gp vss vss sky130_fd_pr__nfet_01v8_lvt w=2.6 l=0.15
X1820 t_Xdrv_Xm_8xb_X0_X0_X0_swn pad_n vss sky130_fd_pr__res_high_po_2p85 l=3.75
X1821 t_Xdrv_Xm_8xb_X0_X0_X1_gpb t_Xdrv_mp t_Xdrv_Xm_8xb_X0_X0_X1_Xgpb_mid vss sky130_fd_pr__nfet_01v8_lvt w=0.85 l=0.15
X1822 t_Xdrv_Xm_8xb_X0_X0_X1_Xgpb_mid m4 vss vss sky130_fd_pr__nfet_01v8_lvt w=0.85 l=0.15
X1823 t_Xdrv_Xm_8xb_X0_X0_X1_gpb t_Xdrv_mp vdd vdd sky130_fd_pr__pfet_01v8 w=2.2 l=0.15
X1824 t_Xdrv_Xm_8xb_X0_X0_X1_gpb m4 vdd vdd sky130_fd_pr__pfet_01v8 w=2.2 l=0.15
X1825 t_Xdrv_Xm_8xb_X0_X0_X1_gnb t_Xdrv_mn t_Xdrv_Xm_8xb_X0_X0_X1_Xgnb_mid vss sky130_fd_pr__nfet_01v8_lvt w=0.85 l=0.15
X1826 t_Xdrv_Xm_8xb_X0_X0_X1_Xgnb_mid m4 vss vss sky130_fd_pr__nfet_01v8_lvt w=0.85 l=0.15
X1827 t_Xdrv_Xm_8xb_X0_X0_X1_gnb t_Xdrv_mn vdd vdd sky130_fd_pr__pfet_01v8 w=2.2 l=0.15
X1828 t_Xdrv_Xm_8xb_X0_X0_X1_gnb m4 vdd vdd sky130_fd_pr__pfet_01v8 w=2.2 l=0.15
X1829 t_Xdrv_Xm_8xb_X0_X0_X1_gp t_Xdrv_Xm_8xb_X0_X0_X1_gpb vss vss sky130_fd_pr__nfet_01v8_lvt w=1.8 l=0.15
X1830 t_Xdrv_Xm_8xb_X0_X0_X1_gp t_Xdrv_Xm_8xb_X0_X0_X1_gpb vdd vdd sky130_fd_pr__pfet_01v8 w=3.3 l=0.15
X1831 t_Xdrv_Xm_8xb_X0_X0_X1_gn t_Xdrv_Xm_8xb_X0_X0_X1_gnb vss vss sky130_fd_pr__nfet_01v8_lvt w=1.8 l=0.15
X1832 t_Xdrv_Xm_8xb_X0_X0_X1_gn t_Xdrv_Xm_8xb_X0_X0_X1_gnb vdd vdd sky130_fd_pr__pfet_01v8 w=3.3 l=0.15
X1833 vdrv t_Xdrv_Xm_8xb_X0_X0_X1_gp t_Xdrv_Xm_8xb_X0_X0_X1_swp vss sky130_fd_pr__nfet_01v8_lvt w=3.8 l=0.15
X1834 t_Xdrv_Xm_8xb_X0_X0_X1_swp t_Xdrv_Xm_8xb_X0_X0_X1_gn vss vss sky130_fd_pr__nfet_01v8_lvt w=2.6 l=0.15
X1835 t_Xdrv_Xm_8xb_X0_X0_X1_swp pad_p vss sky130_fd_pr__res_high_po_2p85 l=3.75
X1836 vdrv t_Xdrv_Xm_8xb_X0_X0_X1_gn t_Xdrv_Xm_8xb_X0_X0_X1_swn vss sky130_fd_pr__nfet_01v8_lvt w=3.8 l=0.15
X1837 t_Xdrv_Xm_8xb_X0_X0_X1_swn t_Xdrv_Xm_8xb_X0_X0_X1_gp vss vss sky130_fd_pr__nfet_01v8_lvt w=2.6 l=0.15
X1838 t_Xdrv_Xm_8xb_X0_X0_X1_swn pad_n vss sky130_fd_pr__res_high_po_2p85 l=3.75
X1839 t_Xdrv_Xm_8xb_X0_X1_X0_gpb t_Xdrv_mp t_Xdrv_Xm_8xb_X0_X1_X0_Xgpb_mid vss sky130_fd_pr__nfet_01v8_lvt w=0.85 l=0.15
X1840 t_Xdrv_Xm_8xb_X0_X1_X0_Xgpb_mid m4 vss vss sky130_fd_pr__nfet_01v8_lvt w=0.85 l=0.15
X1841 t_Xdrv_Xm_8xb_X0_X1_X0_gpb t_Xdrv_mp vdd vdd sky130_fd_pr__pfet_01v8 w=2.2 l=0.15
X1842 t_Xdrv_Xm_8xb_X0_X1_X0_gpb m4 vdd vdd sky130_fd_pr__pfet_01v8 w=2.2 l=0.15
X1843 t_Xdrv_Xm_8xb_X0_X1_X0_gnb t_Xdrv_mn t_Xdrv_Xm_8xb_X0_X1_X0_Xgnb_mid vss sky130_fd_pr__nfet_01v8_lvt w=0.85 l=0.15
X1844 t_Xdrv_Xm_8xb_X0_X1_X0_Xgnb_mid m4 vss vss sky130_fd_pr__nfet_01v8_lvt w=0.85 l=0.15
X1845 t_Xdrv_Xm_8xb_X0_X1_X0_gnb t_Xdrv_mn vdd vdd sky130_fd_pr__pfet_01v8 w=2.2 l=0.15
X1846 t_Xdrv_Xm_8xb_X0_X1_X0_gnb m4 vdd vdd sky130_fd_pr__pfet_01v8 w=2.2 l=0.15
X1847 t_Xdrv_Xm_8xb_X0_X1_X0_gp t_Xdrv_Xm_8xb_X0_X1_X0_gpb vss vss sky130_fd_pr__nfet_01v8_lvt w=1.8 l=0.15
X1848 t_Xdrv_Xm_8xb_X0_X1_X0_gp t_Xdrv_Xm_8xb_X0_X1_X0_gpb vdd vdd sky130_fd_pr__pfet_01v8 w=3.3 l=0.15
X1849 t_Xdrv_Xm_8xb_X0_X1_X0_gn t_Xdrv_Xm_8xb_X0_X1_X0_gnb vss vss sky130_fd_pr__nfet_01v8_lvt w=1.8 l=0.15
X1850 t_Xdrv_Xm_8xb_X0_X1_X0_gn t_Xdrv_Xm_8xb_X0_X1_X0_gnb vdd vdd sky130_fd_pr__pfet_01v8 w=3.3 l=0.15
X1851 vdrv t_Xdrv_Xm_8xb_X0_X1_X0_gp t_Xdrv_Xm_8xb_X0_X1_X0_swp vss sky130_fd_pr__nfet_01v8_lvt w=3.8 l=0.15
X1852 t_Xdrv_Xm_8xb_X0_X1_X0_swp t_Xdrv_Xm_8xb_X0_X1_X0_gn vss vss sky130_fd_pr__nfet_01v8_lvt w=2.6 l=0.15
X1853 t_Xdrv_Xm_8xb_X0_X1_X0_swp pad_p vss sky130_fd_pr__res_high_po_2p85 l=3.75
X1854 vdrv t_Xdrv_Xm_8xb_X0_X1_X0_gn t_Xdrv_Xm_8xb_X0_X1_X0_swn vss sky130_fd_pr__nfet_01v8_lvt w=3.8 l=0.15
X1855 t_Xdrv_Xm_8xb_X0_X1_X0_swn t_Xdrv_Xm_8xb_X0_X1_X0_gp vss vss sky130_fd_pr__nfet_01v8_lvt w=2.6 l=0.15
X1856 t_Xdrv_Xm_8xb_X0_X1_X0_swn pad_n vss sky130_fd_pr__res_high_po_2p85 l=3.75
X1857 t_Xdrv_Xm_8xb_X0_X1_X1_gpb t_Xdrv_mp t_Xdrv_Xm_8xb_X0_X1_X1_Xgpb_mid vss sky130_fd_pr__nfet_01v8_lvt w=0.85 l=0.15
X1858 t_Xdrv_Xm_8xb_X0_X1_X1_Xgpb_mid m4 vss vss sky130_fd_pr__nfet_01v8_lvt w=0.85 l=0.15
X1859 t_Xdrv_Xm_8xb_X0_X1_X1_gpb t_Xdrv_mp vdd vdd sky130_fd_pr__pfet_01v8 w=2.2 l=0.15
X1860 t_Xdrv_Xm_8xb_X0_X1_X1_gpb m4 vdd vdd sky130_fd_pr__pfet_01v8 w=2.2 l=0.15
X1861 t_Xdrv_Xm_8xb_X0_X1_X1_gnb t_Xdrv_mn t_Xdrv_Xm_8xb_X0_X1_X1_Xgnb_mid vss sky130_fd_pr__nfet_01v8_lvt w=0.85 l=0.15
X1862 t_Xdrv_Xm_8xb_X0_X1_X1_Xgnb_mid m4 vss vss sky130_fd_pr__nfet_01v8_lvt w=0.85 l=0.15
X1863 t_Xdrv_Xm_8xb_X0_X1_X1_gnb t_Xdrv_mn vdd vdd sky130_fd_pr__pfet_01v8 w=2.2 l=0.15
X1864 t_Xdrv_Xm_8xb_X0_X1_X1_gnb m4 vdd vdd sky130_fd_pr__pfet_01v8 w=2.2 l=0.15
X1865 t_Xdrv_Xm_8xb_X0_X1_X1_gp t_Xdrv_Xm_8xb_X0_X1_X1_gpb vss vss sky130_fd_pr__nfet_01v8_lvt w=1.8 l=0.15
X1866 t_Xdrv_Xm_8xb_X0_X1_X1_gp t_Xdrv_Xm_8xb_X0_X1_X1_gpb vdd vdd sky130_fd_pr__pfet_01v8 w=3.3 l=0.15
X1867 t_Xdrv_Xm_8xb_X0_X1_X1_gn t_Xdrv_Xm_8xb_X0_X1_X1_gnb vss vss sky130_fd_pr__nfet_01v8_lvt w=1.8 l=0.15
X1868 t_Xdrv_Xm_8xb_X0_X1_X1_gn t_Xdrv_Xm_8xb_X0_X1_X1_gnb vdd vdd sky130_fd_pr__pfet_01v8 w=3.3 l=0.15
X1869 vdrv t_Xdrv_Xm_8xb_X0_X1_X1_gp t_Xdrv_Xm_8xb_X0_X1_X1_swp vss sky130_fd_pr__nfet_01v8_lvt w=3.8 l=0.15
X1870 t_Xdrv_Xm_8xb_X0_X1_X1_swp t_Xdrv_Xm_8xb_X0_X1_X1_gn vss vss sky130_fd_pr__nfet_01v8_lvt w=2.6 l=0.15
X1871 t_Xdrv_Xm_8xb_X0_X1_X1_swp pad_p vss sky130_fd_pr__res_high_po_2p85 l=3.75
X1872 vdrv t_Xdrv_Xm_8xb_X0_X1_X1_gn t_Xdrv_Xm_8xb_X0_X1_X1_swn vss sky130_fd_pr__nfet_01v8_lvt w=3.8 l=0.15
X1873 t_Xdrv_Xm_8xb_X0_X1_X1_swn t_Xdrv_Xm_8xb_X0_X1_X1_gp vss vss sky130_fd_pr__nfet_01v8_lvt w=2.6 l=0.15
X1874 t_Xdrv_Xm_8xb_X0_X1_X1_swn pad_n vss sky130_fd_pr__res_high_po_2p85 l=3.75
X1875 t_Xdrv_Xm_8xb_X1_X0_X0_gpb t_Xdrv_mp t_Xdrv_Xm_8xb_X1_X0_X0_Xgpb_mid vss sky130_fd_pr__nfet_01v8_lvt w=0.85 l=0.15
X1876 t_Xdrv_Xm_8xb_X1_X0_X0_Xgpb_mid m4 vss vss sky130_fd_pr__nfet_01v8_lvt w=0.85 l=0.15
X1877 t_Xdrv_Xm_8xb_X1_X0_X0_gpb t_Xdrv_mp vdd vdd sky130_fd_pr__pfet_01v8 w=2.2 l=0.15
X1878 t_Xdrv_Xm_8xb_X1_X0_X0_gpb m4 vdd vdd sky130_fd_pr__pfet_01v8 w=2.2 l=0.15
X1879 t_Xdrv_Xm_8xb_X1_X0_X0_gnb t_Xdrv_mn t_Xdrv_Xm_8xb_X1_X0_X0_Xgnb_mid vss sky130_fd_pr__nfet_01v8_lvt w=0.85 l=0.15
X1880 t_Xdrv_Xm_8xb_X1_X0_X0_Xgnb_mid m4 vss vss sky130_fd_pr__nfet_01v8_lvt w=0.85 l=0.15
X1881 t_Xdrv_Xm_8xb_X1_X0_X0_gnb t_Xdrv_mn vdd vdd sky130_fd_pr__pfet_01v8 w=2.2 l=0.15
X1882 t_Xdrv_Xm_8xb_X1_X0_X0_gnb m4 vdd vdd sky130_fd_pr__pfet_01v8 w=2.2 l=0.15
X1883 t_Xdrv_Xm_8xb_X1_X0_X0_gp t_Xdrv_Xm_8xb_X1_X0_X0_gpb vss vss sky130_fd_pr__nfet_01v8_lvt w=1.8 l=0.15
X1884 t_Xdrv_Xm_8xb_X1_X0_X0_gp t_Xdrv_Xm_8xb_X1_X0_X0_gpb vdd vdd sky130_fd_pr__pfet_01v8 w=3.3 l=0.15
X1885 t_Xdrv_Xm_8xb_X1_X0_X0_gn t_Xdrv_Xm_8xb_X1_X0_X0_gnb vss vss sky130_fd_pr__nfet_01v8_lvt w=1.8 l=0.15
X1886 t_Xdrv_Xm_8xb_X1_X0_X0_gn t_Xdrv_Xm_8xb_X1_X0_X0_gnb vdd vdd sky130_fd_pr__pfet_01v8 w=3.3 l=0.15
X1887 vdrv t_Xdrv_Xm_8xb_X1_X0_X0_gp t_Xdrv_Xm_8xb_X1_X0_X0_swp vss sky130_fd_pr__nfet_01v8_lvt w=3.8 l=0.15
X1888 t_Xdrv_Xm_8xb_X1_X0_X0_swp t_Xdrv_Xm_8xb_X1_X0_X0_gn vss vss sky130_fd_pr__nfet_01v8_lvt w=2.6 l=0.15
X1889 t_Xdrv_Xm_8xb_X1_X0_X0_swp pad_p vss sky130_fd_pr__res_high_po_2p85 l=3.75
X1890 vdrv t_Xdrv_Xm_8xb_X1_X0_X0_gn t_Xdrv_Xm_8xb_X1_X0_X0_swn vss sky130_fd_pr__nfet_01v8_lvt w=3.8 l=0.15
X1891 t_Xdrv_Xm_8xb_X1_X0_X0_swn t_Xdrv_Xm_8xb_X1_X0_X0_gp vss vss sky130_fd_pr__nfet_01v8_lvt w=2.6 l=0.15
X1892 t_Xdrv_Xm_8xb_X1_X0_X0_swn pad_n vss sky130_fd_pr__res_high_po_2p85 l=3.75
X1893 t_Xdrv_Xm_8xb_X1_X0_X1_gpb t_Xdrv_mp t_Xdrv_Xm_8xb_X1_X0_X1_Xgpb_mid vss sky130_fd_pr__nfet_01v8_lvt w=0.85 l=0.15
X1894 t_Xdrv_Xm_8xb_X1_X0_X1_Xgpb_mid m4 vss vss sky130_fd_pr__nfet_01v8_lvt w=0.85 l=0.15
X1895 t_Xdrv_Xm_8xb_X1_X0_X1_gpb t_Xdrv_mp vdd vdd sky130_fd_pr__pfet_01v8 w=2.2 l=0.15
X1896 t_Xdrv_Xm_8xb_X1_X0_X1_gpb m4 vdd vdd sky130_fd_pr__pfet_01v8 w=2.2 l=0.15
X1897 t_Xdrv_Xm_8xb_X1_X0_X1_gnb t_Xdrv_mn t_Xdrv_Xm_8xb_X1_X0_X1_Xgnb_mid vss sky130_fd_pr__nfet_01v8_lvt w=0.85 l=0.15
X1898 t_Xdrv_Xm_8xb_X1_X0_X1_Xgnb_mid m4 vss vss sky130_fd_pr__nfet_01v8_lvt w=0.85 l=0.15
X1899 t_Xdrv_Xm_8xb_X1_X0_X1_gnb t_Xdrv_mn vdd vdd sky130_fd_pr__pfet_01v8 w=2.2 l=0.15
X1900 t_Xdrv_Xm_8xb_X1_X0_X1_gnb m4 vdd vdd sky130_fd_pr__pfet_01v8 w=2.2 l=0.15
X1901 t_Xdrv_Xm_8xb_X1_X0_X1_gp t_Xdrv_Xm_8xb_X1_X0_X1_gpb vss vss sky130_fd_pr__nfet_01v8_lvt w=1.8 l=0.15
X1902 t_Xdrv_Xm_8xb_X1_X0_X1_gp t_Xdrv_Xm_8xb_X1_X0_X1_gpb vdd vdd sky130_fd_pr__pfet_01v8 w=3.3 l=0.15
X1903 t_Xdrv_Xm_8xb_X1_X0_X1_gn t_Xdrv_Xm_8xb_X1_X0_X1_gnb vss vss sky130_fd_pr__nfet_01v8_lvt w=1.8 l=0.15
X1904 t_Xdrv_Xm_8xb_X1_X0_X1_gn t_Xdrv_Xm_8xb_X1_X0_X1_gnb vdd vdd sky130_fd_pr__pfet_01v8 w=3.3 l=0.15
X1905 vdrv t_Xdrv_Xm_8xb_X1_X0_X1_gp t_Xdrv_Xm_8xb_X1_X0_X1_swp vss sky130_fd_pr__nfet_01v8_lvt w=3.8 l=0.15
X1906 t_Xdrv_Xm_8xb_X1_X0_X1_swp t_Xdrv_Xm_8xb_X1_X0_X1_gn vss vss sky130_fd_pr__nfet_01v8_lvt w=2.6 l=0.15
X1907 t_Xdrv_Xm_8xb_X1_X0_X1_swp pad_p vss sky130_fd_pr__res_high_po_2p85 l=3.75
X1908 vdrv t_Xdrv_Xm_8xb_X1_X0_X1_gn t_Xdrv_Xm_8xb_X1_X0_X1_swn vss sky130_fd_pr__nfet_01v8_lvt w=3.8 l=0.15
X1909 t_Xdrv_Xm_8xb_X1_X0_X1_swn t_Xdrv_Xm_8xb_X1_X0_X1_gp vss vss sky130_fd_pr__nfet_01v8_lvt w=2.6 l=0.15
X1910 t_Xdrv_Xm_8xb_X1_X0_X1_swn pad_n vss sky130_fd_pr__res_high_po_2p85 l=3.75
X1911 t_Xdrv_Xm_8xb_X1_X1_X0_gpb t_Xdrv_mp t_Xdrv_Xm_8xb_X1_X1_X0_Xgpb_mid vss sky130_fd_pr__nfet_01v8_lvt w=0.85 l=0.15
X1912 t_Xdrv_Xm_8xb_X1_X1_X0_Xgpb_mid m4 vss vss sky130_fd_pr__nfet_01v8_lvt w=0.85 l=0.15
X1913 t_Xdrv_Xm_8xb_X1_X1_X0_gpb t_Xdrv_mp vdd vdd sky130_fd_pr__pfet_01v8 w=2.2 l=0.15
X1914 t_Xdrv_Xm_8xb_X1_X1_X0_gpb m4 vdd vdd sky130_fd_pr__pfet_01v8 w=2.2 l=0.15
X1915 t_Xdrv_Xm_8xb_X1_X1_X0_gnb t_Xdrv_mn t_Xdrv_Xm_8xb_X1_X1_X0_Xgnb_mid vss sky130_fd_pr__nfet_01v8_lvt w=0.85 l=0.15
X1916 t_Xdrv_Xm_8xb_X1_X1_X0_Xgnb_mid m4 vss vss sky130_fd_pr__nfet_01v8_lvt w=0.85 l=0.15
X1917 t_Xdrv_Xm_8xb_X1_X1_X0_gnb t_Xdrv_mn vdd vdd sky130_fd_pr__pfet_01v8 w=2.2 l=0.15
X1918 t_Xdrv_Xm_8xb_X1_X1_X0_gnb m4 vdd vdd sky130_fd_pr__pfet_01v8 w=2.2 l=0.15
X1919 t_Xdrv_Xm_8xb_X1_X1_X0_gp t_Xdrv_Xm_8xb_X1_X1_X0_gpb vss vss sky130_fd_pr__nfet_01v8_lvt w=1.8 l=0.15
X1920 t_Xdrv_Xm_8xb_X1_X1_X0_gp t_Xdrv_Xm_8xb_X1_X1_X0_gpb vdd vdd sky130_fd_pr__pfet_01v8 w=3.3 l=0.15
X1921 t_Xdrv_Xm_8xb_X1_X1_X0_gn t_Xdrv_Xm_8xb_X1_X1_X0_gnb vss vss sky130_fd_pr__nfet_01v8_lvt w=1.8 l=0.15
X1922 t_Xdrv_Xm_8xb_X1_X1_X0_gn t_Xdrv_Xm_8xb_X1_X1_X0_gnb vdd vdd sky130_fd_pr__pfet_01v8 w=3.3 l=0.15
X1923 vdrv t_Xdrv_Xm_8xb_X1_X1_X0_gp t_Xdrv_Xm_8xb_X1_X1_X0_swp vss sky130_fd_pr__nfet_01v8_lvt w=3.8 l=0.15
X1924 t_Xdrv_Xm_8xb_X1_X1_X0_swp t_Xdrv_Xm_8xb_X1_X1_X0_gn vss vss sky130_fd_pr__nfet_01v8_lvt w=2.6 l=0.15
X1925 t_Xdrv_Xm_8xb_X1_X1_X0_swp pad_p vss sky130_fd_pr__res_high_po_2p85 l=3.75
X1926 vdrv t_Xdrv_Xm_8xb_X1_X1_X0_gn t_Xdrv_Xm_8xb_X1_X1_X0_swn vss sky130_fd_pr__nfet_01v8_lvt w=3.8 l=0.15
X1927 t_Xdrv_Xm_8xb_X1_X1_X0_swn t_Xdrv_Xm_8xb_X1_X1_X0_gp vss vss sky130_fd_pr__nfet_01v8_lvt w=2.6 l=0.15
X1928 t_Xdrv_Xm_8xb_X1_X1_X0_swn pad_n vss sky130_fd_pr__res_high_po_2p85 l=3.75
X1929 t_Xdrv_Xm_8xb_X1_X1_X1_gpb t_Xdrv_mp t_Xdrv_Xm_8xb_X1_X1_X1_Xgpb_mid vss sky130_fd_pr__nfet_01v8_lvt w=0.85 l=0.15
X1930 t_Xdrv_Xm_8xb_X1_X1_X1_Xgpb_mid m4 vss vss sky130_fd_pr__nfet_01v8_lvt w=0.85 l=0.15
X1931 t_Xdrv_Xm_8xb_X1_X1_X1_gpb t_Xdrv_mp vdd vdd sky130_fd_pr__pfet_01v8 w=2.2 l=0.15
X1932 t_Xdrv_Xm_8xb_X1_X1_X1_gpb m4 vdd vdd sky130_fd_pr__pfet_01v8 w=2.2 l=0.15
X1933 t_Xdrv_Xm_8xb_X1_X1_X1_gnb t_Xdrv_mn t_Xdrv_Xm_8xb_X1_X1_X1_Xgnb_mid vss sky130_fd_pr__nfet_01v8_lvt w=0.85 l=0.15
X1934 t_Xdrv_Xm_8xb_X1_X1_X1_Xgnb_mid m4 vss vss sky130_fd_pr__nfet_01v8_lvt w=0.85 l=0.15
X1935 t_Xdrv_Xm_8xb_X1_X1_X1_gnb t_Xdrv_mn vdd vdd sky130_fd_pr__pfet_01v8 w=2.2 l=0.15
X1936 t_Xdrv_Xm_8xb_X1_X1_X1_gnb m4 vdd vdd sky130_fd_pr__pfet_01v8 w=2.2 l=0.15
X1937 t_Xdrv_Xm_8xb_X1_X1_X1_gp t_Xdrv_Xm_8xb_X1_X1_X1_gpb vss vss sky130_fd_pr__nfet_01v8_lvt w=1.8 l=0.15
X1938 t_Xdrv_Xm_8xb_X1_X1_X1_gp t_Xdrv_Xm_8xb_X1_X1_X1_gpb vdd vdd sky130_fd_pr__pfet_01v8 w=3.3 l=0.15
X1939 t_Xdrv_Xm_8xb_X1_X1_X1_gn t_Xdrv_Xm_8xb_X1_X1_X1_gnb vss vss sky130_fd_pr__nfet_01v8_lvt w=1.8 l=0.15
X1940 t_Xdrv_Xm_8xb_X1_X1_X1_gn t_Xdrv_Xm_8xb_X1_X1_X1_gnb vdd vdd sky130_fd_pr__pfet_01v8 w=3.3 l=0.15
X1941 vdrv t_Xdrv_Xm_8xb_X1_X1_X1_gp t_Xdrv_Xm_8xb_X1_X1_X1_swp vss sky130_fd_pr__nfet_01v8_lvt w=3.8 l=0.15
X1942 t_Xdrv_Xm_8xb_X1_X1_X1_swp t_Xdrv_Xm_8xb_X1_X1_X1_gn vss vss sky130_fd_pr__nfet_01v8_lvt w=2.6 l=0.15
X1943 t_Xdrv_Xm_8xb_X1_X1_X1_swp pad_p vss sky130_fd_pr__res_high_po_2p85 l=3.75
X1944 vdrv t_Xdrv_Xm_8xb_X1_X1_X1_gn t_Xdrv_Xm_8xb_X1_X1_X1_swn vss sky130_fd_pr__nfet_01v8_lvt w=3.8 l=0.15
X1945 t_Xdrv_Xm_8xb_X1_X1_X1_swn t_Xdrv_Xm_8xb_X1_X1_X1_gp vss vss sky130_fd_pr__nfet_01v8_lvt w=2.6 l=0.15
X1946 t_Xdrv_Xm_8xb_X1_X1_X1_swn pad_n vss sky130_fd_pr__res_high_po_2p85 l=3.75
X1947 t_Xdrv_Xf_1x_gpb t_Xdrv_fp t_Xdrv_Xf_1x_Xgpb_mid vss sky130_fd_pr__nfet_01v8_lvt w=0.85 l=0.15
X1948 t_Xdrv_Xf_1x_Xgpb_mid f0 vss vss sky130_fd_pr__nfet_01v8_lvt w=0.85 l=0.15
X1949 t_Xdrv_Xf_1x_gpb t_Xdrv_fp vdd vdd sky130_fd_pr__pfet_01v8 w=2.2 l=0.15
X1950 t_Xdrv_Xf_1x_gpb f0 vdd vdd sky130_fd_pr__pfet_01v8 w=2.2 l=0.15
X1951 t_Xdrv_Xf_1x_gnb t_Xdrv_fn t_Xdrv_Xf_1x_Xgnb_mid vss sky130_fd_pr__nfet_01v8_lvt w=0.85 l=0.15
X1952 t_Xdrv_Xf_1x_Xgnb_mid f0 vss vss sky130_fd_pr__nfet_01v8_lvt w=0.85 l=0.15
X1953 t_Xdrv_Xf_1x_gnb t_Xdrv_fn vdd vdd sky130_fd_pr__pfet_01v8 w=2.2 l=0.15
X1954 t_Xdrv_Xf_1x_gnb f0 vdd vdd sky130_fd_pr__pfet_01v8 w=2.2 l=0.15
X1955 t_Xdrv_Xf_1x_gp t_Xdrv_Xf_1x_gpb vss vss sky130_fd_pr__nfet_01v8_lvt w=1.8 l=0.15
X1956 t_Xdrv_Xf_1x_gp t_Xdrv_Xf_1x_gpb vdd vdd sky130_fd_pr__pfet_01v8 w=3.3 l=0.15
X1957 t_Xdrv_Xf_1x_gn t_Xdrv_Xf_1x_gnb vss vss sky130_fd_pr__nfet_01v8_lvt w=1.8 l=0.15
X1958 t_Xdrv_Xf_1x_gn t_Xdrv_Xf_1x_gnb vdd vdd sky130_fd_pr__pfet_01v8 w=3.3 l=0.15
X1959 vdrv t_Xdrv_Xf_1x_gp t_Xdrv_Xf_1x_swp vss sky130_fd_pr__nfet_01v8_lvt w=3.8 l=0.15
X1960 t_Xdrv_Xf_1x_swp t_Xdrv_Xf_1x_gn vss vss sky130_fd_pr__nfet_01v8_lvt w=2.6 l=0.15
X1961 t_Xdrv_Xf_1x_swp pad_p vss sky130_fd_pr__res_high_po_2p85 l=3.75
X1962 vdrv t_Xdrv_Xf_1x_gn t_Xdrv_Xf_1x_swn vss sky130_fd_pr__nfet_01v8_lvt w=3.8 l=0.15
X1963 t_Xdrv_Xf_1x_swn t_Xdrv_Xf_1x_gp vss vss sky130_fd_pr__nfet_01v8_lvt w=2.6 l=0.15
X1964 t_Xdrv_Xf_1x_swn pad_n vss sky130_fd_pr__res_high_po_2p85 l=3.75
X1965 t_Xdrv_Xf_2xa_X0_gpb t_Xdrv_fp t_Xdrv_Xf_2xa_X0_Xgpb_mid vss sky130_fd_pr__nfet_01v8_lvt w=0.85 l=0.15
X1966 t_Xdrv_Xf_2xa_X0_Xgpb_mid f1 vss vss sky130_fd_pr__nfet_01v8_lvt w=0.85 l=0.15
X1967 t_Xdrv_Xf_2xa_X0_gpb t_Xdrv_fp vdd vdd sky130_fd_pr__pfet_01v8 w=2.2 l=0.15
X1968 t_Xdrv_Xf_2xa_X0_gpb f1 vdd vdd sky130_fd_pr__pfet_01v8 w=2.2 l=0.15
X1969 t_Xdrv_Xf_2xa_X0_gnb t_Xdrv_fn t_Xdrv_Xf_2xa_X0_Xgnb_mid vss sky130_fd_pr__nfet_01v8_lvt w=0.85 l=0.15
X1970 t_Xdrv_Xf_2xa_X0_Xgnb_mid f1 vss vss sky130_fd_pr__nfet_01v8_lvt w=0.85 l=0.15
X1971 t_Xdrv_Xf_2xa_X0_gnb t_Xdrv_fn vdd vdd sky130_fd_pr__pfet_01v8 w=2.2 l=0.15
X1972 t_Xdrv_Xf_2xa_X0_gnb f1 vdd vdd sky130_fd_pr__pfet_01v8 w=2.2 l=0.15
X1973 t_Xdrv_Xf_2xa_X0_gp t_Xdrv_Xf_2xa_X0_gpb vss vss sky130_fd_pr__nfet_01v8_lvt w=1.8 l=0.15
X1974 t_Xdrv_Xf_2xa_X0_gp t_Xdrv_Xf_2xa_X0_gpb vdd vdd sky130_fd_pr__pfet_01v8 w=3.3 l=0.15
X1975 t_Xdrv_Xf_2xa_X0_gn t_Xdrv_Xf_2xa_X0_gnb vss vss sky130_fd_pr__nfet_01v8_lvt w=1.8 l=0.15
X1976 t_Xdrv_Xf_2xa_X0_gn t_Xdrv_Xf_2xa_X0_gnb vdd vdd sky130_fd_pr__pfet_01v8 w=3.3 l=0.15
X1977 vdrv t_Xdrv_Xf_2xa_X0_gp t_Xdrv_Xf_2xa_X0_swp vss sky130_fd_pr__nfet_01v8_lvt w=3.8 l=0.15
X1978 t_Xdrv_Xf_2xa_X0_swp t_Xdrv_Xf_2xa_X0_gn vss vss sky130_fd_pr__nfet_01v8_lvt w=2.6 l=0.15
X1979 t_Xdrv_Xf_2xa_X0_swp pad_p vss sky130_fd_pr__res_high_po_2p85 l=3.75
X1980 vdrv t_Xdrv_Xf_2xa_X0_gn t_Xdrv_Xf_2xa_X0_swn vss sky130_fd_pr__nfet_01v8_lvt w=3.8 l=0.15
X1981 t_Xdrv_Xf_2xa_X0_swn t_Xdrv_Xf_2xa_X0_gp vss vss sky130_fd_pr__nfet_01v8_lvt w=2.6 l=0.15
X1982 t_Xdrv_Xf_2xa_X0_swn pad_n vss sky130_fd_pr__res_high_po_2p85 l=3.75
X1983 t_Xdrv_Xf_2xa_X1_gpb t_Xdrv_fp t_Xdrv_Xf_2xa_X1_Xgpb_mid vss sky130_fd_pr__nfet_01v8_lvt w=0.85 l=0.15
X1984 t_Xdrv_Xf_2xa_X1_Xgpb_mid f1 vss vss sky130_fd_pr__nfet_01v8_lvt w=0.85 l=0.15
X1985 t_Xdrv_Xf_2xa_X1_gpb t_Xdrv_fp vdd vdd sky130_fd_pr__pfet_01v8 w=2.2 l=0.15
X1986 t_Xdrv_Xf_2xa_X1_gpb f1 vdd vdd sky130_fd_pr__pfet_01v8 w=2.2 l=0.15
X1987 t_Xdrv_Xf_2xa_X1_gnb t_Xdrv_fn t_Xdrv_Xf_2xa_X1_Xgnb_mid vss sky130_fd_pr__nfet_01v8_lvt w=0.85 l=0.15
X1988 t_Xdrv_Xf_2xa_X1_Xgnb_mid f1 vss vss sky130_fd_pr__nfet_01v8_lvt w=0.85 l=0.15
X1989 t_Xdrv_Xf_2xa_X1_gnb t_Xdrv_fn vdd vdd sky130_fd_pr__pfet_01v8 w=2.2 l=0.15
X1990 t_Xdrv_Xf_2xa_X1_gnb f1 vdd vdd sky130_fd_pr__pfet_01v8 w=2.2 l=0.15
X1991 t_Xdrv_Xf_2xa_X1_gp t_Xdrv_Xf_2xa_X1_gpb vss vss sky130_fd_pr__nfet_01v8_lvt w=1.8 l=0.15
X1992 t_Xdrv_Xf_2xa_X1_gp t_Xdrv_Xf_2xa_X1_gpb vdd vdd sky130_fd_pr__pfet_01v8 w=3.3 l=0.15
X1993 t_Xdrv_Xf_2xa_X1_gn t_Xdrv_Xf_2xa_X1_gnb vss vss sky130_fd_pr__nfet_01v8_lvt w=1.8 l=0.15
X1994 t_Xdrv_Xf_2xa_X1_gn t_Xdrv_Xf_2xa_X1_gnb vdd vdd sky130_fd_pr__pfet_01v8 w=3.3 l=0.15
X1995 vdrv t_Xdrv_Xf_2xa_X1_gp t_Xdrv_Xf_2xa_X1_swp vss sky130_fd_pr__nfet_01v8_lvt w=3.8 l=0.15
X1996 t_Xdrv_Xf_2xa_X1_swp t_Xdrv_Xf_2xa_X1_gn vss vss sky130_fd_pr__nfet_01v8_lvt w=2.6 l=0.15
X1997 t_Xdrv_Xf_2xa_X1_swp pad_p vss sky130_fd_pr__res_high_po_2p85 l=3.75
X1998 vdrv t_Xdrv_Xf_2xa_X1_gn t_Xdrv_Xf_2xa_X1_swn vss sky130_fd_pr__nfet_01v8_lvt w=3.8 l=0.15
X1999 t_Xdrv_Xf_2xa_X1_swn t_Xdrv_Xf_2xa_X1_gp vss vss sky130_fd_pr__nfet_01v8_lvt w=2.6 l=0.15
X2000 t_Xdrv_Xf_2xa_X1_swn pad_n vss sky130_fd_pr__res_high_po_2p85 l=3.75
X2001 t_Xdrv_Xf_2xb_X0_gpb t_Xdrv_fp t_Xdrv_Xf_2xb_X0_Xgpb_mid vss sky130_fd_pr__nfet_01v8_lvt w=0.85 l=0.15
X2002 t_Xdrv_Xf_2xb_X0_Xgpb_mid f2 vss vss sky130_fd_pr__nfet_01v8_lvt w=0.85 l=0.15
X2003 t_Xdrv_Xf_2xb_X0_gpb t_Xdrv_fp vdd vdd sky130_fd_pr__pfet_01v8 w=2.2 l=0.15
X2004 t_Xdrv_Xf_2xb_X0_gpb f2 vdd vdd sky130_fd_pr__pfet_01v8 w=2.2 l=0.15
X2005 t_Xdrv_Xf_2xb_X0_gnb t_Xdrv_fn t_Xdrv_Xf_2xb_X0_Xgnb_mid vss sky130_fd_pr__nfet_01v8_lvt w=0.85 l=0.15
X2006 t_Xdrv_Xf_2xb_X0_Xgnb_mid f2 vss vss sky130_fd_pr__nfet_01v8_lvt w=0.85 l=0.15
X2007 t_Xdrv_Xf_2xb_X0_gnb t_Xdrv_fn vdd vdd sky130_fd_pr__pfet_01v8 w=2.2 l=0.15
X2008 t_Xdrv_Xf_2xb_X0_gnb f2 vdd vdd sky130_fd_pr__pfet_01v8 w=2.2 l=0.15
X2009 t_Xdrv_Xf_2xb_X0_gp t_Xdrv_Xf_2xb_X0_gpb vss vss sky130_fd_pr__nfet_01v8_lvt w=1.8 l=0.15
X2010 t_Xdrv_Xf_2xb_X0_gp t_Xdrv_Xf_2xb_X0_gpb vdd vdd sky130_fd_pr__pfet_01v8 w=3.3 l=0.15
X2011 t_Xdrv_Xf_2xb_X0_gn t_Xdrv_Xf_2xb_X0_gnb vss vss sky130_fd_pr__nfet_01v8_lvt w=1.8 l=0.15
X2012 t_Xdrv_Xf_2xb_X0_gn t_Xdrv_Xf_2xb_X0_gnb vdd vdd sky130_fd_pr__pfet_01v8 w=3.3 l=0.15
X2013 vdrv t_Xdrv_Xf_2xb_X0_gp t_Xdrv_Xf_2xb_X0_swp vss sky130_fd_pr__nfet_01v8_lvt w=3.8 l=0.15
X2014 t_Xdrv_Xf_2xb_X0_swp t_Xdrv_Xf_2xb_X0_gn vss vss sky130_fd_pr__nfet_01v8_lvt w=2.6 l=0.15
X2015 t_Xdrv_Xf_2xb_X0_swp pad_p vss sky130_fd_pr__res_high_po_2p85 l=3.75
X2016 vdrv t_Xdrv_Xf_2xb_X0_gn t_Xdrv_Xf_2xb_X0_swn vss sky130_fd_pr__nfet_01v8_lvt w=3.8 l=0.15
X2017 t_Xdrv_Xf_2xb_X0_swn t_Xdrv_Xf_2xb_X0_gp vss vss sky130_fd_pr__nfet_01v8_lvt w=2.6 l=0.15
X2018 t_Xdrv_Xf_2xb_X0_swn pad_n vss sky130_fd_pr__res_high_po_2p85 l=3.75
X2019 t_Xdrv_Xf_2xb_X1_gpb t_Xdrv_fp t_Xdrv_Xf_2xb_X1_Xgpb_mid vss sky130_fd_pr__nfet_01v8_lvt w=0.85 l=0.15
X2020 t_Xdrv_Xf_2xb_X1_Xgpb_mid f2 vss vss sky130_fd_pr__nfet_01v8_lvt w=0.85 l=0.15
X2021 t_Xdrv_Xf_2xb_X1_gpb t_Xdrv_fp vdd vdd sky130_fd_pr__pfet_01v8 w=2.2 l=0.15
X2022 t_Xdrv_Xf_2xb_X1_gpb f2 vdd vdd sky130_fd_pr__pfet_01v8 w=2.2 l=0.15
X2023 t_Xdrv_Xf_2xb_X1_gnb t_Xdrv_fn t_Xdrv_Xf_2xb_X1_Xgnb_mid vss sky130_fd_pr__nfet_01v8_lvt w=0.85 l=0.15
X2024 t_Xdrv_Xf_2xb_X1_Xgnb_mid f2 vss vss sky130_fd_pr__nfet_01v8_lvt w=0.85 l=0.15
X2025 t_Xdrv_Xf_2xb_X1_gnb t_Xdrv_fn vdd vdd sky130_fd_pr__pfet_01v8 w=2.2 l=0.15
X2026 t_Xdrv_Xf_2xb_X1_gnb f2 vdd vdd sky130_fd_pr__pfet_01v8 w=2.2 l=0.15
X2027 t_Xdrv_Xf_2xb_X1_gp t_Xdrv_Xf_2xb_X1_gpb vss vss sky130_fd_pr__nfet_01v8_lvt w=1.8 l=0.15
X2028 t_Xdrv_Xf_2xb_X1_gp t_Xdrv_Xf_2xb_X1_gpb vdd vdd sky130_fd_pr__pfet_01v8 w=3.3 l=0.15
X2029 t_Xdrv_Xf_2xb_X1_gn t_Xdrv_Xf_2xb_X1_gnb vss vss sky130_fd_pr__nfet_01v8_lvt w=1.8 l=0.15
X2030 t_Xdrv_Xf_2xb_X1_gn t_Xdrv_Xf_2xb_X1_gnb vdd vdd sky130_fd_pr__pfet_01v8 w=3.3 l=0.15
X2031 vdrv t_Xdrv_Xf_2xb_X1_gp t_Xdrv_Xf_2xb_X1_swp vss sky130_fd_pr__nfet_01v8_lvt w=3.8 l=0.15
X2032 t_Xdrv_Xf_2xb_X1_swp t_Xdrv_Xf_2xb_X1_gn vss vss sky130_fd_pr__nfet_01v8_lvt w=2.6 l=0.15
X2033 t_Xdrv_Xf_2xb_X1_swp pad_p vss sky130_fd_pr__res_high_po_2p85 l=3.75
X2034 vdrv t_Xdrv_Xf_2xb_X1_gn t_Xdrv_Xf_2xb_X1_swn vss sky130_fd_pr__nfet_01v8_lvt w=3.8 l=0.15
X2035 t_Xdrv_Xf_2xb_X1_swn t_Xdrv_Xf_2xb_X1_gp vss vss sky130_fd_pr__nfet_01v8_lvt w=2.6 l=0.15
X2036 t_Xdrv_Xf_2xb_X1_swn pad_n vss sky130_fd_pr__res_high_po_2p85 l=3.75
.ends serdes_tx_sst_top_pdk
