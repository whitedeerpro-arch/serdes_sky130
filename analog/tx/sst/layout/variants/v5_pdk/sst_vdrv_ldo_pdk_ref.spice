* Exact flattened LVS reference netlist for sst_vdrv_ldo_pdk
* Source subckt: sst_vdrv_ldo (v5_5g hardened analog/tx/sst/spice/*_5g.spice)
.subckt sst_vdrv_ldo_pdk vbg vdrv vdd vss
X1 t_vbp t_vbp vdd vdd sky130_fd_pr__pfet_01v8 w=20 l=0.35
X2 t_vbp vss vss sky130_fd_pr__res_high_po_1p41 l=80
X3 t_vbn_b t_vbp vdd vdd sky130_fd_pr__pfet_01v8 w=5 l=0.35
X4 t_vbn_b t_vbn_b vss vss sky130_fd_pr__nfet_01v8 w=4 l=0.5
X5 t_tail_b t_vbn_b vss vss sky130_fd_pr__nfet_01v8 w=8 l=0.5
X6 t_nd_b t_vbg_buf t_tail_b vss sky130_fd_pr__nfet_01v8 w=16 l=1
X7 t_vg_b vbg t_tail_b vss sky130_fd_pr__nfet_01v8 w=16 l=1
X8 t_nd_b t_nd_b vdd vdd sky130_fd_pr__pfet_01v8_lvt w=16 l=1
X9 t_vg_b t_nd_b vdd vdd sky130_fd_pr__pfet_01v8_lvt w=16 l=1
X10 t_vbg_buf t_vg_b vdd vdd sky130_fd_pr__pfet_01v8_lvt w=24 l=0.7
X11 t_vg_b t_cm_mid sky130_fd_pr__cap_mim_m3_1 w=10 l=10
X12 t_cm_mid t_vg_b sky130_fd_pr__cap_mim_m3_2 w=10 l=10
X13 t_cm_mid t_vbg_buf vss sky130_fd_pr__res_high_po_1p41 l=15
X14 t_vbg_buf t_vref vss sky130_fd_pr__res_high_po_1p41 l=63
X15 t_vref vss vss sky130_fd_pr__res_high_po_1p41 l=37
X16 t_tail t_vbp vdd vdd sky130_fd_pr__pfet_01v8 w=40 l=0.35
X17 t_nd t_vref t_tail vdd sky130_fd_pr__pfet_01v8 w=48 l=0.35
X18 t_vgate vdrv t_tail vdd sky130_fd_pr__pfet_01v8 w=48 l=0.35
X19 t_nd t_nd vss vss sky130_fd_pr__nfet_01v8 w=16 l=0.5
X20 t_vgate t_nd vss vss sky130_fd_pr__nfet_01v8 w=16 l=0.5
X21 t_vgate vss sky130_fd_pr__cap_mim_m3_1 w=17 l=17
X22 vss t_vgate sky130_fd_pr__cap_mim_m3_2 w=17 l=17
X23 vdd t_vgate vdrv vss sky130_fd_pr__nfet_01v8_lvt w=240 l=0.15
X24 vdrv vss vss sky130_fd_pr__res_high_po_1p41 l=5
X25 vdrv vss sky130_fd_pr__cap_mim_m3_1 w=24.8 l=24.8
X26 vss vdrv sky130_fd_pr__cap_mim_m3_2 w=24.8 l=24.8
X27 vdrv vss sky130_fd_pr__cap_mim_m3_1 w=24.8 l=24.8
X28 vss vdrv sky130_fd_pr__cap_mim_m3_2 w=24.8 l=24.8
X29 vdrv vss sky130_fd_pr__cap_mim_m3_1 w=24.8 l=24.8
X30 vss vdrv sky130_fd_pr__cap_mim_m3_2 w=24.8 l=24.8
X31 vdrv vss sky130_fd_pr__cap_mim_m3_1 w=24.8 l=24.8
X32 vss vdrv sky130_fd_pr__cap_mim_m3_2 w=24.8 l=24.8
X33 vdrv vss sky130_fd_pr__cap_mim_m3_1 w=24.8 l=24.8
X34 vss vdrv sky130_fd_pr__cap_mim_m3_2 w=24.8 l=24.8
X35 vdrv vss sky130_fd_pr__cap_mim_m3_1 w=24.8 l=24.8
X36 vss vdrv sky130_fd_pr__cap_mim_m3_2 w=24.8 l=24.8
.ends sst_vdrv_ldo_pdk
