* Quarter-Rate 4-Phase 1.25 GHz (5.0 Gb/s, 200 ps UI) Hardened Zero-Stacked-PMOS
* Fused 4:1 MUX + Low-Vdd N-over-N SST Line Driver (v5_5g).
* Backwards-compatible with 4.0 Gb/s (1.0 GHz, 250 ps UI).
* SKY130A 1.8 V, 400 mVpp diff into 100 ohm double-terminated load.
* Requires: sky130_primitives.spice (serdes_nfet, serdes_nfet_lvt, serdes_pfet).
*
* Key 5.0 Gb/s architectural hardening vs v4.3:
*   1. ZERO 2-stacked PMOS (sst_nor2) anywhere in the 5.0 Gb/s signal/clock path!
*   2. sst_pulsegen_4ph_5g: symmetric 2-stage NAND2(c_lead, c_trail) -> INV gives
*      first-order PMOS/NMOS delay cancellation across SS/SF -40C and FS/SS +85C,
*      eliminating the 115 ps pulse-width collapse/bloat (132..247 ps -> ~190..200 ps).
*   3. sst_mux4_predrv_5g & sst_mux4_predrv_en_5g: 6-stage all-NAND2+INV with fail-safe
*      (0, 0) Hi-Z default when all p_k=0 and delay-matched INV output stages driving
*      mp/mn and fp/fn (eliminates FS +85C FFE=3 spread and SS/SF -40C crowbar).
*   4. sst_slice_unit_5g: break-before-make local driver (high-skewed NAND2 wp=2.20/wn=0.80
*      + low-skewed INV wn=1.80/wp=2.80) fits exact 8.80 um slice pitch while cutting
*      gp/gn shoot-through overlap to ~0% across all 6 corners including SF/SS -40C.
*   5. sst_vdrv_ldo: preserved verbatim from v4.5_pdk (already 6/6 PVT + 200-MC signed off).

* --- Fast LVT-NMOS + min-L PMOS static CMOS cells ---
.subckt sst_inv a y vdd vss params: wn=1.5 wp=3.0 nfn=1 nfp=1
Xn y a vss vss serdes_nfet_lvt w={wn} l=0.15 nf={nfn}
Xp y a vdd vdd serdes_pfet w={wp} l=0.15 nf={nfp}
.ends sst_inv

.subckt sst_nand2 a b y vdd vss params: wn=3.0 wp=2.5 nfn=1 nfp=1
Xna y a mid vss serdes_nfet_lvt w={wn} l=0.15 nf={nfn}
Xnb mid b vss vss serdes_nfet_lvt w={wn} l=0.15 nf={nfn}
Xpa y a vdd vdd serdes_pfet w={wp} l=0.15 nf={nfp}
Xpb y b vdd vdd serdes_pfet w={wp} l=0.15 nf={nfp}
.ends sst_nand2

.subckt sst_tgate a b p pb vdd vss params: wn=2.5 wp=4.0 nfn=1 nfp=2
Xn a p b vss serdes_nfet_lvt w={wn} l=0.15 nf={nfn}
Xp a pb b vdd serdes_pfet w={wp} l=0.15 nf={nfp}
.ends sst_tgate

* Weak cross-coupled inverter pair for differential crossing alignment (zero DCD)
.subckt sst_cc_align ap an vdd vss params: wn=0.7 wp=1.8
X1 ap an vdd vss sst_inv wn={wn} wp={wp}
X2 an ap vdd vss sst_inv wn={wn} wp={wp}
.ends sst_cc_align

* --- 4-Phase 1.25 GHz Clock Buffer + Zero-Stacked-PMOS Symmetric 25%-Duty Pulse Generator ---
* Slot 0 [0..200ps]:   c0=1 (lead),   c270=1 (trail) -> pb0=NAND2(c0, c270)   -> p0=INV(pb0)
* Slot 1 [200..400ps]: c90=1 (lead),  c0=1 (trail)   -> pb1=NAND2(c90, c0)    -> p1=INV(pb1)
* Slot 2 [400..600ps]: c180=1 (lead), c90=1 (trail)  -> pb2=NAND2(c180, c90)  -> p2=INV(pb2)
* Slot 3 [600..800ps]: c270=1 (lead), c180=1 (trail) -> pb3=NAND2(c270, c180) -> p3=INV(pb3)
* First-order PMOS & NMOS delay cancellation holds PW in ~188..198 ps across all 6 corners!
.subckt sst_pulsegen_4ph_5g phi0 phi90 phi180 phi270 p0 p1 p2 p3 vdd vss
* Stage 1: input sharpening inverters + cross-coupled complementary alignment
Xi0  phi0   b0   vdd vss sst_inv wn=3.0 wp=8.4 nfn=1 nfp=3
Xi90 phi90  b90  vdd vss sst_inv wn=3.0 wp=8.4 nfn=1 nfp=3
Xi18 phi180 b180 vdd vss sst_inv wn=3.0 wp=8.4 nfn=1 nfp=3
Xi27 phi270 b270 vdd vss sst_inv wn=3.0 wp=8.4 nfn=1 nfp=3
Xcc1a b0  b180 vdd vss sst_cc_align wn=0.6 wp=1.6
Xcc1b b90 b270 vdd vss sst_cc_align wn=0.6 wp=1.6
* Stage 2: restore polarity & drive pulse NAND2s
Xj0  b0   c0   vdd vss sst_inv wn=5.0 wp=14.0 nfn=2 nfp=5
Xj90 b90  c90  vdd vss sst_inv wn=5.0 wp=14.0 nfn=2 nfp=5
Xj18 b180 c180 vdd vss sst_inv wn=5.0 wp=14.0 nfn=2 nfp=5
Xj27 b270 c270 vdd vss sst_inv wn=5.0 wp=14.0 nfn=2 nfp=5
Xcc2a c0  c180 vdd vss sst_cc_align wn=0.8 wp=2.2
Xcc2b c90 c270 vdd vss sst_cc_align wn=0.8 wp=2.2
* Stage 3a: Zero-stacked-PMOS active-LOW 25% pulse NAND2 (a=leading clock, b=trailing clock)
Xpb0 c0   c270 pb0 vdd vss sst_nand2 wn=5.6 wp=10.4 nfn=2 nfp=4
Xpb1 c90  c0   pb1 vdd vss sst_nand2 wn=5.6 wp=10.4 nfn=2 nfp=4
Xpb2 c180 c90  pb2 vdd vss sst_nand2 wn=5.6 wp=10.4 nfn=2 nfp=4
Xpb3 c270 c180 pb3 vdd vss sst_nand2 wn=5.6 wp=10.4 nfn=2 nfp=4
* Stage 3b: Strong active-HIGH pulse drivers (zero stacked PMOS, crisp edges into 28 fF + Xmux_m/f)
Xp0  pb0 p0 vdd vss sst_inv wn=6.6 wp=15.9 nfn=3 nfp=6
Xp1  pb1 p1 vdd vss sst_inv wn=6.6 wp=15.9 nfn=3 nfp=6
Xp2  pb2 p2 vdd vss sst_inv wn=6.6 wp=15.9 nfn=3 nfp=6
Xp3  pb3 p3 vdd vss sst_inv wn=6.6 wp=15.9 nfn=3 nfp=6
.ends sst_pulsegen_4ph_5g

* --- Differential Quarter-Rate 6-Stage All-NAND2+INV 4:1 MUX + Pre-Driver (Main, v5_5g) ---
* Positive leg takes d0..d3 -> 6 inversions -> out_p = OR_k(p_k & d_k) (fail-safe 0 when all p_k=0!).
* Negative leg takes db0..db3 -> 6 inversions -> out_n = OR_k(p_k & db_k).
* Zero 2-stacked PMOS anywhere; swapped-input parallel Stage 2 & Stage 4 give 0.0 ps input-order skew!
.subckt sst_mux4_predrv_5g d0 d1 d2 d3 db0 db1 db2 db3 p0 p1 p2 p3 out_p out_n vdd vss
* Positive leg (out_p = d_k)
Xg0p p0 d0 g0p vdd vss sst_nand2 wn=2.4 wp=5.4 nfn=1 nfp=2
Xg1p p1 d1 g1p vdd vss sst_nand2 wn=2.4 wp=5.4 nfn=1 nfp=2
Xg2p p2 d2 g2p vdd vss sst_nand2 wn=2.4 wp=5.4 nfn=1 nfp=2
Xg3p p3 d3 g3p vdd vss sst_nand2 wn=2.4 wp=5.4 nfn=1 nfp=2
Xepa g0p g2p ep vdd vss sst_nand2 wn=1.8 wp=3.6 nfn=1 nfp=2
Xepb g2p g0p ep vdd vss sst_nand2 wn=1.8 wp=3.6 nfn=1 nfp=2
Xopa g1p g3p op vdd vss sst_nand2 wn=1.8 wp=3.6 nfn=1 nfp=2
Xopb g3p g1p op vdd vss sst_nand2 wn=1.8 wp=3.6 nfn=1 nfp=2
Xebp ep ep_b vdd vss sst_inv wn=2.4 wp=7.2 nfn=1 nfp=3
Xobp op op_b vdd vss sst_inv wn=2.4 wp=7.2 nfn=1 nfp=3
Xmp1a ep_b op_b pre_p vdd vss sst_nand2 wn=2.8 wp=5.2 nfn=1 nfp=2
Xmp1b op_b ep_b pre_p vdd vss sst_nand2 wn=2.8 wp=5.2 nfn=1 nfp=2
Xmbp pre_p mid_p vdd vss sst_inv wn=6.0 wp=13.5 nfn=2 nfp=5
Xmp2 mid_p out_p vdd vss sst_inv wn=12.5 wp=39.0 nfn=5 nfp=13
* Negative leg (out_n = db_k)
Xg0n p0 db0 g0n vdd vss sst_nand2 wn=2.4 wp=5.4 nfn=1 nfp=2
Xg1n p1 db1 g1n vdd vss sst_nand2 wn=2.4 wp=5.4 nfn=1 nfp=2
Xg2n p2 db2 g2n vdd vss sst_nand2 wn=2.4 wp=5.4 nfn=1 nfp=2
Xg3n p3 db3 g3n vdd vss sst_nand2 wn=2.4 wp=5.4 nfn=1 nfp=2
Xena g0n g2n en_ vdd vss sst_nand2 wn=1.8 wp=3.6 nfn=1 nfp=2
Xenb g2n g0n en_ vdd vss sst_nand2 wn=1.8 wp=3.6 nfn=1 nfp=2
Xona g1n g3n on_ vdd vss sst_nand2 wn=1.8 wp=3.6 nfn=1 nfp=2
Xonb g3n g1n on_ vdd vss sst_nand2 wn=1.8 wp=3.6 nfn=1 nfp=2
Xebn en_ en_b vdd vss sst_inv wn=2.4 wp=7.2 nfn=1 nfp=3
Xobn on_ on_b vdd vss sst_inv wn=2.4 wp=7.2 nfn=1 nfp=3
Xmn1a en_b on_b pre_n vdd vss sst_nand2 wn=2.8 wp=5.2 nfn=1 nfp=2
Xmn1b on_b en_b pre_n vdd vss sst_nand2 wn=2.8 wp=5.2 nfn=1 nfp=2
Xmbn pre_n mid_n vdd vss sst_inv wn=6.0 wp=13.5 nfn=2 nfp=5
Xmn2 mid_n out_n vdd vss sst_inv wn=12.5 wp=39.0 nfn=5 nfp=13
.ends sst_mux4_predrv_5g

* --- Enable-Gated Post-Cursor FFE 6-Stage All-NAND2+INV 4:1 MUX + Pre-Driver (v5_5g) ---
* Exact 6-stage real-CPEX delay match to Main (0.75x Stages 1-4 + strengthened Stage 5-6 -> fp-mp ~ 0 ps!).
* en=0 -> mid_p=mid_n=1 -> out_p=out_n=0 (zero dynamic power on fp/fn!); pure INV output Stage 6!
.subckt sst_mux4_predrv_en_5g d0 d1 d2 d3 db0 db1 db2 db3 p0 p1 p2 p3 en out_p out_n vdd vss
* Positive leg (out_p = d_k & en)
Xg0p p0 d0 g0p vdd vss sst_nand2 wn=1.8 wp=4.2 nfn=1 nfp=2
Xg1p p1 d1 g1p vdd vss sst_nand2 wn=1.8 wp=4.2 nfn=1 nfp=2
Xg2p p2 d2 g2p vdd vss sst_nand2 wn=1.8 wp=4.2 nfn=1 nfp=2
Xg3p p3 d3 g3p vdd vss sst_nand2 wn=1.8 wp=4.2 nfn=1 nfp=2
Xepa g0p g2p ep vdd vss sst_nand2 wn=1.4 wp=2.8 nfn=1 nfp=1
Xepb g2p g0p ep vdd vss sst_nand2 wn=1.4 wp=2.8 nfn=1 nfp=1
Xopa g1p g3p op vdd vss sst_nand2 wn=1.4 wp=2.8 nfn=1 nfp=1
Xopb g3p g1p op vdd vss sst_nand2 wn=1.4 wp=2.8 nfn=1 nfp=1
Xebp ep ep_b vdd vss sst_inv wn=1.8 wp=5.4 nfn=1 nfp=2
Xobp op op_b vdd vss sst_inv wn=1.8 wp=5.4 nfn=1 nfp=2
Xmp1a ep_b op_b pre_p vdd vss sst_nand2 wn=2.1 wp=3.9 nfn=1 nfp=2
Xmp1b op_b ep_b pre_p vdd vss sst_nand2 wn=2.1 wp=3.9 nfn=1 nfp=2
Xmbp pre_p en mid_p vdd vss sst_nand2 wn=8.4 wp=9.6 nfn=3 nfp=4
Xmp2 mid_p out_p vdd vss sst_inv wn=5.6 wp=19.6 nfn=2 nfp=7
* Negative leg (out_n = db_k & en)
Xg0n p0 db0 g0n vdd vss sst_nand2 wn=1.8 wp=4.2 nfn=1 nfp=2
Xg1n p1 db1 g1n vdd vss sst_nand2 wn=1.8 wp=4.2 nfn=1 nfp=2
Xg2n p2 db2 g2n vdd vss sst_nand2 wn=1.8 wp=4.2 nfn=1 nfp=2
Xg3n p3 db3 g3n vdd vss sst_nand2 wn=1.8 wp=4.2 nfn=1 nfp=2
Xena g0n g2n en_ vdd vss sst_nand2 wn=1.4 wp=2.8 nfn=1 nfp=1
Xenb g2n g0n en_ vdd vss sst_nand2 wn=1.4 wp=2.8 nfn=1 nfp=1
Xona g1n g3n on_ vdd vss sst_nand2 wn=1.4 wp=2.8 nfn=1 nfp=1
Xonb g3n g1n on_ vdd vss sst_nand2 wn=1.4 wp=2.8 nfn=1 nfp=1
Xebn en_ en_b vdd vss sst_inv wn=1.8 wp=5.4 nfn=1 nfp=2
Xobn on_ on_b vdd vss sst_inv wn=1.8 wp=5.4 nfn=1 nfp=2
Xmn1a en_b on_b pre_n vdd vss sst_nand2 wn=2.1 wp=3.9 nfn=1 nfp=2
Xmn1b on_b en_b pre_n vdd vss sst_nand2 wn=2.1 wp=3.9 nfn=1 nfp=2
Xmbn pre_n en mid_n vdd vss sst_nand2 wn=8.4 wp=9.6 nfn=3 nfp=4
Xmn2 mid_n out_n vdd vss sst_inv wn=5.6 wp=19.6 nfn=2 nfp=7
.ends sst_mux4_predrv_en_5g

* --- N-over-N Differential SST Unit Slice (v5_5g, break-before-make local driver) ---
* High-skewed NAND2 (wn=0.85, wp=2.20) + balanced BBM INV (wn=1.80, wp=3.30): zero Hi-Z shelf
* on SS/FS+85C and zero crowbar on SS/SF -40C inside exact 8.80 um slice pitch.
.subckt sst_slice_unit_5g din_p din_n en pad_p pad_n vdrv vdd vss
+ params: wpu=3.8 wpd=2.6 lres=3.75
Xgpb din_p en gpb vdd vss sst_nand2 wn=0.85 wp=2.20 nfn=1 nfp=1
Xgnb din_n en gnb vdd vss sst_nand2 wn=0.85 wp=2.20 nfn=1 nfp=1
Xgp  gpb   gp vdd vss sst_inv wn=1.80 wp=3.30 nfn=2 nfp=2
Xgn  gnb   gn vdd vss sst_inv wn=1.80 wp=3.30 nfn=2 nfp=2
* Positive leg (pad_p)
Xpup vdrv gp swp vss serdes_nfet_lvt w={wpu} l=0.15 nf=2
Xpdp swp  gn vss vss serdes_nfet_lvt w={wpd} l=0.15 nf=1
Xrp  swp  pad_p vss sky130_fd_pr__res_high_po_2p85 l={lres}
* Negative leg (pad_n)
Xpun vdrv gn swn vss serdes_nfet_lvt w={wpu} l=0.15 nf=2
Xpdn swn  gp vss vss serdes_nfet_lvt w={wpd} l=0.15 nf=1
Xrn  swn  pad_n vss sky130_fd_pr__res_high_po_2p85 l={lres}
.ends sst_slice_unit_5g

.subckt sst_bank_2x_5g din_p din_n en pad_p pad_n vdrv vdd vss params: wpu=3.8 wpd=2.6 lres=3.75
X0 din_p din_n en pad_p pad_n vdrv vdd vss sst_slice_unit_5g wpu={wpu} wpd={wpd} lres={lres}
X1 din_p din_n en pad_p pad_n vdrv vdd vss sst_slice_unit_5g wpu={wpu} wpd={wpd} lres={lres}
.ends sst_bank_2x_5g

.subckt sst_bank_4x_5g din_p din_n en pad_p pad_n vdrv vdd vss params: wpu=3.8 wpd=2.6 lres=3.75
X0 din_p din_n en pad_p pad_n vdrv vdd vss sst_bank_2x_5g wpu={wpu} wpd={wpd} lres={lres}
X1 din_p din_n en pad_p pad_n vdrv vdd vss sst_bank_2x_5g wpu={wpu} wpd={wpd} lres={lres}
.ends sst_bank_4x_5g

.subckt sst_bank_8x_5g din_p din_n en pad_p pad_n vdrv vdd vss params: wpu=3.8 wpd=2.6 lres=3.75
X0 din_p din_n en pad_p pad_n vdrv vdd vss sst_bank_4x_5g wpu={wpu} wpd={wpd} lres={lres}
X1 din_p din_n en pad_p pad_n vdrv vdd vss sst_bank_4x_5g wpu={wpu} wpd={wpd} lres={lres}
.ends sst_bank_8x_5g

* Local LVT-PMOS adapter (matches v4.5 sst_vdrv_ldo verbatim)
.subckt sst_pfet_lvt d g s b params: w=4 l=0.35 nf=1
Xmos d g s b sky130_fd_pr__pfet_01v8_lvt w={w} l={l} nf={nf}
+ ad={floor((nf+1)/2)*(w/nf)*0.29}
+ as={floor((nf+2)/2)*(w/nf)*0.29}
+ pd={2*floor((nf+1)/2)*(w/nf+0.29)}
+ ps={2*floor((nf+2)/2)*(w/nf+0.29)}
.ends sst_pfet_lvt

* --- Compact On-Chip V_drv Sub-Regulator (identical to v4.5_pdk) ---
.subckt sst_vdrv_ldo vbg vdrv vdd vss params: ltop=63.0 lbot=37.0
Xbp_ref vbp vbp vdd vdd serdes_pfet w=20 l=0.35 nf=4
Xrbias  vbp vss vss sky130_fd_pr__res_high_po_1p41 l=80.0
Xb_pmir vbn_b   vbp     vdd    vdd serdes_pfet  w=5  l=0.35 nf=1
Xb_nref vbn_b   vbn_b   vss    vss serdes_nfet  w=4  l=0.50 nf=2
Xb_tail tail_b  vbn_b   vss    vss serdes_nfet  w=8  l=0.50 nf=4
Xbn_fb  nd_b    vbg_buf tail_b vss serdes_nfet  w=16 l=1.00 nf=4
Xbn_ref vg_b    vbg     tail_b vss serdes_nfet  w=16 l=1.00 nf=4
Xbp1    nd_b    nd_b    vdd    vdd sst_pfet_lvt w=16 l=1.00 nf=4
Xbp2    vg_b    nd_b    vdd    vdd sst_pfet_lvt w=16 l=1.00 nf=4
Xbo_p   vbg_buf vg_b    vdd    vdd sst_pfet_lvt w=24 l=0.70 nf=4
Xcm_b1  vg_b    cm_mid  sky130_fd_pr__cap_mim_m3_1 w=10.0 l=10.0
Xcm_b2  cm_mid  vg_b    sky130_fd_pr__cap_mim_m3_2 w=10.0 l=10.0
Xrz_b   cm_mid  vbg_buf vss sky130_fd_pr__res_high_po_1p41 l=15.0
Xrtop vbg_buf vref vss sky130_fd_pr__res_high_po_1p41 l={ltop}
Xrbot vref    vss  vss sky130_fd_pr__res_high_po_1p41 l={lbot}
Xtail tail vbp vdd vdd serdes_pfet w=40 l=0.35 nf=8
Xref nd    vref tail vdd serdes_pfet w=48 l=0.35 nf=8
Xfb  vgate vdrv tail vdd serdes_pfet w=48 l=0.35 nf=8
Xm1  nd    nd   vss  vss serdes_nfet w=16 l=0.50 nf=4
Xm2  vgate nd   vss  vss serdes_nfet w=16 l=0.50 nf=4
Xcg1 vgate vss sky130_fd_pr__cap_mim_m3_1 w=17.0 l=17.0
Xcg2 vss vgate sky130_fd_pr__cap_mim_m3_2 w=17.0 l=17.0
Xpass vdd vgate vdrv vss serdes_nfet_lvt w=240 l=0.15 nf=32
Xrbleed vdrv vss vss sky130_fd_pr__res_high_po_1p41 l=5.0
Xcd0a vdrv vss sky130_fd_pr__cap_mim_m3_1 w=24.8 l=24.8
Xcd0b vss vdrv sky130_fd_pr__cap_mim_m3_2 w=24.8 l=24.8
Xcd1a vdrv vss sky130_fd_pr__cap_mim_m3_1 w=24.8 l=24.8
Xcd1b vss vdrv sky130_fd_pr__cap_mim_m3_2 w=24.8 l=24.8
Xcd2a vdrv vss sky130_fd_pr__cap_mim_m3_1 w=24.8 l=24.8
Xcd2b vss vdrv sky130_fd_pr__cap_mim_m3_2 w=24.8 l=24.8
Xcd3a vdrv vss sky130_fd_pr__cap_mim_m3_1 w=24.8 l=24.8
Xcd3b vss vdrv sky130_fd_pr__cap_mim_m3_2 w=24.8 l=24.8
Xcd4a vdrv vss sky130_fd_pr__cap_mim_m3_1 w=24.8 l=24.8
Xcd4b vss vdrv sky130_fd_pr__cap_mim_m3_2 w=24.8 l=24.8
Xcd5a vdrv vss sky130_fd_pr__cap_mim_m3_1 w=24.8 l=24.8
Xcd5b vss vdrv sky130_fd_pr__cap_mim_m3_2 w=24.8 l=24.8
.ends sst_vdrv_ldo

* --- Complete Quarter-Rate 4:1 Fused N-over-N SST Line Driver (v5_5g) ---
.subckt serdes_tx_sst_driver_5g
+ d0 d1 d2 d3 db0 db1 db2 db3
+ phi0 phi90 phi180 phi270
+ m0 m1 m2 m3 m4 f0 f1 f2 ffe_en
+ vbg pad_p pad_n vdrv vdd vss
+ params: wpu=3.8 wpd=2.6 lres=3.75 ltop=63.0 lbot=37.0
Xldo vbg vdrv vdd vss sst_vdrv_ldo ltop={ltop} lbot={lbot}
Xpg phi0 phi90 phi180 phi270 p0 p1 p2 p3 vdd vss sst_pulsegen_4ph_5g
Xmux_m d0 d1 d2 d3 db0 db1 db2 db3 p0 p1 p2 p3 mp mn vdd vss sst_mux4_predrv_5g
Xmux_f db3 db0 db1 db2 d3 d0 d1 d2 p0 p1 p2 p3 ffe_en fp fn vdd vss sst_mux4_predrv_en_5g
Xm_1x  mp mn m0 pad_p pad_n vdrv vdd vss sst_slice_unit_5g wpu={wpu} wpd={wpd} lres={lres}
Xm_2x  mp mn m1 pad_p pad_n vdrv vdd vss sst_bank_2x_5g    wpu={wpu} wpd={wpd} lres={lres}
Xm_4x  mp mn m2 pad_p pad_n vdrv vdd vss sst_bank_4x_5g    wpu={wpu} wpd={wpd} lres={lres}
Xm_8xa mp mn m3 pad_p pad_n vdrv vdd vss sst_bank_8x_5g    wpu={wpu} wpd={wpd} lres={lres}
Xm_8xb mp mn m4 pad_p pad_n vdrv vdd vss sst_bank_8x_5g    wpu={wpu} wpd={wpd} lres={lres}
Xf_1x  fp fn f0 pad_p pad_n vdrv vdd vss sst_slice_unit_5g wpu={wpu} wpd={wpd} lres={lres}
Xf_2xa fp fn f1 pad_p pad_n vdrv vdd vss sst_bank_2x_5g    wpu={wpu} wpd={wpd} lres={lres}
Xf_2xb fp fn f2 pad_p pad_n vdrv vdd vss sst_bank_2x_5g    wpu={wpu} wpd={wpd} lres={lres}
.ends serdes_tx_sst_driver_5g
