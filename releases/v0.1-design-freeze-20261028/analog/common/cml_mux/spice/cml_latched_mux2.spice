* Final-rank retiming: A tracks while B is selected; B tracks while A is selected.
* Selected input is held; clock phase must still allow upstream data setup.
* Separate physical select followers for each latch and mux preserve local clock drive.
* Design v0.1: final A/B latch current x2 and load R/2, as the measured
* final_latch_current_2x candidate. Set both scales to 1 for the old baseline.
.subckt serdes_cml_latched_mux2 ap an bp bn sp sn qp qn vbias vdd vss
+ params: wdata=40 wselect=64 wtail=12 rload=400 whold=80 wsf=40 wsf_sink=4 latch_tail_scale=2 latch_load_scale=0.5
Xfpa vdd sp sap vss serdes_nfet_lvt w={wsf} nf=4
Xfna vdd sn san vss serdes_nfet_lvt w={wsf} nf=4
Xspa sap vbias vss vss serdes_nfet w={wsf_sink} l=0.5
Xsna san vbias vss vss serdes_nfet w={wsf_sink} l=0.5
Xfpb vdd sp sbp vss serdes_nfet_lvt w={wsf} nf=4
Xfnb vdd sn sbn vss serdes_nfet_lvt w={wsf} nf=4
Xspb sbp vbias vss vss serdes_nfet w={wsf_sink} l=0.5
Xsnb sbn vbias vss vss serdes_nfet w={wsf_sink} l=0.5
Xla ap an ahp ahn sap san vbias vdd vss serdes_cml_data_latch
+ wdata={wdata} whold={whold} wclock={wselect} wtail={latch_tail_scale*wtail} rload={latch_load_scale*rload}
Xlb bp bn bhp bhn sbn sbp vbias vdd vss serdes_cml_data_latch
+ wdata={wdata} whold={whold} wclock={wselect} wtail={latch_tail_scale*wtail} rload={latch_load_scale*rload}
Xm ahp ahn bhp bhn sp sn qp qn vbias vdd vss serdes_cml_mux2
+ wdata={wdata} wselect={wselect} wtail={wtail} rload={rload} wsf={wsf} wsf_sink={wsf_sink}
.ends serdes_cml_latched_mux2
