* CML data selector with direct complementary 0..1.8 V CMOS select gates.
* Same shared tail, data devices and loads as serdes_cml_mux2; no clock followers.
* sp high selects B; sn high selects A. Supply-referenced CMOS inputs required.
* Ideal-clock test variant; physical clock drive and extracted coupling not verified.
.subckt serdes_cml_mux2_cmos_select ap an bp bn sp sn qp qn vbias vdd vss
+ params: wdata=20 wselect=64 wtail=12 rload=400
Rp vdd qp {rload}
Rn vdd qn {rload}
Xap qn ap ta vss serdes_nfet_lvt w={wdata} nf=4
Xan qp an ta vss serdes_nfet_lvt w={wdata} nf=4
Xbp qn bp tb vss serdes_nfet_lvt w={wdata} nf=4
Xbn qp bn tb vss serdes_nfet_lvt w={wdata} nf=4
Xsa ta sn tail vss serdes_nfet_lvt w={wselect} nf=4
Xsb tb sp tail vss serdes_nfet_lvt w={wselect} nf=4
Xtail tail vbias vss vss serdes_nfet w={wtail} l=0.5 nf=4
.ends serdes_cml_mux2_cmos_select
