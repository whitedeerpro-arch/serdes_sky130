* Thin SKY130 MOS adapters for exploratory schematic simulations.
* w and l are micrometres, w is TOTAL width, nf is finger count.
* Diffusion area/perimeter approximate alternating shared fingers at 0.29 um.
* These geometry estimates are not a substitute for layout extraction.
.subckt serdes_nfet d g s b params: w=1 l=0.15 nf=1
Xmos d g s b sky130_fd_pr__nfet_01v8 w={w} l={l} nf={nf}
+ ad={floor((nf+1)/2)*(w/nf)*0.29}
+ as={floor((nf+2)/2)*(w/nf)*0.29}
+ pd={2*floor((nf+1)/2)*(w/nf+0.29)}
+ ps={2*floor((nf+2)/2)*(w/nf+0.29)}
.ends serdes_nfet

.subckt serdes_nfet_lvt d g s b params: w=1 l=0.15 nf=1
Xmos d g s b sky130_fd_pr__nfet_01v8_lvt w={w} l={l} nf={nf}
+ ad={floor((nf+1)/2)*(w/nf)*0.29}
+ as={floor((nf+2)/2)*(w/nf)*0.29}
+ pd={2*floor((nf+1)/2)*(w/nf+0.29)}
+ ps={2*floor((nf+2)/2)*(w/nf+0.29)}
.ends serdes_nfet_lvt

.subckt serdes_pfet d g s b params: w=3 l=0.15 nf=1
Xmos d g s b sky130_fd_pr__pfet_01v8 w={w} l={l} nf={nf}
+ ad={floor((nf+1)/2)*(w/nf)*0.29}
+ as={floor((nf+2)/2)*(w/nf)*0.29}
+ pd={2*floor((nf+1)/2)*(w/nf+0.29)}
+ ps={2*floor((nf+2)/2)*(w/nf+0.29)}
.ends serdes_pfet
