* Baseline series-switch charge pump; actual SKY130 MOS, external bias references.
* UP/DN active high. Positive output current means charge delivered to the filter.
* Long-channel current mirrors; no ideal current source inside the DUT.
.subckt pll_cp up dn out vbn vbp vdd vss
+ params: wn=5 wp=20 lmirror=1 wsn=2 wsp=4 up_wn=0.5 up_wp=2 up_ln=0.88
Xupn up_b up vss vss serdes_nfet w={up_wn} l={up_ln}
Xupp up_b up vdd vdd serdes_pfet w={up_wp}
Xdn1 dn dn_b vdd vss serdes_cmos_inv wn=1 wp=2
Xdn2 dn_b dn_on vdd vss serdes_cmos_inv wn=1 wp=2
Xp ps vbp vdd vdd serdes_pfet w={wp} l={lmirror} nf=4
Xps out up_b ps vdd serdes_pfet w={wsp}
Xns out dn_on ns vss serdes_nfet w={wsn}
Xn ns vbn vss vss serdes_nfet w={wn} l={lmirror}
.ends pll_cp
