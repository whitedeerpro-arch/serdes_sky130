* External-data version of the verified CML master/slave toggle cell.
* Falling input edge captures the master state into the slave.
.subckt pll_cml_dff dp dn clkp clkn qp qn vbias vdd vss
+ params: wsf=40 wsf_sink=4 wdata=20 whold=20 wclock=24 wtail=12 rload=600
Xfp vdd clkp ckp vss serdes_nfet_lvt w={wsf} nf=4
Xfn vdd clkn ckn vss serdes_nfet_lvt w={wsf} nf=4
Xsp ckp vbias vss vss serdes_nfet w={wsf_sink} l=0.5
Xsn ckn vbias vss vss serdes_nfet w={wsf_sink} l=0.5
Xmaster dp dn mp mn ckp ckn vbias vdd vss pll_cml_latch
+ wdata={wdata} whold={whold} wclock={wclock} wtail={wtail} rload={rload}
Xslave mp mn qp qn ckn ckp vbias vdd vss pll_cml_latch
+ wdata={wdata} whold={whold} wclock={wclock} wtail={wtail} rload={rload}
.ends pll_cml_dff
