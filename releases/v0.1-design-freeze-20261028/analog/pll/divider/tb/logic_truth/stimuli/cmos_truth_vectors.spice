* 256 legal digital input vectors; 4 ns settle per code/state pair, 40 ps edges.
* Index i: configuration=floor(i/16), state=i mod 16. Sample at i*4 ns+3.5 ns.
.subckt stim_cmos_truth q0 q1 q2 q3 m0 m1 m2 m3 vss params: supply=1.8
Vq0 q0 vss PWL(0 0
+ 4.00n 0 4.04n {supply}
+ 8.00n {supply} 8.04n 0
+ 12.00n 0 12.04n {supply}
+ 16.00n {supply} 16.04n 0
+ 20.00n 0 20.04n {supply}
+ 24.00n {supply} 24.04n 0
+ 28.00n 0 28.04n {supply}
+ 32.00n {supply} 32.04n 0
+ 36.00n 0 36.04n {supply}
+ 40.00n {supply} 40.04n 0
+ 44.00n 0 44.04n {supply}
+ 48.00n {supply} 48.04n 0
+ 52.00n 0 52.04n {supply}
+ 56.00n {supply} 56.04n 0
+ 60.00n 0 60.04n {supply}
+ 64.00n {supply} 64.04n 0
+ 68.00n 0 68.04n {supply}
+ 72.00n {supply} 72.04n 0
+ 76.00n 0 76.04n {supply}
+ 80.00n {supply} 80.04n 0
+ 84.00n 0 84.04n {supply}
+ 88.00n {supply} 88.04n 0
+ 92.00n 0 92.04n {supply}
+ 96.00n {supply} 96.04n 0
+ 100.00n 0 100.04n {supply}
+ 104.00n {supply} 104.04n 0
+ 108.00n 0 108.04n {supply}
+ 112.00n {supply} 112.04n 0
+ 116.00n 0 116.04n {supply}
+ 120.00n {supply} 120.04n 0
+ 124.00n 0 124.04n {supply}
+ 128.00n {supply} 128.04n 0
+ 132.00n 0 132.04n {supply}
+ 136.00n {supply} 136.04n 0
+ 140.00n 0 140.04n {supply}
+ 144.00n {supply} 144.04n 0
+ 148.00n 0 148.04n {supply}
+ 152.00n {supply} 152.04n 0
+ 156.00n 0 156.04n {supply}
+ 160.00n {supply} 160.04n 0
+ 164.00n 0 164.04n {supply}
+ 168.00n {supply} 168.04n 0
+ 172.00n 0 172.04n {supply}
+ 176.00n {supply} 176.04n 0
+ 180.00n 0 180.04n {supply}
+ 184.00n {supply} 184.04n 0
+ 188.00n 0 188.04n {supply}
+ 192.00n {supply} 192.04n 0
+ 196.00n 0 196.04n {supply}
+ 200.00n {supply} 200.04n 0
+ 204.00n 0 204.04n {supply}
+ 208.00n {supply} 208.04n 0
+ 212.00n 0 212.04n {supply}
+ 216.00n {supply} 216.04n 0
+ 220.00n 0 220.04n {supply}
+ 224.00n {supply} 224.04n 0
+ 228.00n 0 228.04n {supply}
+ 232.00n {supply} 232.04n 0
+ 236.00n 0 236.04n {supply}
+ 240.00n {supply} 240.04n 0
+ 244.00n 0 244.04n {supply}
+ 248.00n {supply} 248.04n 0
+ 252.00n 0 252.04n {supply}
+ 256.00n {supply} 256.04n 0
+ 260.00n 0 260.04n {supply}
+ 264.00n {supply} 264.04n 0
+ 268.00n 0 268.04n {supply}
+ 272.00n {supply} 272.04n 0
+ 276.00n 0 276.04n {supply}
+ 280.00n {supply} 280.04n 0
+ 284.00n 0 284.04n {supply}
+ 288.00n {supply} 288.04n 0
+ 292.00n 0 292.04n {supply}
+ 296.00n {supply} 296.04n 0
+ 300.00n 0 300.04n {supply}
+ 304.00n {supply} 304.04n 0
+ 308.00n 0 308.04n {supply}
+ 312.00n {supply} 312.04n 0
+ 316.00n 0 316.04n {supply}
+ 320.00n {supply} 320.04n 0
+ 324.00n 0 324.04n {supply}
+ 328.00n {supply} 328.04n 0
+ 332.00n 0 332.04n {supply}
+ 336.00n {supply} 336.04n 0
+ 340.00n 0 340.04n {supply}
+ 344.00n {supply} 344.04n 0
+ 348.00n 0 348.04n {supply}
+ 352.00n {supply} 352.04n 0
+ 356.00n 0 356.04n {supply}
+ 360.00n {supply} 360.04n 0
+ 364.00n 0 364.04n {supply}
+ 368.00n {supply} 368.04n 0
+ 372.00n 0 372.04n {supply}
+ 376.00n {supply} 376.04n 0
+ 380.00n 0 380.04n {supply}
+ 384.00n {supply} 384.04n 0
+ 388.00n 0 388.04n {supply}
+ 392.00n {supply} 392.04n 0
+ 396.00n 0 396.04n {supply}
+ 400.00n {supply} 400.04n 0
+ 404.00n 0 404.04n {supply}
+ 408.00n {supply} 408.04n 0
+ 412.00n 0 412.04n {supply}
+ 416.00n {supply} 416.04n 0
+ 420.00n 0 420.04n {supply}
+ 424.00n {supply} 424.04n 0
+ 428.00n 0 428.04n {supply}
+ 432.00n {supply} 432.04n 0
+ 436.00n 0 436.04n {supply}
+ 440.00n {supply} 440.04n 0
+ 444.00n 0 444.04n {supply}
+ 448.00n {supply} 448.04n 0
+ 452.00n 0 452.04n {supply}
+ 456.00n {supply} 456.04n 0
+ 460.00n 0 460.04n {supply}
+ 464.00n {supply} 464.04n 0
+ 468.00n 0 468.04n {supply}
+ 472.00n {supply} 472.04n 0
+ 476.00n 0 476.04n {supply}
+ 480.00n {supply} 480.04n 0
+ 484.00n 0 484.04n {supply}
+ 488.00n {supply} 488.04n 0
+ 492.00n 0 492.04n {supply}
+ 496.00n {supply} 496.04n 0
+ 500.00n 0 500.04n {supply}
+ 504.00n {supply} 504.04n 0
+ 508.00n 0 508.04n {supply}
+ 512.00n {supply} 512.04n 0
+ 516.00n 0 516.04n {supply}
+ 520.00n {supply} 520.04n 0
+ 524.00n 0 524.04n {supply}
+ 528.00n {supply} 528.04n 0
+ 532.00n 0 532.04n {supply}
+ 536.00n {supply} 536.04n 0
+ 540.00n 0 540.04n {supply}
+ 544.00n {supply} 544.04n 0
+ 548.00n 0 548.04n {supply}
+ 552.00n {supply} 552.04n 0
+ 556.00n 0 556.04n {supply}
+ 560.00n {supply} 560.04n 0
+ 564.00n 0 564.04n {supply}
+ 568.00n {supply} 568.04n 0
+ 572.00n 0 572.04n {supply}
+ 576.00n {supply} 576.04n 0
+ 580.00n 0 580.04n {supply}
+ 584.00n {supply} 584.04n 0
+ 588.00n 0 588.04n {supply}
+ 592.00n {supply} 592.04n 0
+ 596.00n 0 596.04n {supply}
+ 600.00n {supply} 600.04n 0
+ 604.00n 0 604.04n {supply}
+ 608.00n {supply} 608.04n 0
+ 612.00n 0 612.04n {supply}
+ 616.00n {supply} 616.04n 0
+ 620.00n 0 620.04n {supply}
+ 624.00n {supply} 624.04n 0
+ 628.00n 0 628.04n {supply}
+ 632.00n {supply} 632.04n 0
+ 636.00n 0 636.04n {supply}
+ 640.00n {supply} 640.04n 0
+ 644.00n 0 644.04n {supply}
+ 648.00n {supply} 648.04n 0
+ 652.00n 0 652.04n {supply}
+ 656.00n {supply} 656.04n 0
+ 660.00n 0 660.04n {supply}
+ 664.00n {supply} 664.04n 0
+ 668.00n 0 668.04n {supply}
+ 672.00n {supply} 672.04n 0
+ 676.00n 0 676.04n {supply}
+ 680.00n {supply} 680.04n 0
+ 684.00n 0 684.04n {supply}
+ 688.00n {supply} 688.04n 0
+ 692.00n 0 692.04n {supply}
+ 696.00n {supply} 696.04n 0
+ 700.00n 0 700.04n {supply}
+ 704.00n {supply} 704.04n 0
+ 708.00n 0 708.04n {supply}
+ 712.00n {supply} 712.04n 0
+ 716.00n 0 716.04n {supply}
+ 720.00n {supply} 720.04n 0
+ 724.00n 0 724.04n {supply}
+ 728.00n {supply} 728.04n 0
+ 732.00n 0 732.04n {supply}
+ 736.00n {supply} 736.04n 0
+ 740.00n 0 740.04n {supply}
+ 744.00n {supply} 744.04n 0
+ 748.00n 0 748.04n {supply}
+ 752.00n {supply} 752.04n 0
+ 756.00n 0 756.04n {supply}
+ 760.00n {supply} 760.04n 0
+ 764.00n 0 764.04n {supply}
+ 768.00n {supply} 768.04n 0
+ 772.00n 0 772.04n {supply}
+ 776.00n {supply} 776.04n 0
+ 780.00n 0 780.04n {supply}
+ 784.00n {supply} 784.04n 0
+ 788.00n 0 788.04n {supply}
+ 792.00n {supply} 792.04n 0
+ 796.00n 0 796.04n {supply}
+ 800.00n {supply} 800.04n 0
+ 804.00n 0 804.04n {supply}
+ 808.00n {supply} 808.04n 0
+ 812.00n 0 812.04n {supply}
+ 816.00n {supply} 816.04n 0
+ 820.00n 0 820.04n {supply}
+ 824.00n {supply} 824.04n 0
+ 828.00n 0 828.04n {supply}
+ 832.00n {supply} 832.04n 0
+ 836.00n 0 836.04n {supply}
+ 840.00n {supply} 840.04n 0
+ 844.00n 0 844.04n {supply}
+ 848.00n {supply} 848.04n 0
+ 852.00n 0 852.04n {supply}
+ 856.00n {supply} 856.04n 0
+ 860.00n 0 860.04n {supply}
+ 864.00n {supply} 864.04n 0
+ 868.00n 0 868.04n {supply}
+ 872.00n {supply} 872.04n 0
+ 876.00n 0 876.04n {supply}
+ 880.00n {supply} 880.04n 0
+ 884.00n 0 884.04n {supply}
+ 888.00n {supply} 888.04n 0
+ 892.00n 0 892.04n {supply}
+ 896.00n {supply} 896.04n 0
+ 900.00n 0 900.04n {supply}
+ 904.00n {supply} 904.04n 0
+ 908.00n 0 908.04n {supply}
+ 912.00n {supply} 912.04n 0
+ 916.00n 0 916.04n {supply}
+ 920.00n {supply} 920.04n 0
+ 924.00n 0 924.04n {supply}
+ 928.00n {supply} 928.04n 0
+ 932.00n 0 932.04n {supply}
+ 936.00n {supply} 936.04n 0
+ 940.00n 0 940.04n {supply}
+ 944.00n {supply} 944.04n 0
+ 948.00n 0 948.04n {supply}
+ 952.00n {supply} 952.04n 0
+ 956.00n 0 956.04n {supply}
+ 960.00n {supply} 960.04n 0
+ 964.00n 0 964.04n {supply}
+ 968.00n {supply} 968.04n 0
+ 972.00n 0 972.04n {supply}
+ 976.00n {supply} 976.04n 0
+ 980.00n 0 980.04n {supply}
+ 984.00n {supply} 984.04n 0
+ 988.00n 0 988.04n {supply}
+ 992.00n {supply} 992.04n 0
+ 996.00n 0 996.04n {supply}
+ 1000.00n {supply} 1000.04n 0
+ 1004.00n 0 1004.04n {supply}
+ 1008.00n {supply} 1008.04n 0
+ 1012.00n 0 1012.04n {supply}
+ 1016.00n {supply} 1016.04n 0
+ 1020.00n 0 1020.04n {supply}
+ 1024n {supply})
Vq1 q1 vss PWL(0 0
+ 8.00n 0 8.04n {supply}
+ 16.00n {supply} 16.04n 0
+ 24.00n 0 24.04n {supply}
+ 32.00n {supply} 32.04n 0
+ 40.00n 0 40.04n {supply}
+ 48.00n {supply} 48.04n 0
+ 56.00n 0 56.04n {supply}
+ 64.00n {supply} 64.04n 0
+ 72.00n 0 72.04n {supply}
+ 80.00n {supply} 80.04n 0
+ 88.00n 0 88.04n {supply}
+ 96.00n {supply} 96.04n 0
+ 104.00n 0 104.04n {supply}
+ 112.00n {supply} 112.04n 0
+ 120.00n 0 120.04n {supply}
+ 128.00n {supply} 128.04n 0
+ 136.00n 0 136.04n {supply}
+ 144.00n {supply} 144.04n 0
+ 152.00n 0 152.04n {supply}
+ 160.00n {supply} 160.04n 0
+ 168.00n 0 168.04n {supply}
+ 176.00n {supply} 176.04n 0
+ 184.00n 0 184.04n {supply}
+ 192.00n {supply} 192.04n 0
+ 200.00n 0 200.04n {supply}
+ 208.00n {supply} 208.04n 0
+ 216.00n 0 216.04n {supply}
+ 224.00n {supply} 224.04n 0
+ 232.00n 0 232.04n {supply}
+ 240.00n {supply} 240.04n 0
+ 248.00n 0 248.04n {supply}
+ 256.00n {supply} 256.04n 0
+ 264.00n 0 264.04n {supply}
+ 272.00n {supply} 272.04n 0
+ 280.00n 0 280.04n {supply}
+ 288.00n {supply} 288.04n 0
+ 296.00n 0 296.04n {supply}
+ 304.00n {supply} 304.04n 0
+ 312.00n 0 312.04n {supply}
+ 320.00n {supply} 320.04n 0
+ 328.00n 0 328.04n {supply}
+ 336.00n {supply} 336.04n 0
+ 344.00n 0 344.04n {supply}
+ 352.00n {supply} 352.04n 0
+ 360.00n 0 360.04n {supply}
+ 368.00n {supply} 368.04n 0
+ 376.00n 0 376.04n {supply}
+ 384.00n {supply} 384.04n 0
+ 392.00n 0 392.04n {supply}
+ 400.00n {supply} 400.04n 0
+ 408.00n 0 408.04n {supply}
+ 416.00n {supply} 416.04n 0
+ 424.00n 0 424.04n {supply}
+ 432.00n {supply} 432.04n 0
+ 440.00n 0 440.04n {supply}
+ 448.00n {supply} 448.04n 0
+ 456.00n 0 456.04n {supply}
+ 464.00n {supply} 464.04n 0
+ 472.00n 0 472.04n {supply}
+ 480.00n {supply} 480.04n 0
+ 488.00n 0 488.04n {supply}
+ 496.00n {supply} 496.04n 0
+ 504.00n 0 504.04n {supply}
+ 512.00n {supply} 512.04n 0
+ 520.00n 0 520.04n {supply}
+ 528.00n {supply} 528.04n 0
+ 536.00n 0 536.04n {supply}
+ 544.00n {supply} 544.04n 0
+ 552.00n 0 552.04n {supply}
+ 560.00n {supply} 560.04n 0
+ 568.00n 0 568.04n {supply}
+ 576.00n {supply} 576.04n 0
+ 584.00n 0 584.04n {supply}
+ 592.00n {supply} 592.04n 0
+ 600.00n 0 600.04n {supply}
+ 608.00n {supply} 608.04n 0
+ 616.00n 0 616.04n {supply}
+ 624.00n {supply} 624.04n 0
+ 632.00n 0 632.04n {supply}
+ 640.00n {supply} 640.04n 0
+ 648.00n 0 648.04n {supply}
+ 656.00n {supply} 656.04n 0
+ 664.00n 0 664.04n {supply}
+ 672.00n {supply} 672.04n 0
+ 680.00n 0 680.04n {supply}
+ 688.00n {supply} 688.04n 0
+ 696.00n 0 696.04n {supply}
+ 704.00n {supply} 704.04n 0
+ 712.00n 0 712.04n {supply}
+ 720.00n {supply} 720.04n 0
+ 728.00n 0 728.04n {supply}
+ 736.00n {supply} 736.04n 0
+ 744.00n 0 744.04n {supply}
+ 752.00n {supply} 752.04n 0
+ 760.00n 0 760.04n {supply}
+ 768.00n {supply} 768.04n 0
+ 776.00n 0 776.04n {supply}
+ 784.00n {supply} 784.04n 0
+ 792.00n 0 792.04n {supply}
+ 800.00n {supply} 800.04n 0
+ 808.00n 0 808.04n {supply}
+ 816.00n {supply} 816.04n 0
+ 824.00n 0 824.04n {supply}
+ 832.00n {supply} 832.04n 0
+ 840.00n 0 840.04n {supply}
+ 848.00n {supply} 848.04n 0
+ 856.00n 0 856.04n {supply}
+ 864.00n {supply} 864.04n 0
+ 872.00n 0 872.04n {supply}
+ 880.00n {supply} 880.04n 0
+ 888.00n 0 888.04n {supply}
+ 896.00n {supply} 896.04n 0
+ 904.00n 0 904.04n {supply}
+ 912.00n {supply} 912.04n 0
+ 920.00n 0 920.04n {supply}
+ 928.00n {supply} 928.04n 0
+ 936.00n 0 936.04n {supply}
+ 944.00n {supply} 944.04n 0
+ 952.00n 0 952.04n {supply}
+ 960.00n {supply} 960.04n 0
+ 968.00n 0 968.04n {supply}
+ 976.00n {supply} 976.04n 0
+ 984.00n 0 984.04n {supply}
+ 992.00n {supply} 992.04n 0
+ 1000.00n 0 1000.04n {supply}
+ 1008.00n {supply} 1008.04n 0
+ 1016.00n 0 1016.04n {supply}
+ 1024n {supply})
Vq2 q2 vss PWL(0 0
+ 16.00n 0 16.04n {supply}
+ 32.00n {supply} 32.04n 0
+ 48.00n 0 48.04n {supply}
+ 64.00n {supply} 64.04n 0
+ 80.00n 0 80.04n {supply}
+ 96.00n {supply} 96.04n 0
+ 112.00n 0 112.04n {supply}
+ 128.00n {supply} 128.04n 0
+ 144.00n 0 144.04n {supply}
+ 160.00n {supply} 160.04n 0
+ 176.00n 0 176.04n {supply}
+ 192.00n {supply} 192.04n 0
+ 208.00n 0 208.04n {supply}
+ 224.00n {supply} 224.04n 0
+ 240.00n 0 240.04n {supply}
+ 256.00n {supply} 256.04n 0
+ 272.00n 0 272.04n {supply}
+ 288.00n {supply} 288.04n 0
+ 304.00n 0 304.04n {supply}
+ 320.00n {supply} 320.04n 0
+ 336.00n 0 336.04n {supply}
+ 352.00n {supply} 352.04n 0
+ 368.00n 0 368.04n {supply}
+ 384.00n {supply} 384.04n 0
+ 400.00n 0 400.04n {supply}
+ 416.00n {supply} 416.04n 0
+ 432.00n 0 432.04n {supply}
+ 448.00n {supply} 448.04n 0
+ 464.00n 0 464.04n {supply}
+ 480.00n {supply} 480.04n 0
+ 496.00n 0 496.04n {supply}
+ 512.00n {supply} 512.04n 0
+ 528.00n 0 528.04n {supply}
+ 544.00n {supply} 544.04n 0
+ 560.00n 0 560.04n {supply}
+ 576.00n {supply} 576.04n 0
+ 592.00n 0 592.04n {supply}
+ 608.00n {supply} 608.04n 0
+ 624.00n 0 624.04n {supply}
+ 640.00n {supply} 640.04n 0
+ 656.00n 0 656.04n {supply}
+ 672.00n {supply} 672.04n 0
+ 688.00n 0 688.04n {supply}
+ 704.00n {supply} 704.04n 0
+ 720.00n 0 720.04n {supply}
+ 736.00n {supply} 736.04n 0
+ 752.00n 0 752.04n {supply}
+ 768.00n {supply} 768.04n 0
+ 784.00n 0 784.04n {supply}
+ 800.00n {supply} 800.04n 0
+ 816.00n 0 816.04n {supply}
+ 832.00n {supply} 832.04n 0
+ 848.00n 0 848.04n {supply}
+ 864.00n {supply} 864.04n 0
+ 880.00n 0 880.04n {supply}
+ 896.00n {supply} 896.04n 0
+ 912.00n 0 912.04n {supply}
+ 928.00n {supply} 928.04n 0
+ 944.00n 0 944.04n {supply}
+ 960.00n {supply} 960.04n 0
+ 976.00n 0 976.04n {supply}
+ 992.00n {supply} 992.04n 0
+ 1008.00n 0 1008.04n {supply}
+ 1024n {supply})
Vq3 q3 vss PWL(0 0
+ 32.00n 0 32.04n {supply}
+ 64.00n {supply} 64.04n 0
+ 96.00n 0 96.04n {supply}
+ 128.00n {supply} 128.04n 0
+ 160.00n 0 160.04n {supply}
+ 192.00n {supply} 192.04n 0
+ 224.00n 0 224.04n {supply}
+ 256.00n {supply} 256.04n 0
+ 288.00n 0 288.04n {supply}
+ 320.00n {supply} 320.04n 0
+ 352.00n 0 352.04n {supply}
+ 384.00n {supply} 384.04n 0
+ 416.00n 0 416.04n {supply}
+ 448.00n {supply} 448.04n 0
+ 480.00n 0 480.04n {supply}
+ 512.00n {supply} 512.04n 0
+ 544.00n 0 544.04n {supply}
+ 576.00n {supply} 576.04n 0
+ 608.00n 0 608.04n {supply}
+ 640.00n {supply} 640.04n 0
+ 672.00n 0 672.04n {supply}
+ 704.00n {supply} 704.04n 0
+ 736.00n 0 736.04n {supply}
+ 768.00n {supply} 768.04n 0
+ 800.00n 0 800.04n {supply}
+ 832.00n {supply} 832.04n 0
+ 864.00n 0 864.04n {supply}
+ 896.00n {supply} 896.04n 0
+ 928.00n 0 928.04n {supply}
+ 960.00n {supply} 960.04n 0
+ 992.00n 0 992.04n {supply}
+ 1024n {supply})
Vm0 m0 vss PWL(0 0
+ 64.00n 0 64.04n {supply}
+ 128.00n {supply} 128.04n 0
+ 192.00n 0 192.04n {supply}
+ 256.00n {supply} 256.04n 0
+ 320.00n 0 320.04n {supply}
+ 384.00n {supply} 384.04n 0
+ 448.00n 0 448.04n {supply}
+ 512.00n {supply} 512.04n 0
+ 576.00n 0 576.04n {supply}
+ 640.00n {supply} 640.04n 0
+ 704.00n 0 704.04n {supply}
+ 768.00n {supply} 768.04n 0
+ 832.00n 0 832.04n {supply}
+ 896.00n {supply} 896.04n 0
+ 960.00n 0 960.04n {supply}
+ 1024n {supply})
Vm1 m1 vss PWL(0 0
+ 128.00n 0 128.04n {supply}
+ 256.00n {supply} 256.04n 0
+ 384.00n 0 384.04n {supply}
+ 512.00n {supply} 512.04n 0
+ 640.00n 0 640.04n {supply}
+ 768.00n {supply} 768.04n 0
+ 896.00n 0 896.04n {supply}
+ 1024n {supply})
Vm2 m2 vss PWL(0 0
+ 256.00n 0 256.04n {supply}
+ 512.00n {supply} 512.04n 0
+ 768.00n 0 768.04n {supply}
+ 1024n {supply})
Vm3 m3 vss PWL(0 0
+ 512.00n 0 512.04n {supply}
+ 1024n {supply})
.ends stim_cmos_truth
