* Additive startup-capable version; legacy balanced core remains unchanged.
* Supervisor, precharge reference/buffer, bias qualification and measurement
* frontends are separate interfaces. This cell is not a fully autonomous PLL.
.subckt pll_balanced_startup_core ref pfd_rst_b cp_en pre_en pre_ref
+ vbn vbp vbias cfg0 cfg1 cfg2 ctrl z up dn fb0
+ cm0p cm0n cm1p cm1n cm2p cm2n cm3p cm3n vdd vdd_dummy vss params: cwire=0.5f
Xclock ctrl cfg0 cfg1 cfg2 vbias pfd_rst_b fb0 cm0p cm0n cm1p cm1n cm2p cm2n cm3p cm3n vdd vdd_dummy vss pll_clock_frontend_balanced cwire={cwire}
Xpfd ref fb0 pfd_rst_b up dn vdd vss pll_pfd
Xcp up dn cp_en out vbn vbp vdd vss pll_cp_enabled
Xlf out ctrl z pre_ref pre_en vdd vss pll_loop_filter_precharge
Cup up vss 20f
Cdn dn vss 20f
.ends pll_balanced_startup_core
