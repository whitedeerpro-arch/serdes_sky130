* Phase-domain VCO plus ideal /N, for mixed-view loop debugging ONLY.
* f_ghz is numerical frequency in GHz; phase is divided phase in cycles.
* Cphase/Bint/Rphase implement d(phase)/dt=f/N, not a physical oscillator.
* No VCO power/noise/startup, clock extraction load, or divider state is modeled.
.subckt pll_vco_feedback_model ctrl fb phase f_ghz vdd vss
+ params: fcenter=2G kvco=485Meg vmid=1.3 ndiv=8 edge_shape=0.02
Bfreq f_ghz vss V={max(0.5,min(3,(fcenter+kvco*(v(ctrl,vss)-vmid))/1G))}
Bint vss phase I={v(f_ghz,vss)*1G/ndiv*1n}
Cphase phase vss 1n
Rphase phase vss 1T
Bclock fb vss V={v(vdd,vss)*(0.5+0.5*tanh(sin(6.283185307179586*v(phase,vss))/edge_shape))}
.ends pll_vco_feedback_model
