* Seven identical physical MIM units, grouped as binary weights 1:2:4.
* Both output legs and all four cells must use identical codes.
* Bottom-plate switches are SKY130 NFETs; off-state parasitics are retained.
* Rdc only defines a DC reference for the otherwise floating off plate.
.subckt pll_vco_cap_unit node en vss params: capw=2 capl=2 sw=1
Xcap node plate sky130_fd_pr__cap_mim_m3_1 w={capw} l={capl}
Xsw plate en vss vss sky130_fd_pr__nfet_01v8 w={sw} l=0.15
+ ad={sw*0.29} as={sw*0.29} pd={2*(sw+0.29)} ps={2*(sw+0.29)}
Rdc plate vss 1T
.ends pll_vco_cap_unit

.subckt pll_vco_cap_bank node b0 b1 b2 vss params: capw=2 capl=2 sw=1
X00 node b0 vss pll_vco_cap_unit capw={capw} capl={capl} sw={sw}
X10 node b1 vss pll_vco_cap_unit capw={capw} capl={capl} sw={sw}
X11 node b1 vss pll_vco_cap_unit capw={capw} capl={capl} sw={sw}
X20 node b2 vss pll_vco_cap_unit capw={capw} capl={capl} sw={sw}
X21 node b2 vss pll_vco_cap_unit capw={capw} capl={capl} sw={sw}
X22 node b2 vss pll_vco_cap_unit capw={capw} capl={capl} sw={sw}
X23 node b2 vss pll_vco_cap_unit capw={capw} capl={capl} sw={sw}
.ends pll_vco_cap_bank
