* Exploratory SKY130 differential inverting delay cell.
* Resistive loads are ideal nominal resistors, not extracted PDK resistors.
* wn/wt and lengths are in micrometres under the SKY130 library scale.
* nf is the number of fingers; w is total device width.
.subckt serdes_cml_delay inp inn outp outn vbias vdd vss
+ params: wn=40 lin=0.15 nfin=8 wt=20 lt=0.5 nftail=4 rload=400
XRp vdd outp 0 sky130_fd_pr__res_high_po w={max(1,ceil(1012/(rload)))} l={((rload)*max(1,ceil(1012/(rload)))-378)/317}
XRn vdd outn 0 sky130_fd_pr__res_high_po w={max(1,ceil(1012/(rload)))} l={((rload)*max(1,ceil(1012/(rload)))-378)/317}
Xmp outp inp tail vss sky130_fd_pr__nfet_01v8_lvt
+ w={wn} l={lin} nf={nfin}
+ ad={floor((nfin+1)/2)*(wn/nfin)*0.29}
+ as={floor((nfin+2)/2)*(wn/nfin)*0.29}
+ pd={2*floor((nfin+1)/2)*(wn/nfin+0.29)}
+ ps={2*floor((nfin+2)/2)*(wn/nfin+0.29)}
Xmn outn inn tail vss sky130_fd_pr__nfet_01v8_lvt
+ w={wn} l={lin} nf={nfin}
+ ad={floor((nfin+1)/2)*(wn/nfin)*0.29}
+ as={floor((nfin+2)/2)*(wn/nfin)*0.29}
+ pd={2*floor((nfin+1)/2)*(wn/nfin+0.29)}
+ ps={2*floor((nfin+2)/2)*(wn/nfin+0.29)}
Xtail tail vbias vss vss sky130_fd_pr__nfet_01v8
+ w={wt} l={lt} nf={nftail}
+ ad={floor((nftail+1)/2)*(wt/nftail)*0.29}
+ as={floor((nftail+2)/2)*(wt/nftail)*0.29}
+ pd={2*floor((nftail+1)/2)*(wt/nftail+0.29)}
+ ps={2*floor((nftail+2)/2)*(wt/nftail+0.29)}
.ends serdes_cml_delay
