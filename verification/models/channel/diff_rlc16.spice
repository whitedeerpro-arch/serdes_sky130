* Passive 16-section pi RLGC channel proxy; not a measured PCB or S-parameter model.
* Defaults PER LEG: R=.05ohm, L=12.5nH, C=5pF: Z0~50ohm, delay~250ps.
* Differential pair symmetric; no mutual coupling, skin/dielectric dispersion or crosstalk.
* Fixed discretization: small-signal behavior near2GHz is a useful first bringup proxy,
* not a wideband channel qualification. Local / remote terminations are external.
.subckt serdes_diff_rlc16 ap an bp bn vss params: rtotal=0.05 ltotal=12.5n ctotal=5p
Cp0 ap vss {ctotal/32}
Rp0 ap mp0 {rtotal/16}
Lp0 mp0 p1 {ltotal/16}
Cp1 p1 vss {ctotal/16}
Rp1 p1 mp1 {rtotal/16}
Lp1 mp1 p2 {ltotal/16}
Cp2 p2 vss {ctotal/16}
Rp2 p2 mp2 {rtotal/16}
Lp2 mp2 p3 {ltotal/16}
Cp3 p3 vss {ctotal/16}
Rp3 p3 mp3 {rtotal/16}
Lp3 mp3 p4 {ltotal/16}
Cp4 p4 vss {ctotal/16}
Rp4 p4 mp4 {rtotal/16}
Lp4 mp4 p5 {ltotal/16}
Cp5 p5 vss {ctotal/16}
Rp5 p5 mp5 {rtotal/16}
Lp5 mp5 p6 {ltotal/16}
Cp6 p6 vss {ctotal/16}
Rp6 p6 mp6 {rtotal/16}
Lp6 mp6 p7 {ltotal/16}
Cp7 p7 vss {ctotal/16}
Rp7 p7 mp7 {rtotal/16}
Lp7 mp7 p8 {ltotal/16}
Cp8 p8 vss {ctotal/16}
Rp8 p8 mp8 {rtotal/16}
Lp8 mp8 p9 {ltotal/16}
Cp9 p9 vss {ctotal/16}
Rp9 p9 mp9 {rtotal/16}
Lp9 mp9 p10 {ltotal/16}
Cp10 p10 vss {ctotal/16}
Rp10 p10 mp10 {rtotal/16}
Lp10 mp10 p11 {ltotal/16}
Cp11 p11 vss {ctotal/16}
Rp11 p11 mp11 {rtotal/16}
Lp11 mp11 p12 {ltotal/16}
Cp12 p12 vss {ctotal/16}
Rp12 p12 mp12 {rtotal/16}
Lp12 mp12 p13 {ltotal/16}
Cp13 p13 vss {ctotal/16}
Rp13 p13 mp13 {rtotal/16}
Lp13 mp13 p14 {ltotal/16}
Cp14 p14 vss {ctotal/16}
Rp14 p14 mp14 {rtotal/16}
Lp14 mp14 p15 {ltotal/16}
Cp15 p15 vss {ctotal/16}
Rp15 p15 mp15 {rtotal/16}
Lp15 mp15 bp {ltotal/16}
Cp16 bp vss {ctotal/32}
Cn0 an vss {ctotal/32}
Rn0 an mn0 {rtotal/16}
Ln0 mn0 n1 {ltotal/16}
Cn1 n1 vss {ctotal/16}
Rn1 n1 mn1 {rtotal/16}
Ln1 mn1 n2 {ltotal/16}
Cn2 n2 vss {ctotal/16}
Rn2 n2 mn2 {rtotal/16}
Ln2 mn2 n3 {ltotal/16}
Cn3 n3 vss {ctotal/16}
Rn3 n3 mn3 {rtotal/16}
Ln3 mn3 n4 {ltotal/16}
Cn4 n4 vss {ctotal/16}
Rn4 n4 mn4 {rtotal/16}
Ln4 mn4 n5 {ltotal/16}
Cn5 n5 vss {ctotal/16}
Rn5 n5 mn5 {rtotal/16}
Ln5 mn5 n6 {ltotal/16}
Cn6 n6 vss {ctotal/16}
Rn6 n6 mn6 {rtotal/16}
Ln6 mn6 n7 {ltotal/16}
Cn7 n7 vss {ctotal/16}
Rn7 n7 mn7 {rtotal/16}
Ln7 mn7 n8 {ltotal/16}
Cn8 n8 vss {ctotal/16}
Rn8 n8 mn8 {rtotal/16}
Ln8 mn8 n9 {ltotal/16}
Cn9 n9 vss {ctotal/16}
Rn9 n9 mn9 {rtotal/16}
Ln9 mn9 n10 {ltotal/16}
Cn10 n10 vss {ctotal/16}
Rn10 n10 mn10 {rtotal/16}
Ln10 mn10 n11 {ltotal/16}
Cn11 n11 vss {ctotal/16}
Rn11 n11 mn11 {rtotal/16}
Ln11 mn11 n12 {ltotal/16}
Cn12 n12 vss {ctotal/16}
Rn12 n12 mn12 {rtotal/16}
Ln12 mn12 n13 {ltotal/16}
Cn13 n13 vss {ctotal/16}
Rn13 n13 mn13 {rtotal/16}
Ln13 mn13 n14 {ltotal/16}
Cn14 n14 vss {ctotal/16}
Rn14 n14 mn14 {rtotal/16}
Ln14 mn14 n15 {ltotal/16}
Cn15 n15 vss {ctotal/16}
Rn15 n15 mn15 {rtotal/16}
Ln15 mn15 bn {ltotal/16}
Cn16 bn vss {ctotal/32}
.ends serdes_diff_rlc16
