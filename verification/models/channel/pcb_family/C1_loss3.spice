* Synthetic PCB only: no package, pad, AC capacitors or termination.
* Include pcb_foster_cells.spice separately. vss is the ideal return reference.
.subckt pcb_c1_loss3 ap an bp bn vss
Xp0 ap p1 vss pcb_foster_cell dx=6.5224348640653489e-04
Xp1 p1 p2 vss pcb_foster_cell dx=6.5224348640653489e-04
Xp2 p2 p3 vss pcb_foster_cell dx=6.5224348640653489e-04
Xp3 p3 p4 vss pcb_foster_cell dx=6.5224348640653489e-04
Xp4 p4 p5 vss pcb_foster_cell dx=6.5224348640653489e-04
Xp5 p5 p6 vss pcb_foster_cell dx=6.5224348640653489e-04
Xp6 p6 p7 vss pcb_foster_cell dx=6.5224348640653489e-04
Xp7 p7 p8 vss pcb_foster_cell dx=6.5224348640653489e-04
Xp8 p8 p9 vss pcb_foster_cell dx=6.5224348640653489e-04
Xp9 p9 p10 vss pcb_foster_cell dx=6.5224348640653489e-04
Xp10 p10 p11 vss pcb_foster_cell dx=6.5224348640653489e-04
Xp11 p11 p12 vss pcb_foster_cell dx=6.5224348640653489e-04
Xp12 p12 p13 vss pcb_foster_cell dx=6.5224348640653489e-04
Xp13 p13 p14 vss pcb_foster_cell dx=6.5224348640653489e-04
Xp14 p14 p15 vss pcb_foster_cell dx=6.5224348640653489e-04
Xp15 p15 p16 vss pcb_foster_cell dx=6.5224348640653489e-04
Xp16 p16 p17 vss pcb_foster_cell dx=6.5224348640653489e-04
Xp17 p17 p18 vss pcb_foster_cell dx=6.5224348640653489e-04
Xp18 p18 p19 vss pcb_foster_cell dx=6.5224348640653489e-04
Xp19 p19 p20 vss pcb_foster_cell dx=6.5224348640653489e-04
Xp20 p20 p21 vss pcb_foster_cell dx=6.5224348640653489e-04
Xp21 p21 p22 vss pcb_foster_cell dx=6.5224348640653489e-04
Xp22 p22 p23 vss pcb_foster_cell dx=6.5224348640653489e-04
Xp23 p23 p24 vss pcb_foster_cell dx=6.5224348640653489e-04
Xp24 p24 p25 vss pcb_foster_cell dx=6.5224348640653489e-04
Xp25 p25 p26 vss pcb_foster_cell dx=6.5224348640653489e-04
Xp26 p26 p27 vss pcb_foster_cell dx=6.5224348640653489e-04
Xp27 p27 p28 vss pcb_foster_cell dx=6.5224348640653489e-04
Xp28 p28 p29 vss pcb_foster_cell dx=6.5224348640653489e-04
Xp29 p29 p30 vss pcb_foster_cell dx=6.5224348640653489e-04
Xp30 p30 p31 vss pcb_foster_cell dx=6.5224348640653489e-04
Xp31 p31 p32 vss pcb_foster_cell dx=6.5224348640653489e-04
Xp32 p32 p33 vss pcb_foster_cell dx=6.5224348640653489e-04
Xp33 p33 p34 vss pcb_foster_cell dx=6.5224348640653489e-04
Xp34 p34 p35 vss pcb_foster_cell dx=6.5224348640653489e-04
Xp35 p35 p36 vss pcb_foster_cell dx=6.5224348640653489e-04
Xp36 p36 p37 vss pcb_foster_cell dx=6.5224348640653489e-04
Xp37 p37 p38 vss pcb_foster_cell dx=6.5224348640653489e-04
Xp38 p38 p39 vss pcb_foster_cell dx=6.5224348640653489e-04
Xp39 p39 p40 vss pcb_foster_cell dx=6.5224348640653489e-04
Xp40 p40 p41 vss pcb_foster_cell dx=6.5224348640653489e-04
Xp41 p41 p42 vss pcb_foster_cell dx=6.5224348640653489e-04
Xp42 p42 p43 vss pcb_foster_cell dx=6.5224348640653489e-04
Xp43 p43 p44 vss pcb_foster_cell dx=6.5224348640653489e-04
Xp44 p44 p45 vss pcb_foster_cell dx=6.5224348640653489e-04
Xp45 p45 p46 vss pcb_foster_cell dx=6.5224348640653489e-04
Xp46 p46 p47 vss pcb_foster_cell dx=6.5224348640653489e-04
Xp47 p47 p48 vss pcb_foster_cell dx=6.5224348640653489e-04
Xp48 p48 p49 vss pcb_foster_cell dx=6.5224348640653489e-04
Xp49 p49 p50 vss pcb_foster_cell dx=6.5224348640653489e-04
Xp50 p50 p51 vss pcb_foster_cell dx=6.5224348640653489e-04
Xp51 p51 p52 vss pcb_foster_cell dx=6.5224348640653489e-04
Xp52 p52 p53 vss pcb_foster_cell dx=6.5224348640653489e-04
Xp53 p53 p54 vss pcb_foster_cell dx=6.5224348640653489e-04
Xp54 p54 p55 vss pcb_foster_cell dx=6.5224348640653489e-04
Xp55 p55 p56 vss pcb_foster_cell dx=6.5224348640653489e-04
Xp56 p56 p57 vss pcb_foster_cell dx=6.5224348640653489e-04
Xp57 p57 p58 vss pcb_foster_cell dx=6.5224348640653489e-04
Xp58 p58 p59 vss pcb_foster_cell dx=6.5224348640653489e-04
Xp59 p59 p60 vss pcb_foster_cell dx=6.5224348640653489e-04
Xp60 p60 p61 vss pcb_foster_cell dx=6.5224348640653489e-04
Xp61 p61 p62 vss pcb_foster_cell dx=6.5224348640653489e-04
Xp62 p62 p63 vss pcb_foster_cell dx=6.5224348640653489e-04
Xp63 p63 p64 vss pcb_foster_cell dx=6.5224348640653489e-04
Xp64 p64 p65 vss pcb_foster_cell dx=6.5224348640653489e-04
Xp65 p65 p66 vss pcb_foster_cell dx=6.5224348640653489e-04
Xp66 p66 p67 vss pcb_foster_cell dx=6.5224348640653489e-04
Xp67 p67 p68 vss pcb_foster_cell dx=6.5224348640653489e-04
Xp68 p68 p69 vss pcb_foster_cell dx=6.5224348640653489e-04
Xp69 p69 p70 vss pcb_foster_cell dx=6.5224348640653489e-04
Xp70 p70 p71 vss pcb_foster_cell dx=6.5224348640653489e-04
Xp71 p71 p72 vss pcb_foster_cell dx=6.5224348640653489e-04
Xp72 p72 p73 vss pcb_foster_cell dx=6.5224348640653489e-04
Xp73 p73 p74 vss pcb_foster_cell dx=6.5224348640653489e-04
Xp74 p74 p75 vss pcb_foster_cell dx=6.5224348640653489e-04
Xp75 p75 p76 vss pcb_foster_cell dx=6.5224348640653489e-04
Xp76 p76 p77 vss pcb_foster_cell dx=6.5224348640653489e-04
Xp77 p77 p78 vss pcb_foster_cell dx=6.5224348640653489e-04
Xp78 p78 p79 vss pcb_foster_cell dx=6.5224348640653489e-04
Xp79 p79 p80 vss pcb_foster_cell dx=6.5224348640653489e-04
Xp80 p80 p81 vss pcb_foster_cell dx=6.5224348640653489e-04
Xp81 p81 p82 vss pcb_foster_cell dx=6.5224348640653489e-04
Xp82 p82 p83 vss pcb_foster_cell dx=6.5224348640653489e-04
Xp83 p83 p84 vss pcb_foster_cell dx=6.5224348640653489e-04
Xp84 p84 p85 vss pcb_foster_cell dx=6.5224348640653489e-04
Xp85 p85 p86 vss pcb_foster_cell dx=6.5224348640653489e-04
Xp86 p86 p87 vss pcb_foster_cell dx=6.5224348640653489e-04
Xp87 p87 p88 vss pcb_foster_cell dx=6.5224348640653489e-04
Xp88 p88 p89 vss pcb_foster_cell dx=6.5224348640653489e-04
Xp89 p89 p90 vss pcb_foster_cell dx=6.5224348640653489e-04
Xp90 p90 p91 vss pcb_foster_cell dx=6.5224348640653489e-04
Xp91 p91 p92 vss pcb_foster_cell dx=6.5224348640653489e-04
Xp92 p92 p93 vss pcb_foster_cell dx=6.5224348640653489e-04
Xp93 p93 p94 vss pcb_foster_cell dx=6.5224348640653489e-04
Xp94 p94 p95 vss pcb_foster_cell dx=6.5224348640653489e-04
Xp95 p95 p96 vss pcb_foster_cell dx=6.5224348640653489e-04
Xp96 p96 p97 vss pcb_foster_cell dx=6.5224348640653489e-04
Xp97 p97 p98 vss pcb_foster_cell dx=6.5224348640653489e-04
Xp98 p98 p99 vss pcb_foster_cell dx=6.5224348640653489e-04
Xp99 p99 p100 vss pcb_foster_cell dx=6.5224348640653489e-04
Xp100 p100 p101 vss pcb_foster_cell dx=6.5224348640653489e-04
Xp101 p101 p102 vss pcb_foster_cell dx=6.5224348640653489e-04
Xp102 p102 p103 vss pcb_foster_cell dx=6.5224348640653489e-04
Xp103 p103 p104 vss pcb_foster_cell dx=6.5224348640653489e-04
Xp104 p104 p105 vss pcb_foster_cell dx=6.5224348640653489e-04
Xp105 p105 p106 vss pcb_foster_cell dx=6.5224348640653489e-04
Xp106 p106 p107 vss pcb_foster_cell dx=6.5224348640653489e-04
Xp107 p107 p108 vss pcb_foster_cell dx=6.5224348640653489e-04
Xp108 p108 p109 vss pcb_foster_cell dx=6.5224348640653489e-04
Xp109 p109 p110 vss pcb_foster_cell dx=6.5224348640653489e-04
Xp110 p110 p111 vss pcb_foster_cell dx=6.5224348640653489e-04
Xp111 p111 p112 vss pcb_foster_cell dx=6.5224348640653489e-04
Xp112 p112 p113 vss pcb_foster_cell dx=6.5224348640653489e-04
Xp113 p113 p114 vss pcb_foster_cell dx=6.5224348640653489e-04
Xp114 p114 p115 vss pcb_foster_cell dx=6.5224348640653489e-04
Xp115 p115 p116 vss pcb_foster_cell dx=6.5224348640653489e-04
Xp116 p116 p117 vss pcb_foster_cell dx=6.5224348640653489e-04
Xp117 p117 p118 vss pcb_foster_cell dx=6.5224348640653489e-04
Xp118 p118 p119 vss pcb_foster_cell dx=6.5224348640653489e-04
Xp119 p119 p120 vss pcb_foster_cell dx=6.5224348640653489e-04
Xp120 p120 p121 vss pcb_foster_cell dx=6.5224348640653489e-04
Xp121 p121 p122 vss pcb_foster_cell dx=6.5224348640653489e-04
Xp122 p122 p123 vss pcb_foster_cell dx=6.5224348640653489e-04
Xp123 p123 p124 vss pcb_foster_cell dx=6.5224348640653489e-04
Xp124 p124 p125 vss pcb_foster_cell dx=6.5224348640653489e-04
Xp125 p125 p126 vss pcb_foster_cell dx=6.5224348640653489e-04
Xp126 p126 p127 vss pcb_foster_cell dx=6.5224348640653489e-04
Xp127 p127 p128 vss pcb_foster_cell dx=6.5224348640653489e-04
Xp128 p128 p129 vss pcb_foster_cell dx=6.5224348640653489e-04
Xp129 p129 p130 vss pcb_foster_cell dx=6.5224348640653489e-04
Xp130 p130 p131 vss pcb_foster_cell dx=6.5224348640653489e-04
Xp131 p131 p132 vss pcb_foster_cell dx=6.5224348640653489e-04
Xp132 p132 p133 vss pcb_foster_cell dx=6.5224348640653489e-04
Xp133 p133 p134 vss pcb_foster_cell dx=6.5224348640653489e-04
Xp134 p134 p135 vss pcb_foster_cell dx=6.5224348640653489e-04
Xp135 p135 p136 vss pcb_foster_cell dx=6.5224348640653489e-04
Xp136 p136 p137 vss pcb_foster_cell dx=6.5224348640653489e-04
Xp137 p137 p138 vss pcb_foster_cell dx=6.5224348640653489e-04
Xp138 p138 p139 vss pcb_foster_cell dx=6.5224348640653489e-04
Xp139 p139 p140 vss pcb_foster_cell dx=6.5224348640653489e-04
Xp140 p140 p141 vss pcb_foster_cell dx=6.5224348640653489e-04
Xp141 p141 p142 vss pcb_foster_cell dx=6.5224348640653489e-04
Xp142 p142 p143 vss pcb_foster_cell dx=6.5224348640653489e-04
Xp143 p143 p144 vss pcb_foster_cell dx=6.5224348640653489e-04
Xp144 p144 p145 vss pcb_foster_cell dx=6.5224348640653489e-04
Xp145 p145 p146 vss pcb_foster_cell dx=6.5224348640653489e-04
Xp146 p146 p147 vss pcb_foster_cell dx=6.5224348640653489e-04
Xp147 p147 p148 vss pcb_foster_cell dx=6.5224348640653489e-04
Xp148 p148 p149 vss pcb_foster_cell dx=6.5224348640653489e-04
Xp149 p149 p150 vss pcb_foster_cell dx=6.5224348640653489e-04
Xp150 p150 p151 vss pcb_foster_cell dx=6.5224348640653489e-04
Xp151 p151 p152 vss pcb_foster_cell dx=6.5224348640653489e-04
Xp152 p152 p153 vss pcb_foster_cell dx=6.5224348640653489e-04
Xp153 p153 p154 vss pcb_foster_cell dx=6.5224348640653489e-04
Xp154 p154 p155 vss pcb_foster_cell dx=6.5224348640653489e-04
Xp155 p155 p156 vss pcb_foster_cell dx=6.5224348640653489e-04
Xp156 p156 p157 vss pcb_foster_cell dx=6.5224348640653489e-04
Xp157 p157 p158 vss pcb_foster_cell dx=6.5224348640653489e-04
Xp158 p158 p159 vss pcb_foster_cell dx=6.5224348640653489e-04
Xp159 p159 p160 vss pcb_foster_cell dx=6.5224348640653489e-04
Xp160 p160 p161 vss pcb_foster_cell dx=6.5224348640653489e-04
Xp161 p161 p162 vss pcb_foster_cell dx=6.5224348640653489e-04
Xp162 p162 p163 vss pcb_foster_cell dx=6.5224348640653489e-04
Xp163 p163 p164 vss pcb_foster_cell dx=6.5224348640653489e-04
Xp164 p164 p165 vss pcb_foster_cell dx=6.5224348640653489e-04
Xp165 p165 p166 vss pcb_foster_cell dx=6.5224348640653489e-04
Xp166 p166 p167 vss pcb_foster_cell dx=6.5224348640653489e-04
Xp167 p167 p168 vss pcb_foster_cell dx=6.5224348640653489e-04
Xp168 p168 p169 vss pcb_foster_cell dx=6.5224348640653489e-04
Xp169 p169 p170 vss pcb_foster_cell dx=6.5224348640653489e-04
Xp170 p170 p171 vss pcb_foster_cell dx=6.5224348640653489e-04
Xp171 p171 p172 vss pcb_foster_cell dx=6.5224348640653489e-04
Xp172 p172 p173 vss pcb_foster_cell dx=6.5224348640653489e-04
Xp173 p173 p174 vss pcb_foster_cell dx=6.5224348640653489e-04
Xp174 p174 p175 vss pcb_foster_cell dx=6.5224348640653489e-04
Xp175 p175 p176 vss pcb_foster_cell dx=6.5224348640653489e-04
Xp176 p176 p177 vss pcb_foster_cell dx=6.5224348640653489e-04
Xp177 p177 p178 vss pcb_foster_cell dx=6.5224348640653489e-04
Xp178 p178 p179 vss pcb_foster_cell dx=6.5224348640653489e-04
Xp179 p179 p180 vss pcb_foster_cell dx=6.5224348640653489e-04
Xp180 p180 p181 vss pcb_foster_cell dx=6.5224348640653489e-04
Xp181 p181 p182 vss pcb_foster_cell dx=6.5224348640653489e-04
Xp182 p182 p183 vss pcb_foster_cell dx=6.5224348640653489e-04
Xp183 p183 p184 vss pcb_foster_cell dx=6.5224348640653489e-04
Xp184 p184 p185 vss pcb_foster_cell dx=6.5224348640653489e-04
Xp185 p185 p186 vss pcb_foster_cell dx=6.5224348640653489e-04
Xp186 p186 p187 vss pcb_foster_cell dx=6.5224348640653489e-04
Xp187 p187 p188 vss pcb_foster_cell dx=6.5224348640653489e-04
Xp188 p188 p189 vss pcb_foster_cell dx=6.5224348640653489e-04
Xp189 p189 p190 vss pcb_foster_cell dx=6.5224348640653489e-04
Xp190 p190 p191 vss pcb_foster_cell dx=6.5224348640653489e-04
Xp191 p191 p192 vss pcb_foster_cell dx=6.5224348640653489e-04
Xp192 p192 p193 vss pcb_foster_cell dx=6.5224348640653489e-04
Xp193 p193 p194 vss pcb_foster_cell dx=6.5224348640653489e-04
Xp194 p194 p195 vss pcb_foster_cell dx=6.5224348640653489e-04
Xp195 p195 p196 vss pcb_foster_cell dx=6.5224348640653489e-04
Xp196 p196 p197 vss pcb_foster_cell dx=6.5224348640653489e-04
Xp197 p197 p198 vss pcb_foster_cell dx=6.5224348640653489e-04
Xp198 p198 p199 vss pcb_foster_cell dx=6.5224348640653489e-04
Xp199 p199 p200 vss pcb_foster_cell dx=6.5224348640653489e-04
Xp200 p200 p201 vss pcb_foster_cell dx=6.5224348640653489e-04
Xp201 p201 p202 vss pcb_foster_cell dx=6.5224348640653489e-04
Xp202 p202 p203 vss pcb_foster_cell dx=6.5224348640653489e-04
Xp203 p203 p204 vss pcb_foster_cell dx=6.5224348640653489e-04
Xp204 p204 p205 vss pcb_foster_cell dx=6.5224348640653489e-04
Xp205 p205 p206 vss pcb_foster_cell dx=6.5224348640653489e-04
Xp206 p206 p207 vss pcb_foster_cell dx=6.5224348640653489e-04
Xp207 p207 p208 vss pcb_foster_cell dx=6.5224348640653489e-04
Xp208 p208 p209 vss pcb_foster_cell dx=6.5224348640653489e-04
Xp209 p209 p210 vss pcb_foster_cell dx=6.5224348640653489e-04
Xp210 p210 p211 vss pcb_foster_cell dx=6.5224348640653489e-04
Xp211 p211 p212 vss pcb_foster_cell dx=6.5224348640653489e-04
Xp212 p212 p213 vss pcb_foster_cell dx=6.5224348640653489e-04
Xp213 p213 p214 vss pcb_foster_cell dx=6.5224348640653489e-04
Xp214 p214 p215 vss pcb_foster_cell dx=6.5224348640653489e-04
Xp215 p215 p216 vss pcb_foster_cell dx=6.5224348640653489e-04
Xp216 p216 p217 vss pcb_foster_cell dx=6.5224348640653489e-04
Xp217 p217 p218 vss pcb_foster_cell dx=6.5224348640653489e-04
Xp218 p218 p219 vss pcb_foster_cell dx=6.5224348640653489e-04
Xp219 p219 p220 vss pcb_foster_cell dx=6.5224348640653489e-04
Xp220 p220 p221 vss pcb_foster_cell dx=6.5224348640653489e-04
Xp221 p221 p222 vss pcb_foster_cell dx=6.5224348640653489e-04
Xp222 p222 p223 vss pcb_foster_cell dx=6.5224348640653489e-04
Xp223 p223 p224 vss pcb_foster_cell dx=6.5224348640653489e-04
Xp224 p224 p225 vss pcb_foster_cell dx=6.5224348640653489e-04
Xp225 p225 p226 vss pcb_foster_cell dx=6.5224348640653489e-04
Xp226 p226 p227 vss pcb_foster_cell dx=6.5224348640653489e-04
Xp227 p227 p228 vss pcb_foster_cell dx=6.5224348640653489e-04
Xp228 p228 p229 vss pcb_foster_cell dx=6.5224348640653489e-04
Xp229 p229 bp vss pcb_foster_cell dx=6.5224348640653489e-04
Xn0 an n1 vss pcb_foster_cell dx=6.5224348640653489e-04
Xn1 n1 n2 vss pcb_foster_cell dx=6.5224348640653489e-04
Xn2 n2 n3 vss pcb_foster_cell dx=6.5224348640653489e-04
Xn3 n3 n4 vss pcb_foster_cell dx=6.5224348640653489e-04
Xn4 n4 n5 vss pcb_foster_cell dx=6.5224348640653489e-04
Xn5 n5 n6 vss pcb_foster_cell dx=6.5224348640653489e-04
Xn6 n6 n7 vss pcb_foster_cell dx=6.5224348640653489e-04
Xn7 n7 n8 vss pcb_foster_cell dx=6.5224348640653489e-04
Xn8 n8 n9 vss pcb_foster_cell dx=6.5224348640653489e-04
Xn9 n9 n10 vss pcb_foster_cell dx=6.5224348640653489e-04
Xn10 n10 n11 vss pcb_foster_cell dx=6.5224348640653489e-04
Xn11 n11 n12 vss pcb_foster_cell dx=6.5224348640653489e-04
Xn12 n12 n13 vss pcb_foster_cell dx=6.5224348640653489e-04
Xn13 n13 n14 vss pcb_foster_cell dx=6.5224348640653489e-04
Xn14 n14 n15 vss pcb_foster_cell dx=6.5224348640653489e-04
Xn15 n15 n16 vss pcb_foster_cell dx=6.5224348640653489e-04
Xn16 n16 n17 vss pcb_foster_cell dx=6.5224348640653489e-04
Xn17 n17 n18 vss pcb_foster_cell dx=6.5224348640653489e-04
Xn18 n18 n19 vss pcb_foster_cell dx=6.5224348640653489e-04
Xn19 n19 n20 vss pcb_foster_cell dx=6.5224348640653489e-04
Xn20 n20 n21 vss pcb_foster_cell dx=6.5224348640653489e-04
Xn21 n21 n22 vss pcb_foster_cell dx=6.5224348640653489e-04
Xn22 n22 n23 vss pcb_foster_cell dx=6.5224348640653489e-04
Xn23 n23 n24 vss pcb_foster_cell dx=6.5224348640653489e-04
Xn24 n24 n25 vss pcb_foster_cell dx=6.5224348640653489e-04
Xn25 n25 n26 vss pcb_foster_cell dx=6.5224348640653489e-04
Xn26 n26 n27 vss pcb_foster_cell dx=6.5224348640653489e-04
Xn27 n27 n28 vss pcb_foster_cell dx=6.5224348640653489e-04
Xn28 n28 n29 vss pcb_foster_cell dx=6.5224348640653489e-04
Xn29 n29 n30 vss pcb_foster_cell dx=6.5224348640653489e-04
Xn30 n30 n31 vss pcb_foster_cell dx=6.5224348640653489e-04
Xn31 n31 n32 vss pcb_foster_cell dx=6.5224348640653489e-04
Xn32 n32 n33 vss pcb_foster_cell dx=6.5224348640653489e-04
Xn33 n33 n34 vss pcb_foster_cell dx=6.5224348640653489e-04
Xn34 n34 n35 vss pcb_foster_cell dx=6.5224348640653489e-04
Xn35 n35 n36 vss pcb_foster_cell dx=6.5224348640653489e-04
Xn36 n36 n37 vss pcb_foster_cell dx=6.5224348640653489e-04
Xn37 n37 n38 vss pcb_foster_cell dx=6.5224348640653489e-04
Xn38 n38 n39 vss pcb_foster_cell dx=6.5224348640653489e-04
Xn39 n39 n40 vss pcb_foster_cell dx=6.5224348640653489e-04
Xn40 n40 n41 vss pcb_foster_cell dx=6.5224348640653489e-04
Xn41 n41 n42 vss pcb_foster_cell dx=6.5224348640653489e-04
Xn42 n42 n43 vss pcb_foster_cell dx=6.5224348640653489e-04
Xn43 n43 n44 vss pcb_foster_cell dx=6.5224348640653489e-04
Xn44 n44 n45 vss pcb_foster_cell dx=6.5224348640653489e-04
Xn45 n45 n46 vss pcb_foster_cell dx=6.5224348640653489e-04
Xn46 n46 n47 vss pcb_foster_cell dx=6.5224348640653489e-04
Xn47 n47 n48 vss pcb_foster_cell dx=6.5224348640653489e-04
Xn48 n48 n49 vss pcb_foster_cell dx=6.5224348640653489e-04
Xn49 n49 n50 vss pcb_foster_cell dx=6.5224348640653489e-04
Xn50 n50 n51 vss pcb_foster_cell dx=6.5224348640653489e-04
Xn51 n51 n52 vss pcb_foster_cell dx=6.5224348640653489e-04
Xn52 n52 n53 vss pcb_foster_cell dx=6.5224348640653489e-04
Xn53 n53 n54 vss pcb_foster_cell dx=6.5224348640653489e-04
Xn54 n54 n55 vss pcb_foster_cell dx=6.5224348640653489e-04
Xn55 n55 n56 vss pcb_foster_cell dx=6.5224348640653489e-04
Xn56 n56 n57 vss pcb_foster_cell dx=6.5224348640653489e-04
Xn57 n57 n58 vss pcb_foster_cell dx=6.5224348640653489e-04
Xn58 n58 n59 vss pcb_foster_cell dx=6.5224348640653489e-04
Xn59 n59 n60 vss pcb_foster_cell dx=6.5224348640653489e-04
Xn60 n60 n61 vss pcb_foster_cell dx=6.5224348640653489e-04
Xn61 n61 n62 vss pcb_foster_cell dx=6.5224348640653489e-04
Xn62 n62 n63 vss pcb_foster_cell dx=6.5224348640653489e-04
Xn63 n63 n64 vss pcb_foster_cell dx=6.5224348640653489e-04
Xn64 n64 n65 vss pcb_foster_cell dx=6.5224348640653489e-04
Xn65 n65 n66 vss pcb_foster_cell dx=6.5224348640653489e-04
Xn66 n66 n67 vss pcb_foster_cell dx=6.5224348640653489e-04
Xn67 n67 n68 vss pcb_foster_cell dx=6.5224348640653489e-04
Xn68 n68 n69 vss pcb_foster_cell dx=6.5224348640653489e-04
Xn69 n69 n70 vss pcb_foster_cell dx=6.5224348640653489e-04
Xn70 n70 n71 vss pcb_foster_cell dx=6.5224348640653489e-04
Xn71 n71 n72 vss pcb_foster_cell dx=6.5224348640653489e-04
Xn72 n72 n73 vss pcb_foster_cell dx=6.5224348640653489e-04
Xn73 n73 n74 vss pcb_foster_cell dx=6.5224348640653489e-04
Xn74 n74 n75 vss pcb_foster_cell dx=6.5224348640653489e-04
Xn75 n75 n76 vss pcb_foster_cell dx=6.5224348640653489e-04
Xn76 n76 n77 vss pcb_foster_cell dx=6.5224348640653489e-04
Xn77 n77 n78 vss pcb_foster_cell dx=6.5224348640653489e-04
Xn78 n78 n79 vss pcb_foster_cell dx=6.5224348640653489e-04
Xn79 n79 n80 vss pcb_foster_cell dx=6.5224348640653489e-04
Xn80 n80 n81 vss pcb_foster_cell dx=6.5224348640653489e-04
Xn81 n81 n82 vss pcb_foster_cell dx=6.5224348640653489e-04
Xn82 n82 n83 vss pcb_foster_cell dx=6.5224348640653489e-04
Xn83 n83 n84 vss pcb_foster_cell dx=6.5224348640653489e-04
Xn84 n84 n85 vss pcb_foster_cell dx=6.5224348640653489e-04
Xn85 n85 n86 vss pcb_foster_cell dx=6.5224348640653489e-04
Xn86 n86 n87 vss pcb_foster_cell dx=6.5224348640653489e-04
Xn87 n87 n88 vss pcb_foster_cell dx=6.5224348640653489e-04
Xn88 n88 n89 vss pcb_foster_cell dx=6.5224348640653489e-04
Xn89 n89 n90 vss pcb_foster_cell dx=6.5224348640653489e-04
Xn90 n90 n91 vss pcb_foster_cell dx=6.5224348640653489e-04
Xn91 n91 n92 vss pcb_foster_cell dx=6.5224348640653489e-04
Xn92 n92 n93 vss pcb_foster_cell dx=6.5224348640653489e-04
Xn93 n93 n94 vss pcb_foster_cell dx=6.5224348640653489e-04
Xn94 n94 n95 vss pcb_foster_cell dx=6.5224348640653489e-04
Xn95 n95 n96 vss pcb_foster_cell dx=6.5224348640653489e-04
Xn96 n96 n97 vss pcb_foster_cell dx=6.5224348640653489e-04
Xn97 n97 n98 vss pcb_foster_cell dx=6.5224348640653489e-04
Xn98 n98 n99 vss pcb_foster_cell dx=6.5224348640653489e-04
Xn99 n99 n100 vss pcb_foster_cell dx=6.5224348640653489e-04
Xn100 n100 n101 vss pcb_foster_cell dx=6.5224348640653489e-04
Xn101 n101 n102 vss pcb_foster_cell dx=6.5224348640653489e-04
Xn102 n102 n103 vss pcb_foster_cell dx=6.5224348640653489e-04
Xn103 n103 n104 vss pcb_foster_cell dx=6.5224348640653489e-04
Xn104 n104 n105 vss pcb_foster_cell dx=6.5224348640653489e-04
Xn105 n105 n106 vss pcb_foster_cell dx=6.5224348640653489e-04
Xn106 n106 n107 vss pcb_foster_cell dx=6.5224348640653489e-04
Xn107 n107 n108 vss pcb_foster_cell dx=6.5224348640653489e-04
Xn108 n108 n109 vss pcb_foster_cell dx=6.5224348640653489e-04
Xn109 n109 n110 vss pcb_foster_cell dx=6.5224348640653489e-04
Xn110 n110 n111 vss pcb_foster_cell dx=6.5224348640653489e-04
Xn111 n111 n112 vss pcb_foster_cell dx=6.5224348640653489e-04
Xn112 n112 n113 vss pcb_foster_cell dx=6.5224348640653489e-04
Xn113 n113 n114 vss pcb_foster_cell dx=6.5224348640653489e-04
Xn114 n114 n115 vss pcb_foster_cell dx=6.5224348640653489e-04
Xn115 n115 n116 vss pcb_foster_cell dx=6.5224348640653489e-04
Xn116 n116 n117 vss pcb_foster_cell dx=6.5224348640653489e-04
Xn117 n117 n118 vss pcb_foster_cell dx=6.5224348640653489e-04
Xn118 n118 n119 vss pcb_foster_cell dx=6.5224348640653489e-04
Xn119 n119 n120 vss pcb_foster_cell dx=6.5224348640653489e-04
Xn120 n120 n121 vss pcb_foster_cell dx=6.5224348640653489e-04
Xn121 n121 n122 vss pcb_foster_cell dx=6.5224348640653489e-04
Xn122 n122 n123 vss pcb_foster_cell dx=6.5224348640653489e-04
Xn123 n123 n124 vss pcb_foster_cell dx=6.5224348640653489e-04
Xn124 n124 n125 vss pcb_foster_cell dx=6.5224348640653489e-04
Xn125 n125 n126 vss pcb_foster_cell dx=6.5224348640653489e-04
Xn126 n126 n127 vss pcb_foster_cell dx=6.5224348640653489e-04
Xn127 n127 n128 vss pcb_foster_cell dx=6.5224348640653489e-04
Xn128 n128 n129 vss pcb_foster_cell dx=6.5224348640653489e-04
Xn129 n129 n130 vss pcb_foster_cell dx=6.5224348640653489e-04
Xn130 n130 n131 vss pcb_foster_cell dx=6.5224348640653489e-04
Xn131 n131 n132 vss pcb_foster_cell dx=6.5224348640653489e-04
Xn132 n132 n133 vss pcb_foster_cell dx=6.5224348640653489e-04
Xn133 n133 n134 vss pcb_foster_cell dx=6.5224348640653489e-04
Xn134 n134 n135 vss pcb_foster_cell dx=6.5224348640653489e-04
Xn135 n135 n136 vss pcb_foster_cell dx=6.5224348640653489e-04
Xn136 n136 n137 vss pcb_foster_cell dx=6.5224348640653489e-04
Xn137 n137 n138 vss pcb_foster_cell dx=6.5224348640653489e-04
Xn138 n138 n139 vss pcb_foster_cell dx=6.5224348640653489e-04
Xn139 n139 n140 vss pcb_foster_cell dx=6.5224348640653489e-04
Xn140 n140 n141 vss pcb_foster_cell dx=6.5224348640653489e-04
Xn141 n141 n142 vss pcb_foster_cell dx=6.5224348640653489e-04
Xn142 n142 n143 vss pcb_foster_cell dx=6.5224348640653489e-04
Xn143 n143 n144 vss pcb_foster_cell dx=6.5224348640653489e-04
Xn144 n144 n145 vss pcb_foster_cell dx=6.5224348640653489e-04
Xn145 n145 n146 vss pcb_foster_cell dx=6.5224348640653489e-04
Xn146 n146 n147 vss pcb_foster_cell dx=6.5224348640653489e-04
Xn147 n147 n148 vss pcb_foster_cell dx=6.5224348640653489e-04
Xn148 n148 n149 vss pcb_foster_cell dx=6.5224348640653489e-04
Xn149 n149 n150 vss pcb_foster_cell dx=6.5224348640653489e-04
Xn150 n150 n151 vss pcb_foster_cell dx=6.5224348640653489e-04
Xn151 n151 n152 vss pcb_foster_cell dx=6.5224348640653489e-04
Xn152 n152 n153 vss pcb_foster_cell dx=6.5224348640653489e-04
Xn153 n153 n154 vss pcb_foster_cell dx=6.5224348640653489e-04
Xn154 n154 n155 vss pcb_foster_cell dx=6.5224348640653489e-04
Xn155 n155 n156 vss pcb_foster_cell dx=6.5224348640653489e-04
Xn156 n156 n157 vss pcb_foster_cell dx=6.5224348640653489e-04
Xn157 n157 n158 vss pcb_foster_cell dx=6.5224348640653489e-04
Xn158 n158 n159 vss pcb_foster_cell dx=6.5224348640653489e-04
Xn159 n159 n160 vss pcb_foster_cell dx=6.5224348640653489e-04
Xn160 n160 n161 vss pcb_foster_cell dx=6.5224348640653489e-04
Xn161 n161 n162 vss pcb_foster_cell dx=6.5224348640653489e-04
Xn162 n162 n163 vss pcb_foster_cell dx=6.5224348640653489e-04
Xn163 n163 n164 vss pcb_foster_cell dx=6.5224348640653489e-04
Xn164 n164 n165 vss pcb_foster_cell dx=6.5224348640653489e-04
Xn165 n165 n166 vss pcb_foster_cell dx=6.5224348640653489e-04
Xn166 n166 n167 vss pcb_foster_cell dx=6.5224348640653489e-04
Xn167 n167 n168 vss pcb_foster_cell dx=6.5224348640653489e-04
Xn168 n168 n169 vss pcb_foster_cell dx=6.5224348640653489e-04
Xn169 n169 n170 vss pcb_foster_cell dx=6.5224348640653489e-04
Xn170 n170 n171 vss pcb_foster_cell dx=6.5224348640653489e-04
Xn171 n171 n172 vss pcb_foster_cell dx=6.5224348640653489e-04
Xn172 n172 n173 vss pcb_foster_cell dx=6.5224348640653489e-04
Xn173 n173 n174 vss pcb_foster_cell dx=6.5224348640653489e-04
Xn174 n174 n175 vss pcb_foster_cell dx=6.5224348640653489e-04
Xn175 n175 n176 vss pcb_foster_cell dx=6.5224348640653489e-04
Xn176 n176 n177 vss pcb_foster_cell dx=6.5224348640653489e-04
Xn177 n177 n178 vss pcb_foster_cell dx=6.5224348640653489e-04
Xn178 n178 n179 vss pcb_foster_cell dx=6.5224348640653489e-04
Xn179 n179 n180 vss pcb_foster_cell dx=6.5224348640653489e-04
Xn180 n180 n181 vss pcb_foster_cell dx=6.5224348640653489e-04
Xn181 n181 n182 vss pcb_foster_cell dx=6.5224348640653489e-04
Xn182 n182 n183 vss pcb_foster_cell dx=6.5224348640653489e-04
Xn183 n183 n184 vss pcb_foster_cell dx=6.5224348640653489e-04
Xn184 n184 n185 vss pcb_foster_cell dx=6.5224348640653489e-04
Xn185 n185 n186 vss pcb_foster_cell dx=6.5224348640653489e-04
Xn186 n186 n187 vss pcb_foster_cell dx=6.5224348640653489e-04
Xn187 n187 n188 vss pcb_foster_cell dx=6.5224348640653489e-04
Xn188 n188 n189 vss pcb_foster_cell dx=6.5224348640653489e-04
Xn189 n189 n190 vss pcb_foster_cell dx=6.5224348640653489e-04
Xn190 n190 n191 vss pcb_foster_cell dx=6.5224348640653489e-04
Xn191 n191 n192 vss pcb_foster_cell dx=6.5224348640653489e-04
Xn192 n192 n193 vss pcb_foster_cell dx=6.5224348640653489e-04
Xn193 n193 n194 vss pcb_foster_cell dx=6.5224348640653489e-04
Xn194 n194 n195 vss pcb_foster_cell dx=6.5224348640653489e-04
Xn195 n195 n196 vss pcb_foster_cell dx=6.5224348640653489e-04
Xn196 n196 n197 vss pcb_foster_cell dx=6.5224348640653489e-04
Xn197 n197 n198 vss pcb_foster_cell dx=6.5224348640653489e-04
Xn198 n198 n199 vss pcb_foster_cell dx=6.5224348640653489e-04
Xn199 n199 n200 vss pcb_foster_cell dx=6.5224348640653489e-04
Xn200 n200 n201 vss pcb_foster_cell dx=6.5224348640653489e-04
Xn201 n201 n202 vss pcb_foster_cell dx=6.5224348640653489e-04
Xn202 n202 n203 vss pcb_foster_cell dx=6.5224348640653489e-04
Xn203 n203 n204 vss pcb_foster_cell dx=6.5224348640653489e-04
Xn204 n204 n205 vss pcb_foster_cell dx=6.5224348640653489e-04
Xn205 n205 n206 vss pcb_foster_cell dx=6.5224348640653489e-04
Xn206 n206 n207 vss pcb_foster_cell dx=6.5224348640653489e-04
Xn207 n207 n208 vss pcb_foster_cell dx=6.5224348640653489e-04
Xn208 n208 n209 vss pcb_foster_cell dx=6.5224348640653489e-04
Xn209 n209 n210 vss pcb_foster_cell dx=6.5224348640653489e-04
Xn210 n210 n211 vss pcb_foster_cell dx=6.5224348640653489e-04
Xn211 n211 n212 vss pcb_foster_cell dx=6.5224348640653489e-04
Xn212 n212 n213 vss pcb_foster_cell dx=6.5224348640653489e-04
Xn213 n213 n214 vss pcb_foster_cell dx=6.5224348640653489e-04
Xn214 n214 n215 vss pcb_foster_cell dx=6.5224348640653489e-04
Xn215 n215 n216 vss pcb_foster_cell dx=6.5224348640653489e-04
Xn216 n216 n217 vss pcb_foster_cell dx=6.5224348640653489e-04
Xn217 n217 n218 vss pcb_foster_cell dx=6.5224348640653489e-04
Xn218 n218 n219 vss pcb_foster_cell dx=6.5224348640653489e-04
Xn219 n219 n220 vss pcb_foster_cell dx=6.5224348640653489e-04
Xn220 n220 n221 vss pcb_foster_cell dx=6.5224348640653489e-04
Xn221 n221 n222 vss pcb_foster_cell dx=6.5224348640653489e-04
Xn222 n222 n223 vss pcb_foster_cell dx=6.5224348640653489e-04
Xn223 n223 n224 vss pcb_foster_cell dx=6.5224348640653489e-04
Xn224 n224 n225 vss pcb_foster_cell dx=6.5224348640653489e-04
Xn225 n225 n226 vss pcb_foster_cell dx=6.5224348640653489e-04
Xn226 n226 n227 vss pcb_foster_cell dx=6.5224348640653489e-04
Xn227 n227 n228 vss pcb_foster_cell dx=6.5224348640653489e-04
Xn228 n228 n229 vss pcb_foster_cell dx=6.5224348640653489e-04
Xn229 n229 bn vss pcb_foster_cell dx=6.5224348640653489e-04
.ends pcb_c1_loss3
