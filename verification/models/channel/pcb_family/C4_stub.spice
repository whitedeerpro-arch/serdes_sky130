* Synthetic PCB only: no package, pad, AC capacitors or termination.
* Include pcb_foster_cells.spice separately. vss is the ideal return reference.
.subckt pcb_c4_stub ap an bp bn vss
Xp0 ap p1 vss pcb_foster_cell dx=6.5222169355373335e-04
Xp1 p1 p2 vss pcb_foster_cell dx=6.5222169355373335e-04
Xp2 p2 p3 vss pcb_foster_cell dx=6.5222169355373335e-04
Xp3 p3 p4 vss pcb_foster_cell dx=6.5222169355373335e-04
Xp4 p4 p5 vss pcb_foster_cell dx=6.5222169355373335e-04
Xp5 p5 p6 vss pcb_foster_cell dx=6.5222169355373335e-04
Xp6 p6 p7 vss pcb_foster_cell dx=6.5222169355373335e-04
Xp7 p7 p8 vss pcb_foster_cell dx=6.5222169355373335e-04
Xp8 p8 p9 vss pcb_foster_cell dx=6.5222169355373335e-04
Xp9 p9 p10 vss pcb_foster_cell dx=6.5222169355373335e-04
Xp10 p10 p11 vss pcb_foster_cell dx=6.5222169355373335e-04
Xp11 p11 p12 vss pcb_foster_cell dx=6.5222169355373335e-04
Xp12 p12 p13 vss pcb_foster_cell dx=6.5222169355373335e-04
Xp13 p13 p14 vss pcb_foster_cell dx=6.5222169355373335e-04
Xp14 p14 p15 vss pcb_foster_cell dx=6.5222169355373335e-04
Xp15 p15 p16 vss pcb_foster_cell dx=6.5222169355373335e-04
Xp16 p16 p17 vss pcb_foster_cell dx=6.5222169355373335e-04
Xp17 p17 p18 vss pcb_foster_cell dx=6.5222169355373335e-04
Xp18 p18 p19 vss pcb_foster_cell dx=6.5222169355373335e-04
Xp19 p19 p20 vss pcb_foster_cell dx=6.5222169355373335e-04
Xp20 p20 p21 vss pcb_foster_cell dx=6.5222169355373335e-04
Xp21 p21 p22 vss pcb_foster_cell dx=6.5222169355373335e-04
Xp22 p22 p23 vss pcb_foster_cell dx=6.5222169355373335e-04
Xp23 p23 p24 vss pcb_foster_cell dx=6.5222169355373335e-04
Xp24 p24 p25 vss pcb_foster_cell dx=6.5222169355373335e-04
Xp25 p25 p26 vss pcb_foster_cell dx=6.5222169355373335e-04
Xp26 p26 p27 vss pcb_foster_cell dx=6.5222169355373335e-04
Xp27 p27 p28 vss pcb_foster_cell dx=6.5222169355373335e-04
Xp28 p28 p29 vss pcb_foster_cell dx=6.5222169355373335e-04
Xp29 p29 p30 vss pcb_foster_cell dx=6.5222169355373335e-04
Xp30 p30 p31 vss pcb_foster_cell dx=6.5222169355373335e-04
Xp31 p31 p32 vss pcb_foster_cell dx=6.5222169355373335e-04
Xp32 p32 p33 vss pcb_foster_cell dx=6.5222169355373335e-04
Xp33 p33 p34 vss pcb_foster_cell dx=6.5222169355373335e-04
Xp34 p34 p35 vss pcb_foster_cell dx=6.5222169355373335e-04
Xp35 p35 p36 vss pcb_foster_cell dx=6.5222169355373335e-04
Xp36 p36 p37 vss pcb_foster_cell dx=6.5222169355373335e-04
Xp37 p37 p38 vss pcb_foster_cell dx=6.5222169355373335e-04
Xp38 p38 p39 vss pcb_foster_cell dx=6.5222169355373335e-04
Xp39 p39 p40 vss pcb_foster_cell dx=6.5222169355373335e-04
Xp40 p40 p41 vss pcb_foster_cell dx=6.5222169355373335e-04
Xp41 p41 p42 vss pcb_foster_cell dx=6.5222169355373335e-04
Xp42 p42 p43 vss pcb_foster_cell dx=6.5222169355373335e-04
Xp43 p43 p44 vss pcb_foster_cell dx=6.5222169355373335e-04
Xp44 p44 p45 vss pcb_foster_cell dx=6.5222169355373335e-04
Xp45 p45 p46 vss pcb_foster_cell dx=6.5222169355373335e-04
Xp46 p46 p47 vss pcb_foster_cell dx=6.5222169355373335e-04
Xp47 p47 p48 vss pcb_foster_cell dx=6.5222169355373335e-04
Xp48 p48 p49 vss pcb_foster_cell dx=6.5222169355373335e-04
Xp49 p49 p50 vss pcb_foster_cell dx=6.5222169355373335e-04
Xp50 p50 p51 vss pcb_foster_cell dx=6.5222169355373335e-04
Xp51 p51 p52 vss pcb_foster_cell dx=6.5222169355373335e-04
Xp52 p52 p53 vss pcb_foster_cell dx=6.5222169355373335e-04
Xp53 p53 p54 vss pcb_foster_cell dx=6.5222169355373335e-04
Xp54 p54 p55 vss pcb_foster_cell dx=6.5222169355373335e-04
Xp55 p55 p56 vss pcb_foster_cell dx=6.5222169355373335e-04
Xp56 p56 p57 vss pcb_foster_cell dx=6.5222169355373335e-04
Xp57 p57 p58 vss pcb_foster_cell dx=6.5222169355373335e-04
Xp58 p58 p59 vss pcb_foster_cell dx=6.5222169355373335e-04
Xp59 p59 p60 vss pcb_foster_cell dx=6.5222169355373335e-04
Xp60 p60 p61 vss pcb_foster_cell dx=6.5222169355373335e-04
Xp61 p61 p62 vss pcb_foster_cell dx=6.5222169355373335e-04
Xp62 p62 p63 vss pcb_foster_cell dx=6.5222169355373335e-04
Xp63 p63 p64 vss pcb_foster_cell dx=6.5222169355373335e-04
Xp64 p64 p65 vss pcb_foster_cell dx=6.5222169355373335e-04
Xp65 p65 p66 vss pcb_foster_cell dx=6.5222169355373335e-04
Xp66 p66 p67 vss pcb_foster_cell dx=6.5222169355373335e-04
Xp67 p67 p68 vss pcb_foster_cell dx=6.5222169355373335e-04
Xp68 p68 p69 vss pcb_foster_cell dx=6.5222169355373335e-04
Xp69 p69 p70 vss pcb_foster_cell dx=6.5222169355373335e-04
Xp70 p70 p71 vss pcb_foster_cell dx=6.5222169355373335e-04
Xp71 p71 p72 vss pcb_foster_cell dx=6.5222169355373335e-04
Xp72 p72 p73 vss pcb_foster_cell dx=6.5222169355373335e-04
Xp73 p73 p74 vss pcb_foster_cell dx=6.5222169355373335e-04
Xp74 p74 p75 vss pcb_foster_cell dx=6.5222169355373335e-04
Xp75 p75 p76 vss pcb_foster_cell dx=6.5222169355373335e-04
Xp76 p76 p77 vss pcb_foster_cell dx=6.5222169355373335e-04
Xp77 p77 p78 vss pcb_foster_cell dx=6.5222169355373335e-04
Xp78 p78 p79 vss pcb_foster_cell dx=6.5222169355373335e-04
Xp79 p79 p80 vss pcb_foster_cell dx=6.5222169355373335e-04
Xp80 p80 p81 vss pcb_foster_cell dx=6.5222169355373335e-04
Xp81 p81 p82 vss pcb_foster_cell dx=6.5222169355373335e-04
Xp82 p82 p83 vss pcb_foster_cell dx=6.5222169355373335e-04
Xp83 p83 p84 vss pcb_foster_cell dx=6.5222169355373335e-04
Xp84 p84 p85 vss pcb_foster_cell dx=6.5222169355373335e-04
Xp85 p85 p86 vss pcb_foster_cell dx=6.5222169355373335e-04
Xp86 p86 p87 vss pcb_foster_cell dx=6.5222169355373335e-04
Xp87 p87 p88 vss pcb_foster_cell dx=6.5222169355373335e-04
Xp88 p88 p89 vss pcb_foster_cell dx=6.5222169355373335e-04
Xp89 p89 p90 vss pcb_foster_cell dx=6.5222169355373335e-04
Xp90 p90 p91 vss pcb_foster_cell dx=6.5222169355373335e-04
Xp91 p91 p92 vss pcb_foster_cell dx=6.5222169355373335e-04
Xp92 p92 p93 vss pcb_foster_cell dx=6.5222169355373335e-04
Xp93 p93 p94 vss pcb_foster_cell dx=6.5222169355373335e-04
Xp94 p94 p95 vss pcb_foster_cell dx=6.5222169355373335e-04
Xp95 p95 p96 vss pcb_foster_cell dx=6.5222169355373335e-04
Xp96 p96 p97 vss pcb_foster_cell dx=6.5222169355373335e-04
Xp97 p97 p98 vss pcb_foster_cell dx=6.5222169355373335e-04
Xp98 p98 p99 vss pcb_foster_cell dx=6.5222169355373335e-04
Xp99 p99 p100 vss pcb_foster_cell dx=6.5222169355373335e-04
Xp100 p100 p101 vss pcb_foster_cell dx=6.5222169355373335e-04
Xp101 p101 p102 vss pcb_foster_cell dx=6.5222169355373335e-04
Xp102 p102 p103 vss pcb_foster_cell dx=6.5222169355373335e-04
Xp103 p103 p104 vss pcb_foster_cell dx=6.5222169355373335e-04
Xp104 p104 p105 vss pcb_foster_cell dx=6.5222169355373335e-04
Xp105 p105 p106 vss pcb_foster_cell dx=6.5222169355373335e-04
Xp106 p106 p107 vss pcb_foster_cell dx=6.5222169355373335e-04
Xp107 p107 p108 vss pcb_foster_cell dx=6.5222169355373335e-04
Xp108 p108 p109 vss pcb_foster_cell dx=6.5222169355373335e-04
Xp109 p109 p110 vss pcb_foster_cell dx=6.5222169355373335e-04
Xp110 p110 p111 vss pcb_foster_cell dx=6.5222169355373335e-04
Xp111 p111 p112 vss pcb_foster_cell dx=6.5222169355373335e-04
Xp112 p112 p113 vss pcb_foster_cell dx=6.5222169355373335e-04
Xp113 p113 p114 vss pcb_foster_cell dx=6.5222169355373335e-04
Xp114 p114 p115 vss pcb_foster_cell dx=6.5222169355373335e-04
Xp115 p115 p116 vss pcb_foster_cell dx=6.5222169355373335e-04
Xp116 p116 p117 vss pcb_foster_cell dx=6.5222169355373335e-04
Xp117 p117 p118 vss pcb_foster_cell dx=6.5222169355373335e-04
Xp118 p118 p119 vss pcb_foster_cell dx=6.5222169355373335e-04
Xp119 p119 p120 vss pcb_foster_cell dx=6.5222169355373335e-04
Xp120 p120 p121 vss pcb_foster_cell dx=6.5222169355373335e-04
Xp121 p121 p122 vss pcb_foster_cell dx=6.5222169355373335e-04
Xp122 p122 p123 vss pcb_foster_cell dx=6.5222169355373335e-04
Xp123 p123 p124 vss pcb_foster_cell dx=6.5222169355373335e-04
Xp124 p124 p125 vss pcb_foster_cell dx=6.5222169355373335e-04
Xp125 p125 p126 vss pcb_foster_cell dx=6.5222169355373335e-04
Xp126 p126 p127 vss pcb_foster_cell dx=6.5222169355373335e-04
Xp127 p127 p128 vss pcb_foster_cell dx=6.5222169355373335e-04
Xp128 p128 p129 vss pcb_foster_cell dx=6.5222169355373335e-04
Xp129 p129 p130 vss pcb_foster_cell dx=6.5222169355373335e-04
Xp130 p130 p131 vss pcb_foster_cell dx=6.5222169355373335e-04
Xp131 p131 p132 vss pcb_foster_cell dx=6.5222169355373335e-04
Xp132 p132 p133 vss pcb_foster_cell dx=6.5222169355373335e-04
Xp133 p133 p134 vss pcb_foster_cell dx=6.5222169355373335e-04
Xp134 p134 p135 vss pcb_foster_cell dx=6.5222169355373335e-04
Xp135 p135 p136 vss pcb_foster_cell dx=6.5222169355373335e-04
Xp136 p136 p137 vss pcb_foster_cell dx=6.5222169355373335e-04
Xp137 p137 p138 vss pcb_foster_cell dx=6.5222169355373335e-04
Xp138 p138 p139 vss pcb_foster_cell dx=6.5222169355373335e-04
Xp139 p139 p140 vss pcb_foster_cell dx=6.5222169355373335e-04
Xp140 p140 p141 vss pcb_foster_cell dx=6.5222169355373335e-04
Xp141 p141 p142 vss pcb_foster_cell dx=6.5222169355373335e-04
Xp142 p142 p143 vss pcb_foster_cell dx=6.5222169355373335e-04
Xp143 p143 p144 vss pcb_foster_cell dx=6.5222169355373335e-04
Xp144 p144 p145 vss pcb_foster_cell dx=6.5222169355373335e-04
Xp145 p145 p146 vss pcb_foster_cell dx=6.5222169355373335e-04
Xp146 p146 p147 vss pcb_foster_cell dx=6.5222169355373335e-04
Xp147 p147 p148 vss pcb_foster_cell dx=6.5222169355373335e-04
Xp148 p148 p149 vss pcb_foster_cell dx=6.5222169355373335e-04
Xp149 p149 p150 vss pcb_foster_cell dx=6.5222169355373335e-04
Xp150 p150 p151 vss pcb_foster_cell dx=6.5222169355373335e-04
Xp151 p151 p152 vss pcb_foster_cell dx=6.5222169355373335e-04
Xp152 p152 p153 vss pcb_foster_cell dx=6.5222169355373335e-04
Xp153 p153 p154 vss pcb_foster_cell dx=6.5222169355373335e-04
Xp154 p154 p155 vss pcb_foster_cell dx=6.5222169355373335e-04
Xp155 p155 p156 vss pcb_foster_cell dx=6.5222169355373335e-04
Xp156 p156 p157 vss pcb_foster_cell dx=6.5222169355373335e-04
Xp157 p157 p158 vss pcb_foster_cell dx=6.5222169355373335e-04
Xp158 p158 p159 vss pcb_foster_cell dx=6.5222169355373335e-04
Xp159 p159 p160 vss pcb_foster_cell dx=6.5222169355373335e-04
Xp160 p160 p161 vss pcb_foster_cell dx=6.5222169355373335e-04
Xp161 p161 p162 vss pcb_foster_cell dx=6.5222169355373335e-04
Xp162 p162 p163 vss pcb_foster_cell dx=6.5222169355373335e-04
Xp163 p163 p164 vss pcb_foster_cell dx=6.5222169355373335e-04
Xp164 p164 p165 vss pcb_foster_cell dx=6.5222169355373335e-04
Xp165 p165 p166 vss pcb_foster_cell dx=6.5222169355373335e-04
Xp166 p166 p167 vss pcb_foster_cell dx=6.5222169355373335e-04
Xp167 p167 p168 vss pcb_foster_cell dx=6.5222169355373335e-04
Xp168 p168 p169 vss pcb_foster_cell dx=6.5222169355373335e-04
Xp169 p169 p170 vss pcb_foster_cell dx=6.5222169355373335e-04
Xp170 p170 p171 vss pcb_foster_cell dx=6.5222169355373335e-04
Xp171 p171 p172 vss pcb_foster_cell dx=6.5222169355373335e-04
Xp172 p172 p173 vss pcb_foster_cell dx=6.5222169355373335e-04
Xp173 p173 p174 vss pcb_foster_cell dx=6.5222169355373335e-04
Xp174 p174 p175 vss pcb_foster_cell dx=6.5222169355373335e-04
Xp175 p175 p176 vss pcb_foster_cell dx=6.5222169355373335e-04
Xp176 p176 p177 vss pcb_foster_cell dx=6.5222169355373335e-04
Xp177 p177 p178 vss pcb_foster_cell dx=6.5222169355373335e-04
Xp178 p178 p179 vss pcb_foster_cell dx=6.5222169355373335e-04
Xp179 p179 p180 vss pcb_foster_cell dx=6.5222169355373335e-04
Xp180 p180 p181 vss pcb_foster_cell dx=6.5222169355373335e-04
Xp181 p181 p182 vss pcb_foster_cell dx=6.5222169355373335e-04
Xp182 p182 p183 vss pcb_foster_cell dx=6.5222169355373335e-04
Xp183 p183 p184 vss pcb_foster_cell dx=6.5222169355373335e-04
Xp184 p184 p185 vss pcb_foster_cell dx=6.5222169355373335e-04
Xp185 p185 p186 vss pcb_foster_cell dx=6.5222169355373335e-04
Xp186 p186 p187 vss pcb_foster_cell dx=6.5222169355373335e-04
Xp187 p187 p188 vss pcb_foster_cell dx=6.5222169355373335e-04
Xp188 p188 p189 vss pcb_foster_cell dx=6.5222169355373335e-04
Xp189 p189 p190 vss pcb_foster_cell dx=6.5222169355373335e-04
Xp190 p190 p191 vss pcb_foster_cell dx=6.5222169355373335e-04
Xp191 p191 p192 vss pcb_foster_cell dx=6.5222169355373335e-04
Xp192 p192 p193 vss pcb_foster_cell dx=6.5222169355373335e-04
Xp193 p193 p194 vss pcb_foster_cell dx=6.5222169355373335e-04
Xp194 p194 p195 vss pcb_foster_cell dx=6.5222169355373335e-04
Xp195 p195 p196 vss pcb_foster_cell dx=6.5222169355373335e-04
Xp196 p196 p197 vss pcb_foster_cell dx=6.5222169355373335e-04
Xp197 p197 p198 vss pcb_foster_cell dx=6.5222169355373335e-04
Xp198 p198 p199 vss pcb_foster_cell dx=6.5222169355373335e-04
Xp199 p199 p200 vss pcb_foster_cell dx=6.5222169355373335e-04
Xp200 p200 p201 vss pcb_foster_cell dx=6.5222169355373335e-04
Xp201 p201 p202 vss pcb_foster_cell dx=6.5222169355373335e-04
Xp202 p202 p203 vss pcb_foster_cell dx=6.5222169355373335e-04
Xp203 p203 p204 vss pcb_foster_cell dx=6.5222169355373335e-04
Xp204 p204 p205 vss pcb_foster_cell dx=6.5222169355373335e-04
Xp205 p205 p206 vss pcb_foster_cell dx=6.5222169355373335e-04
Xp206 p206 p207 vss pcb_foster_cell dx=6.5222169355373335e-04
Xp207 p207 p208 vss pcb_foster_cell dx=6.5222169355373335e-04
Xp208 p208 p209 vss pcb_foster_cell dx=6.5222169355373335e-04
Xp209 p209 p210 vss pcb_foster_cell dx=6.5222169355373335e-04
Xp210 p210 p211 vss pcb_foster_cell dx=6.5222169355373335e-04
Xp211 p211 p212 vss pcb_foster_cell dx=6.5222169355373335e-04
Xp212 p212 p213 vss pcb_foster_cell dx=6.5222169355373335e-04
Xp213 p213 p214 vss pcb_foster_cell dx=6.5222169355373335e-04
Xp214 p214 p215 vss pcb_foster_cell dx=6.5222169355373335e-04
Xp215 p215 p216 vss pcb_foster_cell dx=6.5222169355373335e-04
Xp216 p216 p217 vss pcb_foster_cell dx=6.5222169355373335e-04
Xp217 p217 p218 vss pcb_foster_cell dx=6.5222169355373335e-04
Xp218 p218 p219 vss pcb_foster_cell dx=6.5222169355373335e-04
Xp219 p219 p220 vss pcb_foster_cell dx=6.5222169355373335e-04
Xp220 p220 p221 vss pcb_foster_cell dx=6.5222169355373335e-04
Xp221 p221 p222 vss pcb_foster_cell dx=6.5222169355373335e-04
Xp222 p222 p223 vss pcb_foster_cell dx=6.5222169355373335e-04
Xp223 p223 p224 vss pcb_foster_cell dx=6.5222169355373335e-04
Xp224 p224 p225 vss pcb_foster_cell dx=6.5222169355373335e-04
Xp225 p225 p226 vss pcb_foster_cell dx=6.5222169355373335e-04
Xp226 p226 p227 vss pcb_foster_cell dx=6.5222169355373335e-04
Xp227 p227 p228 vss pcb_foster_cell dx=6.5222169355373335e-04
Xp228 p228 p229 vss pcb_foster_cell dx=6.5222169355373335e-04
Xp229 p229 p230 vss pcb_foster_cell dx=6.5222169355373335e-04
Xp230 p230 p231 vss pcb_foster_cell dx=6.5222169355373335e-04
Xp231 p231 p232 vss pcb_foster_cell dx=6.5222169355373335e-04
Xp232 p232 p233 vss pcb_foster_cell dx=6.5222169355373335e-04
Xp233 p233 p234 vss pcb_foster_cell dx=6.5222169355373335e-04
Xp234 p234 p235 vss pcb_foster_cell dx=6.5222169355373335e-04
Xp235 p235 p236 vss pcb_foster_cell dx=6.5222169355373335e-04
Xp236 p236 p237 vss pcb_foster_cell dx=6.5222169355373335e-04
Xp237 p237 p238 vss pcb_foster_cell dx=6.5222169355373335e-04
Xp238 p238 p239 vss pcb_foster_cell dx=6.5222169355373335e-04
Xp239 p239 p240 vss pcb_foster_cell dx=6.5222169355373335e-04
Xp240 p240 p241 vss pcb_foster_cell dx=6.5222169355373335e-04
Xp241 p241 p242 vss pcb_foster_cell dx=6.5222169355373335e-04
Xp242 p242 p243 vss pcb_foster_cell dx=6.5222169355373335e-04
Xp243 p243 p244 vss pcb_foster_cell dx=6.5222169355373335e-04
Xp244 p244 p245 vss pcb_foster_cell dx=6.5222169355373335e-04
Xp245 p245 p246 vss pcb_foster_cell dx=6.5222169355373335e-04
Xp246 p246 p247 vss pcb_foster_cell dx=6.5222169355373335e-04
Xp247 p247 p248 vss pcb_foster_cell dx=6.5222169355373335e-04
Xp248 p248 p249 vss pcb_foster_cell dx=6.5222169355373335e-04
Xp249 p249 p250 vss pcb_foster_cell dx=6.5222169355373335e-04
Xp250 p250 p251 vss pcb_foster_cell dx=6.5222169355373335e-04
Xp251 p251 p252 vss pcb_foster_cell dx=6.5222169355373335e-04
Xp252 p252 p253 vss pcb_foster_cell dx=6.5222169355373335e-04
Xp253 p253 p254 vss pcb_foster_cell dx=6.5222169355373335e-04
Xp254 p254 p255 vss pcb_foster_cell dx=6.5222169355373335e-04
Xp255 p255 p256 vss pcb_foster_cell dx=6.5222169355373335e-04
Xp256 p256 p257 vss pcb_foster_cell dx=6.5222169355373335e-04
Xp257 p257 p258 vss pcb_foster_cell dx=6.5222169355373335e-04
Xp258 p258 p259 vss pcb_foster_cell dx=6.5222169355373335e-04
Xp259 p259 p260 vss pcb_foster_cell dx=6.5222169355373335e-04
Xp260 p260 p261 vss pcb_foster_cell dx=6.5222169355373335e-04
Xp261 p261 p262 vss pcb_foster_cell dx=6.5222169355373335e-04
Xp262 p262 p263 vss pcb_foster_cell dx=6.5222169355373335e-04
Xp263 p263 p264 vss pcb_foster_cell dx=6.5222169355373335e-04
Xp264 p264 p265 vss pcb_foster_cell dx=6.5222169355373335e-04
Xp265 p265 p266 vss pcb_foster_cell dx=6.5222169355373335e-04
Xp266 p266 p267 vss pcb_foster_cell dx=6.5222169355373335e-04
Xp267 p267 p268 vss pcb_foster_cell dx=6.5222169355373335e-04
Xp268 p268 p269 vss pcb_foster_cell dx=6.5222169355373335e-04
Xp269 p269 p270 vss pcb_foster_cell dx=6.5222169355373335e-04
Xp270 p270 p271 vss pcb_foster_cell dx=6.5222169355373335e-04
Xp271 p271 p272 vss pcb_foster_cell dx=6.5222169355373335e-04
Xp272 p272 p273 vss pcb_foster_cell dx=6.5222169355373335e-04
Xp273 p273 p274 vss pcb_foster_cell dx=6.5222169355373335e-04
Xp274 p274 p275 vss pcb_foster_cell dx=6.5222169355373335e-04
Xp275 p275 p276 vss pcb_foster_cell dx=6.5222169355373335e-04
Xp276 p276 p277 vss pcb_foster_cell dx=6.5222169355373335e-04
Xp277 p277 p278 vss pcb_foster_cell dx=6.5222169355373335e-04
Xp278 p278 p279 vss pcb_foster_cell dx=6.5222169355373335e-04
Xp279 p279 p280 vss pcb_foster_cell dx=6.5222169355373335e-04
Xp280 p280 p281 vss pcb_foster_cell dx=6.5222169355373335e-04
Xp281 p281 p282 vss pcb_foster_cell dx=6.5222169355373335e-04
Xp282 p282 p283 vss pcb_foster_cell dx=6.5222169355373335e-04
Xp283 p283 p284 vss pcb_foster_cell dx=6.5222169355373335e-04
Xp284 p284 p285 vss pcb_foster_cell dx=6.5222169355373335e-04
Xp285 p285 p286 vss pcb_foster_cell dx=6.5222169355373335e-04
Xp286 p286 p287 vss pcb_foster_cell dx=6.5222169355373335e-04
Xp287 p287 p288 vss pcb_foster_cell dx=6.5222169355373335e-04
Xp288 p288 p289 vss pcb_foster_cell dx=6.5222169355373335e-04
Xp289 p289 p290 vss pcb_foster_cell dx=6.5222169355373335e-04
Xp290 p290 p291 vss pcb_foster_cell dx=6.5222169355373335e-04
Xp291 p291 p292 vss pcb_foster_cell dx=6.5222169355373335e-04
Xp292 p292 p293 vss pcb_foster_cell dx=6.5222169355373335e-04
Xp293 p293 p294 vss pcb_foster_cell dx=6.5222169355373335e-04
Xp294 p294 p295 vss pcb_foster_cell dx=6.5222169355373335e-04
Xp295 p295 p296 vss pcb_foster_cell dx=6.5222169355373335e-04
Xp296 p296 p297 vss pcb_foster_cell dx=6.5222169355373335e-04
Xp297 p297 p298 vss pcb_foster_cell dx=6.5222169355373335e-04
Xp298 p298 p299 vss pcb_foster_cell dx=6.5222169355373335e-04
Xp299 p299 p300 vss pcb_foster_cell dx=6.5222169355373335e-04
Xp300 p300 p301 vss pcb_foster_cell dx=6.5222169355373335e-04
Xp301 p301 p302 vss pcb_foster_cell dx=6.5222169355373335e-04
Xp302 p302 p303 vss pcb_foster_cell dx=6.5222169355373335e-04
Xp303 p303 p304 vss pcb_foster_cell dx=6.5222169355373335e-04
Xp304 p304 p305 vss pcb_foster_cell dx=6.5222169355373335e-04
Xp305 p305 p306 vss pcb_foster_cell dx=6.5222169355373335e-04
Xp306 p306 p307 vss pcb_foster_cell dx=6.5222169355373335e-04
Xp307 p307 p308 vss pcb_foster_cell dx=6.5222169355373335e-04
Xp308 p308 p309 vss pcb_foster_cell dx=6.5222169355373335e-04
Xp309 p309 p310 vss pcb_foster_cell dx=6.5222169355373335e-04
Xp310 p310 p311 vss pcb_foster_cell dx=6.5222169355373335e-04
Xp311 p311 p312 vss pcb_foster_cell dx=6.5222169355373335e-04
Xp312 p312 p313 vss pcb_foster_cell dx=6.5222169355373335e-04
Xp313 p313 p314 vss pcb_foster_cell dx=6.5222169355373335e-04
Xp314 p314 p315 vss pcb_foster_cell dx=6.5222169355373335e-04
Xp315 p315 p316 vss pcb_foster_cell dx=6.5222169355373335e-04
Xp316 p316 p317 vss pcb_foster_cell dx=6.5222169355373335e-04
Xp317 p317 p318 vss pcb_foster_cell dx=6.5222169355373335e-04
Xp318 p318 p319 vss pcb_foster_cell dx=6.5222169355373335e-04
Xp319 p319 p320 vss pcb_foster_cell dx=6.5222169355373335e-04
Xp320 p320 p321 vss pcb_foster_cell dx=6.5222169355373335e-04
Xp321 p321 p322 vss pcb_foster_cell dx=6.5222169355373335e-04
Xp322 p322 p323 vss pcb_foster_cell dx=6.5222169355373335e-04
Xp323 p323 p324 vss pcb_foster_cell dx=6.5222169355373335e-04
Xp324 p324 p325 vss pcb_foster_cell dx=6.5222169355373335e-04
Xp325 p325 p326 vss pcb_foster_cell dx=6.5222169355373335e-04
Xp326 p326 p327 vss pcb_foster_cell dx=6.5222169355373335e-04
Xp327 p327 p328 vss pcb_foster_cell dx=6.5222169355373335e-04
Xp328 p328 p329 vss pcb_foster_cell dx=6.5222169355373335e-04
Xp329 p329 p330 vss pcb_foster_cell dx=6.5222169355373335e-04
Xp330 p330 p331 vss pcb_foster_cell dx=6.5222169355373335e-04
Xp331 p331 p332 vss pcb_foster_cell dx=6.5222169355373335e-04
Xp332 p332 p333 vss pcb_foster_cell dx=6.5222169355373335e-04
Xp333 p333 p334 vss pcb_foster_cell dx=6.5222169355373335e-04
Xp334 p334 p335 vss pcb_foster_cell dx=6.5222169355373335e-04
Xp335 p335 p336 vss pcb_foster_cell dx=6.5222169355373335e-04
Xp336 p336 p337 vss pcb_foster_cell dx=6.5222169355373335e-04
Xp337 p337 p338 vss pcb_foster_cell dx=6.5222169355373335e-04
Xp338 p338 p339 vss pcb_foster_cell dx=6.5222169355373335e-04
Xp339 p339 p340 vss pcb_foster_cell dx=6.5222169355373335e-04
Xp340 p340 p341 vss pcb_foster_cell dx=6.5222169355373335e-04
Xp341 p341 p342 vss pcb_foster_cell dx=6.5222169355373335e-04
Xp342 p342 p343 vss pcb_foster_cell dx=6.5222169355373335e-04
Xp343 p343 p344 vss pcb_foster_cell dx=6.5222169355373335e-04
Xp344 p344 p345 vss pcb_foster_cell dx=6.5222169355373335e-04
Xp345 p345 p346 vss pcb_foster_cell dx=6.5222169355373335e-04
Xp346 p346 p347 vss pcb_foster_cell dx=6.5222169355373335e-04
Xp347 p347 p348 vss pcb_foster_cell dx=6.5222169355373335e-04
Xp348 p348 p349 vss pcb_foster_cell dx=6.5222169355373335e-04
Xp349 p349 p350 vss pcb_foster_cell dx=6.5222169355373335e-04
Xp350 p350 p351 vss pcb_foster_cell dx=6.5222169355373335e-04
Xp351 p351 p352 vss pcb_foster_cell dx=6.5222169355373335e-04
Xp352 p352 p353 vss pcb_foster_cell dx=6.5222169355373335e-04
Xp353 p353 p354 vss pcb_foster_cell dx=6.5222169355373335e-04
Xp354 p354 p355 vss pcb_foster_cell dx=6.5222169355373335e-04
Xp355 p355 p356 vss pcb_foster_cell dx=6.5222169355373335e-04
Xp356 p356 p357 vss pcb_foster_cell dx=6.5222169355373335e-04
Xp357 p357 p358 vss pcb_foster_cell dx=6.5222169355373335e-04
Xp358 p358 p359 vss pcb_foster_cell dx=6.5222169355373335e-04
Xp359 p359 p360 vss pcb_foster_cell dx=6.5222169355373335e-04
Xp360 p360 p361 vss pcb_foster_cell dx=6.5222169355373335e-04
Xp361 p361 p362 vss pcb_foster_cell dx=6.5222169355373335e-04
Xp362 p362 p363 vss pcb_foster_cell dx=6.5222169355373335e-04
Xp363 p363 p364 vss pcb_foster_cell dx=6.5222169355373335e-04
Xp364 p364 p365 vss pcb_foster_cell dx=6.5222169355373335e-04
Xp365 p365 p366 vss pcb_foster_cell dx=6.5222169355373335e-04
Xp366 p366 p367 vss pcb_foster_cell dx=6.5222169355373335e-04
Xp367 p367 p368 vss pcb_foster_cell dx=6.5222169355373335e-04
Xp368 p368 p369 vss pcb_foster_cell dx=6.5222169355373335e-04
Xp369 p369 p370 vss pcb_foster_cell dx=6.5222169355373335e-04
Xp370 p370 p371 vss pcb_foster_cell dx=6.5222169355373335e-04
Xp371 p371 p372 vss pcb_foster_cell dx=6.5222169355373335e-04
Xp372 p372 p373 vss pcb_foster_cell dx=6.5222169355373335e-04
Xp373 p373 p374 vss pcb_foster_cell dx=6.5222169355373335e-04
Xp374 p374 p375 vss pcb_foster_cell dx=6.5222169355373335e-04
Xp375 p375 p376 vss pcb_foster_cell dx=6.5222169355373335e-04
Xp376 p376 p377 vss pcb_foster_cell dx=6.5222169355373335e-04
Xp377 p377 p378 vss pcb_foster_cell dx=6.5222169355373335e-04
Xp378 p378 p379 vss pcb_foster_cell dx=6.5222169355373335e-04
Xp379 p379 p380 vss pcb_foster_cell dx=6.5222169355373335e-04
Xp380 p380 p381 vss pcb_foster_cell dx=6.5222169355373335e-04
Xp381 p381 p382 vss pcb_foster_cell dx=6.5222169355373335e-04
Xp382 p382 p383 vss pcb_foster_cell dx=6.5222169355373335e-04
Xp383 p383 p384 vss pcb_foster_cell dx=6.5222169355373335e-04
Xp384 p384 p385 vss pcb_foster_cell dx=6.5222169355373335e-04
Xp385 p385 p386 vss pcb_foster_cell dx=6.5222169355373335e-04
Xp386 p386 p387 vss pcb_foster_cell dx=6.5222169355373335e-04
Xp387 p387 p388 vss pcb_foster_cell dx=6.5222169355373335e-04
Xp388 p388 p389 vss pcb_foster_cell dx=6.5222169355373335e-04
Xp389 p389 p390 vss pcb_foster_cell dx=6.5222169355373335e-04
Xp390 p390 p391 vss pcb_foster_cell dx=6.5222169355373335e-04
Xp391 p391 p392 vss pcb_foster_cell dx=6.5222169355373335e-04
Xp392 p392 p393 vss pcb_foster_cell dx=6.5222169355373335e-04
Xp393 p393 p394 vss pcb_foster_cell dx=6.5222169355373335e-04
Xp394 p394 p395 vss pcb_foster_cell dx=6.5222169355373335e-04
Xp395 p395 p396 vss pcb_foster_cell dx=6.5222169355373335e-04
Xp396 p396 p397 vss pcb_foster_cell dx=6.5222169355373335e-04
Xp397 p397 p398 vss pcb_foster_cell dx=6.5222169355373335e-04
Xp398 p398 p399 vss pcb_foster_cell dx=6.5222169355373335e-04
Xp399 p399 p400 vss pcb_foster_cell dx=6.5222169355373335e-04
Xp400 p400 p401 vss pcb_foster_cell dx=6.5222169355373335e-04
Xp401 p401 p402 vss pcb_foster_cell dx=6.5222169355373335e-04
Xp402 p402 p403 vss pcb_foster_cell dx=6.5222169355373335e-04
Xp403 p403 p404 vss pcb_foster_cell dx=6.5222169355373335e-04
Xp404 p404 p405 vss pcb_foster_cell dx=6.5222169355373335e-04
Xp405 p405 p406 vss pcb_foster_cell dx=6.5222169355373335e-04
Xp406 p406 p407 vss pcb_foster_cell dx=6.5222169355373335e-04
Xp407 p407 p408 vss pcb_foster_cell dx=6.5222169355373335e-04
Xp408 p408 p409 vss pcb_foster_cell dx=6.5222169355373335e-04
Xp409 p409 p410 vss pcb_foster_cell dx=6.5222169355373335e-04
Xp410 p410 p411 vss pcb_foster_cell dx=6.5222169355373335e-04
Xp411 p411 p412 vss pcb_foster_cell dx=6.5222169355373335e-04
Xp412 p412 p413 vss pcb_foster_cell dx=6.5222169355373335e-04
Xp413 p413 p414 vss pcb_foster_cell dx=6.5222169355373335e-04
Xp414 p414 p415 vss pcb_foster_cell dx=6.5222169355373335e-04
Xp415 p415 p416 vss pcb_foster_cell dx=6.5222169355373335e-04
Xp416 p416 p417 vss pcb_foster_cell dx=6.5222169355373335e-04
Xp417 p417 p418 vss pcb_foster_cell dx=6.5222169355373335e-04
Xp418 p418 p419 vss pcb_foster_cell dx=6.5222169355373335e-04
Xp419 p419 p420 vss pcb_foster_cell dx=6.5222169355373335e-04
Xp420 p420 p421 vss pcb_foster_cell dx=6.5222169355373335e-04
Xp421 p421 p422 vss pcb_foster_cell dx=6.5222169355373335e-04
Xp422 p422 p423 vss pcb_foster_cell dx=6.5222169355373335e-04
Xp423 p423 p424 vss pcb_foster_cell dx=6.5222169355373335e-04
Xp424 p424 p425 vss pcb_foster_cell dx=6.5222169355373335e-04
Xp425 p425 p426 vss pcb_foster_cell dx=6.5222169355373335e-04
Xp426 p426 p427 vss pcb_foster_cell dx=6.5222169355373335e-04
Xp427 p427 p428 vss pcb_foster_cell dx=6.5222169355373335e-04
Xp428 p428 p429 vss pcb_foster_cell dx=6.5222169355373335e-04
Xp429 p429 p430 vss pcb_foster_cell dx=6.5222169355373335e-04
Xp430 p430 p431 vss pcb_foster_cell dx=6.5222169355373335e-04
Xp431 p431 p432 vss pcb_foster_cell dx=6.5222169355373335e-04
Xp432 p432 p433 vss pcb_foster_cell dx=6.5222169355373335e-04
Xp433 p433 p434 vss pcb_foster_cell dx=6.5222169355373335e-04
Xp434 p434 p435 vss pcb_foster_cell dx=6.5222169355373335e-04
Xp435 p435 p436 vss pcb_foster_cell dx=6.5222169355373335e-04
Xp436 p436 p437 vss pcb_foster_cell dx=6.5222169355373335e-04
Xp437 p437 p438 vss pcb_foster_cell dx=6.5222169355373335e-04
Xp438 p438 p439 vss pcb_foster_cell dx=6.5222169355373335e-04
Xp439 p439 p440 vss pcb_foster_cell dx=6.5222169355373335e-04
Xp440 p440 p441 vss pcb_foster_cell dx=6.5222169355373335e-04
Xp441 p441 p442 vss pcb_foster_cell dx=6.5222169355373335e-04
Xp442 p442 p443 vss pcb_foster_cell dx=6.5222169355373335e-04
Xp443 p443 p444 vss pcb_foster_cell dx=6.5222169355373335e-04
Xp444 p444 p445 vss pcb_foster_cell dx=6.5222169355373335e-04
Xp445 p445 p446 vss pcb_foster_cell dx=6.5222169355373335e-04
Xp446 p446 p447 vss pcb_foster_cell dx=6.5222169355373335e-04
Xp447 p447 p448 vss pcb_foster_cell dx=6.5222169355373335e-04
Xp448 p448 p449 vss pcb_foster_cell dx=6.5222169355373335e-04
Xp449 p449 p450 vss pcb_foster_cell dx=6.5222169355373335e-04
Xp450 p450 p451 vss pcb_foster_cell dx=6.5222169355373335e-04
Xp451 p451 p452 vss pcb_foster_cell dx=6.5222169355373335e-04
Xp452 p452 p453 vss pcb_foster_cell dx=6.5222169355373335e-04
Xp453 p453 p454 vss pcb_foster_cell dx=6.5222169355373335e-04
Xp454 p454 p455 vss pcb_foster_cell dx=6.5222169355373335e-04
Xp455 p455 p456 vss pcb_foster_cell dx=6.5222169355373335e-04
Xp456 p456 p457 vss pcb_foster_cell dx=6.5222169355373335e-04
Xp457 p457 p458 vss pcb_foster_cell dx=6.5222169355373335e-04
Xp458 p458 p459 vss pcb_foster_cell dx=6.5222169355373335e-04
Xp459 p459 bp vss pcb_foster_cell dx=6.5222169355373335e-04
Rpstub p230 ps0 10.0
Xps0 ps0 ps1 vss pcb_foster_cell dx=6.3453268788073983e-04
Xps1 ps1 ps2 vss pcb_foster_cell dx=6.3453268788073983e-04
Xps2 ps2 ps3 vss pcb_foster_cell dx=6.3453268788073983e-04
Xps3 ps3 ps4 vss pcb_foster_cell dx=6.3453268788073983e-04
Xps4 ps4 ps5 vss pcb_foster_cell dx=6.3453268788073983e-04
Xps5 ps5 ps6 vss pcb_foster_cell dx=6.3453268788073983e-04
Xps6 ps6 ps7 vss pcb_foster_cell dx=6.3453268788073983e-04
Xps7 ps7 ps8 vss pcb_foster_cell dx=6.3453268788073983e-04
Xps8 ps8 ps9 vss pcb_foster_cell dx=6.3453268788073983e-04
Xps9 ps9 ps10 vss pcb_foster_cell dx=6.3453268788073983e-04
Xps10 ps10 ps11 vss pcb_foster_cell dx=6.3453268788073983e-04
Xps11 ps11 ps12 vss pcb_foster_cell dx=6.3453268788073983e-04
Xps12 ps12 ps13 vss pcb_foster_cell dx=6.3453268788073983e-04
Xps13 ps13 ps14 vss pcb_foster_cell dx=6.3453268788073983e-04
Xps14 ps14 ps15 vss pcb_foster_cell dx=6.3453268788073983e-04
Xps15 ps15 ps16 vss pcb_foster_cell dx=6.3453268788073983e-04
Xps16 ps16 ps17 vss pcb_foster_cell dx=6.3453268788073983e-04
Xps17 ps17 ps18 vss pcb_foster_cell dx=6.3453268788073983e-04
Xps18 ps18 ps19 vss pcb_foster_cell dx=6.3453268788073983e-04
Xps19 ps19 ps20 vss pcb_foster_cell dx=6.3453268788073983e-04
Xps20 ps20 ps21 vss pcb_foster_cell dx=6.3453268788073983e-04
Xps21 ps21 ps22 vss pcb_foster_cell dx=6.3453268788073983e-04
Xps22 ps22 ps23 vss pcb_foster_cell dx=6.3453268788073983e-04
Xps23 ps23 ps24 vss pcb_foster_cell dx=6.3453268788073983e-04
Xps24 ps24 ps25 vss pcb_foster_cell dx=6.3453268788073983e-04
Xps25 ps25 ps26 vss pcb_foster_cell dx=6.3453268788073983e-04
Xps26 ps26 ps27 vss pcb_foster_cell dx=6.3453268788073983e-04
Xps27 ps27 ps28 vss pcb_foster_cell dx=6.3453268788073983e-04
Xps28 ps28 ps29 vss pcb_foster_cell dx=6.3453268788073983e-04
Xps29 ps29 ps30 vss pcb_foster_cell dx=6.3453268788073983e-04
Xps30 ps30 ps31 vss pcb_foster_cell dx=6.3453268788073983e-04
Xps31 ps31 ps32 vss pcb_foster_cell dx=6.3453268788073983e-04
Xps32 ps32 ps33 vss pcb_foster_cell dx=6.3453268788073983e-04
Xn0 an n1 vss pcb_foster_cell dx=6.5222169355373335e-04
Xn1 n1 n2 vss pcb_foster_cell dx=6.5222169355373335e-04
Xn2 n2 n3 vss pcb_foster_cell dx=6.5222169355373335e-04
Xn3 n3 n4 vss pcb_foster_cell dx=6.5222169355373335e-04
Xn4 n4 n5 vss pcb_foster_cell dx=6.5222169355373335e-04
Xn5 n5 n6 vss pcb_foster_cell dx=6.5222169355373335e-04
Xn6 n6 n7 vss pcb_foster_cell dx=6.5222169355373335e-04
Xn7 n7 n8 vss pcb_foster_cell dx=6.5222169355373335e-04
Xn8 n8 n9 vss pcb_foster_cell dx=6.5222169355373335e-04
Xn9 n9 n10 vss pcb_foster_cell dx=6.5222169355373335e-04
Xn10 n10 n11 vss pcb_foster_cell dx=6.5222169355373335e-04
Xn11 n11 n12 vss pcb_foster_cell dx=6.5222169355373335e-04
Xn12 n12 n13 vss pcb_foster_cell dx=6.5222169355373335e-04
Xn13 n13 n14 vss pcb_foster_cell dx=6.5222169355373335e-04
Xn14 n14 n15 vss pcb_foster_cell dx=6.5222169355373335e-04
Xn15 n15 n16 vss pcb_foster_cell dx=6.5222169355373335e-04
Xn16 n16 n17 vss pcb_foster_cell dx=6.5222169355373335e-04
Xn17 n17 n18 vss pcb_foster_cell dx=6.5222169355373335e-04
Xn18 n18 n19 vss pcb_foster_cell dx=6.5222169355373335e-04
Xn19 n19 n20 vss pcb_foster_cell dx=6.5222169355373335e-04
Xn20 n20 n21 vss pcb_foster_cell dx=6.5222169355373335e-04
Xn21 n21 n22 vss pcb_foster_cell dx=6.5222169355373335e-04
Xn22 n22 n23 vss pcb_foster_cell dx=6.5222169355373335e-04
Xn23 n23 n24 vss pcb_foster_cell dx=6.5222169355373335e-04
Xn24 n24 n25 vss pcb_foster_cell dx=6.5222169355373335e-04
Xn25 n25 n26 vss pcb_foster_cell dx=6.5222169355373335e-04
Xn26 n26 n27 vss pcb_foster_cell dx=6.5222169355373335e-04
Xn27 n27 n28 vss pcb_foster_cell dx=6.5222169355373335e-04
Xn28 n28 n29 vss pcb_foster_cell dx=6.5222169355373335e-04
Xn29 n29 n30 vss pcb_foster_cell dx=6.5222169355373335e-04
Xn30 n30 n31 vss pcb_foster_cell dx=6.5222169355373335e-04
Xn31 n31 n32 vss pcb_foster_cell dx=6.5222169355373335e-04
Xn32 n32 n33 vss pcb_foster_cell dx=6.5222169355373335e-04
Xn33 n33 n34 vss pcb_foster_cell dx=6.5222169355373335e-04
Xn34 n34 n35 vss pcb_foster_cell dx=6.5222169355373335e-04
Xn35 n35 n36 vss pcb_foster_cell dx=6.5222169355373335e-04
Xn36 n36 n37 vss pcb_foster_cell dx=6.5222169355373335e-04
Xn37 n37 n38 vss pcb_foster_cell dx=6.5222169355373335e-04
Xn38 n38 n39 vss pcb_foster_cell dx=6.5222169355373335e-04
Xn39 n39 n40 vss pcb_foster_cell dx=6.5222169355373335e-04
Xn40 n40 n41 vss pcb_foster_cell dx=6.5222169355373335e-04
Xn41 n41 n42 vss pcb_foster_cell dx=6.5222169355373335e-04
Xn42 n42 n43 vss pcb_foster_cell dx=6.5222169355373335e-04
Xn43 n43 n44 vss pcb_foster_cell dx=6.5222169355373335e-04
Xn44 n44 n45 vss pcb_foster_cell dx=6.5222169355373335e-04
Xn45 n45 n46 vss pcb_foster_cell dx=6.5222169355373335e-04
Xn46 n46 n47 vss pcb_foster_cell dx=6.5222169355373335e-04
Xn47 n47 n48 vss pcb_foster_cell dx=6.5222169355373335e-04
Xn48 n48 n49 vss pcb_foster_cell dx=6.5222169355373335e-04
Xn49 n49 n50 vss pcb_foster_cell dx=6.5222169355373335e-04
Xn50 n50 n51 vss pcb_foster_cell dx=6.5222169355373335e-04
Xn51 n51 n52 vss pcb_foster_cell dx=6.5222169355373335e-04
Xn52 n52 n53 vss pcb_foster_cell dx=6.5222169355373335e-04
Xn53 n53 n54 vss pcb_foster_cell dx=6.5222169355373335e-04
Xn54 n54 n55 vss pcb_foster_cell dx=6.5222169355373335e-04
Xn55 n55 n56 vss pcb_foster_cell dx=6.5222169355373335e-04
Xn56 n56 n57 vss pcb_foster_cell dx=6.5222169355373335e-04
Xn57 n57 n58 vss pcb_foster_cell dx=6.5222169355373335e-04
Xn58 n58 n59 vss pcb_foster_cell dx=6.5222169355373335e-04
Xn59 n59 n60 vss pcb_foster_cell dx=6.5222169355373335e-04
Xn60 n60 n61 vss pcb_foster_cell dx=6.5222169355373335e-04
Xn61 n61 n62 vss pcb_foster_cell dx=6.5222169355373335e-04
Xn62 n62 n63 vss pcb_foster_cell dx=6.5222169355373335e-04
Xn63 n63 n64 vss pcb_foster_cell dx=6.5222169355373335e-04
Xn64 n64 n65 vss pcb_foster_cell dx=6.5222169355373335e-04
Xn65 n65 n66 vss pcb_foster_cell dx=6.5222169355373335e-04
Xn66 n66 n67 vss pcb_foster_cell dx=6.5222169355373335e-04
Xn67 n67 n68 vss pcb_foster_cell dx=6.5222169355373335e-04
Xn68 n68 n69 vss pcb_foster_cell dx=6.5222169355373335e-04
Xn69 n69 n70 vss pcb_foster_cell dx=6.5222169355373335e-04
Xn70 n70 n71 vss pcb_foster_cell dx=6.5222169355373335e-04
Xn71 n71 n72 vss pcb_foster_cell dx=6.5222169355373335e-04
Xn72 n72 n73 vss pcb_foster_cell dx=6.5222169355373335e-04
Xn73 n73 n74 vss pcb_foster_cell dx=6.5222169355373335e-04
Xn74 n74 n75 vss pcb_foster_cell dx=6.5222169355373335e-04
Xn75 n75 n76 vss pcb_foster_cell dx=6.5222169355373335e-04
Xn76 n76 n77 vss pcb_foster_cell dx=6.5222169355373335e-04
Xn77 n77 n78 vss pcb_foster_cell dx=6.5222169355373335e-04
Xn78 n78 n79 vss pcb_foster_cell dx=6.5222169355373335e-04
Xn79 n79 n80 vss pcb_foster_cell dx=6.5222169355373335e-04
Xn80 n80 n81 vss pcb_foster_cell dx=6.5222169355373335e-04
Xn81 n81 n82 vss pcb_foster_cell dx=6.5222169355373335e-04
Xn82 n82 n83 vss pcb_foster_cell dx=6.5222169355373335e-04
Xn83 n83 n84 vss pcb_foster_cell dx=6.5222169355373335e-04
Xn84 n84 n85 vss pcb_foster_cell dx=6.5222169355373335e-04
Xn85 n85 n86 vss pcb_foster_cell dx=6.5222169355373335e-04
Xn86 n86 n87 vss pcb_foster_cell dx=6.5222169355373335e-04
Xn87 n87 n88 vss pcb_foster_cell dx=6.5222169355373335e-04
Xn88 n88 n89 vss pcb_foster_cell dx=6.5222169355373335e-04
Xn89 n89 n90 vss pcb_foster_cell dx=6.5222169355373335e-04
Xn90 n90 n91 vss pcb_foster_cell dx=6.5222169355373335e-04
Xn91 n91 n92 vss pcb_foster_cell dx=6.5222169355373335e-04
Xn92 n92 n93 vss pcb_foster_cell dx=6.5222169355373335e-04
Xn93 n93 n94 vss pcb_foster_cell dx=6.5222169355373335e-04
Xn94 n94 n95 vss pcb_foster_cell dx=6.5222169355373335e-04
Xn95 n95 n96 vss pcb_foster_cell dx=6.5222169355373335e-04
Xn96 n96 n97 vss pcb_foster_cell dx=6.5222169355373335e-04
Xn97 n97 n98 vss pcb_foster_cell dx=6.5222169355373335e-04
Xn98 n98 n99 vss pcb_foster_cell dx=6.5222169355373335e-04
Xn99 n99 n100 vss pcb_foster_cell dx=6.5222169355373335e-04
Xn100 n100 n101 vss pcb_foster_cell dx=6.5222169355373335e-04
Xn101 n101 n102 vss pcb_foster_cell dx=6.5222169355373335e-04
Xn102 n102 n103 vss pcb_foster_cell dx=6.5222169355373335e-04
Xn103 n103 n104 vss pcb_foster_cell dx=6.5222169355373335e-04
Xn104 n104 n105 vss pcb_foster_cell dx=6.5222169355373335e-04
Xn105 n105 n106 vss pcb_foster_cell dx=6.5222169355373335e-04
Xn106 n106 n107 vss pcb_foster_cell dx=6.5222169355373335e-04
Xn107 n107 n108 vss pcb_foster_cell dx=6.5222169355373335e-04
Xn108 n108 n109 vss pcb_foster_cell dx=6.5222169355373335e-04
Xn109 n109 n110 vss pcb_foster_cell dx=6.5222169355373335e-04
Xn110 n110 n111 vss pcb_foster_cell dx=6.5222169355373335e-04
Xn111 n111 n112 vss pcb_foster_cell dx=6.5222169355373335e-04
Xn112 n112 n113 vss pcb_foster_cell dx=6.5222169355373335e-04
Xn113 n113 n114 vss pcb_foster_cell dx=6.5222169355373335e-04
Xn114 n114 n115 vss pcb_foster_cell dx=6.5222169355373335e-04
Xn115 n115 n116 vss pcb_foster_cell dx=6.5222169355373335e-04
Xn116 n116 n117 vss pcb_foster_cell dx=6.5222169355373335e-04
Xn117 n117 n118 vss pcb_foster_cell dx=6.5222169355373335e-04
Xn118 n118 n119 vss pcb_foster_cell dx=6.5222169355373335e-04
Xn119 n119 n120 vss pcb_foster_cell dx=6.5222169355373335e-04
Xn120 n120 n121 vss pcb_foster_cell dx=6.5222169355373335e-04
Xn121 n121 n122 vss pcb_foster_cell dx=6.5222169355373335e-04
Xn122 n122 n123 vss pcb_foster_cell dx=6.5222169355373335e-04
Xn123 n123 n124 vss pcb_foster_cell dx=6.5222169355373335e-04
Xn124 n124 n125 vss pcb_foster_cell dx=6.5222169355373335e-04
Xn125 n125 n126 vss pcb_foster_cell dx=6.5222169355373335e-04
Xn126 n126 n127 vss pcb_foster_cell dx=6.5222169355373335e-04
Xn127 n127 n128 vss pcb_foster_cell dx=6.5222169355373335e-04
Xn128 n128 n129 vss pcb_foster_cell dx=6.5222169355373335e-04
Xn129 n129 n130 vss pcb_foster_cell dx=6.5222169355373335e-04
Xn130 n130 n131 vss pcb_foster_cell dx=6.5222169355373335e-04
Xn131 n131 n132 vss pcb_foster_cell dx=6.5222169355373335e-04
Xn132 n132 n133 vss pcb_foster_cell dx=6.5222169355373335e-04
Xn133 n133 n134 vss pcb_foster_cell dx=6.5222169355373335e-04
Xn134 n134 n135 vss pcb_foster_cell dx=6.5222169355373335e-04
Xn135 n135 n136 vss pcb_foster_cell dx=6.5222169355373335e-04
Xn136 n136 n137 vss pcb_foster_cell dx=6.5222169355373335e-04
Xn137 n137 n138 vss pcb_foster_cell dx=6.5222169355373335e-04
Xn138 n138 n139 vss pcb_foster_cell dx=6.5222169355373335e-04
Xn139 n139 n140 vss pcb_foster_cell dx=6.5222169355373335e-04
Xn140 n140 n141 vss pcb_foster_cell dx=6.5222169355373335e-04
Xn141 n141 n142 vss pcb_foster_cell dx=6.5222169355373335e-04
Xn142 n142 n143 vss pcb_foster_cell dx=6.5222169355373335e-04
Xn143 n143 n144 vss pcb_foster_cell dx=6.5222169355373335e-04
Xn144 n144 n145 vss pcb_foster_cell dx=6.5222169355373335e-04
Xn145 n145 n146 vss pcb_foster_cell dx=6.5222169355373335e-04
Xn146 n146 n147 vss pcb_foster_cell dx=6.5222169355373335e-04
Xn147 n147 n148 vss pcb_foster_cell dx=6.5222169355373335e-04
Xn148 n148 n149 vss pcb_foster_cell dx=6.5222169355373335e-04
Xn149 n149 n150 vss pcb_foster_cell dx=6.5222169355373335e-04
Xn150 n150 n151 vss pcb_foster_cell dx=6.5222169355373335e-04
Xn151 n151 n152 vss pcb_foster_cell dx=6.5222169355373335e-04
Xn152 n152 n153 vss pcb_foster_cell dx=6.5222169355373335e-04
Xn153 n153 n154 vss pcb_foster_cell dx=6.5222169355373335e-04
Xn154 n154 n155 vss pcb_foster_cell dx=6.5222169355373335e-04
Xn155 n155 n156 vss pcb_foster_cell dx=6.5222169355373335e-04
Xn156 n156 n157 vss pcb_foster_cell dx=6.5222169355373335e-04
Xn157 n157 n158 vss pcb_foster_cell dx=6.5222169355373335e-04
Xn158 n158 n159 vss pcb_foster_cell dx=6.5222169355373335e-04
Xn159 n159 n160 vss pcb_foster_cell dx=6.5222169355373335e-04
Xn160 n160 n161 vss pcb_foster_cell dx=6.5222169355373335e-04
Xn161 n161 n162 vss pcb_foster_cell dx=6.5222169355373335e-04
Xn162 n162 n163 vss pcb_foster_cell dx=6.5222169355373335e-04
Xn163 n163 n164 vss pcb_foster_cell dx=6.5222169355373335e-04
Xn164 n164 n165 vss pcb_foster_cell dx=6.5222169355373335e-04
Xn165 n165 n166 vss pcb_foster_cell dx=6.5222169355373335e-04
Xn166 n166 n167 vss pcb_foster_cell dx=6.5222169355373335e-04
Xn167 n167 n168 vss pcb_foster_cell dx=6.5222169355373335e-04
Xn168 n168 n169 vss pcb_foster_cell dx=6.5222169355373335e-04
Xn169 n169 n170 vss pcb_foster_cell dx=6.5222169355373335e-04
Xn170 n170 n171 vss pcb_foster_cell dx=6.5222169355373335e-04
Xn171 n171 n172 vss pcb_foster_cell dx=6.5222169355373335e-04
Xn172 n172 n173 vss pcb_foster_cell dx=6.5222169355373335e-04
Xn173 n173 n174 vss pcb_foster_cell dx=6.5222169355373335e-04
Xn174 n174 n175 vss pcb_foster_cell dx=6.5222169355373335e-04
Xn175 n175 n176 vss pcb_foster_cell dx=6.5222169355373335e-04
Xn176 n176 n177 vss pcb_foster_cell dx=6.5222169355373335e-04
Xn177 n177 n178 vss pcb_foster_cell dx=6.5222169355373335e-04
Xn178 n178 n179 vss pcb_foster_cell dx=6.5222169355373335e-04
Xn179 n179 n180 vss pcb_foster_cell dx=6.5222169355373335e-04
Xn180 n180 n181 vss pcb_foster_cell dx=6.5222169355373335e-04
Xn181 n181 n182 vss pcb_foster_cell dx=6.5222169355373335e-04
Xn182 n182 n183 vss pcb_foster_cell dx=6.5222169355373335e-04
Xn183 n183 n184 vss pcb_foster_cell dx=6.5222169355373335e-04
Xn184 n184 n185 vss pcb_foster_cell dx=6.5222169355373335e-04
Xn185 n185 n186 vss pcb_foster_cell dx=6.5222169355373335e-04
Xn186 n186 n187 vss pcb_foster_cell dx=6.5222169355373335e-04
Xn187 n187 n188 vss pcb_foster_cell dx=6.5222169355373335e-04
Xn188 n188 n189 vss pcb_foster_cell dx=6.5222169355373335e-04
Xn189 n189 n190 vss pcb_foster_cell dx=6.5222169355373335e-04
Xn190 n190 n191 vss pcb_foster_cell dx=6.5222169355373335e-04
Xn191 n191 n192 vss pcb_foster_cell dx=6.5222169355373335e-04
Xn192 n192 n193 vss pcb_foster_cell dx=6.5222169355373335e-04
Xn193 n193 n194 vss pcb_foster_cell dx=6.5222169355373335e-04
Xn194 n194 n195 vss pcb_foster_cell dx=6.5222169355373335e-04
Xn195 n195 n196 vss pcb_foster_cell dx=6.5222169355373335e-04
Xn196 n196 n197 vss pcb_foster_cell dx=6.5222169355373335e-04
Xn197 n197 n198 vss pcb_foster_cell dx=6.5222169355373335e-04
Xn198 n198 n199 vss pcb_foster_cell dx=6.5222169355373335e-04
Xn199 n199 n200 vss pcb_foster_cell dx=6.5222169355373335e-04
Xn200 n200 n201 vss pcb_foster_cell dx=6.5222169355373335e-04
Xn201 n201 n202 vss pcb_foster_cell dx=6.5222169355373335e-04
Xn202 n202 n203 vss pcb_foster_cell dx=6.5222169355373335e-04
Xn203 n203 n204 vss pcb_foster_cell dx=6.5222169355373335e-04
Xn204 n204 n205 vss pcb_foster_cell dx=6.5222169355373335e-04
Xn205 n205 n206 vss pcb_foster_cell dx=6.5222169355373335e-04
Xn206 n206 n207 vss pcb_foster_cell dx=6.5222169355373335e-04
Xn207 n207 n208 vss pcb_foster_cell dx=6.5222169355373335e-04
Xn208 n208 n209 vss pcb_foster_cell dx=6.5222169355373335e-04
Xn209 n209 n210 vss pcb_foster_cell dx=6.5222169355373335e-04
Xn210 n210 n211 vss pcb_foster_cell dx=6.5222169355373335e-04
Xn211 n211 n212 vss pcb_foster_cell dx=6.5222169355373335e-04
Xn212 n212 n213 vss pcb_foster_cell dx=6.5222169355373335e-04
Xn213 n213 n214 vss pcb_foster_cell dx=6.5222169355373335e-04
Xn214 n214 n215 vss pcb_foster_cell dx=6.5222169355373335e-04
Xn215 n215 n216 vss pcb_foster_cell dx=6.5222169355373335e-04
Xn216 n216 n217 vss pcb_foster_cell dx=6.5222169355373335e-04
Xn217 n217 n218 vss pcb_foster_cell dx=6.5222169355373335e-04
Xn218 n218 n219 vss pcb_foster_cell dx=6.5222169355373335e-04
Xn219 n219 n220 vss pcb_foster_cell dx=6.5222169355373335e-04
Xn220 n220 n221 vss pcb_foster_cell dx=6.5222169355373335e-04
Xn221 n221 n222 vss pcb_foster_cell dx=6.5222169355373335e-04
Xn222 n222 n223 vss pcb_foster_cell dx=6.5222169355373335e-04
Xn223 n223 n224 vss pcb_foster_cell dx=6.5222169355373335e-04
Xn224 n224 n225 vss pcb_foster_cell dx=6.5222169355373335e-04
Xn225 n225 n226 vss pcb_foster_cell dx=6.5222169355373335e-04
Xn226 n226 n227 vss pcb_foster_cell dx=6.5222169355373335e-04
Xn227 n227 n228 vss pcb_foster_cell dx=6.5222169355373335e-04
Xn228 n228 n229 vss pcb_foster_cell dx=6.5222169355373335e-04
Xn229 n229 n230 vss pcb_foster_cell dx=6.5222169355373335e-04
Xn230 n230 n231 vss pcb_foster_cell dx=6.5222169355373335e-04
Xn231 n231 n232 vss pcb_foster_cell dx=6.5222169355373335e-04
Xn232 n232 n233 vss pcb_foster_cell dx=6.5222169355373335e-04
Xn233 n233 n234 vss pcb_foster_cell dx=6.5222169355373335e-04
Xn234 n234 n235 vss pcb_foster_cell dx=6.5222169355373335e-04
Xn235 n235 n236 vss pcb_foster_cell dx=6.5222169355373335e-04
Xn236 n236 n237 vss pcb_foster_cell dx=6.5222169355373335e-04
Xn237 n237 n238 vss pcb_foster_cell dx=6.5222169355373335e-04
Xn238 n238 n239 vss pcb_foster_cell dx=6.5222169355373335e-04
Xn239 n239 n240 vss pcb_foster_cell dx=6.5222169355373335e-04
Xn240 n240 n241 vss pcb_foster_cell dx=6.5222169355373335e-04
Xn241 n241 n242 vss pcb_foster_cell dx=6.5222169355373335e-04
Xn242 n242 n243 vss pcb_foster_cell dx=6.5222169355373335e-04
Xn243 n243 n244 vss pcb_foster_cell dx=6.5222169355373335e-04
Xn244 n244 n245 vss pcb_foster_cell dx=6.5222169355373335e-04
Xn245 n245 n246 vss pcb_foster_cell dx=6.5222169355373335e-04
Xn246 n246 n247 vss pcb_foster_cell dx=6.5222169355373335e-04
Xn247 n247 n248 vss pcb_foster_cell dx=6.5222169355373335e-04
Xn248 n248 n249 vss pcb_foster_cell dx=6.5222169355373335e-04
Xn249 n249 n250 vss pcb_foster_cell dx=6.5222169355373335e-04
Xn250 n250 n251 vss pcb_foster_cell dx=6.5222169355373335e-04
Xn251 n251 n252 vss pcb_foster_cell dx=6.5222169355373335e-04
Xn252 n252 n253 vss pcb_foster_cell dx=6.5222169355373335e-04
Xn253 n253 n254 vss pcb_foster_cell dx=6.5222169355373335e-04
Xn254 n254 n255 vss pcb_foster_cell dx=6.5222169355373335e-04
Xn255 n255 n256 vss pcb_foster_cell dx=6.5222169355373335e-04
Xn256 n256 n257 vss pcb_foster_cell dx=6.5222169355373335e-04
Xn257 n257 n258 vss pcb_foster_cell dx=6.5222169355373335e-04
Xn258 n258 n259 vss pcb_foster_cell dx=6.5222169355373335e-04
Xn259 n259 n260 vss pcb_foster_cell dx=6.5222169355373335e-04
Xn260 n260 n261 vss pcb_foster_cell dx=6.5222169355373335e-04
Xn261 n261 n262 vss pcb_foster_cell dx=6.5222169355373335e-04
Xn262 n262 n263 vss pcb_foster_cell dx=6.5222169355373335e-04
Xn263 n263 n264 vss pcb_foster_cell dx=6.5222169355373335e-04
Xn264 n264 n265 vss pcb_foster_cell dx=6.5222169355373335e-04
Xn265 n265 n266 vss pcb_foster_cell dx=6.5222169355373335e-04
Xn266 n266 n267 vss pcb_foster_cell dx=6.5222169355373335e-04
Xn267 n267 n268 vss pcb_foster_cell dx=6.5222169355373335e-04
Xn268 n268 n269 vss pcb_foster_cell dx=6.5222169355373335e-04
Xn269 n269 n270 vss pcb_foster_cell dx=6.5222169355373335e-04
Xn270 n270 n271 vss pcb_foster_cell dx=6.5222169355373335e-04
Xn271 n271 n272 vss pcb_foster_cell dx=6.5222169355373335e-04
Xn272 n272 n273 vss pcb_foster_cell dx=6.5222169355373335e-04
Xn273 n273 n274 vss pcb_foster_cell dx=6.5222169355373335e-04
Xn274 n274 n275 vss pcb_foster_cell dx=6.5222169355373335e-04
Xn275 n275 n276 vss pcb_foster_cell dx=6.5222169355373335e-04
Xn276 n276 n277 vss pcb_foster_cell dx=6.5222169355373335e-04
Xn277 n277 n278 vss pcb_foster_cell dx=6.5222169355373335e-04
Xn278 n278 n279 vss pcb_foster_cell dx=6.5222169355373335e-04
Xn279 n279 n280 vss pcb_foster_cell dx=6.5222169355373335e-04
Xn280 n280 n281 vss pcb_foster_cell dx=6.5222169355373335e-04
Xn281 n281 n282 vss pcb_foster_cell dx=6.5222169355373335e-04
Xn282 n282 n283 vss pcb_foster_cell dx=6.5222169355373335e-04
Xn283 n283 n284 vss pcb_foster_cell dx=6.5222169355373335e-04
Xn284 n284 n285 vss pcb_foster_cell dx=6.5222169355373335e-04
Xn285 n285 n286 vss pcb_foster_cell dx=6.5222169355373335e-04
Xn286 n286 n287 vss pcb_foster_cell dx=6.5222169355373335e-04
Xn287 n287 n288 vss pcb_foster_cell dx=6.5222169355373335e-04
Xn288 n288 n289 vss pcb_foster_cell dx=6.5222169355373335e-04
Xn289 n289 n290 vss pcb_foster_cell dx=6.5222169355373335e-04
Xn290 n290 n291 vss pcb_foster_cell dx=6.5222169355373335e-04
Xn291 n291 n292 vss pcb_foster_cell dx=6.5222169355373335e-04
Xn292 n292 n293 vss pcb_foster_cell dx=6.5222169355373335e-04
Xn293 n293 n294 vss pcb_foster_cell dx=6.5222169355373335e-04
Xn294 n294 n295 vss pcb_foster_cell dx=6.5222169355373335e-04
Xn295 n295 n296 vss pcb_foster_cell dx=6.5222169355373335e-04
Xn296 n296 n297 vss pcb_foster_cell dx=6.5222169355373335e-04
Xn297 n297 n298 vss pcb_foster_cell dx=6.5222169355373335e-04
Xn298 n298 n299 vss pcb_foster_cell dx=6.5222169355373335e-04
Xn299 n299 n300 vss pcb_foster_cell dx=6.5222169355373335e-04
Xn300 n300 n301 vss pcb_foster_cell dx=6.5222169355373335e-04
Xn301 n301 n302 vss pcb_foster_cell dx=6.5222169355373335e-04
Xn302 n302 n303 vss pcb_foster_cell dx=6.5222169355373335e-04
Xn303 n303 n304 vss pcb_foster_cell dx=6.5222169355373335e-04
Xn304 n304 n305 vss pcb_foster_cell dx=6.5222169355373335e-04
Xn305 n305 n306 vss pcb_foster_cell dx=6.5222169355373335e-04
Xn306 n306 n307 vss pcb_foster_cell dx=6.5222169355373335e-04
Xn307 n307 n308 vss pcb_foster_cell dx=6.5222169355373335e-04
Xn308 n308 n309 vss pcb_foster_cell dx=6.5222169355373335e-04
Xn309 n309 n310 vss pcb_foster_cell dx=6.5222169355373335e-04
Xn310 n310 n311 vss pcb_foster_cell dx=6.5222169355373335e-04
Xn311 n311 n312 vss pcb_foster_cell dx=6.5222169355373335e-04
Xn312 n312 n313 vss pcb_foster_cell dx=6.5222169355373335e-04
Xn313 n313 n314 vss pcb_foster_cell dx=6.5222169355373335e-04
Xn314 n314 n315 vss pcb_foster_cell dx=6.5222169355373335e-04
Xn315 n315 n316 vss pcb_foster_cell dx=6.5222169355373335e-04
Xn316 n316 n317 vss pcb_foster_cell dx=6.5222169355373335e-04
Xn317 n317 n318 vss pcb_foster_cell dx=6.5222169355373335e-04
Xn318 n318 n319 vss pcb_foster_cell dx=6.5222169355373335e-04
Xn319 n319 n320 vss pcb_foster_cell dx=6.5222169355373335e-04
Xn320 n320 n321 vss pcb_foster_cell dx=6.5222169355373335e-04
Xn321 n321 n322 vss pcb_foster_cell dx=6.5222169355373335e-04
Xn322 n322 n323 vss pcb_foster_cell dx=6.5222169355373335e-04
Xn323 n323 n324 vss pcb_foster_cell dx=6.5222169355373335e-04
Xn324 n324 n325 vss pcb_foster_cell dx=6.5222169355373335e-04
Xn325 n325 n326 vss pcb_foster_cell dx=6.5222169355373335e-04
Xn326 n326 n327 vss pcb_foster_cell dx=6.5222169355373335e-04
Xn327 n327 n328 vss pcb_foster_cell dx=6.5222169355373335e-04
Xn328 n328 n329 vss pcb_foster_cell dx=6.5222169355373335e-04
Xn329 n329 n330 vss pcb_foster_cell dx=6.5222169355373335e-04
Xn330 n330 n331 vss pcb_foster_cell dx=6.5222169355373335e-04
Xn331 n331 n332 vss pcb_foster_cell dx=6.5222169355373335e-04
Xn332 n332 n333 vss pcb_foster_cell dx=6.5222169355373335e-04
Xn333 n333 n334 vss pcb_foster_cell dx=6.5222169355373335e-04
Xn334 n334 n335 vss pcb_foster_cell dx=6.5222169355373335e-04
Xn335 n335 n336 vss pcb_foster_cell dx=6.5222169355373335e-04
Xn336 n336 n337 vss pcb_foster_cell dx=6.5222169355373335e-04
Xn337 n337 n338 vss pcb_foster_cell dx=6.5222169355373335e-04
Xn338 n338 n339 vss pcb_foster_cell dx=6.5222169355373335e-04
Xn339 n339 n340 vss pcb_foster_cell dx=6.5222169355373335e-04
Xn340 n340 n341 vss pcb_foster_cell dx=6.5222169355373335e-04
Xn341 n341 n342 vss pcb_foster_cell dx=6.5222169355373335e-04
Xn342 n342 n343 vss pcb_foster_cell dx=6.5222169355373335e-04
Xn343 n343 n344 vss pcb_foster_cell dx=6.5222169355373335e-04
Xn344 n344 n345 vss pcb_foster_cell dx=6.5222169355373335e-04
Xn345 n345 n346 vss pcb_foster_cell dx=6.5222169355373335e-04
Xn346 n346 n347 vss pcb_foster_cell dx=6.5222169355373335e-04
Xn347 n347 n348 vss pcb_foster_cell dx=6.5222169355373335e-04
Xn348 n348 n349 vss pcb_foster_cell dx=6.5222169355373335e-04
Xn349 n349 n350 vss pcb_foster_cell dx=6.5222169355373335e-04
Xn350 n350 n351 vss pcb_foster_cell dx=6.5222169355373335e-04
Xn351 n351 n352 vss pcb_foster_cell dx=6.5222169355373335e-04
Xn352 n352 n353 vss pcb_foster_cell dx=6.5222169355373335e-04
Xn353 n353 n354 vss pcb_foster_cell dx=6.5222169355373335e-04
Xn354 n354 n355 vss pcb_foster_cell dx=6.5222169355373335e-04
Xn355 n355 n356 vss pcb_foster_cell dx=6.5222169355373335e-04
Xn356 n356 n357 vss pcb_foster_cell dx=6.5222169355373335e-04
Xn357 n357 n358 vss pcb_foster_cell dx=6.5222169355373335e-04
Xn358 n358 n359 vss pcb_foster_cell dx=6.5222169355373335e-04
Xn359 n359 n360 vss pcb_foster_cell dx=6.5222169355373335e-04
Xn360 n360 n361 vss pcb_foster_cell dx=6.5222169355373335e-04
Xn361 n361 n362 vss pcb_foster_cell dx=6.5222169355373335e-04
Xn362 n362 n363 vss pcb_foster_cell dx=6.5222169355373335e-04
Xn363 n363 n364 vss pcb_foster_cell dx=6.5222169355373335e-04
Xn364 n364 n365 vss pcb_foster_cell dx=6.5222169355373335e-04
Xn365 n365 n366 vss pcb_foster_cell dx=6.5222169355373335e-04
Xn366 n366 n367 vss pcb_foster_cell dx=6.5222169355373335e-04
Xn367 n367 n368 vss pcb_foster_cell dx=6.5222169355373335e-04
Xn368 n368 n369 vss pcb_foster_cell dx=6.5222169355373335e-04
Xn369 n369 n370 vss pcb_foster_cell dx=6.5222169355373335e-04
Xn370 n370 n371 vss pcb_foster_cell dx=6.5222169355373335e-04
Xn371 n371 n372 vss pcb_foster_cell dx=6.5222169355373335e-04
Xn372 n372 n373 vss pcb_foster_cell dx=6.5222169355373335e-04
Xn373 n373 n374 vss pcb_foster_cell dx=6.5222169355373335e-04
Xn374 n374 n375 vss pcb_foster_cell dx=6.5222169355373335e-04
Xn375 n375 n376 vss pcb_foster_cell dx=6.5222169355373335e-04
Xn376 n376 n377 vss pcb_foster_cell dx=6.5222169355373335e-04
Xn377 n377 n378 vss pcb_foster_cell dx=6.5222169355373335e-04
Xn378 n378 n379 vss pcb_foster_cell dx=6.5222169355373335e-04
Xn379 n379 n380 vss pcb_foster_cell dx=6.5222169355373335e-04
Xn380 n380 n381 vss pcb_foster_cell dx=6.5222169355373335e-04
Xn381 n381 n382 vss pcb_foster_cell dx=6.5222169355373335e-04
Xn382 n382 n383 vss pcb_foster_cell dx=6.5222169355373335e-04
Xn383 n383 n384 vss pcb_foster_cell dx=6.5222169355373335e-04
Xn384 n384 n385 vss pcb_foster_cell dx=6.5222169355373335e-04
Xn385 n385 n386 vss pcb_foster_cell dx=6.5222169355373335e-04
Xn386 n386 n387 vss pcb_foster_cell dx=6.5222169355373335e-04
Xn387 n387 n388 vss pcb_foster_cell dx=6.5222169355373335e-04
Xn388 n388 n389 vss pcb_foster_cell dx=6.5222169355373335e-04
Xn389 n389 n390 vss pcb_foster_cell dx=6.5222169355373335e-04
Xn390 n390 n391 vss pcb_foster_cell dx=6.5222169355373335e-04
Xn391 n391 n392 vss pcb_foster_cell dx=6.5222169355373335e-04
Xn392 n392 n393 vss pcb_foster_cell dx=6.5222169355373335e-04
Xn393 n393 n394 vss pcb_foster_cell dx=6.5222169355373335e-04
Xn394 n394 n395 vss pcb_foster_cell dx=6.5222169355373335e-04
Xn395 n395 n396 vss pcb_foster_cell dx=6.5222169355373335e-04
Xn396 n396 n397 vss pcb_foster_cell dx=6.5222169355373335e-04
Xn397 n397 n398 vss pcb_foster_cell dx=6.5222169355373335e-04
Xn398 n398 n399 vss pcb_foster_cell dx=6.5222169355373335e-04
Xn399 n399 n400 vss pcb_foster_cell dx=6.5222169355373335e-04
Xn400 n400 n401 vss pcb_foster_cell dx=6.5222169355373335e-04
Xn401 n401 n402 vss pcb_foster_cell dx=6.5222169355373335e-04
Xn402 n402 n403 vss pcb_foster_cell dx=6.5222169355373335e-04
Xn403 n403 n404 vss pcb_foster_cell dx=6.5222169355373335e-04
Xn404 n404 n405 vss pcb_foster_cell dx=6.5222169355373335e-04
Xn405 n405 n406 vss pcb_foster_cell dx=6.5222169355373335e-04
Xn406 n406 n407 vss pcb_foster_cell dx=6.5222169355373335e-04
Xn407 n407 n408 vss pcb_foster_cell dx=6.5222169355373335e-04
Xn408 n408 n409 vss pcb_foster_cell dx=6.5222169355373335e-04
Xn409 n409 n410 vss pcb_foster_cell dx=6.5222169355373335e-04
Xn410 n410 n411 vss pcb_foster_cell dx=6.5222169355373335e-04
Xn411 n411 n412 vss pcb_foster_cell dx=6.5222169355373335e-04
Xn412 n412 n413 vss pcb_foster_cell dx=6.5222169355373335e-04
Xn413 n413 n414 vss pcb_foster_cell dx=6.5222169355373335e-04
Xn414 n414 n415 vss pcb_foster_cell dx=6.5222169355373335e-04
Xn415 n415 n416 vss pcb_foster_cell dx=6.5222169355373335e-04
Xn416 n416 n417 vss pcb_foster_cell dx=6.5222169355373335e-04
Xn417 n417 n418 vss pcb_foster_cell dx=6.5222169355373335e-04
Xn418 n418 n419 vss pcb_foster_cell dx=6.5222169355373335e-04
Xn419 n419 n420 vss pcb_foster_cell dx=6.5222169355373335e-04
Xn420 n420 n421 vss pcb_foster_cell dx=6.5222169355373335e-04
Xn421 n421 n422 vss pcb_foster_cell dx=6.5222169355373335e-04
Xn422 n422 n423 vss pcb_foster_cell dx=6.5222169355373335e-04
Xn423 n423 n424 vss pcb_foster_cell dx=6.5222169355373335e-04
Xn424 n424 n425 vss pcb_foster_cell dx=6.5222169355373335e-04
Xn425 n425 n426 vss pcb_foster_cell dx=6.5222169355373335e-04
Xn426 n426 n427 vss pcb_foster_cell dx=6.5222169355373335e-04
Xn427 n427 n428 vss pcb_foster_cell dx=6.5222169355373335e-04
Xn428 n428 n429 vss pcb_foster_cell dx=6.5222169355373335e-04
Xn429 n429 n430 vss pcb_foster_cell dx=6.5222169355373335e-04
Xn430 n430 n431 vss pcb_foster_cell dx=6.5222169355373335e-04
Xn431 n431 n432 vss pcb_foster_cell dx=6.5222169355373335e-04
Xn432 n432 n433 vss pcb_foster_cell dx=6.5222169355373335e-04
Xn433 n433 n434 vss pcb_foster_cell dx=6.5222169355373335e-04
Xn434 n434 n435 vss pcb_foster_cell dx=6.5222169355373335e-04
Xn435 n435 n436 vss pcb_foster_cell dx=6.5222169355373335e-04
Xn436 n436 n437 vss pcb_foster_cell dx=6.5222169355373335e-04
Xn437 n437 n438 vss pcb_foster_cell dx=6.5222169355373335e-04
Xn438 n438 n439 vss pcb_foster_cell dx=6.5222169355373335e-04
Xn439 n439 n440 vss pcb_foster_cell dx=6.5222169355373335e-04
Xn440 n440 n441 vss pcb_foster_cell dx=6.5222169355373335e-04
Xn441 n441 n442 vss pcb_foster_cell dx=6.5222169355373335e-04
Xn442 n442 n443 vss pcb_foster_cell dx=6.5222169355373335e-04
Xn443 n443 n444 vss pcb_foster_cell dx=6.5222169355373335e-04
Xn444 n444 n445 vss pcb_foster_cell dx=6.5222169355373335e-04
Xn445 n445 n446 vss pcb_foster_cell dx=6.5222169355373335e-04
Xn446 n446 n447 vss pcb_foster_cell dx=6.5222169355373335e-04
Xn447 n447 n448 vss pcb_foster_cell dx=6.5222169355373335e-04
Xn448 n448 n449 vss pcb_foster_cell dx=6.5222169355373335e-04
Xn449 n449 n450 vss pcb_foster_cell dx=6.5222169355373335e-04
Xn450 n450 n451 vss pcb_foster_cell dx=6.5222169355373335e-04
Xn451 n451 n452 vss pcb_foster_cell dx=6.5222169355373335e-04
Xn452 n452 n453 vss pcb_foster_cell dx=6.5222169355373335e-04
Xn453 n453 n454 vss pcb_foster_cell dx=6.5222169355373335e-04
Xn454 n454 n455 vss pcb_foster_cell dx=6.5222169355373335e-04
Xn455 n455 n456 vss pcb_foster_cell dx=6.5222169355373335e-04
Xn456 n456 n457 vss pcb_foster_cell dx=6.5222169355373335e-04
Xn457 n457 n458 vss pcb_foster_cell dx=6.5222169355373335e-04
Xn458 n458 n459 vss pcb_foster_cell dx=6.5222169355373335e-04
Xn459 n459 bn vss pcb_foster_cell dx=6.5222169355373335e-04
Rnstub n230 ns0 10.0
Xns0 ns0 ns1 vss pcb_foster_cell dx=6.3453268788073983e-04
Xns1 ns1 ns2 vss pcb_foster_cell dx=6.3453268788073983e-04
Xns2 ns2 ns3 vss pcb_foster_cell dx=6.3453268788073983e-04
Xns3 ns3 ns4 vss pcb_foster_cell dx=6.3453268788073983e-04
Xns4 ns4 ns5 vss pcb_foster_cell dx=6.3453268788073983e-04
Xns5 ns5 ns6 vss pcb_foster_cell dx=6.3453268788073983e-04
Xns6 ns6 ns7 vss pcb_foster_cell dx=6.3453268788073983e-04
Xns7 ns7 ns8 vss pcb_foster_cell dx=6.3453268788073983e-04
Xns8 ns8 ns9 vss pcb_foster_cell dx=6.3453268788073983e-04
Xns9 ns9 ns10 vss pcb_foster_cell dx=6.3453268788073983e-04
Xns10 ns10 ns11 vss pcb_foster_cell dx=6.3453268788073983e-04
Xns11 ns11 ns12 vss pcb_foster_cell dx=6.3453268788073983e-04
Xns12 ns12 ns13 vss pcb_foster_cell dx=6.3453268788073983e-04
Xns13 ns13 ns14 vss pcb_foster_cell dx=6.3453268788073983e-04
Xns14 ns14 ns15 vss pcb_foster_cell dx=6.3453268788073983e-04
Xns15 ns15 ns16 vss pcb_foster_cell dx=6.3453268788073983e-04
Xns16 ns16 ns17 vss pcb_foster_cell dx=6.3453268788073983e-04
Xns17 ns17 ns18 vss pcb_foster_cell dx=6.3453268788073983e-04
Xns18 ns18 ns19 vss pcb_foster_cell dx=6.3453268788073983e-04
Xns19 ns19 ns20 vss pcb_foster_cell dx=6.3453268788073983e-04
Xns20 ns20 ns21 vss pcb_foster_cell dx=6.3453268788073983e-04
Xns21 ns21 ns22 vss pcb_foster_cell dx=6.3453268788073983e-04
Xns22 ns22 ns23 vss pcb_foster_cell dx=6.3453268788073983e-04
Xns23 ns23 ns24 vss pcb_foster_cell dx=6.3453268788073983e-04
Xns24 ns24 ns25 vss pcb_foster_cell dx=6.3453268788073983e-04
Xns25 ns25 ns26 vss pcb_foster_cell dx=6.3453268788073983e-04
Xns26 ns26 ns27 vss pcb_foster_cell dx=6.3453268788073983e-04
Xns27 ns27 ns28 vss pcb_foster_cell dx=6.3453268788073983e-04
Xns28 ns28 ns29 vss pcb_foster_cell dx=6.3453268788073983e-04
Xns29 ns29 ns30 vss pcb_foster_cell dx=6.3453268788073983e-04
Xns30 ns30 ns31 vss pcb_foster_cell dx=6.3453268788073983e-04
Xns31 ns31 ns32 vss pcb_foster_cell dx=6.3453268788073983e-04
Xns32 ns32 ns33 vss pcb_foster_cell dx=6.3453268788073983e-04
.ends pcb_c4_stub
