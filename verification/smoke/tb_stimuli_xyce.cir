Stimulus infrastructure check - Xyce; no DUT or PDK
.include "verification/smoke/stimuli_fixture.inc"
.tran 10p 30n 0 10p
.PRINT TRAN FORMAT=STD V(clk) V(diff) V(cm) V(ref) V(fb) V(up) V(dn) V(vctrl)
.measure tran cmos_high MAX V(clk) FROM=2n TO=29n
.measure tran diff_high MAX V(diff) FROM=2n TO=29n
.measure tran diff_low MIN V(diff) FROM=2n TO=29n
.measure tran common_mode AVG V(cm) FROM=2n TO=29n
.measure tran clock_period TRIG V(clk) VAL=0.9 RISE=2 TARG V(clk) VAL=0.9 RISE=3
.measure tran ramp_end FIND V(vctrl) AT=29n
.measure tran ref_fb_delay TRIG V(ref) VAL=0.9 RISE=2 TARG V(fb) VAL=0.9 RISE=2
.measure tran up_width TRIG V(up) VAL=0.9 RISE=2 TARG V(up) VAL=0.9 FALL=2
.measure tran dn_width TRIG V(dn) VAL=0.9 RISE=2 TARG V(dn) VAL=0.9 FALL=2
.measure tran up_dn_delay TRIG V(up) VAL=0.9 RISE=2 TARG V(dn) VAL=0.9 RISE=2
.end
