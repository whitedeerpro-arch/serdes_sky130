Resident simulation and waveform-retention validation (no SerDes)
* Slow state deliberately retains input history over1us; fast state has1ns tau.
V1 in 0 PWL(0 0 1p 0 2p 1)
Rfast in fast 1k
Cfast fast 0 1p
Rslow in slow 1k
Cslow slow 0 1n
.save v(in) v(fast) v(slow)
.options reltol=1e-6 method=gear maxord=2
.tran 2p 2u 0 2p
.end
